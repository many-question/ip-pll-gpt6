simulator lang=spectre
include "lc_core_filtered_slow.scs"
include "cap_bank_biased.scs"
// Combined candidate reconstructed from fine02/neighbor tests.
// Core and switches: PDK MOS. Fine tuning: PDK nmoscap (tt_bbmvar, etc.).
// Tank L/R, fixed/bank C and bias-current reference remain explicit assumptions.
subckt tx_lc_vco_off_biased (vp vn ctrl b0 b1 b2 b3 b4 b5 b6 b7 vdd vss)
parameters fixed_c=190f
RH (vdd bcm) resistor r=100k
RL (bcm vss) resistor r=100k
CB (bcm vss) capacitor c=1p
XL (vp vn vdd vss) tx_lc_core_filtered_slow tank_r=5 tank_c=fixed_c core_w=40u
XBP (vp b0 b1 b2 b3 b4 b5 b6 b7 bcm vss) tx_cap_bank_biased unit_c=5.7f unit_w=2.4u
XBN (vn b0 b1 b2 b3 b4 b5 b6 b7 bcm vss) tx_cap_bank_biased unit_c=5.7f unit_w=2.4u
CVP (vp ctrl) nmoscap lr=2u wr=3u mr=1
CVN (vn ctrl) nmoscap lr=2u wr=3u mr=1
ends tx_lc_vco_off_biased
