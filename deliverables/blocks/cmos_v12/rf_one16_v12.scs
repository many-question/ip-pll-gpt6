simulator lang=spectre
subckt rf_one16_v12 (rf clk vdd vss)
C0 (rf g0) capacitor c=1p
R0 (g0 clk) resistor r=20k
X0 (g0 clk vdd vss) pll_inv wn=16u wp=40.0u
ends rf_one16_v12
