simulator lang=spectre
// Project RTL mapped to actual MOS cells.
subckt tx_fll_rebracket108_v14 (refclk reset target_k0 target_k1 target_k2 target_k3 target_k4 target_k5 measured0 measured1 measured2 measured3 measured4 measured5 measured6 measured7 measured8 measured9 measured10 measured11 measured12 measured13 coarse0 coarse1 coarse2 coarse3 coarse4 coarse5 coarse6 coarse7 dac0 dac1 dac2 dac3 dac4 dac5 count_gate count_reset enable range_error state_out0 state_out1 state_out2 vdd vss)
X0 (n45 refclk reset enable vdd vss) tx_dff_r0
X1 (n46 refclk reset n47 vdd vss) tx_dff_r0
X2 (n48 refclk reset n49 vdd vss) tx_dff_r0
X3 (n50 refclk reset n51 vdd vss) tx_dff_r0
X4 (n52 refclk reset n53 vdd vss) tx_dff_r0
X5 (n54 refclk reset n55 vdd vss) tx_dff_r0
X6 (n56 refclk reset n57 vdd vss) tx_dff_r0
X7 (n58 refclk reset n59 vdd vss) tx_dff_r0
X8 (n60 refclk reset n61 vdd vss) tx_dff_r1
X9 (n62 refclk reset range_error vdd vss) tx_dff_r0
X10 (n63 refclk reset n64 vdd vss) tx_dff_r0
X11 (n65 refclk reset n66 vdd vss) tx_dff_r0
X12 (n67 refclk reset n68 vdd vss) tx_dff_r0
X13 (n69 refclk reset state_out0 vdd vss) tx_dff_r0
X14 (n70 refclk reset state_out1 vdd vss) tx_dff_r0
X15 (n71 refclk reset state_out2 vdd vss) tx_dff_r0
X16 (n72 refclk reset n73 vdd vss) tx_dff_r0
X17 (n74 refclk reset n75 vdd vss) tx_dff_r0
X18 (n76 refclk reset n77 vdd vss) tx_dff_r0
X19 (n78 refclk reset n79 vdd vss) tx_dff_r0
X20 (n80 refclk reset n81 vdd vss) tx_dff_r0
X21 (n82 refclk reset n83 vdd vss) tx_dff_r0
X22 (n84 refclk reset n85 vdd vss) tx_dff_r0
X23 (n86 refclk reset n87 vdd vss) tx_dff_r0
X24 (n88 refclk reset n89 vdd vss) tx_dff_r0
X25 (n90 refclk reset n91 vdd vss) tx_dff_r1
X26 (n92 refclk reset n93 vdd vss) tx_dff_r0
X27 (n94 refclk reset n95 vdd vss) tx_dff_r1
X28 (n96 refclk reset n97 vdd vss) tx_dff_r0
X29 (n98 refclk reset n99 vdd vss) tx_dff_r1
X30 (n100 refclk reset n101 vdd vss) tx_dff_r1
X31 (n102 refclk reset coarse0 vdd vss) tx_dff_r0
X32 (n103 refclk reset coarse1 vdd vss) tx_dff_r0
X33 (n104 refclk reset coarse2 vdd vss) tx_dff_r0
X34 (n105 refclk reset coarse3 vdd vss) tx_dff_r0
X35 (n106 refclk reset coarse4 vdd vss) tx_dff_r0
X36 (n107 refclk reset coarse5 vdd vss) tx_dff_r0
X37 (n108 refclk reset coarse6 vdd vss) tx_dff_r0
X38 (n109 refclk reset coarse7 vdd vss) tx_dff_r0
X39 (n110 refclk reset n111 vdd vss) tx_dff_r0
X40 (n112 refclk reset dac0 vdd vss) tx_dff_r1
X41 (n113 refclk reset dac1 vdd vss) tx_dff_r1
X42 (n114 refclk reset dac2 vdd vss) tx_dff_r0
X43 (n115 refclk reset dac3 vdd vss) tx_dff_r1
X44 (n116 refclk reset dac4 vdd vss) tx_dff_r0
X45 (n117 refclk reset n118 vdd vss) tx_dff_r0
X46 (n119 refclk reset count_gate vdd vss) tx_dff_r0
X47 (n120 refclk reset dac5 vdd vss) tx_dff_r0
X48 (n121 refclk reset n122 vdd vss) tx_dff_r0
X49 (n123 refclk reset count_reset vdd vss) tx_dff_r1
X50 (n124 refclk reset n125 vdd vss) tx_dff_r1
X51 (n126 refclk reset n127 vdd vss) tx_dff_r1
X52 (n128 refclk reset n129 vdd vss) tx_dff_r0
X53 (n130 refclk reset n131 vdd vss) tx_dff_r1
X54 (n132 refclk reset n133 vdd vss) tx_dff_r0
X55 (n134 refclk reset n135 vdd vss) tx_dff_r0
X56 (state_out1 n136 n137 n70 vdd vss) tx_mux
X57 (state_out0 n138 n137 n69 vdd vss) tx_mux
X58 (n66 n139 n140 n65 vdd vss) tx_mux
X59 (n64 n141 n140 n63 vdd vss) tx_mux
X60 (n59 n142 n143 n58 vdd vss) tx_mux
X61 (n57 n144 n143 n56 vdd vss) tx_mux
X62 (n55 n145 n143 n54 vdd vss) tx_mux
X63 (n53 n146 n143 n52 vdd vss) tx_mux
X64 (n51 n147 n143 n50 vdd vss) tx_mux
X65 (n49 n148 n143 n48 vdd vss) tx_mux
X66 (n47 n149 n143 n46 vdd vss) tx_mux
X67 (n133 n150 n151 n132 vdd vss) tx_mux
X68 (n131 n152 n151 n130 vdd vss) tx_mux
X69 (n129 n153 n151 n128 vdd vss) tx_mux
X70 (n127 n154 n151 n126 vdd vss) tx_mux
X71 (n125 n155 n151 n124 vdd vss) tx_mux
X72 (dac4 n156 n157 n116 vdd vss) tx_mux
X73 (dac3 n158 n157 n115 vdd vss) tx_mux
X74 (dac2 n159 n157 n114 vdd vss) tx_mux
X75 (dac1 n160 n157 n113 vdd vss) tx_mux
X76 (dac0 n161 n157 n112 vdd vss) tx_mux
X77 (coarse6 n162 n163 n108 vdd vss) tx_mux
X78 (coarse5 n164 n163 n107 vdd vss) tx_mux
X79 (coarse4 n165 n163 n106 vdd vss) tx_mux
X80 (coarse3 n166 n163 n105 vdd vss) tx_mux
X81 (coarse2 n167 n163 n104 vdd vss) tx_mux
X82 (coarse1 n168 n163 n103 vdd vss) tx_mux
X83 (coarse0 n169 n163 n102 vdd vss) tx_mux
X84 (n99 n170 n171 n98 vdd vss) tx_mux
X85 (n97 n172 n171 n96 vdd vss) tx_mux
X86 (n95 n173 n171 n94 vdd vss) tx_mux
X87 (n93 n174 n171 n92 vdd vss) tx_mux
X88 (n91 n175 n171 n90 vdd vss) tx_mux
X89 (n101 n176 n171 n100 vdd vss) tx_mux
X90 (coarse7 n177 n163 n109 vdd vss) tx_mux
X91 (n111 n178 n179 n110 vdd vss) tx_mux
X92 (dac5 n180 n181 n120 vdd vss) tx_mux
X93 (n118 n182 n140 n117 vdd vss) tx_mux
X94 (count_gate n183 n184 n119 vdd vss) tx_mux
X95 (n122 vdd n185 n121 vdd vss) tx_mux
X96 (count_reset n186 n187 n123 vdd vss) tx_mux
X97 (n135 n188 n151 n134 vdd vss) tx_mux
X98 (enable n189 n190 n45 vdd vss) tx_mux
X99 (n61 n191 n143 n60 vdd vss) tx_mux
X100 (range_error n192 n193 n62 vdd vss) tx_mux
X101 (n68 n194 n140 n67 vdd vss) tx_mux
X102 (state_out2 n195 n137 n71 vdd vss) tx_mux
X103 (n73 n196 n197 n72 vdd vss) tx_mux
X104 (n198 n87 n199 n86 vdd vss) tx_mux
X105 (n200 n85 n199 n84 vdd vss) tx_mux
X106 (n201 n83 n199 n82 vdd vss) tx_mux
X107 (n202 n81 n199 n80 vdd vss) tx_mux
X108 (n203 n79 n199 n78 vdd vss) tx_mux
X109 (n204 n77 n199 n76 vdd vss) tx_mux
X110 (n205 n75 n199 n74 vdd vss) tx_mux
X111 (n206 n89 n199 n88 vdd vss) tx_mux
X112 (dac2 n207 vdd vss) pll_inv
X113 (dac3 n208 vdd vss) pll_inv
X114 (dac5 n209 vdd vss) pll_inv
X115 (dac4 n210 vdd vss) pll_inv
X116 (target_k2 n211 vdd vss) pll_inv
X117 (target_k3 n212 vdd vss) pll_inv
X118 (n213 n214 vdd vss) pll_inv
X119 (n215 n216 vdd vss) pll_inv
X120 (n217 n218 vdd vss) pll_inv
X121 (n219 n220 vdd vss) pll_inv
X122 (n221 n222 vdd vss) pll_inv
X123 (n223 n224 vdd vss) pll_inv
X124 (n225 n226 vdd vss) pll_inv
X125 (n227 n228 vdd vss) pll_inv
X126 (n229 n230 vdd vss) pll_inv
X127 (n231 n232 vdd vss) pll_inv
X128 (n233 n234 vdd vss) pll_inv
X129 (n235 n236 vdd vss) pll_inv
X130 (n237 n238 vdd vss) pll_inv
X131 (n64 n239 vdd vss) pll_inv
X132 (n240 n241 vdd vss) pll_inv
X133 (n242 n243 vdd vss) pll_inv
X134 (n244 n245 vdd vss) pll_inv
X135 (n246 n247 vdd vss) pll_inv
X136 (n248 n249 vdd vss) pll_inv
X137 (n250 n251 vdd vss) pll_inv
X138 (n252 n253 vdd vss) pll_inv
X139 (dac0 n254 vdd vss) pll_inv
X140 (target_k0 n255 vdd vss) pll_inv
X141 (state_out1 n256 vdd vss) pll_inv
X142 (state_out0 n257 vdd vss) pll_inv
X143 (n47 n258 vdd vss) pll_inv
X144 (n66 n259 vdd vss) pll_inv
X145 (n68 n260 vdd vss) pll_inv
X146 (state_out2 n261 vdd vss) pll_inv
X147 (n262 n263 vdd vss) pll_inv
X148 (n73 n264 vdd vss) pll_inv
X149 (n265 n266 vdd vss) pll_inv
X150 (n267 n268 vdd vss) pll_inv
X151 (n269 n270 vdd vss) pll_inv
X152 (measured3 n271 vdd vss) pll_inv
X153 (measured0 n272 vdd vss) pll_inv
X154 (measured1 n273 vdd vss) pll_inv
X155 (measured2 n274 vdd vss) pll_inv
X156 (n275 n276 vdd vss) pll_inv
X157 (n277 n278 vdd vss) pll_inv
X158 (n279 n280 vdd vss) pll_inv
X159 (n281 n282 vdd vss) pll_inv
X160 (n283 n284 vdd vss) pll_inv
X161 (n285 n286 vdd vss) pll_inv
X162 (n287 n288 vdd vss) pll_inv
X163 (n122 n289 vdd vss) pll_inv
X164 (n111 n290 vdd vss) pll_inv
X165 (n291 n292 vdd vss) pll_inv
X166 (coarse0 n258 n293 vdd vss) tx_and
X167 (coarse1 n294 n295 vdd vss) tx_and
X168 (coarse2 n296 n297 vdd vss) tx_and
X169 (coarse3 n298 n299 vdd vss) tx_and
X170 (coarse4 n300 n301 vdd vss) tx_and
X171 (coarse5 n302 n303 vdd vss) tx_and
X172 (coarse6 n304 n305 vdd vss) tx_and
X173 (coarse7 n306 n307 vdd vss) tx_and
X174 (dac0 n258 n308 vdd vss) tx_and
X175 (dac1 n294 n309 vdd vss) tx_and
X176 (dac2 n296 n310 vdd vss) tx_and
X177 (dac3 n298 n311 vdd vss) tx_and
X178 (dac4 n300 n312 vdd vss) tx_and
X179 (dac5 n302 n313 vdd vss) tx_and
X180 (n81 n73 n314 vdd vss) tx_xor
X181 (n83 n73 n315 vdd vss) tx_xor
X182 (n85 n111 n316 vdd vss) tx_xor
X183 (n87 n111 n317 vdd vss) tx_xor
X184 (n240 n49 n318 vdd vss) tx_or
X185 (n279 n51 n319 vdd vss) tx_or
X186 (n320 n53 n321 vdd vss) tx_or
X187 (n322 n55 n323 vdd vss) tx_or
X188 (n324 n57 n325 vdd vss) tx_or
X189 (n326 n59 n327 vdd vss) tx_or
X190 (n328 n61 n329 vdd vss) tx_or
X191 (n330 n49 n331 vdd vss) tx_or
X192 (n332 n51 n333 vdd vss) tx_or
X193 (n334 n53 n335 vdd vss) tx_or
X194 (n336 n55 n337 vdd vss) tx_or
X195 (n338 n57 n339 vdd vss) tx_or
X196 (n278 n340 n341 vdd vss) tx_or
X197 (n342 n343 n344 vdd vss) tx_or
X198 (n345 n346 n347 vdd vss) tx_or
X199 (n348 n349 n350 vdd vss) tx_xor
X200 (n351 n352 n353 vdd vss) tx_xor
X201 (target_k5 n354 n355 vdd vss) tx_xor
X202 (n356 n357 n358 vdd vss) tx_xor
X203 (n359 n360 n361 vdd vss) tx_xor
X204 (n362 n363 n364 vdd vss) tx_xor
X205 (target_k4 n365 n366 vdd vss) tx_xor
X206 (target_k5 n367 n368 vdd vss) tx_xor
X207 (n369 n370 n371 vdd vss) tx_xor
X208 (n372 n373 n374 vdd vss) tx_xor
X209 (n348 n375 n376 vdd vss) tx_xor
X210 (n351 n377 n378 vdd vss) tx_xor
X211 (target_k5 n379 n380 vdd vss) tx_xor
X212 (n381 n370 n382 vdd vss) tx_xor
X213 (n383 n384 n385 vdd vss) tx_xor
X214 (n386 n387 n388 vdd vss) tx_xor
X215 (n389 n390 n391 vdd vss) tx_xor
X216 (n378 n392 n393 vdd vss) tx_xor
X217 (n380 n394 n395 vdd vss) tx_xor
X218 (n396 n397 n398 vdd vss) tx_xor
X219 (n273 n272 n399 vdd vss) tx_xor
X220 (n274 n400 n401 vdd vss) tx_xor
X221 (n271 n402 n403 vdd vss) tx_xor
X222 (n404 n405 n406 vdd vss) tx_xor
X223 (n407 n408 n409 vdd vss) tx_xor
X224 (n410 n411 n412 vdd vss) tx_xor
X225 (n413 n414 n415 vdd vss) tx_xor
X226 (n416 n417 n418 vdd vss) tx_xor
X227 (n419 n420 n421 vdd vss) tx_xor
X228 (n422 n423 n424 vdd vss) tx_xor
X229 (n425 n426 n427 vdd vss) tx_xor
X230 (n428 n429 n430 vdd vss) tx_xor
X231 (n431 n432 n433 vdd vss) tx_xor
X232 (n434 n435 n242 vdd vss) tx_xor
X233 (n436 n437 n246 vdd vss) tx_xor
X234 (n438 n439 n244 vdd vss) tx_xor
X235 (n440 n441 n248 vdd vss) tx_xor
X236 (n442 n443 n250 vdd vss) tx_xor
X237 (n243 n444 n445 vdd vss) tx_xor
X238 (n247 n446 n447 vdd vss) tx_xor
X239 (n245 n448 n449 vdd vss) tx_xor
X240 (n249 n450 n451 vdd vss) tx_xor
X241 (n251 n452 n453 vdd vss) tx_xor
X242 (n253 n454 n455 vdd vss) tx_xor
X243 (dac1 dac0 n456 vdd vss) tx_xor
X244 (dac4 n457 n458 vdd vss) tx_xor
X245 (dac5 n459 n460 vdd vss) tx_xor
X246 (n461 n462 n463 vdd vss) tx_xor
X247 (n464 n465 n466 vdd vss) tx_xor
X248 (n467 n468 n469 vdd vss) tx_xor
X249 (n470 n471 n472 vdd vss) tx_xor
X250 (n473 n474 n475 vdd vss) tx_xor
X251 (n476 n477 n478 vdd vss) tx_xor
X252 (n324 n479 n480 vdd vss) tx_xor
X253 (n326 n481 n482 vdd vss) tx_xor
X254 (n320 n279 n483 vdd vss) tx_xor
X255 (n322 n484 n485 vdd vss) tx_xor
X256 (n328 n486 n487 vdd vss) tx_xor
X257 (n488 n489 n490 vdd vss) tx_xor
X258 (n66 n64 n491 vdd vss) tx_xor
X259 (n68 n492 n493 vdd vss) tx_xor
X260 (n494 n495 n496 vdd vss) tx_xor
X261 (n497 n498 n499 vdd vss) tx_xor
X262 (n500 n501 n502 vdd vss) tx_xor
X263 (n503 n504 n505 vdd vss) tx_xor
X264 (n506 n507 n508 vdd vss) tx_xor
X265 (n509 n510 n511 vdd vss) tx_xor
X266 (n512 n513 n514 vdd vss) tx_xor
X267 (n515 n516 n517 vdd vss) tx_xor
X268 (n518 n519 n520 vdd vss) tx_xor
X269 (n521 n522 n523 vdd vss) tx_xor
X270 (n524 dac0 n525 vdd vss) tx_xor
X271 (n207 n526 n527 vdd vss) tx_xor
X272 (n208 n528 n529 vdd vss) tx_xor
X273 (n210 n530 n531 vdd vss) tx_xor
X274 (n209 n532 n533 vdd vss) tx_xor
X275 (dac2 n534 n535 vdd vss) tx_xor
X276 (dac3 n536 n537 vdd vss) tx_xor
X277 (n77 n75 n538 vdd vss) tx_xor
X278 (n79 n539 n540 vdd vss) tx_xor
X279 (n81 n541 n542 vdd vss) tx_xor
X280 (n83 n543 n544 vdd vss) tx_xor
X281 (n85 n545 n546 vdd vss) tx_xor
X282 (n87 n547 n548 vdd vss) tx_xor
X283 (n89 n549 n550 vdd vss) tx_xor
X284 (measured4 n551 n552 vdd vss) tx_and
X285 (measured9 n553 n554 vdd vss) tx_and
X286 (measured10 n555 n556 vdd vss) tx_and
X287 (measured12 n557 n558 vdd vss) tx_and
X288 (measured13 n559 n560 vdd vss) tx_and
X289 (measured5 n561 n497 vdd vss) tx_xor
X290 (measured12 n557 n518 vdd vss) tx_xor
X291 (n562 n563 n504 vdd vss) tx_or
X292 (n564 n565 n513 vdd vss) tx_or
X293 (n566 n567 n519 vdd vss) tx_or
X294 (n568 n569 n507 vdd vss) tx_or
X295 (n570 n495 n569 vdd vss) tx_and
X296 (n571 n564 n572 vdd vss) tx_and
X297 (n558 n573 n522 vdd vss) tx_or
X298 (n560 n574 n575 vdd vss) tx_or
X299 (n521 n558 n574 vdd vss) tx_and
X300 (n515 n556 n576 vdd vss) tx_and
X301 (n554 n577 n564 vdd vss) tx_or
X302 (n509 n578 n577 vdd vss) tx_and
X303 (n503 n500 n579 vdd vss) tx_and
X304 (n503 n562 n580 vdd vss) tx_and
X305 (n271 n274 n581 vdd vss) tx_and
X306 (measured3 n582 n583 vdd vss) tx_or
X307 (n271 measured2 n582 vdd vss) tx_and
X308 (n506 n507 n584 vdd vss) tx_and
X309 (measured8 n585 n506 vdd vss) tx_xor
X310 (measured10 n555 n512 vdd vss) tx_xor
X311 (target_k3 target_k4 n348 vdd vss) tx_xor
X312 (n586 n587 n352 vdd vss) tx_or
X313 (target_k5 n354 n588 vdd vss) tx_and
X314 (n589 n590 n354 vdd vss) tx_or
X315 (n591 n349 n590 vdd vss) tx_and
X316 (n592 n593 n349 vdd vss) tx_or
X317 (n594 n370 n593 vdd vss) tx_and
X318 (n351 n348 n591 vdd vss) tx_and
X319 (n595 n596 n589 vdd vss) tx_or
X320 (n351 n586 n596 vdd vss) tx_and
X321 (n372 n369 n594 vdd vss) tx_and
X322 (n597 n598 n592 vdd vss) tx_or
X323 (n372 n599 n598 vdd vss) tx_and
X324 (n348 n349 n587 vdd vss) tx_and
X325 (target_k5 n600 n287 vdd vss) tx_or
X326 (n601 n602 n600 vdd vss) tx_and
X327 (target_k3 target_k2 n597 vdd vss) tx_and
X328 (target_k5 n603 n285 vdd vss) tx_or
X329 (n601 n604 n603 vdd vss) tx_and
X330 (n605 n606 n604 vdd vss) tx_or
X331 (n607 target_k1 n606 vdd vss) tx_and
X332 (n608 target_k4 n601 vdd vss) tx_and
X333 (target_k3 n609 n605 vdd vss) tx_or
X334 (n212 target_k2 n609 vdd vss) tx_and
X335 (target_k0 target_k2 n357 vdd vss) tx_and
X336 (target_k1 target_k3 n610 vdd vss) tx_and
X337 (target_k2 target_k4 n611 vdd vss) tx_and
X338 (target_k3 target_k5 n612 vdd vss) tx_and
X339 (target_k0 target_k2 n613 vdd vss) tx_xor
X340 (target_k1 target_k3 n356 vdd vss) tx_xor
X341 (target_k2 target_k4 n359 vdd vss) tx_xor
X342 (target_k3 target_k5 n362 vdd vss) tx_xor
X343 (n611 n614 n363 vdd vss) tx_or
X344 (target_k4 n365 n367 vdd vss) tx_and
X345 (n615 n616 n365 vdd vss) tx_or
X346 (n617 n360 n616 vdd vss) tx_and
X347 (n618 n619 n620 vdd vss) tx_or
X348 (n621 n360 n619 vdd vss) tx_and
X349 (n595 n617 n621 vdd vss) tx_and
X350 (n595 n615 n618 vdd vss) tx_and
X351 (target_k5 target_k4 n595 vdd vss) tx_and
X352 (n362 n359 n617 vdd vss) tx_and
X353 (n612 n622 n615 vdd vss) tx_or
X354 (n362 n611 n622 vdd vss) tx_and
X355 (n610 n623 n360 vdd vss) tx_or
X356 (n356 n357 n623 vdd vss) tx_and
X357 (n359 n360 n614 vdd vss) tx_and
X358 (n624 n625 n283 vdd vss) tx_or
X359 (n626 n627 n625 vdd vss) tx_and
X360 (n597 n628 n627 vdd vss) tx_and
X361 (target_k5 n601 n624 vdd vss) tx_or
X362 (target_k1 n629 n628 vdd vss) tx_or
X363 (target_k0 target_k1 n370 vdd vss) tx_and
X364 (target_k1 target_k2 n599 vdd vss) tx_and
X365 (target_k3 target_k4 n586 vdd vss) tx_and
X366 (target_k0 target_k1 n630 vdd vss) tx_xor
X367 (target_k1 target_k2 n369 vdd vss) tx_xor
X368 (target_k2 target_k3 n372 vdd vss) tx_xor
X369 (target_k4 target_k5 n351 vdd vss) tx_xor
X370 (n597 n631 n375 vdd vss) tx_or
X371 (n351 n377 n632 vdd vss) tx_and
X372 (n633 n634 n377 vdd vss) tx_or
X373 (n635 n373 n634 vdd vss) tx_and
X374 (n595 n632 n379 vdd vss) tx_or
X375 (n636 n637 n396 vdd vss) tx_or
X376 (n638 n373 n637 vdd vss) tx_and
X377 (n639 n635 n638 vdd vss) tx_and
X378 (n640 n641 n636 vdd vss) tx_or
X379 (n639 n633 n641 vdd vss) tx_and
X380 (target_k5 n351 n639 vdd vss) tx_and
X381 (target_k5 n595 n640 vdd vss) tx_and
X382 (n348 n372 n635 vdd vss) tx_and
X383 (n586 n642 n633 vdd vss) tx_or
X384 (n348 n597 n642 vdd vss) tx_and
X385 (n599 n643 n373 vdd vss) tx_or
X386 (n369 n370 n643 vdd vss) tx_and
X387 (n372 n373 n631 vdd vss) tx_and
X388 (n624 n644 n281 vdd vss) tx_or
X389 (n626 n602 n644 vdd vss) tx_and
X390 (n597 n645 n602 vdd vss) tx_or
X391 (n630 target_k2 n646 vdd vss) tx_and
X392 (n371 target_k3 n647 vdd vss) tx_and
X393 (n374 target_k4 n648 vdd vss) tx_and
X394 (n376 target_k5 n649 vdd vss) tx_and
X395 (n630 target_k2 n381 vdd vss) tx_xor
X396 (n371 target_k3 n383 vdd vss) tx_xor
X397 (n374 target_k4 n386 vdd vss) tx_xor
X398 (n376 target_k5 n389 vdd vss) tx_xor
X399 (n648 n650 n390 vdd vss) tx_or
X400 (n646 n651 n384 vdd vss) tx_or
X401 (n378 n392 n394 vdd vss) tx_and
X402 (n652 n653 n392 vdd vss) tx_or
X403 (n654 n387 n653 vdd vss) tx_and
X404 (n381 n370 n651 vdd vss) tx_and
X405 (n655 n656 n397 vdd vss) tx_or
X406 (n657 n387 n656 vdd vss) tx_and
X407 (n396 n397 n658 vdd vss) tx_and
X408 (n659 n654 n657 vdd vss) tx_and
X409 (n659 n652 n655 vdd vss) tx_and
X410 (n660 n661 n387 vdd vss) tx_or
X411 (n662 n370 n661 vdd vss) tx_and
X412 (n380 n378 n659 vdd vss) tx_and
X413 (n389 n386 n654 vdd vss) tx_and
X414 (n649 n663 n652 vdd vss) tx_or
X415 (n389 n648 n663 vdd vss) tx_and
X416 (n383 n381 n662 vdd vss) tx_and
X417 (n647 n664 n660 vdd vss) tx_or
X418 (n383 n646 n664 vdd vss) tx_and
X419 (n386 n387 n650 vdd vss) tx_and
X420 (n665 n666 n667 vdd vss) tx_and
X421 (n668 n669 n670 vdd vss) tx_and
X422 (n671 n672 n673 vdd vss) tx_and
X423 (n674 n675 n676 vdd vss) tx_and
X424 (n677 n678 n679 vdd vss) tx_and
X425 (n680 n681 n682 vdd vss) tx_and
X426 (n683 n684 n685 vdd vss) tx_and
X427 (n686 n687 n688 vdd vss) tx_and
X428 (n689 n690 n691 vdd vss) tx_and
X429 (n665 n666 n404 vdd vss) tx_xor
X430 (n668 n669 n407 vdd vss) tx_xor
X431 (n671 n672 n410 vdd vss) tx_xor
X432 (n674 n675 n413 vdd vss) tx_xor
X433 (n677 n678 n416 vdd vss) tx_xor
X434 (n680 n681 n419 vdd vss) tx_xor
X435 (n683 n684 n422 vdd vss) tx_xor
X436 (n686 n687 n425 vdd vss) tx_xor
X437 (n689 n690 n428 vdd vss) tx_xor
X438 (n692 n693 n431 vdd vss) tx_xor
X439 (n667 n694 n408 vdd vss) tx_or
X440 (n404 n405 n694 vdd vss) tx_and
X441 (n679 n695 n420 vdd vss) tx_or
X442 (n274 n400 n402 vdd vss) tx_and
X443 (n673 n696 n414 vdd vss) tx_or
X444 (n422 n423 n697 vdd vss) tx_and
X445 (n698 n699 n423 vdd vss) tx_or
X446 (n700 n417 n699 vdd vss) tx_and
X447 (n685 n697 n426 vdd vss) tx_or
X448 (n701 n702 n411 vdd vss) tx_or
X449 (n703 n405 n702 vdd vss) tx_and
X450 (n410 n411 n696 vdd vss) tx_and
X451 (n704 n705 n429 vdd vss) tx_or
X452 (n706 n417 n705 vdd vss) tx_and
X453 (n428 n429 n707 vdd vss) tx_and
X454 (n708 n709 n417 vdd vss) tx_or
X455 (n710 n405 n709 vdd vss) tx_and
X456 (n711 n700 n706 vdd vss) tx_and
X457 (n712 n713 n704 vdd vss) tx_or
X458 (n711 n698 n713 vdd vss) tx_and
X459 (n714 n703 n710 vdd vss) tx_and
X460 (n715 n716 n708 vdd vss) tx_or
X461 (n714 n701 n716 vdd vss) tx_and
X462 (n691 n707 n432 vdd vss) tx_or
X463 (n425 n422 n711 vdd vss) tx_and
X464 (n688 n717 n712 vdd vss) tx_or
X465 (n425 n685 n717 vdd vss) tx_and
X466 (n419 n416 n700 vdd vss) tx_and
X467 (n682 n718 n698 vdd vss) tx_or
X468 (n419 n679 n718 vdd vss) tx_and
X469 (n413 n410 n714 vdd vss) tx_and
X470 (n676 n719 n715 vdd vss) tx_or
X471 (n413 n673 n719 vdd vss) tx_and
X472 (n407 n404 n703 vdd vss) tx_and
X473 (n670 n720 n701 vdd vss) tx_or
X474 (n407 n667 n720 vdd vss) tx_and
X475 (n416 n417 n695 vdd vss) tx_and
X476 (n125 dac0 n435 vdd vss) tx_and
X477 (n127 dac1 n721 vdd vss) tx_and
X478 (n129 dac2 n722 vdd vss) tx_and
X479 (n131 dac3 n723 vdd vss) tx_and
X480 (n133 dac4 n724 vdd vss) tx_and
X481 (n135 dac5 n725 vdd vss) tx_and
X482 (n125 dac0 n444 vdd vss) tx_xor
X483 (n127 dac1 n434 vdd vss) tx_xor
X484 (n129 dac2 n436 vdd vss) tx_xor
X485 (n131 dac3 n438 vdd vss) tx_xor
X486 (n133 dac4 n440 vdd vss) tx_xor
X487 (n135 dac5 n442 vdd vss) tx_xor
X488 (n724 n726 n443 vdd vss) tx_or
X489 (n722 n727 n439 vdd vss) tx_or
X490 (n436 n437 n727 vdd vss) tx_and
X491 (n728 n729 n252 vdd vss) tx_or
X492 (n730 n441 n729 vdd vss) tx_and
X493 (n731 n732 n441 vdd vss) tx_or
X494 (n733 n437 n732 vdd vss) tx_and
X495 (n442 n440 n730 vdd vss) tx_and
X496 (n725 n734 n728 vdd vss) tx_or
X497 (n442 n724 n734 vdd vss) tx_and
X498 (n438 n436 n733 vdd vss) tx_and
X499 (n723 n735 n731 vdd vss) tx_or
X500 (n438 n722 n735 vdd vss) tx_and
X501 (n440 n441 n726 vdd vss) tx_and
X502 (n721 n736 n437 vdd vss) tx_or
X503 (n434 n435 n736 vdd vss) tx_and
X504 (n248 n737 n452 vdd vss) tx_or
X505 (n246 n738 n448 vdd vss) tx_or
X506 (n247 n446 n738 vdd vss) tx_and
X507 (n739 n740 n454 vdd vss) tx_or
X508 (n741 n450 n740 vdd vss) tx_and
X509 (n742 n743 n450 vdd vss) tx_or
X510 (n744 n446 n743 vdd vss) tx_and
X511 (n251 n249 n741 vdd vss) tx_and
X512 (n250 n745 n739 vdd vss) tx_or
X513 (n251 n248 n745 vdd vss) tx_and
X514 (n245 n247 n744 vdd vss) tx_and
X515 (n244 n746 n742 vdd vss) tx_or
X516 (n245 n246 n746 vdd vss) tx_and
X517 (n249 n450 n737 vdd vss) tx_and
X518 (n242 n747 n446 vdd vss) tx_or
X519 (n243 n444 n747 vdd vss) tx_and
X520 (dac2 n534 n536 vdd vss) tx_and
X521 (n748 n534 n457 vdd vss) tx_and
X522 (n254 n91 n462 vdd vss) tx_and
X523 (n456 n93 n749 vdd vss) tx_and
X524 (n535 n95 n750 vdd vss) tx_and
X525 (n537 n97 n751 vdd vss) tx_and
X526 (n458 n99 n752 vdd vss) tx_and
X527 (n460 n101 n753 vdd vss) tx_and
X528 (n456 n93 n461 vdd vss) tx_xor
X529 (n535 n95 n464 vdd vss) tx_xor
X530 (n537 n97 n467 vdd vss) tx_xor
X531 (n458 n99 n470 vdd vss) tx_xor
X532 (n460 n101 n473 vdd vss) tx_xor
X533 (n752 n754 n474 vdd vss) tx_or
X534 (n750 n755 n468 vdd vss) tx_or
X535 (n464 n465 n755 vdd vss) tx_and
X536 (n756 n757 n477 vdd vss) tx_or
X537 (n758 n471 n757 vdd vss) tx_and
X538 (n759 n760 n471 vdd vss) tx_or
X539 (n761 n465 n760 vdd vss) tx_and
X540 (n473 n470 n758 vdd vss) tx_and
X541 (n753 n762 n756 vdd vss) tx_or
X542 (n473 n752 n762 vdd vss) tx_and
X543 (n467 n464 n761 vdd vss) tx_and
X544 (n751 n763 n759 vdd vss) tx_or
X545 (n467 n750 n763 vdd vss) tx_and
X546 (n470 n471 n754 vdd vss) tx_and
X547 (n749 n764 n465 vdd vss) tx_or
X548 (n461 n462 n764 vdd vss) tx_and
X549 (n324 n479 n481 vdd vss) tx_and
X550 (n765 n479 n277 vdd vss) tx_and
X551 (n766 n279 n479 vdd vss) tx_and
X552 (n488 n328 n767 vdd vss) tx_and
X553 (n322 n320 n766 vdd vss) tx_and
X554 (n328 n486 n489 vdd vss) tx_and
X555 (n320 n279 n484 vdd vss) tx_and
X556 (n768 n479 n486 vdd vss) tx_and
X557 (n66 n64 n492 vdd vss) tx_and
X558 (n769 n770 n275 vdd vss) tx_or
X559 (n771 n772 n770 vdd vss) tx_and
X560 (n773 n774 n769 vdd vss) tx_or
X561 (n775 n776 n774 vdd vss) tx_and
X562 (n777 n778 n772 vdd vss) tx_or
X563 (n779 n780 n778 vdd vss) tx_and
X564 (n781 n782 n776 vdd vss) tx_or
X565 (n783 n784 n782 vdd vss) tx_and
X566 (n785 n786 n777 vdd vss) tx_or
X567 (n787 n788 n786 vdd vss) tx_and
X568 (n789 n790 n780 vdd vss) tx_or
X569 (n791 n792 n790 vdd vss) tx_and
X570 (n215 n793 n773 vdd vss) tx_or
X571 (n216 n217 n793 vdd vss) tx_and
X572 (n220 n222 n783 vdd vss) tx_and
X573 (n219 n794 n781 vdd vss) tx_or
X574 (n220 n221 n794 vdd vss) tx_and
X575 (n223 n795 n784 vdd vss) tx_or
X576 (n224 n225 n795 vdd vss) tx_and
X577 (n228 n230 n787 vdd vss) tx_and
X578 (n227 n796 n785 vdd vss) tx_or
X579 (n228 n229 n796 vdd vss) tx_and
X580 (n232 n234 n797 vdd vss) tx_and
X581 (n231 n798 n788 vdd vss) tx_or
X582 (n232 n233 n798 vdd vss) tx_and
X583 (n236 n238 n791 vdd vss) tx_and
X584 (n235 n799 n789 vdd vss) tx_or
X585 (n236 n237 n799 vdd vss) tx_and
X586 (n213 n800 n792 vdd vss) tx_or
X587 (n214 measured0 n800 vdd vss) tx_and
X588 (measured5 n561 n801 vdd vss) tx_and
X589 (measured6 n802 n562 vdd vss) tx_and
X590 (measured7 n803 n804 vdd vss) tx_and
X591 (measured8 n585 n578 vdd vss) tx_and
X592 (measured11 n805 n806 vdd vss) tx_and
X593 (measured4 n551 n494 vdd vss) tx_xor
X594 (measured6 n802 n500 vdd vss) tx_xor
X595 (measured7 n803 n503 vdd vss) tx_xor
X596 (measured9 n553 n509 vdd vss) tx_xor
X597 (measured11 n805 n515 vdd vss) tx_xor
X598 (measured13 n559 n521 vdd vss) tx_xor
X599 (n552 n807 n498 vdd vss) tx_or
X600 (n494 n495 n807 vdd vss) tx_and
X601 (n578 n584 n510 vdd vss) tx_or
X602 (n575 n808 n809 vdd vss) tx_or
X603 (n810 n519 n808 vdd vss) tx_and
X604 (n512 n513 n811 vdd vss) tx_and
X605 (n812 n507 n565 vdd vss) tx_and
X606 (n556 n811 n516 vdd vss) tx_or
X607 (n813 n814 n501 vdd vss) tx_or
X608 (n815 n495 n814 vdd vss) tx_and
X609 (n500 n501 n563 vdd vss) tx_and
X610 (n816 n507 n567 vdd vss) tx_and
X611 (n518 n519 n573 vdd vss) tx_and
X612 (n817 n572 n566 vdd vss) tx_or
X613 (n818 n819 n568 vdd vss) tx_or
X614 (n579 n813 n819 vdd vss) tx_and
X615 (n583 n581 n495 vdd vss) tx_or
X616 (n515 n512 n571 vdd vss) tx_and
X617 (n806 n576 n817 vdd vss) tx_or
X618 (n804 n580 n818 vdd vss) tx_or
X619 (n801 n820 n813 vdd vss) tx_or
X620 (n497 n552 n820 vdd vss) tx_and
X621 (dac0 n821 n822 vdd vss) tx_and
X622 (dac1 n823 n824 vdd vss) tx_and
X623 (dac2 n825 n826 vdd vss) tx_and
X624 (dac3 n827 n828 vdd vss) tx_and
X625 (dac4 n829 n830 vdd vss) tx_and
X626 (dac5 n831 n832 vdd vss) tx_and
X627 (dac0 n821 n833 vdd vss) tx_xor
X628 (dac1 n823 n834 vdd vss) tx_xor
X629 (dac2 n825 n835 vdd vss) tx_xor
X630 (dac3 n827 n836 vdd vss) tx_xor
X631 (dac4 n829 n837 vdd vss) tx_xor
X632 (dac5 n831 n838 vdd vss) tx_xor
X633 (n839 n840 n841 vdd vss) tx_or
X634 (n842 n843 n840 vdd vss) tx_and
X635 (n844 n845 n843 vdd vss) tx_or
X636 (n846 n847 n845 vdd vss) tx_and
X637 (n832 n848 n839 vdd vss) tx_or
X638 (n838 n830 n848 vdd vss) tx_and
X639 (n828 n849 n844 vdd vss) tx_or
X640 (n836 n826 n849 vdd vss) tx_and
X641 (n824 n850 n847 vdd vss) tx_or
X642 (n834 n851 n850 vdd vss) tx_and
X643 (n822 n833 n851 vdd vss) tx_or
X644 (n207 n526 n852 vdd vss) tx_and
X645 (n210 n530 n853 vdd vss) tx_and
X646 (dac4 n853 n532 vdd vss) tx_or
X647 (n854 n855 n530 vdd vss) tx_or
X648 (n856 n526 n855 vdd vss) tx_and
X649 (n208 n207 n856 vdd vss) tx_and
X650 (dac3 n857 n854 vdd vss) tx_or
X651 (n208 dac2 n857 vdd vss) tx_and
X652 (dac2 n852 n528 vdd vss) tx_or
X653 (dac1 n858 n526 vdd vss) tx_or
X654 (n524 dac0 n858 vdd vss) tx_and
X655 (dac0 n859 n860 vdd vss) tx_and
X656 (dac1 n861 n862 vdd vss) tx_and
X657 (dac2 n863 n864 vdd vss) tx_and
X658 (dac3 n865 n866 vdd vss) tx_and
X659 (dac4 n867 n868 vdd vss) tx_and
X660 (dac5 n869 n870 vdd vss) tx_and
X661 (dac0 n859 n871 vdd vss) tx_xor
X662 (dac1 n861 n872 vdd vss) tx_xor
X663 (dac2 n863 n873 vdd vss) tx_xor
X664 (dac3 n865 n874 vdd vss) tx_xor
X665 (dac4 n867 n875 vdd vss) tx_xor
X666 (dac5 n869 n876 vdd vss) tx_xor
X667 (n877 n878 n879 vdd vss) tx_or
X668 (n880 n881 n878 vdd vss) tx_and
X669 (n882 n883 n881 vdd vss) tx_or
X670 (n884 n885 n883 vdd vss) tx_and
X671 (n876 n875 n880 vdd vss) tx_and
X672 (n870 n886 n877 vdd vss) tx_or
X673 (n876 n868 n886 vdd vss) tx_and
X674 (n874 n873 n884 vdd vss) tx_and
X675 (n866 n887 n882 vdd vss) tx_or
X676 (n874 n864 n887 vdd vss) tx_and
X677 (n862 n888 n885 vdd vss) tx_or
X678 (n872 n889 n888 vdd vss) tx_and
X679 (n860 n871 n889 vdd vss) tx_or
X680 (dac4 n457 n459 vdd vss) tx_and
X681 (n890 n457 n476 vdd vss) tx_and
X682 (dac5 dac4 n890 vdd vss) tx_and
X683 (dac3 dac2 n748 vdd vss) tx_and
X684 (dac1 dac0 n534 vdd vss) tx_and
X685 (n79 n539 n541 vdd vss) tx_and
X686 (n83 n543 n545 vdd vss) tx_and
X687 (n891 n543 n547 vdd vss) tx_and
X688 (n87 n547 n549 vdd vss) tx_and
X689 (n892 n539 n543 vdd vss) tx_and
X690 (n85 n83 n891 vdd vss) tx_and
X691 (n81 n79 n892 vdd vss) tx_and
X692 (n77 n75 n539 vdd vss) tx_and
X693 (n893 n894 n895 vdd vss) tx_or
X694 (n266 n894 n896 vdd vss) tx_or
X695 (n73 n894 n897 vdd vss) tx_or
X696 (n122 n894 n898 vdd vss) tx_or
X697 (n111 n894 n899 vdd vss) tx_or
X698 (n900 n901 n902 vdd vss) tx_and
X699 (n902 n185 n143 vdd vss) tx_and
X700 (n903 n291 n900 vdd vss) tx_or
X701 (n903 n264 n901 vdd vss) tx_or
X702 (n266 n904 n905 vdd vss) tx_and
X703 (n906 n893 n907 vdd vss) tx_and
X704 (n73 n185 n908 vdd vss) tx_and
X705 (n905 n907 n909 vdd vss) tx_and
X706 (n910 n908 n911 vdd vss) tx_and
X707 (n909 n911 n193 vdd vss) tx_and
X708 (n912 n269 n904 vdd vss) tx_or
X709 (n913 n914 n915 vdd vss) tx_or
X710 (n915 n267 n906 vdd vss) tx_or
X711 (n913 n263 n893 vdd vss) tx_or
X712 (n916 n917 n918 vdd vss) tx_and
X713 (n919 n111 n920 vdd vss) tx_and
X714 (n122 n185 n921 vdd vss) tx_and
X715 (n918 n920 n922 vdd vss) tx_and
X716 (n922 n921 n140 vdd vss) tx_and
X717 (n923 n924 n925 vdd vss) tx_and
X718 (n926 n927 n928 vdd vss) tx_and
X719 (n925 n928 n929 vdd vss) tx_and
X720 (n929 n930 n137 vdd vss) tx_and
X721 (n931 n932 n926 vdd vss) tx_or
X722 (n933 n934 n927 vdd vss) tx_or
X723 (n935 n936 n930 vdd vss) tx_or
X724 (n111 n122 n910 vdd vss) tx_and
X725 (n910 n185 n197 vdd vss) tx_and
X726 (n185 n937 n199 vdd vss) tx_or
X727 (n937 n938 n939 vdd vss) tx_or
X728 (n939 n940 n941 vdd vss) tx_or
X729 (n255 target_k1 n942 vdd vss) tx_or
X730 (target_k2 n212 n943 vdd vss) tx_or
X731 (target_k4 target_k5 n944 vdd vss) tx_or
X732 (n942 n943 n945 vdd vss) tx_or
X733 (n945 n944 n946 vdd vss) tx_or
X734 (n947 n314 n948 vdd vss) tx_or
X735 (n315 n85 n949 vdd vss) tx_or
X736 (n950 n948 n951 vdd vss) tx_or
X737 (n949 n952 n953 vdd vss) tx_or
X738 (n951 n953 n954 vdd vss) tx_or
X739 (n955 n316 n956 vdd vss) tx_or
X740 (n317 n89 n957 vdd vss) tx_or
X741 (n956 n957 n958 vdd vss) tx_or
X742 (n959 n958 n960 vdd vss) tx_or
X743 (n75 n961 n962 vdd vss) tx_or
X744 (n79 n81 n963 vdd vss) tx_or
X745 (n83 n85 n964 vdd vss) tx_or
X746 (n962 n963 n965 vdd vss) tx_or
X747 (n964 n952 n966 vdd vss) tx_or
X748 (n965 n966 n967 vdd vss) tx_or
X749 (n239 n259 n968 vdd vss) tx_or
X750 (n968 n260 n969 vdd vss) tx_or
X751 (n258 n49 n970 vdd vss) tx_or
X752 (n51 n53 n971 vdd vss) tx_or
X753 (n55 n57 n972 vdd vss) tx_or
X754 (n59 n61 n973 vdd vss) tx_or
X755 (n970 n971 n974 vdd vss) tx_or
X756 (n972 n973 n975 vdd vss) tx_or
X757 (n974 n975 n291 vdd vss) tx_or
X758 (n976 n961 n950 vdd vss) tx_or
X759 (n947 n977 n978 vdd vss) tx_or
X760 (n955 n85 n979 vdd vss) tx_or
X761 (n87 n89 n952 vdd vss) tx_or
X762 (n950 n978 n959 vdd vss) tx_or
X763 (n979 n952 n980 vdd vss) tx_or
X764 (n959 n980 n981 vdd vss) tx_or
X765 (n982 n261 n983 vdd vss) tx_or
X766 (n984 n261 n923 vdd vss) tx_or
X767 (state_out0 n256 n985 vdd vss) tx_or
X768 (n985 state_out2 n932 vdd vss) tx_or
X769 (n257 state_out1 n984 vdd vss) tx_or
X770 (n984 state_out2 n934 vdd vss) tx_or
X771 (n257 n256 n986 vdd vss) tx_or
X772 (n986 state_out2 n894 vdd vss) tx_or
X773 (n914 n343 n987 vdd vss) tx_or
X774 (n815 n579 n570 vdd vss) tx_and
X775 (n812 n571 n816 vdd vss) tx_and
X776 (n405 n570 n988 vdd vss) tx_and
X777 (n816 n810 n989 vdd vss) tx_and
X778 (n288 n990 n991 vdd vss) tx_or
X779 (n645 n601 n990 vdd vss) tx_and
X780 (n286 n992 n993 vdd vss) tx_or
X781 (n255 target_k1 n994 vdd vss) tx_and
X782 (n211 n212 n607 vdd vss) tx_and
X783 (n994 n607 n995 vdd vss) tx_and
X784 (n995 n601 n992 vdd vss) tx_and
X785 (n284 n996 n997 vdd vss) tx_or
X786 (target_k0 n998 n629 vdd vss) tx_and
X787 (n629 n597 n999 vdd vss) tx_and
X788 (n999 n626 n996 vdd vss) tx_and
X789 (n282 n1000 n1001 vdd vss) tx_or
X790 (n211 target_k3 n1002 vdd vss) tx_and
X791 (n1003 n608 n626 vdd vss) tx_and
X792 (n370 n1002 n645 vdd vss) tx_and
X793 (n645 n626 n1000 vdd vss) tx_and
X794 (n241 n279 n1004 vdd vss) tx_and
X795 (n324 n326 n768 vdd vss) tx_and
X796 (n1004 n766 n1005 vdd vss) tx_and
X797 (n768 n767 n765 vdd vss) tx_and
X798 (n1005 n765 n340 vdd vss) tx_and
X799 (n1006 n340 n1007 vdd vss) tx_or
X800 (n226 n224 n1008 vdd vss) tx_and
X801 (n218 n216 n775 vdd vss) tx_and
X802 (n800 n791 n1009 vdd vss) tx_and
X803 (n797 n787 n779 vdd vss) tx_and
X804 (n1008 n783 n1010 vdd vss) tx_and
X805 (n1009 n779 n1011 vdd vss) tx_and
X806 (n1010 n775 n771 vdd vss) tx_and
X807 (n1011 n771 n1012 vdd vss) tx_and
X808 (n276 n1012 n262 vdd vss) tx_or
X809 (n272 n273 n400 vdd vss) tx_and
X810 (n494 n497 n815 vdd vss) tx_and
X811 (n506 n509 n812 vdd vss) tx_and
X812 (n518 n521 n810 vdd vss) tx_and
X813 (n400 n581 n405 vdd vss) tx_and
X814 (n988 n989 n343 vdd vss) tx_and
X815 (n833 n834 n1013 vdd vss) tx_and
X816 (n835 n836 n846 vdd vss) tx_and
X817 (n837 n838 n842 vdd vss) tx_and
X818 (n1013 n846 n1014 vdd vss) tx_and
X819 (n1014 n842 n1015 vdd vss) tx_and
X820 (n1016 n1015 n269 vdd vss) tx_or
X821 (n871 n872 n1017 vdd vss) tx_and
X822 (n1017 n884 n1018 vdd vss) tx_and
X823 (n1018 n880 n346 vdd vss) tx_and
X824 (n1019 n346 n267 vdd vss) tx_or
X825 (n1020 n1021 n1022 vdd vss) tx_and
X826 (n1022 n1023 n1024 vdd vss) tx_and
X827 (n1024 n1025 n1026 vdd vss) tx_and
X828 (n1026 n185 n171 vdd vss) tx_and
X829 (n264 n270 n1020 vdd vss) tx_or
X830 (n903 n185 n163 vdd vss) tx_and
X831 (n1027 n185 n179 vdd vss) tx_and
X832 (n1027 n1028 n1029 vdd vss) tx_and
X833 (n1030 n1031 n1032 vdd vss) tx_and
X834 (n1033 n1034 n1035 vdd vss) tx_and
X835 (n1036 n185 n1037 vdd vss) tx_and
X836 (n1029 n1032 n1038 vdd vss) tx_and
X837 (n1035 n1037 n1039 vdd vss) tx_and
X838 (n1038 n1039 n157 vdd vss) tx_and
X839 (n122 n1040 n1027 vdd vss) tx_or
X840 (n264 n344 n1041 vdd vss) tx_or
X841 (n903 n1041 n1042 vdd vss) tx_or
X842 (n1042 n270 n1028 vdd vss) tx_or
X843 (n264 n914 n1021 vdd vss) tx_or
X844 (n903 n1021 n1043 vdd vss) tx_or
X845 (n1043 n268 n1030 vdd vss) tx_or
X846 (n903 n1044 n1031 vdd vss) tx_or
X847 (n903 n916 n1033 vdd vss) tx_or
X848 (n290 n289 n903 vdd vss) tx_or
X849 (n903 n917 n1034 vdd vss) tx_or
X850 (n111 n289 n1045 vdd vss) tx_or
X851 (n1045 n292 n1036 vdd vss) tx_or
X852 (n292 n290 n1046 vdd vss) tx_or
X853 (n289 n73 n1047 vdd vss) tx_or
X854 (n1046 n1047 n1048 vdd vss) tx_or
X855 (n1048 n1049 n1050 vdd vss) tx_or
X856 (n1050 n157 n181 vdd vss) tx_and
X857 (n1051 n1041 n1052 vdd vss) tx_and
X858 (n1044 n916 n1023 vdd vss) tx_and
X859 (n917 n919 n1053 vdd vss) tx_and
X860 (n1052 n1023 n1054 vdd vss) tx_and
X861 (n1053 n910 n1025 vdd vss) tx_and
X862 (n1054 n1025 n1055 vdd vss) tx_and
X863 (n1055 n185 n151 vdd vss) tx_and
X864 (n264 n268 n1051 vdd vss) tx_or
X865 (n264 n263 n1044 vdd vss) tx_or
X866 (n264 n969 n916 vdd vss) tx_or
X867 (n264 n266 n917 vdd vss) tx_or
X868 (n73 n292 n919 vdd vss) tx_or
X869 (n1056 n1057 n1058 vdd vss) tx_and
X870 (n1059 n895 n1060 vdd vss) tx_and
X871 (n896 n897 n1061 vdd vss) tx_and
X872 (n898 n899 n1062 vdd vss) tx_and
X873 (n1058 n1060 n1063 vdd vss) tx_and
X874 (n1061 n1062 n1064 vdd vss) tx_and
X875 (n1063 n1064 n1065 vdd vss) tx_and
X876 (n1065 n924 n190 vdd vss) tx_and
X877 (n1066 n983 n924 vdd vss) tx_or
X878 (n913 n344 n912 vdd vss) tx_or
X879 (n269 n894 n1067 vdd vss) tx_or
X880 (n912 n1067 n1057 vdd vss) tx_or
X881 (n267 n894 n1068 vdd vss) tx_or
X882 (n915 n1068 n1059 vdd vss) tx_or
X883 (n938 n1069 n1070 vdd vss) tx_or
X884 (n1071 n1070 n1072 vdd vss) tx_or
X885 (n1072 n199 n1073 vdd vss) tx_or
X886 (n1074 n1075 n1076 vdd vss) tx_or
X887 (n1077 n1078 n1079 vdd vss) tx_or
X888 (n1076 n1079 n1080 vdd vss) tx_or
X889 (n1081 n1082 n1083 vdd vss) tx_or
X890 (n1084 n1085 n1086 vdd vss) tx_or
X891 (n1083 n1086 n1087 vdd vss) tx_or
X892 (n1088 n1089 n1090 vdd vss) tx_or
X893 (n1091 n1092 n1093 vdd vss) tx_or
X894 (n1090 n1093 n1094 vdd vss) tx_or
X895 (n1095 n1096 n1097 vdd vss) tx_or
X896 (n1098 n1099 n1100 vdd vss) tx_or
X897 (n1097 n1100 n1101 vdd vss) tx_or
X898 (n1102 n1103 n1104 vdd vss) tx_or
X899 (n1105 n1106 n1107 vdd vss) tx_or
X900 (n1104 n1107 n1108 vdd vss) tx_or
X901 (n1109 n1110 n1111 vdd vss) tx_or
X902 (n1112 n1113 n1114 vdd vss) tx_or
X903 (n1111 n1114 n1115 vdd vss) tx_or
X904 (n1116 n1117 n1118 vdd vss) tx_or
X905 (n1119 n1120 n1121 vdd vss) tx_or
X906 (n1118 n1121 n1122 vdd vss) tx_or
X907 (n1123 n1124 n1125 vdd vss) tx_or
X908 (n1126 n1127 n1128 vdd vss) tx_or
X909 (n1125 n1128 n1129 vdd vss) tx_or
X910 (n937 n1069 n1130 vdd vss) tx_or
X911 (n185 n938 n1131 vdd vss) tx_or
X912 (n1132 n940 n1071 vdd vss) tx_or
X913 (n1130 n1131 n1133 vdd vss) tx_or
X914 (n1133 n1071 n1134 vdd vss) tx_or
X915 (n1135 n1136 n1137 vdd vss) tx_or
X916 (n1138 n1139 n1140 vdd vss) tx_or
X917 (n1141 n1137 n1142 vdd vss) tx_or
X918 (n1142 n1140 n1143 vdd vss) tx_or
X919 (n1144 n1145 n1146 vdd vss) tx_or
X920 (n1147 n1136 n1148 vdd vss) tx_or
X921 (n1148 n1146 n1149 vdd vss) tx_or
X922 (n1150 n1151 n1152 vdd vss) tx_or
X923 (n1138 n1145 n1153 vdd vss) tx_or
X924 (n1141 n1152 n1154 vdd vss) tx_or
X925 (n1154 n1153 n1155 vdd vss) tx_or
X926 (n1069 n185 n1056 vdd vss) tx_or
X927 (n1156 n1157 n1158 vdd vss) tx_or
X928 (n940 n199 n187 vdd vss) tx_or
X929 (n1159 n199 n1160 vdd vss) tx_or
X930 (n1132 n941 n184 vdd vss) tx_or
X931 (state_out0 state_out1 n982 vdd vss) tx_or
X932 (n982 state_out2 n936 vdd vss) tx_or
X933 (n954 n935 vdd vss) pll_inv
X934 (n960 n933 vdd vss) pll_inv
X935 (n967 n931 vdd vss) pll_inv
X936 (n969 n913 vdd vss) pll_inv
X937 (n981 n1066 vdd vss) pll_inv
X938 (range_error n1161 vdd vss) pll_inv
X939 (n983 n1069 vdd vss) pll_inv
X940 (n923 n937 vdd vss) pll_inv
X941 (n932 n938 vdd vss) pll_inv
X942 (n934 n1132 vdd vss) pll_inv
X943 (n936 n940 vdd vss) pll_inv
X944 (n894 n185 vdd vss) pll_inv
X945 (n262 n118 n265 vdd vss) tx_and
X946 (vss target_k0 n991 n1162 vdd vss) tx_mux
X947 (target_k0 n630 n991 n1163 vdd vss) tx_mux
X948 (target_k1 n371 n991 n1164 vdd vss) tx_mux
X949 (target_k2 n374 n991 n1165 vdd vss) tx_mux
X950 (target_k3 n350 n991 n1166 vdd vss) tx_mux
X951 (target_k4 n353 n991 n1167 vdd vss) tx_mux
X952 (target_k5 n355 n991 n1168 vdd vss) tx_mux
X953 (vss n588 n991 n1169 vdd vss) tx_mux
X954 (n1162 vss n993 n1170 vdd vss) tx_mux
X955 (n1163 vss n993 n1171 vdd vss) tx_mux
X956 (n1164 target_k0 n993 n1172 vdd vss) tx_mux
X957 (n1165 target_k1 n993 n1173 vdd vss) tx_mux
X958 (n1166 target_k2 n993 n1174 vdd vss) tx_mux
X959 (n1167 target_k3 n993 n1175 vdd vss) tx_mux
X960 (n1168 target_k4 n993 n1176 vdd vss) tx_mux
X961 (n1169 target_k5 n993 n1177 vdd vss) tx_mux
X962 (n1170 target_k0 n997 n1178 vdd vss) tx_mux
X963 (n1171 target_k1 n997 n1179 vdd vss) tx_mux
X964 (n1172 n613 n997 n1180 vdd vss) tx_mux
X965 (n1173 n358 n997 n1181 vdd vss) tx_mux
X966 (n1174 n361 n997 n1182 vdd vss) tx_mux
X967 (n1175 n364 n997 n1183 vdd vss) tx_mux
X968 (n1176 n366 n997 n1184 vdd vss) tx_mux
X969 (n1177 n368 n997 n1185 vdd vss) tx_mux
X970 (vss n620 n997 n1186 vdd vss) tx_mux
X971 (n1178 vss n1001 n1187 vdd vss) tx_mux
X972 (n1179 target_k0 n1001 n1188 vdd vss) tx_mux
X973 (n1180 n630 n1001 n1189 vdd vss) tx_mux
X974 (n1181 n371 n1001 n1190 vdd vss) tx_mux
X975 (n1182 n374 n1001 n1191 vdd vss) tx_mux
X976 (n1183 n376 n1001 n1192 vdd vss) tx_mux
X977 (n1184 n378 n1001 n1193 vdd vss) tx_mux
X978 (n1185 n380 n1001 n1194 vdd vss) tx_mux
X979 (n1186 n396 n1001 n1195 vdd vss) tx_mux
X980 (target_k0 n1187 n946 n1196 vdd vss) tx_mux
X981 (n630 n1188 n946 n1197 vdd vss) tx_mux
X982 (n382 n1189 n946 n1198 vdd vss) tx_mux
X983 (n385 n1190 n946 n1199 vdd vss) tx_mux
X984 (n388 n1191 n946 n1200 vdd vss) tx_mux
X985 (n391 n1192 n946 n1201 vdd vss) tx_mux
X986 (n393 n1193 n946 n1202 vdd vss) tx_mux
X987 (n395 n1194 n946 n1203 vdd vss) tx_mux
X988 (n398 n1195 n946 n1204 vdd vss) tx_mux
X989 (n658 vss n946 n1205 vdd vss) tx_mux
X990 (n1196 vss n111 n665 vdd vss) tx_mux
X991 (n1197 vss n111 n668 vdd vss) tx_mux
X992 (n1198 n1196 n111 n671 vdd vss) tx_mux
X993 (n1199 n1197 n111 n674 vdd vss) tx_mux
X994 (n1200 n1198 n111 n677 vdd vss) tx_mux
X995 (n1201 n1199 n111 n680 vdd vss) tx_mux
X996 (n1202 n1200 n111 n683 vdd vss) tx_mux
X997 (n1203 n1201 n111 n686 vdd vss) tx_mux
X998 (n1204 n1202 n111 n689 vdd vss) tx_mux
X999 (n1205 n1203 n111 n692 vdd vss) tx_mux
X1000 (n914 n987 n111 n1049 vdd vss) tx_mux
X1001 (n293 coarse0 n1049 n240 vdd vss) tx_mux
X1002 (n295 coarse1 n1049 n279 vdd vss) tx_mux
X1003 (n297 coarse2 n1049 n320 vdd vss) tx_mux
X1004 (n299 coarse3 n1049 n322 vdd vss) tx_mux
X1005 (n301 coarse4 n1049 n324 vdd vss) tx_mux
X1006 (n303 coarse5 n1049 n326 vdd vss) tx_mux
X1007 (n305 coarse6 n1049 n328 vdd vss) tx_mux
X1008 (n307 coarse7 n1049 n488 vdd vss) tx_mux
X1009 (dac0 n308 n1049 n330 vdd vss) tx_mux
X1010 (dac1 n309 n1049 n332 vdd vss) tx_mux
X1011 (dac2 n310 n1049 n334 vdd vss) tx_mux
X1012 (dac3 n311 n1049 n336 vdd vss) tx_mux
X1013 (dac4 n312 n1049 n338 vdd vss) tx_mux
X1014 (vss n313 n1049 n1206 vdd vss) tx_mux
X1015 (n399 measured1 n987 n213 vdd vss) tx_mux
X1016 (n401 measured2 n987 n237 vdd vss) tx_mux
X1017 (n403 measured3 n987 n235 vdd vss) tx_mux
X1018 (n406 n496 n987 n233 vdd vss) tx_mux
X1019 (n409 n499 n987 n231 vdd vss) tx_mux
X1020 (n412 n502 n987 n229 vdd vss) tx_mux
X1021 (n415 n505 n987 n227 vdd vss) tx_mux
X1022 (n418 n508 n987 n225 vdd vss) tx_mux
X1023 (n421 n511 n987 n223 vdd vss) tx_mux
X1024 (n424 n514 n987 n221 vdd vss) tx_mux
X1025 (n427 n517 n987 n219 vdd vss) tx_mux
X1026 (n430 n520 n987 n217 vdd vss) tx_mux
X1027 (n433 n523 n987 n215 vdd vss) tx_mux
X1028 (n240 vdd n1007 n1207 vdd vss) tx_mux
X1029 (n280 vdd n1007 n1208 vdd vss) tx_mux
X1030 (n483 vdd n1007 n1209 vdd vss) tx_mux
X1031 (n485 vdd n1007 n1210 vdd vss) tx_mux
X1032 (n480 vdd n1007 n1211 vdd vss) tx_mux
X1033 (n482 vdd n1007 n1212 vdd vss) tx_mux
X1034 (n487 vdd n1007 n1213 vdd vss) tx_mux
X1035 (n490 vdd n1007 n1214 vdd vss) tx_mux
X1036 (n254 vss n269 n1215 vdd vss) tx_mux
X1037 (n525 vss n269 n1216 vdd vss) tx_mux
X1038 (n527 vss n269 n1217 vdd vss) tx_mux
X1039 (n529 vss n269 n1218 vdd vss) tx_mux
X1040 (n531 vss n269 n1219 vdd vss) tx_mux
X1041 (n533 vss n269 n1220 vdd vss) tx_mux
X1042 (n1215 vss n344 n1221 vdd vss) tx_mux
X1043 (n1216 vss n344 n1222 vdd vss) tx_mux
X1044 (n1217 vss n344 n1223 vdd vss) tx_mux
X1045 (n1218 vss n344 n1224 vdd vss) tx_mux
X1046 (n1219 vss n344 n1225 vdd vss) tx_mux
X1047 (n1220 vss n344 n1226 vdd vss) tx_mux
X1048 (n1221 vss n262 n1227 vdd vss) tx_mux
X1049 (n1222 vss n262 n1228 vdd vss) tx_mux
X1050 (n1223 vss n262 n1229 vdd vss) tx_mux
X1051 (n1224 vss n262 n1230 vdd vss) tx_mux
X1052 (n1225 vss n262 n1231 vdd vss) tx_mux
X1053 (n1226 vss n262 n1232 vdd vss) tx_mux
X1054 (vss n1227 n969 n1233 vdd vss) tx_mux
X1055 (vss n1228 n969 n1234 vdd vss) tx_mux
X1056 (vss n1229 n969 n1235 vdd vss) tx_mux
X1057 (vss n1230 n969 n1236 vdd vss) tx_mux
X1058 (vss n1231 n969 n1237 vdd vss) tx_mux
X1059 (vss n1232 n969 n1238 vdd vss) tx_mux
X1060 (n1233 vss n265 n1239 vdd vss) tx_mux
X1061 (n1234 vss n265 n1240 vdd vss) tx_mux
X1062 (n1235 vss n265 n1241 vdd vss) tx_mux
X1063 (n1236 vss n265 n1242 vdd vss) tx_mux
X1064 (n1237 vss n265 n1243 vdd vss) tx_mux
X1065 (n1238 vss n265 n1244 vdd vss) tx_mux
X1066 (n1245 n1239 n73 n175 vdd vss) tx_mux
X1067 (n1246 n1240 n73 n174 vdd vss) tx_mux
X1068 (n1245 n1241 n73 n173 vdd vss) tx_mux
X1069 (n1246 n1242 n73 n172 vdd vss) tx_mux
X1070 (n1245 n1243 n73 n170 vdd vss) tx_mux
X1071 (n1245 n1244 n73 n176 vdd vss) tx_mux
X1072 (vdd vss n291 n1245 vdd vss) tx_mux
X1073 (n254 vss n267 n1247 vdd vss) tx_mux
X1074 (n456 vss n267 n1248 vdd vss) tx_mux
X1075 (n535 vss n267 n1249 vdd vss) tx_mux
X1076 (n537 vss n267 n1250 vdd vss) tx_mux
X1077 (n458 vss n267 n1251 vdd vss) tx_mux
X1078 (n460 vss n267 n1252 vdd vss) tx_mux
X1079 (vss n1247 n344 n1253 vdd vss) tx_mux
X1080 (vss n1248 n344 n1254 vdd vss) tx_mux
X1081 (vss n1249 n344 n1255 vdd vss) tx_mux
X1082 (vss n1250 n344 n1256 vdd vss) tx_mux
X1083 (vss n1251 n344 n1257 vdd vss) tx_mux
X1084 (vss n1252 n344 n1258 vdd vss) tx_mux
X1085 (n1253 vss n262 n1259 vdd vss) tx_mux
X1086 (n1254 vss n262 n1260 vdd vss) tx_mux
X1087 (n1255 vss n262 n1261 vdd vss) tx_mux
X1088 (n1256 vss n262 n1262 vdd vss) tx_mux
X1089 (n1257 vss n262 n1263 vdd vss) tx_mux
X1090 (n1258 vss n262 n1264 vdd vss) tx_mux
X1091 (vss n1259 n969 n1265 vdd vss) tx_mux
X1092 (vss n1260 n969 n1266 vdd vss) tx_mux
X1093 (vss n1261 n969 n1267 vdd vss) tx_mux
X1094 (vss n1262 n969 n1268 vdd vss) tx_mux
X1095 (vss n1263 n969 n1269 vdd vss) tx_mux
X1096 (vss n1264 n969 n1270 vdd vss) tx_mux
X1097 (n1265 vss n265 n1271 vdd vss) tx_mux
X1098 (n1266 vss n265 n1272 vdd vss) tx_mux
X1099 (n1267 vss n265 n1273 vdd vss) tx_mux
X1100 (n1268 vss n265 n1274 vdd vss) tx_mux
X1101 (n1269 vss n265 n1275 vdd vss) tx_mux
X1102 (n1270 vss n265 n1276 vdd vss) tx_mux
X1103 (n1245 n1271 n73 n155 vdd vss) tx_mux
X1104 (n1245 n1272 n73 n154 vdd vss) tx_mux
X1105 (n1246 n1273 n73 n153 vdd vss) tx_mux
X1106 (n1245 n1274 n73 n152 vdd vss) tx_mux
X1107 (n1246 n1275 n73 n150 vdd vss) tx_mux
X1108 (n1246 n1276 n73 n188 vdd vss) tx_mux
X1109 (vss n239 n969 n1277 vdd vss) tx_mux
X1110 (vss n491 n969 n1278 vdd vss) tx_mux
X1111 (vss n493 n969 n1279 vdd vss) tx_mux
X1112 (n1277 vss n265 n1280 vdd vss) tx_mux
X1113 (n1278 vss n265 n1281 vdd vss) tx_mux
X1114 (n1279 vss n265 n1282 vdd vss) tx_mux
X1115 (n1246 n1280 n73 n141 vdd vss) tx_mux
X1116 (n1246 n1281 n73 n139 vdd vss) tx_mux
X1117 (n1246 n1282 n73 n194 vdd vss) tx_mux
X1118 (vss n262 n969 n1283 vdd vss) tx_mux
X1119 (n1283 vss n265 n1284 vdd vss) tx_mux
X1120 (n1246 n1284 n73 n182 vdd vss) tx_mux
X1121 (n292 vdd n73 n196 vdd vss) tx_mux
X1122 (vss n49 n291 n1285 vdd vss) tx_mux
X1123 (vss n51 n291 n1286 vdd vss) tx_mux
X1124 (vss n53 n291 n1287 vdd vss) tx_mux
X1125 (vss n55 n291 n1288 vdd vss) tx_mux
X1126 (vss n57 n291 n1289 vdd vss) tx_mux
X1127 (vss n59 n291 n1290 vdd vss) tx_mux
X1128 (vss n61 n291 n1291 vdd vss) tx_mux
X1129 (vss vss n291 n1292 vdd vss) tx_mux
X1130 (n1285 vss n73 n1293 vdd vss) tx_mux
X1131 (n1286 vss n73 n1294 vdd vss) tx_mux
X1132 (n1287 vss n73 n1295 vdd vss) tx_mux
X1133 (n1288 vss n73 n1296 vdd vss) tx_mux
X1134 (n1289 vss n73 n1297 vdd vss) tx_mux
X1135 (n1290 vss n73 n1298 vdd vss) tx_mux
X1136 (n1291 vss n73 n1299 vdd vss) tx_mux
X1137 (n1292 vss n73 n1300 vdd vss) tx_mux
X1138 (vss n49 n291 n1301 vdd vss) tx_mux
X1139 (vss n51 n291 n1302 vdd vss) tx_mux
X1140 (vss n53 n291 n1303 vdd vss) tx_mux
X1141 (vss n55 n291 n1304 vdd vss) tx_mux
X1142 (vss n57 n291 n1305 vdd vss) tx_mux
X1143 (vdd n59 n291 n1306 vdd vss) tx_mux
X1144 (vss n61 n291 n1307 vdd vss) tx_mux
X1145 (n1301 n1293 n111 n1308 vdd vss) tx_mux
X1146 (n1302 n1294 n111 n1309 vdd vss) tx_mux
X1147 (n1303 n1295 n111 n1310 vdd vss) tx_mux
X1148 (n1304 n1296 n111 n1311 vdd vss) tx_mux
X1149 (n1305 n1297 n111 n1312 vdd vss) tx_mux
X1150 (n1306 n1298 n111 n1313 vdd vss) tx_mux
X1151 (n1307 n1299 n111 n1314 vdd vss) tx_mux
X1152 (vss n1300 n111 n1315 vdd vss) tx_mux
X1153 (n1049 n1040 vdd vss) pll_inv
X1154 (vss n1308 n122 n149 vdd vss) tx_mux
X1155 (vss n1309 n122 n148 vdd vss) tx_mux
X1156 (vss n1310 n122 n147 vdd vss) tx_mux
X1157 (vss n1311 n122 n146 vdd vss) tx_mux
X1158 (vss n1312 n122 n145 vdd vss) tx_mux
X1159 (n1040 n1313 n122 n144 vdd vss) tx_mux
X1160 (vss n1314 n122 n142 vdd vss) tx_mux
X1161 (n1049 n1315 n122 n191 vdd vss) tx_mux
X1162 (n292 vdd n111 n1316 vdd vss) tx_mux
X1163 (n1317 n1316 n122 n178 vdd vss) tx_mux
X1164 (vss n976 n981 n1318 vdd vss) tx_mux
X1165 (vss n538 n981 n1319 vdd vss) tx_mux
X1166 (vss n540 n981 n1320 vdd vss) tx_mux
X1167 (vss n542 n981 n1321 vdd vss) tx_mux
X1168 (vss n544 n981 n1322 vdd vss) tx_mux
X1169 (vss n546 n981 n1323 vdd vss) tx_mux
X1170 (vss n548 n981 n1324 vdd vss) tx_mux
X1171 (vss n550 n981 n1325 vdd vss) tx_mux
X1172 (vss n976 n967 n1326 vdd vss) tx_mux
X1173 (vss n538 n967 n1327 vdd vss) tx_mux
X1174 (vss n540 n967 n1328 vdd vss) tx_mux
X1175 (vss n542 n967 n1329 vdd vss) tx_mux
X1176 (vss n544 n967 n1330 vdd vss) tx_mux
X1177 (vss n546 n967 n1331 vdd vss) tx_mux
X1178 (vss n548 n967 n1332 vdd vss) tx_mux
X1179 (vss n550 n967 n1333 vdd vss) tx_mux
X1180 (vss n976 n960 n1334 vdd vss) tx_mux
X1181 (vss n538 n960 n1335 vdd vss) tx_mux
X1182 (vss n540 n960 n1336 vdd vss) tx_mux
X1183 (vss n542 n960 n1337 vdd vss) tx_mux
X1184 (vss n544 n960 n1338 vdd vss) tx_mux
X1185 (vss n546 n960 n1339 vdd vss) tx_mux
X1186 (vss n548 n960 n1340 vdd vss) tx_mux
X1187 (vss n550 n960 n1341 vdd vss) tx_mux
X1188 (vss n976 n954 n1342 vdd vss) tx_mux
X1189 (vss n538 n954 n1343 vdd vss) tx_mux
X1190 (vss n540 n954 n1344 vdd vss) tx_mux
X1191 (vss n542 n954 n1345 vdd vss) tx_mux
X1192 (vss n544 n954 n1346 vdd vss) tx_mux
X1193 (vss n546 n954 n1347 vdd vss) tx_mux
X1194 (vss n548 n954 n1348 vdd vss) tx_mux
X1195 (vss n550 n954 n1349 vdd vss) tx_mux
X1196 (vdd vss n981 n1350 vdd vss) tx_mux
X1197 (vss vss n981 n1351 vdd vss) tx_mux
X1198 (n269 n267 n344 n1352 vdd vss) tx_mux
X1199 (n1352 vss n262 n1353 vdd vss) tx_mux
X1200 (vdd n1353 n969 n1354 vdd vss) tx_mux
X1201 (n1354 vss n265 n1355 vdd vss) tx_mux
X1202 (n1354 vdd n265 n1356 vdd vss) tx_mux
X1203 (vss n1355 n73 n1357 vdd vss) tx_mux
X1204 (vss n1356 n73 n1358 vdd vss) tx_mux
X1205 (vss n1357 n111 n1359 vdd vss) tx_mux
X1206 (vss n1358 n111 n1360 vdd vss) tx_mux
X1207 (vss n1359 n122 n1361 vdd vss) tx_mux
X1208 (vss n1360 n122 n1362 vdd vss) tx_mux
X1209 (vdd vss n967 n1363 vdd vss) tx_mux
X1210 (vss vss n967 n1364 vdd vss) tx_mux
X1211 (vss vss n960 n1365 vdd vss) tx_mux
X1212 (vdd vss n960 n1366 vdd vss) tx_mux
X1213 (vdd vss n954 n1367 vdd vss) tx_mux
X1214 (vss vss n954 n1368 vdd vss) tx_mux
X1215 (vss vdd n267 n1369 vdd vss) tx_mux
X1216 (vss vdd n269 n1370 vdd vss) tx_mux
X1217 (n1370 n1369 n344 n1371 vdd vss) tx_mux
X1218 (n1371 vss n262 n1372 vdd vss) tx_mux
X1219 (vdd n1372 n969 n192 vdd vss) tx_mux
X1220 (n1161 vss n981 n1373 vdd vss) tx_mux
X1221 (vss vss n267 n1374 vdd vss) tx_mux
X1222 (vss vss n269 n1375 vdd vss) tx_mux
X1223 (n1375 n1374 n344 n1376 vdd vss) tx_mux
X1224 (n1376 vss n262 n1377 vdd vss) tx_mux
X1225 (vss n1377 n969 n1378 vdd vss) tx_mux
X1226 (n1378 vss n265 n1379 vdd vss) tx_mux
X1227 (vss n1379 n73 n1380 vdd vss) tx_mux
X1228 (vss n1380 n111 n1381 vdd vss) tx_mux
X1229 (vss n1381 n122 n1382 vdd vss) tx_mux
X1230 (vss n331 n291 n1383 vdd vss) tx_mux
X1231 (vss n333 n291 n1384 vdd vss) tx_mux
X1232 (vss n335 n291 n1385 vdd vss) tx_mux
X1233 (vss n337 n291 n1386 vdd vss) tx_mux
X1234 (vss n339 n291 n1387 vdd vss) tx_mux
X1235 (vdd n1206 n291 n1388 vdd vss) tx_mux
X1236 (n463 vss n267 n1389 vdd vss) tx_mux
X1237 (n466 vss n267 n1390 vdd vss) tx_mux
X1238 (n469 vss n267 n1391 vdd vss) tx_mux
X1239 (n472 vss n267 n1392 vdd vss) tx_mux
X1240 (n475 vss n267 n1393 vdd vss) tx_mux
X1241 (n478 vss n267 n1394 vdd vss) tx_mux
X1242 (n445 vss n269 n1395 vdd vss) tx_mux
X1243 (n447 vss n269 n1396 vdd vss) tx_mux
X1244 (n449 vss n269 n1397 vdd vss) tx_mux
X1245 (n451 vss n269 n1398 vdd vss) tx_mux
X1246 (n453 vss n269 n1399 vdd vss) tx_mux
X1247 (n455 vss n269 n1400 vdd vss) tx_mux
X1248 (n1395 n1389 n344 n1401 vdd vss) tx_mux
X1249 (n1396 n1390 n344 n1402 vdd vss) tx_mux
X1250 (n1397 n1391 n344 n1403 vdd vss) tx_mux
X1251 (n1398 n1392 n344 n1404 vdd vss) tx_mux
X1252 (n1399 n1393 n344 n1405 vdd vss) tx_mux
X1253 (n1400 n1394 n344 n1406 vdd vss) tx_mux
X1254 (n1401 vss n262 n1407 vdd vss) tx_mux
X1255 (n1402 vss n262 n1408 vdd vss) tx_mux
X1256 (n1403 vss n262 n1409 vdd vss) tx_mux
X1257 (n1404 vss n262 n1410 vdd vss) tx_mux
X1258 (n1405 vss n262 n1411 vdd vss) tx_mux
X1259 (n1406 vss n262 n1412 vdd vss) tx_mux
X1260 (vss n1407 n969 n1413 vdd vss) tx_mux
X1261 (vss n1408 n969 n1414 vdd vss) tx_mux
X1262 (vss n1409 n969 n1415 vdd vss) tx_mux
X1263 (vss n1410 n969 n1416 vdd vss) tx_mux
X1264 (vss n1411 n969 n1417 vdd vss) tx_mux
X1265 (vss n1412 n969 n1418 vdd vss) tx_mux
X1266 (n1413 vss n265 n1419 vdd vss) tx_mux
X1267 (n1414 vss n265 n1420 vdd vss) tx_mux
X1268 (n1415 vss n265 n1421 vdd vss) tx_mux
X1269 (n1416 vss n265 n1422 vdd vss) tx_mux
X1270 (n1417 vss n265 n1423 vdd vss) tx_mux
X1271 (n1418 vss n265 n1424 vdd vss) tx_mux
X1272 (n1383 n1419 n73 n1425 vdd vss) tx_mux
X1273 (n1384 n1420 n73 n1426 vdd vss) tx_mux
X1274 (n1385 n1421 n73 n1427 vdd vss) tx_mux
X1275 (n1386 n1422 n73 n1428 vdd vss) tx_mux
X1276 (n1387 n1423 n73 n1429 vdd vss) tx_mux
X1277 (n1388 n1424 n73 n1430 vdd vss) tx_mux
X1278 (vss vss n291 n1246 vdd vss) tx_mux
X1279 (n1246 n1425 n111 n1431 vdd vss) tx_mux
X1280 (n1246 n1426 n111 n1432 vdd vss) tx_mux
X1281 (n1246 n1427 n111 n1433 vdd vss) tx_mux
X1282 (n1246 n1428 n111 n1434 vdd vss) tx_mux
X1283 (n1246 n1429 n111 n1435 vdd vss) tx_mux
X1284 (n1245 n1430 n111 n1436 vdd vss) tx_mux
X1285 (vss vss n1049 n1437 vdd vss) tx_mux
X1286 (vdd vss n1049 n1317 vdd vss) tx_mux
X1287 (n1437 n1431 n122 n161 vdd vss) tx_mux
X1288 (n1437 n1432 n122 n160 vdd vss) tx_mux
X1289 (n1437 n1433 n122 n159 vdd vss) tx_mux
X1290 (n1437 n1434 n122 n158 vdd vss) tx_mux
X1291 (n1437 n1435 n122 n156 vdd vss) tx_mux
X1292 (n1317 n1436 n122 n180 vdd vss) tx_mux
X1293 (n1207 n318 n291 n1438 vdd vss) tx_mux
X1294 (n1208 n319 n291 n1439 vdd vss) tx_mux
X1295 (n1209 n321 n291 n1440 vdd vss) tx_mux
X1296 (n1210 n323 n291 n1441 vdd vss) tx_mux
X1297 (n1211 n325 n291 n1442 vdd vss) tx_mux
X1298 (n1212 n327 n291 n1443 vdd vss) tx_mux
X1299 (n1213 n329 n291 n1444 vdd vss) tx_mux
X1300 (n1214 n488 n291 n1445 vdd vss) tx_mux
X1301 (n1438 vss n111 n1446 vdd vss) tx_mux
X1302 (n1439 vss n111 n1447 vdd vss) tx_mux
X1303 (n1440 vss n111 n1448 vdd vss) tx_mux
X1304 (n1441 vss n111 n1449 vdd vss) tx_mux
X1305 (n1442 vss n111 n1450 vdd vss) tx_mux
X1306 (n1443 vss n111 n1451 vdd vss) tx_mux
X1307 (n1444 vss n111 n1452 vdd vss) tx_mux
X1308 (n1445 vss n111 n1453 vdd vss) tx_mux
X1309 (vss n1446 n122 n169 vdd vss) tx_mux
X1310 (vss n1447 n122 n168 vdd vss) tx_mux
X1311 (vss n1448 n122 n167 vdd vss) tx_mux
X1312 (vss n1449 n122 n166 vdd vss) tx_mux
X1313 (vss n1450 n122 n165 vdd vss) tx_mux
X1314 (vss n1451 n122 n164 vdd vss) tx_mux
X1315 (vss n1452 n122 n162 vdd vss) tx_mux
X1316 (n1049 n1453 n122 n177 vdd vss) tx_mux
X1317 (n1342 n940 n1074 vdd vss) tx_and
X1318 (n1334 n1132 n1075 vdd vss) tx_and
X1319 (n1326 n938 n1077 vdd vss) tx_and
X1320 (n1318 n1069 n1078 vdd vss) tx_and
X1321 (n1343 n940 n1081 vdd vss) tx_and
X1322 (n1335 n1132 n1082 vdd vss) tx_and
X1323 (n1327 n938 n1084 vdd vss) tx_and
X1324 (n1319 n1069 n1085 vdd vss) tx_and
X1325 (n1344 n940 n1088 vdd vss) tx_and
X1326 (n1336 n1132 n1089 vdd vss) tx_and
X1327 (n1328 n938 n1091 vdd vss) tx_and
X1328 (n1320 n1069 n1092 vdd vss) tx_and
X1329 (n1345 n940 n1095 vdd vss) tx_and
X1330 (n1337 n1132 n1096 vdd vss) tx_and
X1331 (n1329 n938 n1098 vdd vss) tx_and
X1332 (n1321 n1069 n1099 vdd vss) tx_and
X1333 (n1346 n940 n1102 vdd vss) tx_and
X1334 (n1338 n1132 n1103 vdd vss) tx_and
X1335 (n1330 n938 n1105 vdd vss) tx_and
X1336 (n1322 n1069 n1106 vdd vss) tx_and
X1337 (n1347 n940 n1109 vdd vss) tx_and
X1338 (n1339 n1132 n1110 vdd vss) tx_and
X1339 (n1331 n938 n1112 vdd vss) tx_and
X1340 (n1323 n1069 n1113 vdd vss) tx_and
X1341 (n1348 n940 n1116 vdd vss) tx_and
X1342 (n1340 n1132 n1117 vdd vss) tx_and
X1343 (n1332 n938 n1119 vdd vss) tx_and
X1344 (n1324 n1069 n1120 vdd vss) tx_and
X1345 (n1349 n940 n1123 vdd vss) tx_and
X1346 (n1341 n1132 n1124 vdd vss) tx_and
X1347 (n1333 n938 n1126 vdd vss) tx_and
X1348 (n1325 n1069 n1127 vdd vss) tx_and
X1349 (n1361 n185 n1135 vdd vss) tx_and
X1350 (n1367 n940 n1139 vdd vss) tx_and
X1351 (n1351 n1069 n1147 vdd vss) tx_and
X1352 (n1363 n938 n1136 vdd vss) tx_and
X1353 (n1366 n1132 n1144 vdd vss) tx_and
X1354 (n1350 n1069 n1141 vdd vss) tx_and
X1355 (n1362 n185 n1150 vdd vss) tx_and
X1356 (n1364 n938 n1151 vdd vss) tx_and
X1357 (n1365 n1132 n1138 vdd vss) tx_and
X1358 (n1368 n940 n1145 vdd vss) tx_and
X1359 (n1373 n1069 n1156 vdd vss) tx_and
X1360 (n1382 n185 n1157 vdd vss) tx_and
X1361 (n954 n940 n1159 vdd vss) tx_and
X1362 (n57 n302 vdd vss) pll_inv
X1363 (n59 n304 vdd vss) pll_inv
X1364 (n61 n306 vdd vss) pll_inv
X1365 (n49 n294 vdd vss) pll_inv
X1366 (n51 n296 vdd vss) pll_inv
X1367 (n53 n298 vdd vss) pll_inv
X1368 (n55 n300 vdd vss) pll_inv
X1369 (n344 n914 vdd vss) pll_inv
X1370 (n341 n1006 vdd vss) pll_inv
X1371 (n809 n342 vdd vss) pll_inv
X1372 (n841 n1016 vdd vss) pll_inv
X1373 (n347 n1019 vdd vss) pll_inv
X1374 (n879 n345 vdd vss) pll_inv
X1375 (n668 n561 vdd vss) pll_inv
X1376 (n671 n802 vdd vss) pll_inv
X1377 (n674 n803 vdd vss) pll_inv
X1378 (n677 n585 vdd vss) pll_inv
X1379 (n680 n553 vdd vss) pll_inv
X1380 (n683 n555 vdd vss) pll_inv
X1381 (n686 n805 vdd vss) pll_inv
X1382 (target_k1 n998 vdd vss) pll_inv
X1383 (target_k4 n1003 vdd vss) pll_inv
X1384 (target_k5 n608 vdd vss) pll_inv
X1385 (measured4 n666 vdd vss) pll_inv
X1386 (measured5 n669 vdd vss) pll_inv
X1387 (measured6 n672 vdd vss) pll_inv
X1388 (measured7 n675 vdd vss) pll_inv
X1389 (measured8 n678 vdd vss) pll_inv
X1390 (measured9 n681 vdd vss) pll_inv
X1391 (measured10 n684 vdd vss) pll_inv
X1392 (measured11 n687 vdd vss) pll_inv
X1393 (measured12 n690 vdd vss) pll_inv
X1394 (measured13 n693 vdd vss) pll_inv
X1395 (n93 n861 vdd vss) pll_inv
X1396 (n95 n863 vdd vss) pll_inv
X1397 (n665 n551 vdd vss) pll_inv
X1398 (n689 n557 vdd vss) pll_inv
X1399 (n692 n559 vdd vss) pll_inv
X1400 (n125 n821 vdd vss) pll_inv
X1401 (n127 n823 vdd vss) pll_inv
X1402 (n129 n825 vdd vss) pll_inv
X1403 (n131 n827 vdd vss) pll_inv
X1404 (n133 n829 vdd vss) pll_inv
X1405 (n135 n831 vdd vss) pll_inv
X1406 (n91 n859 vdd vss) pll_inv
X1407 (n97 n865 vdd vss) pll_inv
X1408 (n99 n867 vdd vss) pll_inv
X1409 (n101 n869 vdd vss) pll_inv
X1410 (dac1 n524 vdd vss) pll_inv
X1411 (n75 n976 vdd vss) pll_inv
X1412 (n77 n961 vdd vss) pll_inv
X1413 (n79 n947 vdd vss) pll_inv
X1414 (n81 n977 vdd vss) pll_inv
X1415 (n83 n955 vdd vss) pll_inv
X1416 (vss n1080 n1073 n205 vdd vss) tx_mux
X1417 (vss n1087 n1073 n204 vdd vss) tx_mux
X1418 (vss n1094 n1073 n203 vdd vss) tx_mux
X1419 (vss n1101 n1073 n202 vdd vss) tx_mux
X1420 (vss n1108 n1073 n201 vdd vss) tx_mux
X1421 (vss n1115 n1073 n200 vdd vss) tx_mux
X1422 (vss n1122 n1073 n198 vdd vss) tx_mux
X1423 (vss n1129 n1073 n206 vdd vss) tx_mux
X1424 (vss n1143 n1134 n138 vdd vss) tx_mux
X1425 (vss n1149 n1134 n136 vdd vss) tx_mux
X1426 (vss n1155 n1134 n195 vdd vss) tx_mux
X1427 (vss n1158 n1056 n189 vdd vss) tx_mux
X1428 (vss n1160 n187 n186 vdd vss) tx_mux
X1429 (vss n1132 n184 n183 vdd vss) tx_mux
ends tx_fll_rebracket108_v14
