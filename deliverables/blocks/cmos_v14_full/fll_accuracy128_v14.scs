simulator lang=spectre
// Candidate only; no integration or analog-capture acceptance.
subckt tx_fll_accuracy128_v14 (refclk reset target_k0 target_k1 target_k2 target_k3 target_k4 target_k5 measured0 measured1 measured2 measured3 measured4 measured5 measured6 measured7 measured8 measured9 measured10 measured11 measured12 measured13 coarse0 coarse1 coarse2 coarse3 coarse4 coarse5 coarse6 coarse7 dac0 dac1 dac2 dac3 dac4 dac5 count_gate count_reset enable range_error state_out0 state_out1 state_out2 vdd vss)
X0 (n45 refclk reset range_error vdd vss) tx_dff_r0
X1 (n46 refclk reset coarse0 vdd vss) tx_dff_r0
X2 (n47 refclk reset coarse1 vdd vss) tx_dff_r0
X3 (n48 refclk reset coarse2 vdd vss) tx_dff_r0
X4 (n49 refclk reset coarse3 vdd vss) tx_dff_r0
X5 (n50 refclk reset coarse4 vdd vss) tx_dff_r0
X6 (n51 refclk reset coarse5 vdd vss) tx_dff_r0
X7 (n52 refclk reset coarse6 vdd vss) tx_dff_r0
X8 (n53 refclk reset coarse7 vdd vss) tx_dff_r0
X9 (n54 refclk reset n55 vdd vss) tx_dff_r0
X10 (n56 refclk reset dac0 vdd vss) tx_dff_r1
X11 (n57 refclk reset dac1 vdd vss) tx_dff_r1
X12 (n58 refclk reset dac2 vdd vss) tx_dff_r0
X13 (n59 refclk reset dac3 vdd vss) tx_dff_r1
X14 (n60 refclk reset dac4 vdd vss) tx_dff_r0
X15 (n61 refclk reset dac5 vdd vss) tx_dff_r0
X16 (n62 refclk reset state_out0 vdd vss) tx_dff_r0
X17 (n63 refclk reset state_out1 vdd vss) tx_dff_r0
X18 (n64 refclk reset state_out2 vdd vss) tx_dff_r0
X19 (n65 refclk reset count_gate vdd vss) tx_dff_r0
X20 (n66 refclk reset n67 vdd vss) tx_dff_r0
X21 (n68 refclk reset n69 vdd vss) tx_dff_r0
X22 (n70 refclk reset n71 vdd vss) tx_dff_r0
X23 (n72 refclk reset n73 vdd vss) tx_dff_r0
X24 (n74 refclk reset n75 vdd vss) tx_dff_r0
X25 (n76 refclk reset n77 vdd vss) tx_dff_r0
X26 (n78 refclk reset n79 vdd vss) tx_dff_r0
X27 (n80 refclk reset n81 vdd vss) tx_dff_r1
X28 (n82 refclk reset count_reset vdd vss) tx_dff_r1
X29 (n83 refclk reset n84 vdd vss) tx_dff_r0
X30 (n85 refclk reset n86 vdd vss) tx_dff_r0
X31 (n87 refclk reset n88 vdd vss) tx_dff_r0
X32 (n89 refclk reset n90 vdd vss) tx_dff_r0
X33 (n91 refclk reset n92 vdd vss) tx_dff_r0
X34 (n93 refclk reset n94 vdd vss) tx_dff_r0
X35 (n95 refclk reset n96 vdd vss) tx_dff_r0
X36 (n97 refclk reset n98 vdd vss) tx_dff_r0
X37 (n99 refclk reset enable vdd vss) tx_dff_r0
X38 (n100 refclk reset n101 vdd vss) tx_dff_r0
X39 (n79 n102 n103 n78 vdd vss) tx_mux
X40 (n77 n104 n103 n76 vdd vss) tx_mux
X41 (n75 n105 n103 n74 vdd vss) tx_mux
X42 (n73 n106 n103 n72 vdd vss) tx_mux
X43 (n71 n107 n103 n70 vdd vss) tx_mux
X44 (n69 n108 n103 n68 vdd vss) tx_mux
X45 (n67 n109 n103 n66 vdd vss) tx_mux
X46 (state_out1 n110 n111 n63 vdd vss) tx_mux
X47 (state_out0 n112 n111 n62 vdd vss) tx_mux
X48 (dac4 n113 n114 n60 vdd vss) tx_mux
X49 (dac3 n115 n114 n59 vdd vss) tx_mux
X50 (dac2 n116 n114 n58 vdd vss) tx_mux
X51 (dac1 n117 n114 n57 vdd vss) tx_mux
X52 (dac0 n118 n114 n56 vdd vss) tx_mux
X53 (coarse6 n119 n120 n52 vdd vss) tx_mux
X54 (coarse5 n121 n120 n51 vdd vss) tx_mux
X55 (coarse4 n122 n120 n50 vdd vss) tx_mux
X56 (coarse3 n123 n120 n49 vdd vss) tx_mux
X57 (coarse2 n124 n120 n48 vdd vss) tx_mux
X58 (coarse1 n125 n120 n47 vdd vss) tx_mux
X59 (coarse0 n126 n120 n46 vdd vss) tx_mux
X60 (range_error n127 n128 n45 vdd vss) tx_mux
X61 (coarse7 n129 n120 n53 vdd vss) tx_mux
X62 (n55 n130 n131 n54 vdd vss) tx_mux
X63 (dac5 n132 n114 n61 vdd vss) tx_mux
X64 (state_out2 n133 n111 n64 vdd vss) tx_mux
X65 (count_gate n134 n135 n65 vdd vss) tx_mux
X66 (n81 n136 n103 n80 vdd vss) tx_mux
X67 (count_reset n137 n138 n82 vdd vss) tx_mux
X68 (enable n139 n140 n99 vdd vss) tx_mux
X69 (n101 vdd n141 n100 vdd vss) tx_mux
X70 (n142 n96 n143 n95 vdd vss) tx_mux
X71 (n144 n94 n143 n93 vdd vss) tx_mux
X72 (n145 n92 n143 n91 vdd vss) tx_mux
X73 (n146 n90 n143 n89 vdd vss) tx_mux
X74 (n147 n88 n143 n87 vdd vss) tx_mux
X75 (n148 n86 n143 n85 vdd vss) tx_mux
X76 (n149 n84 n143 n83 vdd vss) tx_mux
X77 (n150 n98 n143 n97 vdd vss) tx_mux
X78 (n84 n151 vdd vss) pll_inv
X79 (n152 n153 vdd vss) pll_inv
X80 (n154 n155 vdd vss) pll_inv
X81 (n156 n157 vdd vss) pll_inv
X82 (n158 n159 vdd vss) pll_inv
X83 (n160 n161 vdd vss) pll_inv
X84 (target_k0 n162 vdd vss) pll_inv
X85 (n67 n163 vdd vss) pll_inv
X86 (state_out1 n164 vdd vss) pll_inv
X87 (state_out0 n165 vdd vss) pll_inv
X88 (state_out2 n166 vdd vss) pll_inv
X89 (n101 n167 vdd vss) pll_inv
X90 (n55 n168 vdd vss) pll_inv
X91 (measured0 n169 vdd vss) pll_inv
X92 (measured2 n170 vdd vss) pll_inv
X93 (measured3 n171 vdd vss) pll_inv
X94 (measured1 n172 vdd vss) pll_inv
X95 (n173 n174 vdd vss) pll_inv
X96 (n175 n176 vdd vss) pll_inv
X97 (n177 n178 vdd vss) pll_inv
X98 (n179 n180 vdd vss) pll_inv
X99 (n181 n182 vdd vss) pll_inv
X100 (n183 n184 vdd vss) pll_inv
X101 (n158 n73 n185 vdd vss) tx_or
X102 (n186 n75 n187 vdd vss) tx_or
X103 (n156 n77 n188 vdd vss) tx_or
X104 (n189 n190 n191 vdd vss) tx_or
X105 (n174 n192 n193 vdd vss) tx_or
X106 (n194 n195 n196 vdd vss) tx_xor
X107 (n197 n198 n199 vdd vss) tx_xor
X108 (target_k5 n200 n201 vdd vss) tx_xor
X109 (n202 n203 n204 vdd vss) tx_xor
X110 (n205 n206 n207 vdd vss) tx_xor
X111 (n208 n209 n210 vdd vss) tx_xor
X112 (n211 n212 n213 vdd vss) tx_xor
X113 (n199 n214 n215 vdd vss) tx_xor
X114 (n201 n216 n217 vdd vss) tx_xor
X115 (n218 n219 n220 vdd vss) tx_xor
X116 (target_k1 target_k0 n221 vdd vss) tx_xor
X117 (n222 n223 n224 vdd vss) tx_xor
X118 (n225 n226 n227 vdd vss) tx_xor
X119 (n228 n229 n230 vdd vss) tx_xor
X120 (target_k4 n231 n232 vdd vss) tx_xor
X121 (target_k5 n233 n234 vdd vss) tx_xor
X122 (n235 n203 n236 vdd vss) tx_xor
X123 (n237 n238 n239 vdd vss) tx_xor
X124 (n194 n240 n241 vdd vss) tx_xor
X125 (n197 n242 n243 vdd vss) tx_xor
X126 (target_k5 n244 n245 vdd vss) tx_xor
X127 (n246 n160 n247 vdd vss) tx_xor
X128 (n248 n249 n250 vdd vss) tx_xor
X129 (n251 n252 n253 vdd vss) tx_xor
X130 (n254 n255 n256 vdd vss) tx_xor
X131 (n257 n258 n259 vdd vss) tx_xor
X132 (n260 n261 n262 vdd vss) tx_xor
X133 (n263 n264 n265 vdd vss) tx_xor
X134 (n266 n152 n267 vdd vss) tx_xor
X135 (n158 n268 n269 vdd vss) tx_xor
X136 (n186 n270 n271 vdd vss) tx_xor
X137 (n156 n272 n273 vdd vss) tx_xor
X138 (n154 n274 n275 vdd vss) tx_xor
X139 (n86 n84 n276 vdd vss) tx_xor
X140 (n88 n277 n278 vdd vss) tx_xor
X141 (n90 n279 n280 vdd vss) tx_xor
X142 (n92 n281 n282 vdd vss) tx_xor
X143 (n94 n283 n284 vdd vss) tx_xor
X144 (n96 n285 n286 vdd vss) tx_xor
X145 (n98 n287 n288 vdd vss) tx_xor
X146 (target_k0 target_k1 n203 vdd vss) tx_and
X147 (target_k4 target_k5 n289 vdd vss) tx_and
X148 (target_k1 target_k2 n235 vdd vss) tx_xor
X149 (target_k2 target_k3 n237 vdd vss) tx_xor
X150 (target_k3 target_k4 n194 vdd vss) tx_xor
X151 (target_k4 target_k5 n197 vdd vss) tx_xor
X152 (n290 n291 n195 vdd vss) tx_or
X153 (n197 n198 n292 vdd vss) tx_and
X154 (n293 n294 n198 vdd vss) tx_or
X155 (n295 n238 n294 vdd vss) tx_and
X156 (n289 n292 n200 vdd vss) tx_or
X157 (n296 n297 n218 vdd vss) tx_or
X158 (n298 n238 n297 vdd vss) tx_and
X159 (n299 n295 n298 vdd vss) tx_and
X160 (n300 n301 n296 vdd vss) tx_or
X161 (n299 n293 n301 vdd vss) tx_and
X162 (target_k5 n197 n299 vdd vss) tx_and
X163 (target_k5 n289 n300 vdd vss) tx_and
X164 (n194 n237 n295 vdd vss) tx_and
X165 (n302 n303 n293 vdd vss) tx_or
X166 (n194 n290 n303 vdd vss) tx_and
X167 (n304 n305 n238 vdd vss) tx_or
X168 (n237 n238 n291 vdd vss) tx_and
X169 (n221 target_k2 n306 vdd vss) tx_and
X170 (n236 target_k3 n307 vdd vss) tx_and
X171 (n239 target_k4 n308 vdd vss) tx_and
X172 (n196 target_k5 n309 vdd vss) tx_and
X173 (n221 target_k2 n202 vdd vss) tx_xor
X174 (n236 target_k3 n205 vdd vss) tx_xor
X175 (n239 target_k4 n208 vdd vss) tx_xor
X176 (n196 target_k5 n211 vdd vss) tx_xor
X177 (n308 n310 n212 vdd vss) tx_or
X178 (n306 n311 n206 vdd vss) tx_or
X179 (n199 n214 n216 vdd vss) tx_and
X180 (n312 n313 n214 vdd vss) tx_or
X181 (n314 n209 n313 vdd vss) tx_and
X182 (n202 n203 n311 vdd vss) tx_and
X183 (n315 n316 n219 vdd vss) tx_or
X184 (n317 n209 n316 vdd vss) tx_and
X185 (n218 n219 n318 vdd vss) tx_and
X186 (n319 n314 n317 vdd vss) tx_and
X187 (n319 n312 n315 vdd vss) tx_and
X188 (n320 n321 n209 vdd vss) tx_or
X189 (n322 n203 n321 vdd vss) tx_and
X190 (n201 n199 n319 vdd vss) tx_and
X191 (n211 n208 n314 vdd vss) tx_and
X192 (n309 n323 n312 vdd vss) tx_or
X193 (n211 n308 n323 vdd vss) tx_and
X194 (n205 n202 n322 vdd vss) tx_and
X195 (n307 n324 n320 vdd vss) tx_or
X196 (n205 n306 n324 vdd vss) tx_and
X197 (n208 n209 n310 vdd vss) tx_and
X198 (n325 n326 n327 vdd vss) tx_and
X199 (n328 n327 n183 vdd vss) tx_or
X200 (n329 n330 n325 vdd vss) tx_and
X201 (target_k5 n331 n328 vdd vss) tx_or
X202 (n325 n332 n333 vdd vss) tx_and
X203 (n328 n333 n181 vdd vss) tx_or
X204 (n290 n334 n332 vdd vss) tx_and
X205 (n329 target_k4 n331 vdd vss) tx_and
X206 (target_k1 n335 n334 vdd vss) tx_or
X207 (n336 target_k0 n335 vdd vss) tx_and
X208 (target_k0 target_k2 n223 vdd vss) tx_and
X209 (target_k1 target_k3 n337 vdd vss) tx_and
X210 (target_k2 target_k4 n338 vdd vss) tx_and
X211 (target_k3 target_k5 n339 vdd vss) tx_and
X212 (target_k0 target_k2 n340 vdd vss) tx_xor
X213 (target_k1 target_k3 n222 vdd vss) tx_xor
X214 (target_k2 target_k4 n225 vdd vss) tx_xor
X215 (target_k3 target_k5 n228 vdd vss) tx_xor
X216 (n338 n341 n229 vdd vss) tx_or
X217 (target_k4 n231 n233 vdd vss) tx_and
X218 (n342 n343 n231 vdd vss) tx_or
X219 (n344 n226 n343 vdd vss) tx_and
X220 (n345 n346 n347 vdd vss) tx_or
X221 (n348 n226 n346 vdd vss) tx_and
X222 (n289 n344 n348 vdd vss) tx_and
X223 (n289 n342 n345 vdd vss) tx_and
X224 (n228 n225 n344 vdd vss) tx_and
X225 (n339 n349 n342 vdd vss) tx_or
X226 (n228 n338 n349 vdd vss) tx_and
X227 (n337 n350 n226 vdd vss) tx_or
X228 (n222 n223 n350 vdd vss) tx_and
X229 (n225 n226 n341 vdd vss) tx_and
X230 (n331 n351 n352 vdd vss) tx_and
X231 (target_k5 n352 n179 vdd vss) tx_or
X232 (n353 n354 n351 vdd vss) tx_or
X233 (n355 target_k1 n354 vdd vss) tx_and
X234 (n356 n357 n355 vdd vss) tx_and
X235 (target_k3 n358 n353 vdd vss) tx_or
X236 (n356 target_k2 n358 vdd vss) tx_and
X237 (target_k5 n359 n177 vdd vss) tx_or
X238 (n331 n326 n359 vdd vss) tx_and
X239 (n290 n360 n326 vdd vss) tx_or
X240 (target_k3 n357 n361 vdd vss) tx_and
X241 (target_k3 target_k2 n290 vdd vss) tx_and
X242 (target_k1 target_k2 n304 vdd vss) tx_and
X243 (target_k3 target_k4 n302 vdd vss) tx_and
X244 (n302 n362 n242 vdd vss) tx_or
X245 (target_k5 n244 n363 vdd vss) tx_and
X246 (n364 n365 n244 vdd vss) tx_or
X247 (n366 n240 n365 vdd vss) tx_and
X248 (n235 n203 n305 vdd vss) tx_and
X249 (n367 n368 n240 vdd vss) tx_or
X250 (n369 n203 n368 vdd vss) tx_and
X251 (n197 n194 n366 vdd vss) tx_and
X252 (n289 n370 n364 vdd vss) tx_or
X253 (n197 n302 n370 vdd vss) tx_and
X254 (n237 n235 n369 vdd vss) tx_and
X255 (n290 n371 n367 vdd vss) tx_or
X256 (n237 n304 n371 vdd vss) tx_and
X257 (n194 n240 n362 vdd vss) tx_and
X258 (measured4 n372 n373 vdd vss) tx_and
X259 (measured5 n374 n375 vdd vss) tx_and
X260 (measured6 n376 n377 vdd vss) tx_and
X261 (measured7 n378 n379 vdd vss) tx_and
X262 (measured10 n380 n381 vdd vss) tx_and
X263 (measured4 n372 n382 vdd vss) tx_xor
X264 (measured5 n374 n383 vdd vss) tx_xor
X265 (measured6 n376 n384 vdd vss) tx_xor
X266 (measured10 n380 n385 vdd vss) tx_xor
X267 (n386 n387 n388 vdd vss) tx_or
X268 (n389 n390 n391 vdd vss) tx_and
X269 (n392 n393 n394 vdd vss) tx_and
X270 (n395 n396 n397 vdd vss) tx_or
X271 (n392 n398 n396 vdd vss) tx_and
X272 (n399 n400 n401 vdd vss) tx_or
X273 (n402 n403 n404 vdd vss) tx_and
X274 (n402 n405 n406 vdd vss) tx_and
X275 (n407 n385 n392 vdd vss) tx_and
X276 (n408 n409 n395 vdd vss) tx_or
X277 (n379 n410 n399 vdd vss) tx_or
X278 (n411 n377 n410 vdd vss) tx_and
X279 (n375 n412 n413 vdd vss) tx_or
X280 (n383 n373 n412 vdd vss) tx_and
X281 (measured3 n414 n415 vdd vss) tx_or
X282 (n171 measured2 n414 vdd vss) tx_and
X283 (measured8 n416 n417 vdd vss) tx_and
X284 (measured9 n418 n419 vdd vss) tx_and
X285 (measured11 n420 n408 vdd vss) tx_and
X286 (measured12 n421 n405 vdd vss) tx_and
X287 (measured13 n422 n423 vdd vss) tx_and
X288 (measured7 n378 n411 vdd vss) tx_xor
X289 (measured8 n416 n424 vdd vss) tx_xor
X290 (measured9 n418 n425 vdd vss) tx_xor
X291 (measured11 n420 n407 vdd vss) tx_xor
X292 (measured12 n421 n403 vdd vss) tx_xor
X293 (measured13 n422 n402 vdd vss) tx_xor
X294 (n404 n426 n387 vdd vss) tx_and
X295 (n397 n427 n426 vdd vss) tx_or
X296 (n394 n428 n427 vdd vss) tx_and
X297 (n401 n391 n428 vdd vss) tx_or
X298 (n429 n430 n389 vdd vss) tx_and
X299 (n429 n413 n400 vdd vss) tx_and
X300 (n415 n431 n390 vdd vss) tx_or
X301 (n423 n406 n386 vdd vss) tx_or
X302 (n407 n381 n409 vdd vss) tx_and
X303 (n419 n432 n398 vdd vss) tx_or
X304 (n425 n417 n432 vdd vss) tx_and
X305 (n411 n384 n429 vdd vss) tx_and
X306 (n383 n382 n430 vdd vss) tx_and
X307 (n171 n170 n431 vdd vss) tx_and
X308 (n260 n261 n264 vdd vss) tx_and
X309 (n254 n255 n258 vdd vss) tx_and
X310 (n248 n249 n252 vdd vss) tx_and
X311 (n433 n255 n261 vdd vss) tx_and
X312 (n434 n249 n255 vdd vss) tx_and
X313 (n257 n254 n433 vdd vss) tx_and
X314 (n251 n248 n434 vdd vss) tx_and
X315 (n246 n160 n249 vdd vss) tx_and
X316 (n435 n436 n175 vdd vss) tx_or
X317 (n437 n438 n436 vdd vss) tx_and
X318 (n439 n440 n438 vdd vss) tx_or
X319 (n441 n268 n440 vdd vss) tx_and
X320 (n155 n157 n437 vdd vss) tx_and
X321 (n154 n442 n435 vdd vss) tx_or
X322 (n155 n156 n442 vdd vss) tx_and
X323 (n186 n159 n441 vdd vss) tx_and
X324 (n443 n444 n173 vdd vss) tx_and
X325 (n186 n445 n444 vdd vss) tx_or
X326 (n158 n268 n270 vdd vss) tx_and
X327 (n156 n272 n274 vdd vss) tx_and
X328 (n439 n268 n272 vdd vss) tx_and
X329 (n186 n158 n439 vdd vss) tx_and
X330 (n266 n152 n268 vdd vss) tx_and
X331 (n88 n277 n279 vdd vss) tx_and
X332 (n92 n281 n283 vdd vss) tx_and
X333 (n446 n281 n285 vdd vss) tx_and
X334 (n96 n285 n287 vdd vss) tx_and
X335 (n447 n277 n281 vdd vss) tx_and
X336 (n94 n92 n446 vdd vss) tx_and
X337 (n90 n88 n447 vdd vss) tx_and
X338 (n86 n84 n277 vdd vss) tx_and
X339 (coarse0 n163 n448 vdd vss) tx_and
X340 (coarse1 n449 n450 vdd vss) tx_and
X341 (coarse2 n451 n452 vdd vss) tx_and
X342 (coarse3 n453 n454 vdd vss) tx_and
X343 (coarse4 n455 n456 vdd vss) tx_and
X344 (coarse5 n457 n458 vdd vss) tx_and
X345 (coarse6 n459 n460 vdd vss) tx_and
X346 (coarse7 n461 n462 vdd vss) tx_and
X347 (dac0 n163 n463 vdd vss) tx_and
X348 (dac1 n449 n464 vdd vss) tx_and
X349 (dac2 n451 n465 vdd vss) tx_and
X350 (dac3 n453 n466 vdd vss) tx_and
X351 (dac4 n455 n467 vdd vss) tx_and
X352 (dac5 n457 n468 vdd vss) tx_and
X353 (n94 n55 n469 vdd vss) tx_xor
X354 (n96 n55 n470 vdd vss) tx_xor
X355 (n160 n69 n471 vdd vss) tx_or
X356 (n246 n71 n472 vdd vss) tx_or
X357 (n248 n73 n473 vdd vss) tx_or
X358 (n251 n75 n474 vdd vss) tx_or
X359 (n254 n77 n475 vdd vss) tx_or
X360 (n257 n79 n476 vdd vss) tx_or
X361 (n260 n81 n477 vdd vss) tx_or
X362 (n152 n69 n478 vdd vss) tx_or
X363 (n266 n71 n479 vdd vss) tx_or
X364 (n151 n480 n481 vdd vss) tx_or
X365 (n482 n483 n484 vdd vss) tx_or
X366 (n485 n94 n486 vdd vss) tx_or
X367 (n96 n98 n487 vdd vss) tx_or
X368 (n481 n484 n488 vdd vss) tx_or
X369 (n486 n487 n489 vdd vss) tx_or
X370 (n488 n489 n490 vdd vss) tx_or
X371 (n491 n166 n492 vdd vss) tx_or
X372 (n493 n166 n494 vdd vss) tx_or
X373 (state_out0 n164 n495 vdd vss) tx_or
X374 (n495 state_out2 n496 vdd vss) tx_or
X375 (n165 state_out1 n493 vdd vss) tx_or
X376 (n493 state_out2 n497 vdd vss) tx_or
X377 (n165 n164 n498 vdd vss) tx_or
X378 (n498 state_out2 n499 vdd vss) tx_or
X379 (n203 n361 n360 vdd vss) tx_and
X380 (n360 n325 n500 vdd vss) tx_and
X381 (n184 n500 n501 vdd vss) tx_or
X382 (n335 n290 n502 vdd vss) tx_and
X383 (n502 n325 n503 vdd vss) tx_and
X384 (n182 n503 n504 vdd vss) tx_or
X385 (n162 target_k1 n505 vdd vss) tx_and
X386 (n505 n355 n506 vdd vss) tx_and
X387 (n506 n331 n507 vdd vss) tx_and
X388 (n180 n507 n508 vdd vss) tx_or
X389 (n360 n331 n509 vdd vss) tx_and
X390 (n178 n509 n510 vdd vss) tx_or
X391 (n511 n190 n512 vdd vss) tx_or
X392 (n169 n172 n513 vdd vss) tx_and
X393 (n424 n425 n393 vdd vss) tx_and
X394 (n513 n431 n514 vdd vss) tx_and
X395 (n514 n389 n515 vdd vss) tx_and
X396 (n394 n404 n516 vdd vss) tx_and
X397 (n515 n516 n190 vdd vss) tx_and
X398 (n153 n517 n518 vdd vss) tx_and
X399 (n158 n519 n445 vdd vss) tx_and
X400 (n156 n154 n443 vdd vss) tx_and
X401 (n518 n445 n520 vdd vss) tx_and
X402 (n520 n443 n192 vdd vss) tx_and
X403 (n521 n55 n522 vdd vss) tx_and
X404 (n101 n523 n524 vdd vss) tx_and
X405 (n522 n524 n525 vdd vss) tx_and
X406 (n525 n141 n128 vdd vss) tx_and
X407 (n176 n526 n521 vdd vss) tx_or
X408 (n527 n141 n120 vdd vss) tx_and
X409 (n528 n141 n131 vdd vss) tx_and
X410 (n528 n529 n530 vdd vss) tx_and
X411 (n530 n141 n114 vdd vss) tx_and
X412 (n101 n531 n528 vdd vss) tx_or
X413 (n55 n167 n532 vdd vss) tx_or
X414 (n532 n523 n529 vdd vss) tx_or
X415 (n494 n533 n534 vdd vss) tx_and
X416 (n535 n536 n537 vdd vss) tx_and
X417 (n534 n537 n538 vdd vss) tx_and
X418 (n538 n539 n111 vdd vss) tx_and
X419 (n540 n492 n533 vdd vss) tx_or
X420 (n541 n496 n535 vdd vss) tx_or
X421 (n542 n497 n536 vdd vss) tx_or
X422 (n543 n544 n539 vdd vss) tx_or
X423 (n545 n141 n103 vdd vss) tx_and
X424 (n168 n167 n527 vdd vss) tx_or
X425 (n527 n546 n545 vdd vss) tx_or
X426 (n540 n547 n140 vdd vss) tx_and
X427 (n141 n548 n143 vdd vss) tx_or
X428 (n548 n549 n550 vdd vss) tx_or
X429 (n550 n551 n552 vdd vss) tx_or
X430 (n162 target_k1 n553 vdd vss) tx_or
X431 (target_k2 n356 n554 vdd vss) tx_or
X432 (target_k4 target_k5 n555 vdd vss) tx_or
X433 (n553 n554 n556 vdd vss) tx_or
X434 (n556 n555 n557 vdd vss) tx_or
X435 (n482 n90 n558 vdd vss) tx_or
X436 (n481 n558 n559 vdd vss) tx_or
X437 (n559 n560 n561 vdd vss) tx_or
X438 (n485 n469 n562 vdd vss) tx_or
X439 (n470 n98 n563 vdd vss) tx_or
X440 (n562 n563 n564 vdd vss) tx_or
X441 (n488 n564 n565 vdd vss) tx_or
X442 (n84 n480 n566 vdd vss) tx_or
X443 (n88 n90 n567 vdd vss) tx_or
X444 (n92 n94 n568 vdd vss) tx_or
X445 (n566 n567 n569 vdd vss) tx_or
X446 (n568 n487 n560 vdd vss) tx_or
X447 (n569 n560 n570 vdd vss) tx_or
X448 (n161 n571 n572 vdd vss) tx_or
X449 (n573 n574 n575 vdd vss) tx_or
X450 (n576 n577 n578 vdd vss) tx_or
X451 (n579 n580 n581 vdd vss) tx_or
X452 (n572 n575 n582 vdd vss) tx_or
X453 (n578 n581 n583 vdd vss) tx_or
X454 (n582 n583 n584 vdd vss) tx_or
X455 (n163 n69 n585 vdd vss) tx_or
X456 (n71 n73 n586 vdd vss) tx_or
X457 (n75 n77 n587 vdd vss) tx_or
X458 (n79 n81 n588 vdd vss) tx_or
X459 (n585 n586 n589 vdd vss) tx_or
X460 (n587 n588 n590 vdd vss) tx_or
X461 (n589 n590 n546 vdd vss) tx_or
X462 (n549 n547 n591 vdd vss) tx_or
X463 (n592 n591 n593 vdd vss) tx_or
X464 (n593 n143 n594 vdd vss) tx_or
X465 (n595 n596 n597 vdd vss) tx_or
X466 (n598 n599 n600 vdd vss) tx_or
X467 (n597 n600 n601 vdd vss) tx_or
X468 (n602 n603 n604 vdd vss) tx_or
X469 (n605 n606 n607 vdd vss) tx_or
X470 (n604 n607 n608 vdd vss) tx_or
X471 (n609 n610 n611 vdd vss) tx_or
X472 (n612 n613 n614 vdd vss) tx_or
X473 (n611 n614 n615 vdd vss) tx_or
X474 (n616 n617 n618 vdd vss) tx_or
X475 (n619 n620 n621 vdd vss) tx_or
X476 (n618 n621 n622 vdd vss) tx_or
X477 (n623 n624 n625 vdd vss) tx_or
X478 (n626 n627 n628 vdd vss) tx_or
X479 (n625 n628 n629 vdd vss) tx_or
X480 (n630 n631 n632 vdd vss) tx_or
X481 (n633 n634 n635 vdd vss) tx_or
X482 (n632 n635 n636 vdd vss) tx_or
X483 (n637 n638 n639 vdd vss) tx_or
X484 (n640 n641 n642 vdd vss) tx_or
X485 (n639 n642 n643 vdd vss) tx_or
X486 (n644 n645 n646 vdd vss) tx_or
X487 (n647 n648 n649 vdd vss) tx_or
X488 (n646 n649 n650 vdd vss) tx_or
X489 (n548 n547 n651 vdd vss) tx_or
X490 (n141 n549 n652 vdd vss) tx_or
X491 (n653 n551 n592 vdd vss) tx_or
X492 (n651 n652 n654 vdd vss) tx_or
X493 (n654 n592 n655 vdd vss) tx_or
X494 (n656 n657 n658 vdd vss) tx_or
X495 (n659 n660 n661 vdd vss) tx_or
X496 (n661 n658 n662 vdd vss) tx_or
X497 (n663 n664 n665 vdd vss) tx_or
X498 (n666 n660 n667 vdd vss) tx_or
X499 (n667 n665 n668 vdd vss) tx_or
X500 (n669 n670 n671 vdd vss) tx_or
X501 (n656 n664 n672 vdd vss) tx_or
X502 (n659 n671 n673 vdd vss) tx_or
X503 (n673 n672 n674 vdd vss) tx_or
X504 (n551 n143 n138 vdd vss) tx_or
X505 (n675 n143 n676 vdd vss) tx_or
X506 (n653 n552 n135 vdd vss) tx_or
X507 (state_out0 state_out1 n491 vdd vss) tx_or
X508 (n491 state_out2 n544 vdd vss) tx_or
X509 (n490 n540 vdd vss) pll_inv
X510 (range_error n139 vdd vss) pll_inv
X511 (n492 n547 vdd vss) pll_inv
X512 (n494 n548 vdd vss) pll_inv
X513 (n496 n549 vdd vss) pll_inv
X514 (n497 n653 vdd vss) pll_inv
X515 (n544 n551 vdd vss) pll_inv
X516 (n499 n141 vdd vss) pll_inv
X517 (n561 n543 vdd vss) pll_inv
X518 (n565 n542 vdd vss) pll_inv
X519 (n570 n541 vdd vss) pll_inv
X520 (vss n69 n546 n677 vdd vss) tx_mux
X521 (vss n71 n546 n678 vdd vss) tx_mux
X522 (vss n73 n546 n679 vdd vss) tx_mux
X523 (vss n75 n546 n680 vdd vss) tx_mux
X524 (vss n77 n546 n681 vdd vss) tx_mux
X525 (vss n79 n546 n682 vdd vss) tx_mux
X526 (vss n81 n546 n683 vdd vss) tx_mux
X527 (vss vss n546 n684 vdd vss) tx_mux
X528 (vss n69 n546 n685 vdd vss) tx_mux
X529 (vss n71 n546 n686 vdd vss) tx_mux
X530 (vss n73 n546 n687 vdd vss) tx_mux
X531 (vss n75 n546 n688 vdd vss) tx_mux
X532 (vss n77 n546 n689 vdd vss) tx_mux
X533 (vdd n79 n546 n690 vdd vss) tx_mux
X534 (vss n81 n546 n691 vdd vss) tx_mux
X535 (n685 n677 n55 n692 vdd vss) tx_mux
X536 (n686 n678 n55 n693 vdd vss) tx_mux
X537 (n687 n679 n55 n694 vdd vss) tx_mux
X538 (n688 n680 n55 n695 vdd vss) tx_mux
X539 (n689 n681 n55 n696 vdd vss) tx_mux
X540 (n690 n682 n55 n697 vdd vss) tx_mux
X541 (n691 n683 n55 n698 vdd vss) tx_mux
X542 (vss n684 n55 n699 vdd vss) tx_mux
X543 (n700 n531 vdd vss) pll_inv
X544 (vss n692 n101 n109 vdd vss) tx_mux
X545 (vss n693 n101 n108 vdd vss) tx_mux
X546 (vss n694 n101 n107 vdd vss) tx_mux
X547 (vss n695 n101 n106 vdd vss) tx_mux
X548 (vss n696 n101 n105 vdd vss) tx_mux
X549 (n531 n697 n101 n104 vdd vss) tx_mux
X550 (vss n698 n101 n102 vdd vss) tx_mux
X551 (n700 n699 n101 n136 vdd vss) tx_mux
X552 (n523 vdd n55 n701 vdd vss) tx_mux
X553 (n702 n701 n101 n130 vdd vss) tx_mux
X554 (vss n151 n490 n703 vdd vss) tx_mux
X555 (vss n276 n490 n704 vdd vss) tx_mux
X556 (vss n278 n490 n705 vdd vss) tx_mux
X557 (vss n280 n490 n706 vdd vss) tx_mux
X558 (vss n282 n490 n707 vdd vss) tx_mux
X559 (vss n284 n490 n708 vdd vss) tx_mux
X560 (vss n286 n490 n709 vdd vss) tx_mux
X561 (vss n288 n490 n710 vdd vss) tx_mux
X562 (vss n151 n570 n711 vdd vss) tx_mux
X563 (vss n276 n570 n712 vdd vss) tx_mux
X564 (vss n278 n570 n713 vdd vss) tx_mux
X565 (vss n280 n570 n714 vdd vss) tx_mux
X566 (vss n282 n570 n715 vdd vss) tx_mux
X567 (vss n284 n570 n716 vdd vss) tx_mux
X568 (vss n286 n570 n717 vdd vss) tx_mux
X569 (vss n288 n570 n718 vdd vss) tx_mux
X570 (vss n151 n565 n719 vdd vss) tx_mux
X571 (vss n276 n565 n720 vdd vss) tx_mux
X572 (vss n278 n565 n721 vdd vss) tx_mux
X573 (vss n280 n565 n722 vdd vss) tx_mux
X574 (vss n282 n565 n723 vdd vss) tx_mux
X575 (vss n284 n565 n724 vdd vss) tx_mux
X576 (vss n286 n565 n725 vdd vss) tx_mux
X577 (vss n288 n565 n726 vdd vss) tx_mux
X578 (vss n151 n561 n727 vdd vss) tx_mux
X579 (vss n276 n561 n728 vdd vss) tx_mux
X580 (vss n278 n561 n729 vdd vss) tx_mux
X581 (vss n280 n561 n730 vdd vss) tx_mux
X582 (vss n282 n561 n731 vdd vss) tx_mux
X583 (vss n284 n561 n732 vdd vss) tx_mux
X584 (vss n286 n561 n733 vdd vss) tx_mux
X585 (vss n288 n561 n734 vdd vss) tx_mux
X586 (vdd vss n490 n735 vdd vss) tx_mux
X587 (vss vss n490 n736 vdd vss) tx_mux
X588 (n546 n523 vdd vss) pll_inv
X589 (vss n523 n55 n737 vdd vss) tx_mux
X590 (vss n737 n101 n738 vdd vss) tx_mux
X591 (vdd vss n570 n739 vdd vss) tx_mux
X592 (vss vss n570 n740 vdd vss) tx_mux
X593 (vss vss n565 n741 vdd vss) tx_mux
X594 (vdd vss n565 n742 vdd vss) tx_mux
X595 (vdd vss n561 n743 vdd vss) tx_mux
X596 (vss vss n561 n744 vdd vss) tx_mux
X597 (vdd vss n193 n745 vdd vss) tx_mux
X598 (vdd n745 n175 n127 vdd vss) tx_mux
X599 (vdd n153 n193 n746 vdd vss) tx_mux
X600 (vss n267 n193 n747 vdd vss) tx_mux
X601 (vdd n269 n193 n748 vdd vss) tx_mux
X602 (vss n271 n193 n749 vdd vss) tx_mux
X603 (vdd n273 n193 n750 vdd vss) tx_mux
X604 (vdd n275 n193 n751 vdd vss) tx_mux
X605 (vdd n746 n175 n752 vdd vss) tx_mux
X606 (vdd n747 n175 n753 vdd vss) tx_mux
X607 (vss n748 n175 n754 vdd vss) tx_mux
X608 (vdd n749 n175 n755 vdd vss) tx_mux
X609 (vss n750 n175 n756 vdd vss) tx_mux
X610 (vss n751 n175 n757 vdd vss) tx_mux
X611 (n752 n478 n546 n758 vdd vss) tx_mux
X612 (n753 n479 n546 n759 vdd vss) tx_mux
X613 (n754 n185 n546 n760 vdd vss) tx_mux
X614 (n755 n187 n546 n761 vdd vss) tx_mux
X615 (n756 n188 n546 n762 vdd vss) tx_mux
X616 (n757 n154 n546 n763 vdd vss) tx_mux
X617 (vss vss n546 n764 vdd vss) tx_mux
X618 (vdd vss n546 n765 vdd vss) tx_mux
X619 (n764 n758 n55 n766 vdd vss) tx_mux
X620 (n764 n759 n55 n767 vdd vss) tx_mux
X621 (n764 n760 n55 n768 vdd vss) tx_mux
X622 (n764 n761 n55 n769 vdd vss) tx_mux
X623 (n764 n762 n55 n770 vdd vss) tx_mux
X624 (n765 n763 n55 n771 vdd vss) tx_mux
X625 (vss vss n700 n772 vdd vss) tx_mux
X626 (vdd vss n700 n702 vdd vss) tx_mux
X627 (n772 n766 n101 n118 vdd vss) tx_mux
X628 (n772 n767 n101 n117 vdd vss) tx_mux
X629 (n772 n768 n101 n116 vdd vss) tx_mux
X630 (n772 n769 n101 n115 vdd vss) tx_mux
X631 (n772 n770 n101 n113 vdd vss) tx_mux
X632 (n702 n771 n101 n132 vdd vss) tx_mux
X633 (n773 n471 n546 n774 vdd vss) tx_mux
X634 (n775 n472 n546 n776 vdd vss) tx_mux
X635 (n777 n473 n546 n778 vdd vss) tx_mux
X636 (n779 n474 n546 n780 vdd vss) tx_mux
X637 (n781 n475 n546 n782 vdd vss) tx_mux
X638 (n783 n476 n546 n784 vdd vss) tx_mux
X639 (n785 n477 n546 n786 vdd vss) tx_mux
X640 (n787 n263 n546 n788 vdd vss) tx_mux
X641 (n774 vss n55 n789 vdd vss) tx_mux
X642 (n776 vss n55 n790 vdd vss) tx_mux
X643 (n778 vss n55 n791 vdd vss) tx_mux
X644 (n780 vss n55 n792 vdd vss) tx_mux
X645 (n782 vss n55 n793 vdd vss) tx_mux
X646 (n784 vss n55 n794 vdd vss) tx_mux
X647 (n786 vss n55 n795 vdd vss) tx_mux
X648 (n788 vss n55 n796 vdd vss) tx_mux
X649 (vss n789 n101 n126 vdd vss) tx_mux
X650 (vss n790 n101 n125 vdd vss) tx_mux
X651 (vss n791 n101 n124 vdd vss) tx_mux
X652 (vss n792 n101 n123 vdd vss) tx_mux
X653 (vss n793 n101 n122 vdd vss) tx_mux
X654 (vss n794 n101 n121 vdd vss) tx_mux
X655 (vss n795 n101 n119 vdd vss) tx_mux
X656 (n700 n796 n101 n129 vdd vss) tx_mux
X657 (vss target_k0 n510 n797 vdd vss) tx_mux
X658 (target_k0 n221 n510 n798 vdd vss) tx_mux
X659 (target_k1 n236 n510 n799 vdd vss) tx_mux
X660 (target_k2 n239 n510 n800 vdd vss) tx_mux
X661 (target_k3 n241 n510 n801 vdd vss) tx_mux
X662 (target_k4 n243 n510 n802 vdd vss) tx_mux
X663 (target_k5 n245 n510 n803 vdd vss) tx_mux
X664 (vss n363 n510 n804 vdd vss) tx_mux
X665 (n797 vss n508 n805 vdd vss) tx_mux
X666 (n798 vss n508 n806 vdd vss) tx_mux
X667 (n799 target_k0 n508 n807 vdd vss) tx_mux
X668 (n800 target_k1 n508 n808 vdd vss) tx_mux
X669 (n801 target_k2 n508 n809 vdd vss) tx_mux
X670 (n802 target_k3 n508 n810 vdd vss) tx_mux
X671 (n803 target_k4 n508 n811 vdd vss) tx_mux
X672 (n804 target_k5 n508 n812 vdd vss) tx_mux
X673 (n805 target_k0 n504 n813 vdd vss) tx_mux
X674 (n806 target_k1 n504 n814 vdd vss) tx_mux
X675 (n807 n340 n504 n815 vdd vss) tx_mux
X676 (n808 n224 n504 n816 vdd vss) tx_mux
X677 (n809 n227 n504 n817 vdd vss) tx_mux
X678 (n810 n230 n504 n818 vdd vss) tx_mux
X679 (n811 n232 n504 n819 vdd vss) tx_mux
X680 (n812 n234 n504 n820 vdd vss) tx_mux
X681 (vss n347 n504 n821 vdd vss) tx_mux
X682 (n813 vss n501 n822 vdd vss) tx_mux
X683 (n814 target_k0 n501 n823 vdd vss) tx_mux
X684 (n815 n221 n501 n824 vdd vss) tx_mux
X685 (n816 n236 n501 n825 vdd vss) tx_mux
X686 (n817 n239 n501 n826 vdd vss) tx_mux
X687 (n818 n196 n501 n827 vdd vss) tx_mux
X688 (n819 n199 n501 n828 vdd vss) tx_mux
X689 (n820 n201 n501 n829 vdd vss) tx_mux
X690 (n821 n218 n501 n830 vdd vss) tx_mux
X691 (target_k0 n822 n557 n831 vdd vss) tx_mux
X692 (n221 n823 n557 n832 vdd vss) tx_mux
X693 (n204 n824 n557 n833 vdd vss) tx_mux
X694 (n207 n825 n557 n834 vdd vss) tx_mux
X695 (n210 n826 n557 n835 vdd vss) tx_mux
X696 (n213 n827 n557 n836 vdd vss) tx_mux
X697 (n215 n828 n557 n837 vdd vss) tx_mux
X698 (n217 n829 n557 n838 vdd vss) tx_mux
X699 (n220 n830 n557 n839 vdd vss) tx_mux
X700 (n318 vss n557 n840 vdd vss) tx_mux
X701 (n831 vss n55 n841 vdd vss) tx_mux
X702 (n832 vss n55 n842 vdd vss) tx_mux
X703 (n833 n831 n55 n843 vdd vss) tx_mux
X704 (n834 n832 n55 n844 vdd vss) tx_mux
X705 (n835 n833 n55 n845 vdd vss) tx_mux
X706 (n836 n834 n55 n846 vdd vss) tx_mux
X707 (n837 n835 n55 n847 vdd vss) tx_mux
X708 (n838 n836 n55 n848 vdd vss) tx_mux
X709 (n839 n837 n55 n849 vdd vss) tx_mux
X710 (n840 n838 n55 n850 vdd vss) tx_mux
X711 (n511 n512 n55 n700 vdd vss) tx_mux
X712 (n448 coarse0 n700 n160 vdd vss) tx_mux
X713 (n450 coarse1 n700 n246 vdd vss) tx_mux
X714 (n452 coarse2 n700 n248 vdd vss) tx_mux
X715 (n454 coarse3 n700 n251 vdd vss) tx_mux
X716 (n456 coarse4 n700 n254 vdd vss) tx_mux
X717 (n458 coarse5 n700 n257 vdd vss) tx_mux
X718 (n460 coarse6 n700 n260 vdd vss) tx_mux
X719 (n462 coarse7 n700 n263 vdd vss) tx_mux
X720 (dac0 n463 n700 n152 vdd vss) tx_mux
X721 (dac1 n464 n700 n266 vdd vss) tx_mux
X722 (dac2 n465 n700 n158 vdd vss) tx_mux
X723 (dac3 n466 n700 n186 vdd vss) tx_mux
X724 (dac4 n467 n700 n156 vdd vss) tx_mux
X725 (dac5 n468 n700 n154 vdd vss) tx_mux
X726 (vdd n161 n584 n773 vdd vss) tx_mux
X727 (vdd n247 n584 n775 vdd vss) tx_mux
X728 (vdd n250 n584 n777 vdd vss) tx_mux
X729 (vdd n253 n584 n779 vdd vss) tx_mux
X730 (vdd n256 n584 n781 vdd vss) tx_mux
X731 (vdd n259 n584 n783 vdd vss) tx_mux
X732 (vdd n262 n584 n785 vdd vss) tx_mux
X733 (vdd n265 n584 n787 vdd vss) tx_mux
X734 (n727 n551 n595 vdd vss) tx_and
X735 (n719 n653 n596 vdd vss) tx_and
X736 (n711 n549 n598 vdd vss) tx_and
X737 (n703 n547 n599 vdd vss) tx_and
X738 (n728 n551 n602 vdd vss) tx_and
X739 (n720 n653 n603 vdd vss) tx_and
X740 (n712 n549 n605 vdd vss) tx_and
X741 (n704 n547 n606 vdd vss) tx_and
X742 (n729 n551 n609 vdd vss) tx_and
X743 (n721 n653 n610 vdd vss) tx_and
X744 (n713 n549 n612 vdd vss) tx_and
X745 (n705 n547 n613 vdd vss) tx_and
X746 (n730 n551 n616 vdd vss) tx_and
X747 (n722 n653 n617 vdd vss) tx_and
X748 (n714 n549 n619 vdd vss) tx_and
X749 (n706 n547 n620 vdd vss) tx_and
X750 (n731 n551 n623 vdd vss) tx_and
X751 (n723 n653 n624 vdd vss) tx_and
X752 (n715 n549 n626 vdd vss) tx_and
X753 (n707 n547 n627 vdd vss) tx_and
X754 (n732 n551 n630 vdd vss) tx_and
X755 (n724 n653 n631 vdd vss) tx_and
X756 (n716 n549 n633 vdd vss) tx_and
X757 (n708 n547 n634 vdd vss) tx_and
X758 (n733 n551 n637 vdd vss) tx_and
X759 (n725 n653 n638 vdd vss) tx_and
X760 (n717 n549 n640 vdd vss) tx_and
X761 (n709 n547 n641 vdd vss) tx_and
X762 (n734 n551 n644 vdd vss) tx_and
X763 (n726 n653 n645 vdd vss) tx_and
X764 (n718 n549 n647 vdd vss) tx_and
X765 (n710 n547 n648 vdd vss) tx_and
X766 (n743 n551 n657 vdd vss) tx_and
X767 (n736 n547 n666 vdd vss) tx_and
X768 (n739 n549 n660 vdd vss) tx_and
X769 (n742 n653 n663 vdd vss) tx_and
X770 (n735 n547 n659 vdd vss) tx_and
X771 (n738 n141 n669 vdd vss) tx_and
X772 (n740 n549 n670 vdd vss) tx_and
X773 (n741 n653 n656 vdd vss) tx_and
X774 (n744 n551 n664 vdd vss) tx_and
X775 (n561 n551 n675 vdd vss) tx_and
X776 (n191 n511 vdd vss) pll_inv
X777 (n388 n189 vdd vss) pll_inv
X778 (n193 n526 vdd vss) pll_inv
X779 (target_k1 n336 vdd vss) pll_inv
X780 (target_k2 n357 vdd vss) pll_inv
X781 (target_k3 n356 vdd vss) pll_inv
X782 (target_k4 n330 vdd vss) pll_inv
X783 (target_k5 n329 vdd vss) pll_inv
X784 (n841 n372 vdd vss) pll_inv
X785 (n848 n420 vdd vss) pll_inv
X786 (n849 n421 vdd vss) pll_inv
X787 (n842 n374 vdd vss) pll_inv
X788 (n843 n376 vdd vss) pll_inv
X789 (n844 n378 vdd vss) pll_inv
X790 (n845 n416 vdd vss) pll_inv
X791 (n846 n418 vdd vss) pll_inv
X792 (n847 n380 vdd vss) pll_inv
X793 (n850 n422 vdd vss) pll_inv
X794 (n246 n571 vdd vss) pll_inv
X795 (n248 n573 vdd vss) pll_inv
X796 (n251 n574 vdd vss) pll_inv
X797 (n254 n576 vdd vss) pll_inv
X798 (n257 n577 vdd vss) pll_inv
X799 (n260 n579 vdd vss) pll_inv
X800 (n263 n580 vdd vss) pll_inv
X801 (n266 n517 vdd vss) pll_inv
X802 (n186 n519 vdd vss) pll_inv
X803 (n86 n480 vdd vss) pll_inv
X804 (n88 n482 vdd vss) pll_inv
X805 (n90 n483 vdd vss) pll_inv
X806 (n92 n485 vdd vss) pll_inv
X807 (n77 n457 vdd vss) pll_inv
X808 (n79 n459 vdd vss) pll_inv
X809 (n81 n461 vdd vss) pll_inv
X810 (n69 n449 vdd vss) pll_inv
X811 (n71 n451 vdd vss) pll_inv
X812 (n73 n453 vdd vss) pll_inv
X813 (n75 n455 vdd vss) pll_inv
X814 (vss n601 n594 n149 vdd vss) tx_mux
X815 (vss n608 n594 n148 vdd vss) tx_mux
X816 (vss n615 n594 n147 vdd vss) tx_mux
X817 (vss n622 n594 n146 vdd vss) tx_mux
X818 (vss n629 n594 n145 vdd vss) tx_mux
X819 (vss n636 n594 n144 vdd vss) tx_mux
X820 (vss n643 n594 n142 vdd vss) tx_mux
X821 (vss n650 n594 n150 vdd vss) tx_mux
X822 (vss n662 n655 n112 vdd vss) tx_mux
X823 (vss n668 n655 n110 vdd vss) tx_mux
X824 (vss n674 n655 n133 vdd vss) tx_mux
X825 (vss n676 n138 n137 vdd vss) tx_mux
X826 (vss n653 n135 n134 vdd vss) tx_mux
ends tx_fll_accuracy128_v14
