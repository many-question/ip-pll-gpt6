simulator lang=spectre
subckt rt_noise_scale4_v14 (data clk out vdd vss)
XFF (data clk qb vdd vss) rtcomb_ff_v13 scale=4.8
X0 (qb ob vdd vss) pll_inv wn=12u wp=2u
X1 (ob out vdd vss) pll_inv wn=3.2u wp=12u
ends rt_noise_scale4_v14
