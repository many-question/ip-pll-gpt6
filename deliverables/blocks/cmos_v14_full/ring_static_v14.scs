simulator lang=spectre
subckt ring_static_latch_v14 (d ck ckb q vdd vss)
XT (d x ck ckb vdd vss) pll_tg wn=1u wp=2u
XI (x qb vdd vss) pll_inv wn=0.8u wp=1.6u
XO (qb q vdd vss) pll_inv wn=1.6u wp=3.2u
XFB (q x ckb ck vdd vss) pll_tg wn=0.5u wp=1u
ends ring_static_latch_v14
subckt ring_static_sync_v14 (d clk clkb load loadb init q vdd vss)
XDATA (d din loadb load vdd vss) pll_tg wn=2u wp=4u
XINIT (init din load loadb vdd vss) pll_tg wn=2u wp=4u
XM (din clkb clk qm vdd vss) ring_static_latch_v14
XS (qm clk clkb q vdd vss) ring_static_latch_v14
ends ring_static_sync_v14
