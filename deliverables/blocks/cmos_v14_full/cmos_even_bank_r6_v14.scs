simulator lang=spectre
include "ff_fbdelay50_v14.scs"
include "ring_c2keep_v14.scs"
// Shared RF /2 retains V14 first stage; downstream rings run at RF/2.
// Ring initial patterns rotate. Odd N has non-50% duty; no duty correction.
subckt cmos_even_bank_r6_v14 (clk reset s0 s1 s2 s3 s4 s5 q1 out vdd vss)
XPRE (q0 clk q0 vdd vss) ff_fbdelay50_v14
XPB0 (q0 qb0 vdd vss) pll_inv wn=0.8u wp=0.5u
XPB1 (qb0 q1 vdd vss) pll_inv wn=2u wp=4u
XCB0 (q1 ckbn vdd vss) pll_inv wn=1u wp=4u
XCB1 (ckbn ckmid vdd vss) pll_inv wn=4u wp=10u
XCB2 (ckmid ckbank vdd vss) pll_inv wn=16u wp=40u
XCI (ckbank ckb vdd vss) pll_inv wn=4u wp=10u
XSI0 (s0 ns0 vdd vss) pll_inv
XRS0 (reset ns0 rst0 vdd vss) tx_or
XRE0 (rst0 allow0 vdd vss) pll_inv
XSE0 (allow0 ckb ckbank safe0 vdd vss) pll_latch
XGN0 (ckbank safe0 gn0 vdd vss) pll_nand2 wn=1u wp=1.25u
XGB00 (gn0 gb00 vdd vss) pll_inv wn=1u wp=2.5u
XGB10 (gb00 gb10 vdd vss) pll_inv wn=2u wp=5.0u
XGO0 (gb10 ck0 vdd vss) pll_inv wn=4u wp=10u
XCINV0 (ck0 ckn0 vdd vss) pll_inv wn=2u wp=5.0u
XF0_0 (r0_1 ck0 ckn0 rst0 allow0 r0_0 vdd vss) ring_c2k_r1_v14
XF0_1 (r0_0 ck0 ckn0 rst0 allow0 r0_1 vdd vss) ring_c2k_r0_v14
XSEL0 (r0_0 s0 o0 vdd vss) tx_and
XSI1 (s1 ns1 vdd vss) pll_inv
XRS1 (reset ns1 rst1 vdd vss) tx_or
XRE1 (rst1 allow1 vdd vss) pll_inv
XSE1 (allow1 ckb ckbank safe1 vdd vss) pll_latch
XGN1 (ckbank safe1 gn1 vdd vss) pll_nand2 wn=1u wp=1.25u
XGB01 (gn1 gb01 vdd vss) pll_inv wn=1u wp=2.5u
XGB11 (gb01 gb11 vdd vss) pll_inv wn=3u wp=7.5u
XGO1 (gb11 ck1 vdd vss) pll_inv wn=6u wp=15u
XCINV1 (ck1 ckn1 vdd vss) pll_inv wn=3u wp=7.5u
XF1_0 (r1_2 ck1 ckn1 rst1 allow1 r1_0 vdd vss) ring_c2k_r1_v14
XF1_1 (r1_0 ck1 ckn1 rst1 allow1 r1_1 vdd vss) ring_c2k_r1_v14
XF1_2 (r1_1 ck1 ckn1 rst1 allow1 r1_2 vdd vss) ring_c2k_r0_v14
XSEL1 (r1_0 s1 o1 vdd vss) tx_and
XSI2 (s2 ns2 vdd vss) pll_inv
XRS2 (reset ns2 rst2 vdd vss) tx_or
XRE2 (rst2 allow2 vdd vss) pll_inv
XSE2 (allow2 ckb ckbank safe2 vdd vss) pll_latch
XGN2 (ckbank safe2 gn2 vdd vss) pll_nand2 wn=1u wp=1.25u
XGB02 (gn2 gb02 vdd vss) pll_inv wn=1u wp=2.5u
XGB12 (gb02 gb12 vdd vss) pll_inv wn=4u wp=10.0u
XGO2 (gb12 ck2 vdd vss) pll_inv wn=8u wp=20u
XCINV2 (ck2 ckn2 vdd vss) pll_inv wn=4u wp=10.0u
XF2_0 (r2_3 ck2 ckn2 rst2 allow2 r2_0 vdd vss) ring_c2k_r1_v14
XF2_1 (r2_0 ck2 ckn2 rst2 allow2 r2_1 vdd vss) ring_c2k_r1_v14
XF2_2 (r2_1 ck2 ckn2 rst2 allow2 r2_2 vdd vss) ring_c2k_r0_v14
XF2_3 (r2_2 ck2 ckn2 rst2 allow2 r2_3 vdd vss) ring_c2k_r0_v14
XSEL2 (r2_0 s2 o2 vdd vss) tx_and
XSI3 (s3 ns3 vdd vss) pll_inv
XRS3 (reset ns3 rst3 vdd vss) tx_or
XRE3 (rst3 allow3 vdd vss) pll_inv
XSE3 (allow3 ckb ckbank safe3 vdd vss) pll_latch
XGN3 (ckbank safe3 gn3 vdd vss) pll_nand2 wn=1u wp=1.25u
XGB03 (gn3 gb03 vdd vss) pll_inv wn=1u wp=2.5u
XGB13 (gb03 gb13 vdd vss) pll_inv wn=5u wp=12.5u
XGO3 (gb13 ck3 vdd vss) pll_inv wn=10u wp=25u
XCINV3 (ck3 ckn3 vdd vss) pll_inv wn=5u wp=12.5u
XF3_0 (r3_4 ck3 ckn3 rst3 allow3 r3_0 vdd vss) ring_c2k_r1_v14
XF3_1 (r3_0 ck3 ckn3 rst3 allow3 r3_1 vdd vss) ring_c2k_r1_v14
XF3_2 (r3_1 ck3 ckn3 rst3 allow3 r3_2 vdd vss) ring_c2k_r1_v14
XF3_3 (r3_2 ck3 ckn3 rst3 allow3 r3_3 vdd vss) ring_c2k_r0_v14
XF3_4 (r3_3 ck3 ckn3 rst3 allow3 r3_4 vdd vss) ring_c2k_r0_v14
XSEL3 (r3_0 s3 o3 vdd vss) tx_and
XSI4 (s4 ns4 vdd vss) pll_inv
XRS4 (reset ns4 rst4 vdd vss) tx_or
XRE4 (rst4 allow4 vdd vss) pll_inv
XSE4 (allow4 ckb ckbank safe4 vdd vss) pll_latch
XGN4 (ckbank safe4 gn4 vdd vss) pll_nand2 wn=1u wp=1.25u
XGB04 (gn4 gb04 vdd vss) pll_inv wn=1u wp=2.5u
XGB14 (gb04 gb14 vdd vss) pll_inv wn=6u wp=15.0u
XGO4 (gb14 ck4 vdd vss) pll_inv wn=12u wp=30u
XCINV4 (ck4 ckn4 vdd vss) pll_inv wn=6u wp=15.0u
XF4_0 (r4_5 ck4 ckn4 rst4 allow4 r4_0 vdd vss) ring_c2k_r1_v14
XF4_1 (r4_0 ck4 ckn4 rst4 allow4 r4_1 vdd vss) ring_c2k_r1_v14
XF4_2 (r4_1 ck4 ckn4 rst4 allow4 r4_2 vdd vss) ring_c2k_r1_v14
XF4_3 (r4_2 ck4 ckn4 rst4 allow4 r4_3 vdd vss) ring_c2k_r0_v14
XF4_4 (r4_3 ck4 ckn4 rst4 allow4 r4_4 vdd vss) ring_c2k_r0_v14
XF4_5 (r4_4 ck4 ckn4 rst4 allow4 r4_5 vdd vss) ring_c2k_r0_v14
XSEL4 (r4_0 s4 o4 vdd vss) tx_and
XSI5 (s5 ns5 vdd vss) pll_inv
XRS5 (reset ns5 rst5 vdd vss) tx_or
XRE5 (rst5 allow5 vdd vss) pll_inv
XSE5 (allow5 ckb ckbank safe5 vdd vss) pll_latch
XGN5 (ckbank safe5 gn5 vdd vss) pll_nand2 wn=1u wp=1.25u
XGB05 (gn5 gb05 vdd vss) pll_inv wn=1u wp=2.5u
XGB15 (gb05 gb15 vdd vss) pll_inv wn=7u wp=17.5u
XGO5 (gb15 ck5 vdd vss) pll_inv wn=14u wp=35u
XCINV5 (ck5 ckn5 vdd vss) pll_inv wn=7u wp=17.5u
XF5_0 (r5_6 ck5 ckn5 rst5 allow5 r5_0 vdd vss) ring_c2k_r1_v14
XF5_1 (r5_0 ck5 ckn5 rst5 allow5 r5_1 vdd vss) ring_c2k_r1_v14
XF5_2 (r5_1 ck5 ckn5 rst5 allow5 r5_2 vdd vss) ring_c2k_r1_v14
XF5_3 (r5_2 ck5 ckn5 rst5 allow5 r5_3 vdd vss) ring_c2k_r1_v14
XF5_4 (r5_3 ck5 ckn5 rst5 allow5 r5_4 vdd vss) ring_c2k_r0_v14
XF5_5 (r5_4 ck5 ckn5 rst5 allow5 r5_5 vdd vss) ring_c2k_r0_v14
XF5_6 (r5_5 ck5 ckn5 rst5 allow5 r5_6 vdd vss) ring_c2k_r0_v14
XSEL5 (r5_0 s5 o5 vdd vss) tx_and
XOR1 (o0 o1 or1 vdd vss) tx_or
XOR2 (or1 o2 or2 vdd vss) tx_or
XOR3 (or2 o3 or3 vdd vss) tx_or
XOR4 (or3 o4 or4 vdd vss) tx_or
XOR5 (or4 o5 or5 vdd vss) tx_or
XRSTI (reset resetb vdd vss) pll_inv
XMUTE (or5 resetb out vdd vss) tx_and
ends cmos_even_bank_r6_v14
