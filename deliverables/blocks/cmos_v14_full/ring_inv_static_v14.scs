simulator lang=spectre
subckt ring_inv_latch_v14 (d ck ckb qb vdd vss)
XT (d x ck ckb vdd vss) pll_tg wn=1u wp=2u
XO (x qb vdd vss) pll_inv wn=2u wp=4u
XFI (qb fb vdd vss) pll_inv wn=0.5u wp=1u
XFB (fb x ckb ck vdd vss) pll_tg wn=0.5u wp=1u
ends ring_inv_latch_v14
subckt ring_inv_sync_v14 (d clk clkb load loadb init q vdd vss)
XDATA (d din loadb load vdd vss) pll_tg wn=2u wp=4u
XINIT (init din load loadb vdd vss) pll_tg wn=2u wp=4u
XM (din clkb clk qm vdd vss) ring_inv_latch_v14
XS (qm clk clkb q vdd vss) ring_inv_latch_v14
ends ring_inv_sync_v14
