`include "disciplines.vams"
`include "constants.vams"
// External RF phase perturbation fixture: phi volts equals RF radians.
module tank_replay_pm_v14(vp,vn,phi,vss);
output vp,vn;input phi,vss;electrical vp,vn,phi,vss;
parameter real frequency=3.936G;
parameter real phase_deg=0;
real theta;
analog begin
theta=2*`M_PI*frequency*$abstime+phase_deg*`M_PI/180+V(phi,vss);
V(vp,vss)<+1.191358743076886+(-0.1034836200523905)*cos(1*theta)+(0.3735453555532832)*sin(1*theta)+(0.03892475493803109)*cos(2*theta)+(0.006098155736310461)*sin(2*theta)+(-0.01200489790409878)*cos(3*theta)+(-0.002859095167985822)*sin(3*theta)+(0.004777404765383041)*cos(4*theta)+(0.006019662552585166)*sin(4*theta)+(0.0013544164484121)*cos(5*theta)+(-0.00378689906064168)*sin(5*theta)+(-0.0007270894893155996)*cos(6*theta)+(0.0008915133026798947)*sin(6*theta)+(0.0001980565398189783)*cos(7*theta)+(-0.0001746444969200507)*sin(7*theta)+(0.0001585737324962102)*cos(8*theta)+(0.0003105073966740959)*sin(8*theta)+(0.0002071599812438265)*cos(9*theta)+(-0.0001244318598838496)*sin(9*theta)+(-6.093357611178668e-05)*cos(10*theta)+(7.356695632278387e-05)*sin(10*theta)+(8.061302890014367e-05)*cos(11*theta)+(-2.959702827837396e-05)*sin(11*theta)+(-1.518111152883164e-05)*cos(12*theta)+(1.134874926742488e-05)*sin(12*theta)+(-8.227190023830473e-06)*cos(13*theta)+(2.943220286817347e-05)*sin(13*theta)+(9.547311645887887e-06)*cos(14*theta)+(1.561638960372518e-05)*sin(14*theta)+(5.912363845132312e-06)*cos(15*theta)+(-7.339911595471617e-06)*sin(15*theta)+(-1.537559201298211e-06)*cos(16*theta)+(3.52844685898451e-06)*sin(16*theta)+(5.334599935576112e-07)*cos(17*theta)+(-2.456515431535633e-06)*sin(17*theta)+(4.693065510071384e-06)*cos(18*theta)+(-2.807665548736418e-06)*sin(18*theta)+(2.250908074513669e-06)*cos(19*theta)+(-1.605461817122693e-08)*sin(19*theta)+(3.019299494422256e-06)*cos(20*theta)+(-3.339163189515493e-06)*sin(20*theta);
V(vn,vss)<+1.188686805216024+(-0.09267845137435718)*cos(1*theta)+(-0.4405724429005388)*sin(1*theta)+(0.02279665193092708)*cos(2*theta)+(0.02410538790163461)*sin(2*theta)+(0.004010952881786258)*cos(3*theta)+(0.006273405934760254)*sin(3*theta)+(0.001473021112384325)*cos(4*theta)+(0.005393410701619841)*sin(4*theta)+(-0.001972234187551476)*cos(5*theta)+(0.002950125912098961)*sin(5*theta)+(-0.0008223281784873927)*cos(6*theta)+(6.404156717766655e-05)*sin(6*theta)+(-0.0003335824109605725)*cos(7*theta)+(8.288308795655156e-05)*sin(7*theta)+(1.585440794613714e-05)*cos(8*theta)+(2.040039555593817e-05)*sin(8*theta)+(-0.0001735459434398431)*cos(9*theta)+(0.0002271314933125306)*sin(9*theta)+(-4.610348634370599e-05)*cos(10*theta)+(-3.564463138192363e-05)*sin(10*theta)+(-9.552155661721645e-05)*cos(11*theta)+(1.045349572055339e-05)*sin(11*theta)+(1.179346021306794e-05)*cos(12*theta)+(-4.727514986448163e-05)*sin(12*theta)+(-6.141619204714087e-06)*cos(13*theta)+(1.849535906742469e-05)*sin(13*theta)+(3.632432768837752e-06)*cos(14*theta)+(-4.720051774180508e-06)*sin(14*theta)+(-1.250340545637247e-05)*cos(15*theta)+(6.593916621234937e-06)*sin(15*theta)+(-5.356302275580436e-06)*cos(16*theta)+(-8.172374546889794e-06)*sin(16*theta)+(-5.636178983693153e-06)*cos(17*theta)+(6.304149439719658e-06)*sin(17*theta)+(1.2306738343109e-06)*cos(18*theta)+(-3.79536977687233e-06)*sin(18*theta)+(-1.72513497775223e-08)*cos(19*theta)+(-2.128843880140026e-06)*sin(19*theta)+(-1.684924149873007e-06)*cos(20*theta)+(1.236010214724845e-06)*sin(20*theta);
end
endmodule
