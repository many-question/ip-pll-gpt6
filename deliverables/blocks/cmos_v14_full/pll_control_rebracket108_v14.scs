simulator lang=spectre
// Sample phase qualification after the sampler has held for half a reference cycle.
// Shared-counter control assembly. phase_good is driven by the physical phase/envelope detector in the top DUT.
// frequency_good is an OUTPUT from the physical counter/watchdog.
// Include frequency_watchdog.scs in addition to the base dependencies.
// Include cells, digital_cells_v2, fll_circuit, pll_config, pll_supervisor,
// and cp_timing before this file. All below are MOS circuits except DAC resistors.
subckt pll_control_rebracket108_v14 (refclk reset apply k0 k1 k2 k3 k4 k5 outclk acqclk phase_good frequency_good b0 b1 b2 b3 b4 b5 b6 b7 s0 s1 s2 s3 s4 s5 divider_reset enable pulse preset qualified range_error config_ready config_invalid restart count_gate count_reset vdd vss)
XC (refclk reset apply k0 k1 k2 k3 k4 k5 ak0 ak1 ak2 ak3 ak4 ak5 s0 s1 s2 s3 s4 s5 config_ready config_invalid cfg_reset vdd vss) tx_pll_config
XR (cfg_reset restart fll_reset vdd vss) tx_or
XDRESET (cfg_reset restart divider_reset vdd vss) tx_or
XF (refclk fll_reset ak0 ak1 ak2 ak3 ak4 ak5 m0 m1 m2 m3 m4 m5 m6 m7 m8 m9 m10 m11 m12 m13 b0 b1 b2 b3 b4 b5 b6 b7 d0 d1 d2 d3 d4 d5 fll_gate fll_count_reset acquired range_error state0 state1 state2 vdd vss) tx_fll_rebracket108_v14
// acquired changes with counter gated off and reset asserted.
XACQI (acquired acquired_b vdd vss) pll_inv
XACQ0 (acqclk clock_mux acquired_b acquired vdd vss) pll_tg wn=1u wp=2u
XACQ1 (outclk clock_mux acquired acquired_b vdd vss) pll_tg wn=1u wp=2u
XACB0 (clock_mux clock_b vdd vss) pll_inv wn=1u wp=2u
XACB1 (clock_b count_clock vdd vss) pll_inv wn=2u wp=4u
XCOUNT (count_clock count_gate count_reset q0 q1 q2 q3 q4 q5 q6 q7 q8 q9 q10 q11 q12 q13 vdd vss) tx_fll_counter
XSN (count_gate q0 q1 q2 q3 q4 q5 q6 q7 q8 q9 q10 q11 q12 q13 m0 m1 m2 m3 m4 m5 m6 m7 m8 m9 m10 m11 m12 m13 vdd vss) tx_fll_snapshot
// DAC is disabled only by the physical acquisition controller after fine search.
XDAC (d0 d1 d2 d3 d4 d5 acquired preset vdd vss) tx_fll_dac
XPHCLK (refclk ref_fall vdd vss) pll_inv
XPH (phase_good ref_fall reset phase_held vdd vss) tx_dff_r0
XS (refclk reset config_ready acquired range_error phase_held frequency_good enable qualified restart fault vdd vss) tx_pll_supervisor_capture_v14
XP (refclk enable fll_reset pulse vdd vss) tx_cp_timing
// Acquired switches only while both gate sources are low and reset high.
XWG (fll_gate watch_gate acquired count_gate vdd vss) tx_mux
XWR (fll_count_reset watch_reset acquired count_reset vdd vss) tx_mux
XW (refclk fll_reset acquired ak0 ak1 ak2 ak3 ak4 ak5 m0 m1 m2 m3 m4 m5 m6 m7 m8 m9 m10 m11 m12 m13 watch_gate watch_reset frequency_good watchdog_valid vdd vss) tx_frequency_watchdog
ends pll_control_rebracket108_v14
