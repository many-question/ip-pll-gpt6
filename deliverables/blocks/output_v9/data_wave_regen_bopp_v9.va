`include "disciplines.vams"
`include "constants.vams"
// Diagnostic only: ideal replay of actual raw divider waveform, no source noise/impedance.
module data_wave_regen_bopp_v9(dp,dn,vss);
output dp,dn; input vss; electrical dp,dn,vss;
parameter real delay_s=0;
real theta;
analog begin
theta=2*`M_PI*984e6*($abstime-delay_s);
V(dp,vss)<+1.061543377729034+(0.05778467690921681)*cos(1*theta)+(-0.06889279170007197)*sin(1*theta)+(0.001250060722382636)*cos(2*theta)+(-0.003283048493717288)*sin(2*theta)+(0.0008549136325241239)*cos(3*theta)+(-0.01352369810323293)*sin(3*theta)+(0.003247729940413867)*cos(4*theta)+(0.007304466534537491)*sin(4*theta)+(0.002373275788855488)*cos(5*theta)+(-0.003318305224892779)*sin(5*theta)+(-0.0004416096108137262)*cos(6*theta)+(5.387285158664959e-05)*sin(6*theta)+(-0.001453646102761414)*cos(7*theta)+(-0.0001018081339051656)*sin(7*theta)+(0.002328568286151071)*cos(8*theta)+(-0.0003797358323402435)*sin(8*theta)+(0.0004035227007742116)*cos(9*theta)+(-7.895482639308279e-05)*sin(9*theta)+(-0.0001005017021661277)*cos(10*theta)+(-1.183440234906897e-06)*sin(10*theta)+(-0.0001037550546877767)*cos(11*theta)+(-0.0001967934663462587)*sin(11*theta)+(-0.001178941088688412)*cos(12*theta)+(-0.0002750802761095711)*sin(12*theta)+(-0.0001987666831456724)*cos(13*theta)+(0.000140773830588754)*sin(13*theta)+(7.574779312365867e-05)*cos(14*theta)+(-4.005425693118137e-05)*sin(14*theta)+(-4.316809521360128e-05)*cos(15*theta)+(3.283563057660614e-05)*sin(15*theta)+(0.0002440179940773973)*cos(16*theta)+(0.0004460757673314654)*sin(16*theta)+(7.665455867251263e-06)*cos(17*theta)+(2.970898343070191e-05)*sin(17*theta)+(-2.745546369544954e-05)*cos(18*theta)+(-2.745261521092507e-05)*sin(18*theta)+(3.939563976433653e-05)*cos(19*theta)+(-1.990872846193496e-05)*sin(19*theta)+(-2.493782183644736e-05)*cos(20*theta)+(-0.0001311431686890672)*sin(20*theta)+(-2.493684624616261e-05)*cos(21*theta)+(-1.966906443416759e-05)*sin(21*theta)+(6.399398606834872e-06)*cos(22*theta)+(2.305123384769311e-05)*sin(22*theta)+(-1.434292229474867e-05)*cos(23*theta)+(-9.714687651098297e-06)*sin(23*theta)+(-4.403992135155782e-05)*cos(24*theta)+(3.167577900421706e-05)*sin(24*theta)+(-4.195439625012714e-07)*cos(25*theta)+(6.798965070512968e-06)*sin(25*theta)+(8.212486945398763e-06)*cos(26*theta)+(-4.888874963406123e-06)*sin(26*theta)+(8.253654362070979e-06)*cos(27*theta)+(9.401693771758352e-06)*sin(27*theta)+(1.709262023672333e-05)*cos(28*theta)+(-5.097255204344152e-06)*sin(28*theta)+(4.103211988372552e-06)*cos(29*theta)+(-3.66278098525862e-06)*sin(29*theta)+(-2.266394712902414e-06)*cos(30*theta)+(9.824307687123074e-07)*sin(30*theta)+(3.903890451104127e-06)*cos(31*theta)+(-4.703044783461862e-06)*sin(31*theta)+(-7.329446096862486e-06)*cos(32*theta)+(-9.813882401010849e-06)*sin(32*theta)+(2.236708310228786e-07)*cos(33*theta)+(-2.248137830469479e-06)*sin(33*theta)+(1.571302774530169e-06)*cos(34*theta)+(1.090041724637782e-08)*sin(34*theta)+(-2.298403947992833e-06)*cos(35*theta)+(-1.349205751938171e-07)*sin(35*theta)+(2.342459754450828e-07)*cos(36*theta)+(2.24078664010587e-06)*sin(36*theta)+(-1.740010850323735e-06)*cos(37*theta)+(-7.257473139582507e-07)*sin(37*theta)+(-1.813753673346894e-06)*cos(38*theta)+(-1.451932816702802e-06)*sin(38*theta)+(-8.720147831743506e-07)*cos(39*theta)+(1.287899320490571e-06)*sin(39*theta)+(-7.986896689057795e-07)*cos(40*theta)+(-9.262177042567631e-07)*sin(40*theta)+(-1.120738274994015e-07)*cos(41*theta)+(1.77139546366841e-06)*sin(41*theta)+(-1.264660812909413e-06)*cos(42*theta)+(1.781025553421605e-06)*sin(42*theta)+(2.907852398519018e-07)*cos(43*theta)+(7.419954374475234e-07)*sin(43*theta)+(-2.612142263931723e-07)*cos(44*theta)+(2.232643718916121e-06)*sin(44*theta)+(9.619833250199972e-07)*cos(45*theta)+(-1.173241301898549e-07)*sin(45*theta)+(1.656816476117207e-06)*cos(46*theta)+(8.732404754515791e-07)*sin(46*theta)+(4.023708507471995e-07)*cos(47*theta)+(8.811540833535767e-09)*sin(47*theta)+(2.135562833848175e-06)*cos(48*theta)+(1.352699609756177e-07)*sin(48*theta)+(1.093498379142947e-07)*cos(49*theta)+(-1.255482480088642e-07)*sin(49*theta)+(4.789721048546382e-07)*cos(50*theta)+(-1.583538634539654e-06)*sin(50*theta)+(4.408231083600696e-07)*cos(51*theta)+(-3.607614199472724e-07)*sin(51*theta)+(-5.053327712930335e-07)*cos(52*theta)+(-1.017175270058952e-06)*sin(52*theta)+(3.374881223498803e-07)*cos(53*theta)+(-5.602162015056348e-07)*sin(53*theta)+(-1.042174254170926e-06)*cos(54*theta)+(-2.053152070442719e-07)*sin(54*theta)+(-4.790246170263501e-07)*cos(55*theta)+(-8.880677109791447e-07)*sin(55*theta)+(-2.374896350406008e-07)*cos(56*theta)+(6.414028948253029e-07)*sin(56*theta)+(-9.335975074030041e-07)*cos(57*theta)+(-2.743858134531956e-07)*sin(57*theta)+(-3.406695929502443e-08)*cos(58*theta)+(5.184890776071082e-07)*sin(58*theta)+(-7.967653918758265e-07)*cos(59*theta)+(7.203676139858058e-07)*sin(59*theta)+(-3.421062387469396e-08)*cos(60*theta)+(2.403064646086346e-07)*sin(60*theta)+(-5.882319647844997e-08)*cos(61*theta)+(8.874696632687924e-07)*sin(61*theta)+(-7.139565305536183e-08)*cos(62*theta)+(1.120600715035086e-07)*sin(62*theta)+(7.219420630213803e-07)*cos(63*theta)+(5.750385124231169e-07)*sin(63*theta);
V(dn,vss)<+1.06131192340816+(-0.05749248199280657)*cos(1*theta)+(0.06964994925204433)*sin(1*theta)+(0.001369926654659558)*cos(2*theta)+(-0.003355587773951482)*sin(2*theta)+(-0.0007252052706232808)*cos(3*theta)+(0.01360957289253083)*sin(3*theta)+(0.00328185301476909)*cos(4*theta)+(0.007318538551718148)*sin(4*theta)+(-0.002253038007171148)*cos(5*theta)+(0.003460138308314207)*sin(5*theta)+(-0.0004565976009324943)*cos(6*theta)+(5.610820995126853e-05)*sin(6*theta)+(0.001494607686926424)*cos(7*theta)+(0.0001173045735412575)*sin(7*theta)+(0.002249880443904355)*cos(8*theta)+(-0.0004083158402411231)*sin(8*theta)+(-0.0003810550666938405)*cos(9*theta)+(0.000105558061950487)*sin(9*theta)+(-0.000103764787541945)*cos(10*theta)+(-1.90041058095803e-06)*sin(10*theta)+(0.000106593851795595)*cos(11*theta)+(0.0001976125717151421)*sin(11*theta)+(-0.001185123885242937)*cos(12*theta)+(-0.000271473198255302)*sin(12*theta)+(0.0001979884895467178)*cos(13*theta)+(-0.0001441889404613063)*sin(13*theta)+(7.514906506876814e-05)*cos(14*theta)+(-3.996920497716681e-05)*sin(14*theta)+(4.083929203487039e-05)*cos(15*theta)+(-3.365993593613776e-05)*sin(15*theta)+(0.0002464722104551642)*cos(16*theta)+(0.000444761435077437)*sin(16*theta)+(-1.002407771024775e-05)*cos(17*theta)+(-2.970526269598689e-05)*sin(17*theta)+(-2.745156677786827e-05)*cos(18*theta)+(-2.749477841042875e-05)*sin(18*theta)+(-4.006028963323948e-05)*cos(19*theta)+(1.937745174864338e-05)*sin(19*theta)+(-2.533337508732106e-05)*cos(20*theta)+(-0.0001314613425513189)*sin(20*theta)+(2.509762242182272e-05)*cos(21*theta)+(1.979511977579704e-05)*sin(21*theta)+(6.528333127923278e-06)*cos(22*theta)+(2.337318401739537e-05)*sin(22*theta)+(1.450946198352352e-05)*cos(23*theta)+(9.343107236825126e-06)*sin(23*theta)+(-4.351846448444326e-05)*cos(24*theta)+(3.189152936481848e-05)*sin(24*theta)+(1.261424806522809e-07)*cos(25*theta)+(-7.167441448673649e-06)*sin(25*theta)+(8.370793347791778e-06)*cos(26*theta)+(-5.158524556551582e-06)*sin(26*theta)+(-8.152321693034208e-06)*cos(27*theta)+(-9.564204316089379e-06)*sin(27*theta)+(1.704580578114013e-05)*cos(28*theta)+(-5.273829639050098e-06)*sin(28*theta)+(-4.382807955427276e-06)*cos(29*theta)+(3.713002464998593e-06)*sin(29*theta)+(-2.337914063915509e-06)*cos(30*theta)+(9.059930436610553e-07)*sin(30*theta)+(-3.865248786048247e-06)*cos(31*theta)+(5.029079128936106e-06)*sin(31*theta)+(-7.574003377841053e-06)*cos(32*theta)+(-9.842233286979488e-06)*sin(32*theta)+(1.451168168461207e-07)*cos(33*theta)+(2.29478150609933e-06)*sin(33*theta)+(1.54099481809797e-06)*cos(34*theta)+(1.419989984291673e-07)*sin(34*theta)+(2.482451637224389e-06)*cos(35*theta)+(-6.244769784381024e-08)*sin(35*theta)+(2.925679447881263e-07)*cos(36*theta)+(2.264464918435661e-06)*sin(36*theta)+(1.802479115221502e-06)*cos(37*theta)+(5.322959302531173e-07)*sin(37*theta)+(-1.94086106529855e-06)*cos(38*theta)+(-1.52115366964838e-06)*sin(38*theta)+(8.133495795078957e-07)*cos(39*theta)+(-1.470493038758468e-06)*sin(39*theta)+(-8.222125328748567e-07)*cos(40*theta)+(-7.72564575560511e-07)*sin(40*theta)+(-1.389034994626971e-07)*cos(41*theta)+(-1.899844838464082e-06)*sin(41*theta)+(-1.123583626900527e-06)*cos(42*theta)+(1.889264398215314e-06)*sin(42*theta)+(-3.702993176803355e-07)*cos(43*theta)+(-5.712431728802614e-07)*sin(43*theta)+(-1.813000926085504e-07)*cos(44*theta)+(2.146778526254414e-06)*sin(44*theta)+(-8.900992679336315e-07)*cos(45*theta)+(1.889277856725173e-07)*sin(45*theta)+(1.776034551523272e-06)*cos(46*theta)+(8.120703108129999e-07)*sin(46*theta)+(-4.429105645163175e-07)*cos(47*theta)+(-1.031625484277591e-07)*sin(47*theta)+(2.149382291389595e-06)*cos(48*theta)+(-3.027226198236964e-08)*sin(48*theta)+(-8.784096734759213e-08)*cos(49*theta)+(2.076229499534109e-07)*sin(49*theta)+(2.772558832737493e-07)*cos(50*theta)+(-1.736464533371642e-06)*sin(50*theta)+(-3.785500213353591e-07)*cos(51*theta)+(3.968059857201851e-07)*sin(51*theta)+(-6.20068159920987e-07)*cos(52*theta)+(-8.886244103612422e-07)*sin(52*theta)+(-3.094458782506915e-07)*cos(53*theta)+(4.988911320824662e-07)*sin(53*theta)+(-1.033151848539597e-06)*cos(54*theta)+(-9.755793818310362e-08)*sin(54*theta)+(5.990524705281192e-07)*cos(55*theta)+(8.881853873473442e-07)*sin(55*theta)+(-2.268645058642048e-07)*cos(56*theta)+(6.351741283593961e-07)*sin(56*theta)+(1.000942903618542e-06)*cos(57*theta)+(1.151656509143203e-07)*sin(57*theta)+(3.405785353399379e-08)*cos(58*theta)+(5.825359029464235e-07)*sin(58*theta)+(6.671264394713121e-07)*cos(59*theta)+(-9.269282337686866e-07)*sin(59*theta)+(9.509207270280609e-09)*cos(60*theta)+(2.147786464613303e-07)*sin(60*theta)+(-7.836581745893424e-08)*cos(61*theta)+(-8.323797868883432e-07)*sin(61*theta)+(-8.705090939134685e-08)*cos(62*theta)+(5.698803138275806e-08)*sin(62*theta)+(-7.943031891798965e-07)*cos(63*theta)+(-4.956467395622093e-07)*sin(63*theta);
end
endmodule
