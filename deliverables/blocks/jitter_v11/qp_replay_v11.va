`include "disciplines.vams"
`include "constants.vams"
module qp_replay_v11(inp,vss);
output inp;input vss;electrical inp,vss;
real th;
analog begin
th=2*`M_PI*984e6*$abstime;
V(inp,vss)<+1.063141693528823+(0.03116133383857401)*cos(1*th)+(0.1021526890295893)*sin(1*th)+(-0.007356557679150017)*cos(2*th)+(-0.0004974304347004655)*sin(2*th)+(0.0181633688262909)*cos(3*th)+(0.02806503184644407)*sin(3*th)+(-0.0002930148824032738)*cos(4*th)+(-0.01251881326681354)*sin(4*th)+(0.007786925295366631)*cos(5*th)+(-0.009965434883127186)*sin(5*th)+(0.0009286190566905887)*cos(6*th)+(-6.323990503661967e-05)*sin(6*th)+(-0.0001530150066182678)*cos(7*th)+(-0.00747229975216883)*sin(7*th)+(0.003633958141292463)*cos(8*th)+(0.01207335311591774)*sin(8*th)+(0.001012585607294614)*cos(9*th)+(-0.001131550886081158)*sin(9*th)+(1.455314843976923e-05)*cos(10*th)+(-8.459525046720623e-05)*sin(10*th)+(-0.0003880424732006499)*cos(11*th)+(-0.00076663859533516)*sin(11*th)+(0.001296710161339195)*cos(12*th)+(0.0003885346610837898)*sin(12*th)+(0.0002307378887604565)*cos(13*th)+(0.0005577448723040339)*sin(13*th)+(-6.781254269118579e-05)*cos(14*th)+(0.0003355534002133782)*sin(14*th)+(0.0004360406408614857)*cos(15*th)+(-0.0001103041193773195)*sin(15*th)+(-0.0009445549404595336)*cos(16*th)+(9.818618329642408e-05)*sin(16*th)+(8.95657929602184e-05)*cos(17*th)+(0.0001091397103420978)*sin(17*th)+(0.0001067876449395996)*cos(18*th)+(3.878975311428977e-06)*sin(18*th)+(8.635595562455333e-05)*cos(19*th)+(-3.752511944012239e-05)*sin(19*th)+(-2.234913150397491e-05)*cos(20*th)+(0.0001397220310184268)*sin(20*th)+(-5.668835144055932e-05)*cos(21*th)+(3.215990553326102e-05)*sin(21*th)+(-5.07267542264012e-05)*cos(22*th)+(-1.853586863422542e-05)*sin(22*th)+(3.557989933869684e-05)*cos(23*th)+(4.567612812289658e-05)*sin(23*th)+(3.556583108717689e-06)*cos(24*th)+(-0.0001279827636102386)*sin(24*th)+(-1.860906682149911e-05)*cos(25*th)+(1.350856705605415e-05)*sin(25*th)+(7.233170130509784e-07)*cos(26*th)+(2.67423268012725e-05)*sin(26*th)+(1.165834052619223e-05)*cos(27*th)+(1.459766191408436e-05)*sin(27*th)+(-1.666277919998639e-05)*cos(28*th)+(-7.155157277434045e-06)*sin(28*th)+(-7.679640423556611e-06)*cos(29*th)+(-5.734522959804396e-06)*sin(29*th)+(3.978206190611656e-06)*cos(30*th)+(-9.625660262320529e-06)*sin(30*th)+(-4.888041816032902e-06)*cos(31*th)+(7.967784654992099e-06)*sin(31*th)+(1.992803832616056e-05)*cos(32*th)+(-1.596854683615643e-06)*sin(32*th)+(-2.648059712178102e-06)*cos(33*th)+(-3.354469428953565e-06)*sin(33*th)+(-6.510069679445839e-06)*cos(34*th)+(9.606469908591448e-07)*sin(34*th)+(-1.818445667368505e-06)*cos(35*th)+(2.981169952719819e-06)*sin(35*th)+(1.31327028936557e-06)*cos(36*th)+(-3.769120937203453e-06)*sin(36*th)+(5.862767011914187e-07)*cos(37*th)+(-1.549536621752764e-06)*sin(37*th)+(1.722388444244331e-06)*cos(38*th)+(6.050754426472666e-07)*sin(38*th)+(-1.968046556909407e-06)*cos(39*th)+(-1.100833350334445e-07)*sin(39*th)+(7.140635654924127e-07)*cos(40*th)+(2.22648481588364e-06)*sin(40*th)+(5.104254100643841e-07)*cos(41*th)+(-7.190298170118747e-07)*sin(41*th)+(-2.303327217219796e-07)*cos(42*th)+(-1.04568313596839e-06)*sin(42*th)+(-7.441851440146078e-07)*cos(43*th)+(-2.577712297183896e-07)*sin(43*th)+(4.415251005264605e-07)*cos(44*th)+(2.211987336927441e-07)*sin(44*th)+(4.014904556513811e-07)*cos(45*th)+(1.020067794741465e-07)*sin(45*th)+(8.945451434306137e-08)*cos(46*th)+(1.261657723036994e-07)*sin(46*th)+(-2.846593372424461e-07)*cos(47*th)+(-2.969062577918452e-07)*sin(47*th)+(-3.647759677808338e-07)*cos(48*th)+(2.557987428621235e-07)*sin(48*th)+(1.612124205755148e-07)*cos(49*th)+(-1.510208687353892e-08)*sin(49*th)+(1.078160792089603e-07)*cos(50*th)+(-7.065892926300879e-08)*sin(50*th)+(3.889064369118881e-08)*cos(51*th)+(-1.388700361144012e-07)*sin(51*th)+(-5.383753980937023e-09)*cos(52*th)+(2.048052550895356e-07)*sin(52*th)+(7.49212574034686e-09)*cos(53*th)+(6.353049455712907e-08)*sin(53*th)+(-2.034621165793119e-08)*cos(54*th)+(2.192160271327003e-08)*sin(54*th)+(1.044056144686445e-07)*cos(55*th)+(-4.955023776019522e-08)*sin(55*th)+(6.794238596337264e-09)*cos(56*th)+(6.406364511434427e-08)*sin(56*th)+(-5.801472832425912e-08)*cos(57*th)+(6.409165515029723e-08)*sin(57*th)+(4.7300677440825e-08)*cos(58*th)+(1.252321399575809e-08)*sin(58*th)+(4.543082502277716e-08)*cos(59*th)+(-3.959080356242485e-08)*sin(59*th)+(8.297468026604531e-09)*cos(60*th)+(6.406254697120578e-08)*sin(60*th)+(1.439676049851995e-08)*cos(61*th)+(3.452280489301782e-08)*sin(61*th)+(-1.364930648593454e-08)*cos(62*th)+(-2.728571694301681e-08)*sin(62*th)+(-8.835923870117592e-09)*cos(63*th)+(1.566781893403862e-09)*sin(63*th);
end
endmodule
