simulator lang=spectre
subckt rf_wide128_v13 (rf clk vdd vss)
C0 (rf g0) capacitor c=1p
R0 (g0 clk) resistor r=20k
X0 (g0 clk vdd vss) pll_inv wn=128u wp=320.0u
ends rf_wide128_v13
