simulator lang=spectre
include "div_fastff_v13.scs"
subckt divsingle4_v13 (clk q1 out vdd vss)
X0 (q0 clk q0 vdd vss) div_fastff_v13 scale=1
XB0 (q0 q1 vdd vss) pll_inv wn=4u wp=2u
X1 (q2 q1 q2 vdd vss) pll_tspc_inv
XB (q2 out vdd vss) pll_inv wn=2u wp=5u
ends divsingle4_v13
