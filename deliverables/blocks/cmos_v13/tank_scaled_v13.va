`include "disciplines.vams"
`include "constants.vams"
// Measured waveform replay, testbench only; ideal drive has no VCO impedance.
module tank_scaled_v13(vp,vn,vss);
output vp,vn; input vss; electrical vp,vn,vss;
parameter real amplitude=1; parameter real phase_deg=0; parameter real frequency=3.936G;
real theta;
analog begin
 theta=2*`M_PI*frequency*$abstime+phase_deg*`M_PI/180;
 V(vp,vss)<+1.195975085389418+amplitude*((0.002146129743206584)*cos(1*theta)+(0.1799428879730518)*sin(1*theta)+(0.01019198897991862)*cos(2*theta)+(0.003163380895620135)*sin(2*theta)+(-0.00212326010213662)*cos(3*theta)+(-0.002915517117109891)*sin(3*theta)+(0.0002436722765271113)*cos(4*theta)+(0.0006251705742142907)*sin(4*theta)+(-2.681638754559113e-06)*cos(5*theta)+(-0.0004847675785836829)*sin(5*theta)+(-2.133943765752078e-05)*cos(6*theta)+(5.047560303585413e-05)*sin(6*theta)+(3.275597608666428e-05)*cos(7*theta)+(-7.931627769522815e-05)*sin(7*theta)+(-1.4450977012317e-05)*cos(8*theta)+(-6.160427963453584e-06)*sin(8*theta)+(3.404604823439024e-06)*cos(9*theta)+(-1.144611831933212e-05)*sin(9*theta)+(-8.670666415092643e-06)*cos(10*theta)+(5.364707636005409e-07)*sin(10*theta)+(-4.662115250974637e-06)*cos(11*theta)+(3.279555615479116e-06)*sin(11*theta)+(-4.588170028738711e-06)*cos(12*theta)+(2.601785018941438e-06)*sin(12*theta)+(-1.370508626629791e-06)*cos(13*theta)+(4.139034598863077e-06)*sin(13*theta)+(-7.396244663843123e-07)*cos(14*theta)+(3.049779986431853e-06)*sin(14*theta)+(6.812556441814572e-07)*cos(15*theta)+(1.476289738860176e-06)*sin(15*theta)+(6.154432565066309e-07)*cos(16*theta)+(2.499428566958482e-06)*sin(16*theta)+(-2.322572476267624e-07)*cos(17*theta)+(1.120191984282875e-06)*sin(17*theta)+(-3.919838093816099e-07)*cos(18*theta)+(-1.624574578707994e-07)*sin(18*theta)+(-8.114082276973411e-07)*cos(19*theta)+(1.532053367568028e-06)*sin(19*theta)+(-9.526413633015933e-07)*cos(20*theta)+(1.408476559722094e-07)*sin(20*theta));
 V(vn,vss)<+1.195733868954054+amplitude*((-0.002037772130369328)*cos(1*theta)+(-0.1795396024743575)*sin(1*theta)+(0.01039140224183651)*cos(2*theta)+(0.003126345607086415)*sin(2*theta)+(0.002073970812653861)*cos(3*theta)+(0.002956858118509004)*sin(3*theta)+(0.0002811662073389821)*cos(4*theta)+(0.0006324345248793291)*sin(4*theta)+(-1.322860727931117e-05)*cos(5*theta)+(0.0004955858294607504)*sin(5*theta)+(-8.082383485240629e-06)*cos(6*theta)+(5.076498208239741e-05)*sin(6*theta)+(-3.697074095333889e-05)*cos(7*theta)+(8.498016207530231e-05)*sin(7*theta)+(-6.89132122430183e-06)*cos(8*theta)+(-6.615994396870519e-06)*sin(8*theta)+(-2.960730943841105e-06)*cos(9*theta)+(1.659125401788284e-05)*sin(9*theta)+(-3.627204378139736e-06)*cos(10*theta)+(3.728582380838116e-07)*sin(10*theta)+(5.731403048821278e-06)*cos(11*theta)+(1.84398885919455e-06)*sin(11*theta)+(-8.978878403543476e-07)*cos(12*theta)+(2.556569308330341e-06)*sin(12*theta)+(2.221898713664698e-06)*cos(13*theta)+(3.605511855828501e-07)*sin(13*theta)+(2.025090539924377e-06)*cos(14*theta)+(2.945065159144627e-06)*sin(14*theta)+(1.292631274888936e-07)*cos(15*theta)+(2.097836320102631e-06)*sin(15*theta)+(2.731805138203066e-06)*cos(16*theta)+(2.469473559291987e-06)*sin(16*theta)+(1.321046956914077e-06)*cos(17*theta)+(1.982207380888822e-06)*sin(17*theta)+(1.217540306562658e-06)*cos(18*theta)+(-4.649725473727048e-08)*sin(18*theta)+(2.019929094853598e-06)*cos(19*theta)+(1.096793803194248e-06)*sin(19*theta)+(3.168928157353202e-07)*cos(20*theta)+(1.333168209756403e-07)*sin(20*theta));
end
endmodule
