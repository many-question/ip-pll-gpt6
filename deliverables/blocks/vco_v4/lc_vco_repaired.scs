simulator lang=spectre
include "inductor_pi.scs"
include "lc_core_v4r.scs"
include "cap_bank_switched_v4.scs"
// Q and parasitics are provisional RLC assumptions. Bias reference stays ideal.
subckt tx_lc_vco_repaired (vp vn ctrl b0 b1 b2 b3 b4 b5 b6 b7 vdd vss)
parameters fixed_c=10f tank_l=2n series_r=6.8224303440060226 cscale=1 core_w=120u ibias=80u unit_c=4.4f unit_w=1.2u fine_w=4.5u boost_unit=500n
XL (vp vn b3 b4 b5 b6 b7 vdd vss) tx_lc_core_v4r tank_l=tank_l tank_r=series_r tank_c=fixed_c core_w=core_w ibias=ibias cscale=cscale boost_unit=boost_unit
XBP (vp b0 b1 b2 b3 b4 b5 b6 b7 vdd vss) tx_cap_bank_switched_v4 unit_c=unit_c unit_w=unit_w
XBN (vn b0 b1 b2 b3 b4 b5 b6 b7 vdd vss) tx_cap_bank_switched_v4 unit_c=unit_c unit_w=unit_w
CVP (vp ctrl) nmoscap lr=2u wr=fine_w mr=1
CVN (vn ctrl) nmoscap lr=2u wr=fine_w mr=1
ends tx_lc_vco_repaired
