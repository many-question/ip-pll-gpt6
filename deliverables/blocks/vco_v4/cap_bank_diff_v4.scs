simulator lang=spectre
// Differential capacitors share one NMOS bridge. The weak DC paths set
// bottom plates high when OFF and near ground when ON; all devices are PDK MOS.
subckt tx_cap_bank_diff_v4 (vp vn b0 b1 b2 b3 b4 b5 b6 b7 vdd vss)
parameters unit_c=6f unit_w=1.2u off_r=1Meg
CP0 (vp xp0) capacitor c=unit_c*1
CN0 (vn xn0) capacitor c=unit_c*1
M0 (xp0 b0 xn0 vss) nch w=unit_w*1 l=180n ad=unit_w*1*240n as=unit_w*1*240n pd=2*(unit_w*1+240n) ps=2*(unit_w*1+240n)
XI0 (b0 bb0 vdd vss) pll_inv wn=300n wp=750n
RP0 (xp0 bb0) resistor r=off_r
RN0 (xn0 bb0) resistor r=off_r
CP1 (vp xp1) capacitor c=unit_c*2
CN1 (vn xn1) capacitor c=unit_c*2
M1 (xp1 b1 xn1 vss) nch w=unit_w*2 l=180n ad=unit_w*2*240n as=unit_w*2*240n pd=2*(unit_w*2+240n) ps=2*(unit_w*2+240n)
XI1 (b1 bb1 vdd vss) pll_inv wn=300n wp=750n
RP1 (xp1 bb1) resistor r=off_r
RN1 (xn1 bb1) resistor r=off_r
CP2 (vp xp2) capacitor c=unit_c*4
CN2 (vn xn2) capacitor c=unit_c*4
M2 (xp2 b2 xn2 vss) nch w=unit_w*4 l=180n ad=unit_w*4*240n as=unit_w*4*240n pd=2*(unit_w*4+240n) ps=2*(unit_w*4+240n)
XI2 (b2 bb2 vdd vss) pll_inv wn=300n wp=750n
RP2 (xp2 bb2) resistor r=off_r
RN2 (xn2 bb2) resistor r=off_r
CP3 (vp xp3) capacitor c=unit_c*8
CN3 (vn xn3) capacitor c=unit_c*8
M3 (xp3 b3 xn3 vss) nch w=unit_w*8 l=180n ad=unit_w*8*240n as=unit_w*8*240n pd=2*(unit_w*8+240n) ps=2*(unit_w*8+240n)
XI3 (b3 bb3 vdd vss) pll_inv wn=300n wp=750n
RP3 (xp3 bb3) resistor r=off_r
RN3 (xn3 bb3) resistor r=off_r
CP4 (vp xp4) capacitor c=unit_c*16
CN4 (vn xn4) capacitor c=unit_c*16
M4 (xp4 b4 xn4 vss) nch w=unit_w*16 l=180n ad=unit_w*16*240n as=unit_w*16*240n pd=2*(unit_w*16+240n) ps=2*(unit_w*16+240n)
XI4 (b4 bb4 vdd vss) pll_inv wn=300n wp=750n
RP4 (xp4 bb4) resistor r=off_r
RN4 (xn4 bb4) resistor r=off_r
CP5 (vp xp5) capacitor c=unit_c*32
CN5 (vn xn5) capacitor c=unit_c*32
M5 (xp5 b5 xn5 vss) nch w=unit_w*32 l=180n ad=unit_w*32*240n as=unit_w*32*240n pd=2*(unit_w*32+240n) ps=2*(unit_w*32+240n)
XI5 (b5 bb5 vdd vss) pll_inv wn=300n wp=750n
RP5 (xp5 bb5) resistor r=off_r
RN5 (xn5 bb5) resistor r=off_r
CP6 (vp xp6) capacitor c=unit_c*64
CN6 (vn xn6) capacitor c=unit_c*64
M6 (xp6 b6 xn6 vss) nch w=unit_w*64 l=180n ad=unit_w*64*240n as=unit_w*64*240n pd=2*(unit_w*64+240n) ps=2*(unit_w*64+240n)
XI6 (b6 bb6 vdd vss) pll_inv wn=300n wp=750n
RP6 (xp6 bb6) resistor r=off_r
RN6 (xn6 bb6) resistor r=off_r
CP7 (vp xp7) capacitor c=unit_c*128
CN7 (vn xn7) capacitor c=unit_c*128
M7 (xp7 b7 xn7 vss) nch w=unit_w*128 l=180n ad=unit_w*128*240n as=unit_w*128*240n pd=2*(unit_w*128+240n) ps=2*(unit_w*128+240n)
XI7 (b7 bb7 vdd vss) pll_inv wn=300n wp=750n
RP7 (xp7 bb7) resistor r=off_r
RN7 (xn7 bb7) resistor r=off_r
ends tx_cap_bank_diff_v4
