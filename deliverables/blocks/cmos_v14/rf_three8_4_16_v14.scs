simulator lang=spectre
subckt rf_three8_4_16_v14 (rf clk vdd vss)
C0 (rf g0) capacitor c=4p
R0 (g0 r0) resistor r=20k
X0 (g0 r0 vdd vss) pll_inv wn=8u wp=20.0u
X1 (r0 r1 vdd vss) pll_inv wn=4u wp=10.0u
X2 (r1 clk vdd vss) pll_inv wn=16u wp=40.0u
ends rf_three8_4_16_v14
