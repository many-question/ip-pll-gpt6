simulator lang=spectre
// Dynamic transmission-gate master/slave first divide2; no stopclock retention claimed.
subckt div_tg1_v14 (clk q1 out vdd vss)
XC (clk clkb vdd vss) pll_inv wn=2u wp=5u
XM (qfb m clkb clk vdd vss) pll_tg wn=0.5u wp=1u
XMI (m mb vdd vss) pll_inv wn=0.5u wp=1.25u
XS (mb s clk clkb vdd vss) pll_tg wn=0.5u wp=1u
XSI (s q1 vdd vss) pll_inv wn=1u wp=2.5u
XFB (q1 qfb vdd vss) pll_inv wn=0.5u wp=1.25u
X1 (q2 q1 q2 vdd vss) pll_tspc_inv
XB (q2 out vdd vss) pll_inv wn=2u wp=5u
ends div_tg1_v14
