simulator lang=spectre
subckt rf_light24s15_v14 (rf clk vdd vss)
C0 (rf g0) capacitor c=4p
R0 (g0 clk) resistor r=20k
X0 (g0 clk vdd vss) pll_inv wn=24u wp=60.0u
ends rf_light24s15_v14
