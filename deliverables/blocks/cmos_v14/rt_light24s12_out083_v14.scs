simulator lang=spectre
subckt rt_light24s12_out083_v14 (data clk out vdd vss)
XFF (data clk qb vdd vss) rtcomb_ff_v13 scale=1.2
X0 (qb ob vdd vss) pll_inv wn=3u wp=0.5u
X1 (ob out vdd vss) pll_inv wn=0.8u wp=3u
ends rt_light24s12_out083_v14
