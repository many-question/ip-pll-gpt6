simulator lang=spectre
subckt ff_negative_v14 (d ck qb vdd vss)
MP0 (p0 d vss vss) nch w=0.8u l=180n ad=0.8u*240n as=0.8u*240n pd=2*(0.8u+240n) ps=2*(0.8u+240n)
MPC0 (b ck p0 vss) nch w=0.8u l=180n ad=0.8u*240n as=0.8u*240n pd=2*(0.8u+240n) ps=2*(0.8u+240n)
MN0 (b d vdd vdd) pch w=2u l=180n ad=2u*240n as=2u*240n pd=2*(2u+240n) ps=2*(2u+240n)
MP1 (a ck vss vss) nch w=0.8u l=180n ad=0.8u*240n as=0.8u*240n pd=2*(0.8u+240n) ps=2*(0.8u+240n)
MN1 (a b n1 vdd) pch w=4u l=180n ad=4u*240n as=4u*240n pd=2*(4u+240n) ps=2*(4u+240n)
MNC1 (n1 ck vdd vdd) pch w=4u l=180n ad=4u*240n as=4u*240n pd=2*(4u+240n) ps=2*(4u+240n)
MP2 (qb a vss vss) nch w=0.8u l=180n ad=0.8u*240n as=0.8u*240n pd=2*(0.8u+240n) ps=2*(0.8u+240n)
MNC2 (qb ck n2 vdd) pch w=4u l=180n ad=4u*240n as=4u*240n pd=2*(4u+240n) ps=2*(4u+240n)
MN2 (n2 a vdd vdd) pch w=4u l=180n ad=4u*240n as=4u*240n pd=2*(4u+240n) ps=2*(4u+240n)
ends ff_negative_v14
