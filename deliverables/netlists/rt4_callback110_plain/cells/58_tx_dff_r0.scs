simulator lang=spectre
subckt tx_dff_r0_pdk110_58 (d clk reset q vdd vss)
XC (clk clkb vdd vss) pll_inv_pdk110_59
XR (reset resetb vdd vss) pll_inv_pdk110_7
XM (d clkb clk resetb qm vdd vss) tx_latch_r_pdk110_60
XS (qm clk clkb resetb q vdd vss) tx_latch_r_pdk110_60
ends tx_dff_r0_pdk110_58
