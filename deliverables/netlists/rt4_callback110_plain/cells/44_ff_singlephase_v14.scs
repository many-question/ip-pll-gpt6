simulator lang=spectre
subckt ff_singlephase_v14_pdk110_44 (d clk clkb q vdd vss)
XF (d clk qb vdd vss) pll_tspc_inv_pdk110_25
XO (qb q vdd vss) pll_inv_pdk110_27
XK (q qb vdd vss) pll_inv_pdk110_45
ends ff_singlephase_v14_pdk110_44
