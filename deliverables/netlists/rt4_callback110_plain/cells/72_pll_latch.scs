simulator lang=spectre
subckt pll_latch_pdk110_72 (d gate gateb q vdd vss)
XT (d x gate gateb vdd vss) pll_tg_pdk110_61
XI (x qb vdd vss) pll_inv_pdk110_48
XO (qb q vdd vss) pll_inv_pdk110_62
XF (q x gateb gate vdd vss) pll_tg_pdk110_63
ends pll_latch_pdk110_72
