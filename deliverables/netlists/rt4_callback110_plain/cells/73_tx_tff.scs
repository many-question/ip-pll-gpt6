simulator lang=spectre
subckt tx_tff_pdk110_73 (clk reset q qb vdd vss)
XF (qb clk reset q vdd vss) tx_dff_r0_pdk110_58
XI (q qb vdd vss) pll_inv_pdk110_7
ends tx_tff_pdk110_73
