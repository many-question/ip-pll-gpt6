simulator lang=spectre
subckt tx_bias_mid_v5_pdk110_5 (vdd vss vmid)
R0 (vdd vmid) resistor r=100000
R1 (vmid vss) resistor r=100000
C0 (vmid vss) capacitor c=9.999999999999999e-12
ends tx_bias_mid_v5_pdk110_5
