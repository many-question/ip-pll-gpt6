simulator lang=spectre
subckt tx_cp_timing_pdk110_78 (ref enable reset pulse vdd vss)
XI (ref refb vdd vss) pll_inv_pdk110_7
XR (reset resetb vdd vss) pll_inv_pdk110_7
XE (enable refb ref resetb en_hold vdd vss) tx_latch_r_pdk110_60
XD0 (ref d1 vdd vss) pll_inv_pdk110_79
XD1 (d1 d2 vdd vss) pll_inv_pdk110_79
XD2 (d2 d3 vdd vss) pll_inv_pdk110_79
XD3 (d3 d4 vdd vss) pll_inv_pdk110_79
XD4 (d4 d5 vdd vss) pll_inv_pdk110_79
XD5 (d5 d6 vdd vss) pll_inv_pdk110_79
XD6 (d6 d7 vdd vss) pll_inv_pdk110_79
XD7 (d7 d8 vdd vss) pll_inv_pdk110_79
XD8 (d8 d9 vdd vss) pll_inv_pdk110_79
XD9 (d9 d10 vdd vss) pll_inv_pdk110_79
XD10 (d10 d11 vdd vss) pll_inv_pdk110_79
XD11 (d11 d12 vdd vss) pll_inv_pdk110_79
XD12 (d12 d13 vdd vss) pll_inv_pdk110_79
XD13 (d13 d14 vdd vss) pll_inv_pdk110_79
XD14 (d14 d15 vdd vss) pll_inv_pdk110_79
XD15 (d15 d16 vdd vss) pll_inv_pdk110_79
XD16 (d16 d17 vdd vss) pll_inv_pdk110_79
XD17 (d17 d18 vdd vss) pll_inv_pdk110_79
XD18 (d18 d19 vdd vss) pll_inv_pdk110_79
XD19 (d19 d20 vdd vss) pll_inv_pdk110_79
XD20 (d20 d21 vdd vss) pll_inv_pdk110_79
XD21 (d21 d22 vdd vss) pll_inv_pdk110_79
XD22 (d22 d23 vdd vss) pll_inv_pdk110_79
XD23 (d23 d24 vdd vss) pll_inv_pdk110_79
XN (d24 d24b vdd vss) pll_inv_pdk110_7
XP (d12 d24b raw vdd vss) tx_and_pdk110_47
XS (raw ref held vdd vss) tx_and_pdk110_47
XEN (held en_hold enabled vdd vss) tx_and_pdk110_47
XRESET (enabled resetb pulse vdd vss) tx_and_pdk110_47
ends tx_cp_timing_pdk110_78
