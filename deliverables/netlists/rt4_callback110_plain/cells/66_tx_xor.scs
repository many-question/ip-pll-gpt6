simulator lang=spectre
subckt tx_xor_pdk110_66 (a b y vdd vss)
XI (a ab vdd vss) pll_inv_pdk110_48
XM (a ab b y vdd vss) tx_mux_pdk110_64
ends tx_xor_pdk110_66
