simulator lang=spectre
subckt tx_reference_buffer_pdk110_6 (inp out vdd vss)
X0 (inp a vdd vss) pll_inv_pdk110_7
X1 (a b vdd vss) pll_inv_pdk110_8
X2 (b c vdd vss) pll_inv_pdk110_9
X3 (c out vdd vss) pll_inv_pdk110_10
ends tx_reference_buffer_pdk110_6
