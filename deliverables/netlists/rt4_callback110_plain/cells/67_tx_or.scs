simulator lang=spectre
subckt tx_or_pdk110_67 (a b y vdd vss)
XN (a b n vdd vss) pll_nor2_pdk110_68
XI (n y vdd vss) pll_inv_pdk110_48
ends tx_or_pdk110_67
