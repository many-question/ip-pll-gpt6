simulator lang=spectre
subckt tx_fll_recenter109_v14_pdk110_69 (refclk reset target_k0 target_k1 target_k2 target_k3 target_k4 target_k5 measured0 measured1 measured2 measured3 measured4 measured5 measured6 measured7 measured8 measured9 measured10 measured11 measured12 measured13 coarse0 coarse1 coarse2 coarse3 coarse4 coarse5 coarse6 coarse7 dac0 dac1 dac2 dac3 dac4 dac5 count_gate count_reset enable range_error state_out0 state_out1 state_out2 vdd vss)
X0 (n45 refclk reset dac0 vdd vss) tx_dff_r1_pdk110_70
X1 (n46 refclk reset dac1 vdd vss) tx_dff_r1_pdk110_70
X2 (n47 refclk reset dac2 vdd vss) tx_dff_r0_pdk110_58
X3 (n48 refclk reset dac3 vdd vss) tx_dff_r1_pdk110_70
X4 (n49 refclk reset dac4 vdd vss) tx_dff_r0_pdk110_58
X5 (n50 refclk reset n51 vdd vss) tx_dff_r0_pdk110_58
X6 (n52 refclk reset count_gate vdd vss) tx_dff_r0_pdk110_58
X7 (n53 refclk reset n54 vdd vss) tx_dff_r0_pdk110_58
X8 (n55 refclk reset count_reset vdd vss) tx_dff_r1_pdk110_70
X9 (n56 refclk reset dac5 vdd vss) tx_dff_r0_pdk110_58
X10 (n57 refclk reset n58 vdd vss) tx_dff_r0_pdk110_58
X11 (n59 refclk reset n60 vdd vss) tx_dff_r0_pdk110_58
X12 (n61 refclk reset n62 vdd vss) tx_dff_r0_pdk110_58
X13 (n63 refclk reset n64 vdd vss) tx_dff_r0_pdk110_58
X14 (n65 refclk reset n66 vdd vss) tx_dff_r0_pdk110_58
X15 (n67 refclk reset n68 vdd vss) tx_dff_r0_pdk110_58
X16 (n69 refclk reset n70 vdd vss) tx_dff_r0_pdk110_58
X17 (n71 refclk reset n72 vdd vss) tx_dff_r1_pdk110_70
X18 (n73 refclk reset enable vdd vss) tx_dff_r0_pdk110_58
X19 (n74 refclk reset n75 vdd vss) tx_dff_r1_pdk110_70
X20 (n76 refclk reset n77 vdd vss) tx_dff_r1_pdk110_70
X21 (n78 refclk reset n79 vdd vss) tx_dff_r0_pdk110_58
X22 (n80 refclk reset n81 vdd vss) tx_dff_r1_pdk110_70
X23 (n82 refclk reset n83 vdd vss) tx_dff_r0_pdk110_58
X24 (n84 refclk reset n85 vdd vss) tx_dff_r0_pdk110_58
X25 (n86 refclk reset range_error vdd vss) tx_dff_r0_pdk110_58
X26 (n87 refclk reset n88 vdd vss) tx_dff_r0_pdk110_58
X27 (n89 refclk reset state_out0 vdd vss) tx_dff_r0_pdk110_58
X28 (n90 refclk reset state_out1 vdd vss) tx_dff_r0_pdk110_58
X29 (n91 refclk reset state_out2 vdd vss) tx_dff_r0_pdk110_58
X30 (n92 refclk reset n93 vdd vss) tx_dff_r0_pdk110_58
X31 (n94 refclk reset n95 vdd vss) tx_dff_r0_pdk110_58
X32 (n96 refclk reset n97 vdd vss) tx_dff_r0_pdk110_58
X33 (n98 refclk reset n99 vdd vss) tx_dff_r0_pdk110_58
X34 (n100 refclk reset n101 vdd vss) tx_dff_r0_pdk110_58
X35 (n102 refclk reset n103 vdd vss) tx_dff_r0_pdk110_58
X36 (n104 refclk reset n105 vdd vss) tx_dff_r0_pdk110_58
X37 (n106 refclk reset n107 vdd vss) tx_dff_r0_pdk110_58
X38 (n108 refclk reset n109 vdd vss) tx_dff_r0_pdk110_58
X39 (n110 refclk reset n111 vdd vss) tx_dff_r0_pdk110_58
X40 (n112 refclk reset n113 vdd vss) tx_dff_r0_pdk110_58
X41 (n114 refclk reset n115 vdd vss) tx_dff_r0_pdk110_58
X42 (n116 refclk reset n117 vdd vss) tx_dff_r0_pdk110_58
X43 (n118 refclk reset coarse0 vdd vss) tx_dff_r0_pdk110_58
X44 (n119 refclk reset coarse1 vdd vss) tx_dff_r0_pdk110_58
X45 (n120 refclk reset coarse2 vdd vss) tx_dff_r0_pdk110_58
X46 (n121 refclk reset coarse3 vdd vss) tx_dff_r0_pdk110_58
X47 (n122 refclk reset coarse4 vdd vss) tx_dff_r0_pdk110_58
X48 (n123 refclk reset coarse5 vdd vss) tx_dff_r0_pdk110_58
X49 (n124 refclk reset coarse6 vdd vss) tx_dff_r0_pdk110_58
X50 (n125 refclk reset coarse7 vdd vss) tx_dff_r0_pdk110_58
X51 (n126 refclk reset n127 vdd vss) tx_dff_r1_pdk110_70
X52 (n128 refclk reset n129 vdd vss) tx_dff_r0_pdk110_58
X53 (n130 refclk reset n131 vdd vss) tx_dff_r1_pdk110_70
X54 (n132 refclk reset n133 vdd vss) tx_dff_r0_pdk110_58
X55 (n134 refclk reset n135 vdd vss) tx_dff_r1_pdk110_70
X56 (n136 refclk reset n137 vdd vss) tx_dff_r1_pdk110_70
X57 (n95 n138 n139 n94 vdd vss) tx_mux_pdk110_64
X58 (n93 n140 n139 n92 vdd vss) tx_mux_pdk110_64
X59 (state_out1 n141 n142 n90 vdd vss) tx_mux_pdk110_64
X60 (state_out0 n143 n142 n89 vdd vss) tx_mux_pdk110_64
X61 (n83 n144 n145 n82 vdd vss) tx_mux_pdk110_64
X62 (n81 n146 n145 n80 vdd vss) tx_mux_pdk110_64
X63 (n79 n147 n145 n78 vdd vss) tx_mux_pdk110_64
X64 (n77 n148 n145 n76 vdd vss) tx_mux_pdk110_64
X65 (n75 n149 n145 n74 vdd vss) tx_mux_pdk110_64
X66 (n70 n150 n151 n69 vdd vss) tx_mux_pdk110_64
X67 (n68 n152 n151 n67 vdd vss) tx_mux_pdk110_64
X68 (n66 n153 n151 n65 vdd vss) tx_mux_pdk110_64
X69 (n64 n154 n151 n63 vdd vss) tx_mux_pdk110_64
X70 (n62 n155 n151 n61 vdd vss) tx_mux_pdk110_64
X71 (n60 n156 n151 n59 vdd vss) tx_mux_pdk110_64
X72 (n58 n157 n151 n57 vdd vss) tx_mux_pdk110_64
X73 (dac4 n158 n159 n49 vdd vss) tx_mux_pdk110_64
X74 (dac3 n160 n159 n48 vdd vss) tx_mux_pdk110_64
X75 (dac2 n161 n159 n47 vdd vss) tx_mux_pdk110_64
X76 (dac1 n162 n159 n46 vdd vss) tx_mux_pdk110_64
X77 (dac0 n163 n159 n45 vdd vss) tx_mux_pdk110_64
X78 (n135 n164 n165 n134 vdd vss) tx_mux_pdk110_64
X79 (n133 n166 n165 n132 vdd vss) tx_mux_pdk110_64
X80 (n131 n167 n165 n130 vdd vss) tx_mux_pdk110_64
X81 (n129 n168 n165 n128 vdd vss) tx_mux_pdk110_64
X82 (n127 n169 n165 n126 vdd vss) tx_mux_pdk110_64
X83 (coarse6 n170 n171 n124 vdd vss) tx_mux_pdk110_64
X84 (coarse5 n172 n171 n123 vdd vss) tx_mux_pdk110_64
X85 (coarse4 n173 n171 n122 vdd vss) tx_mux_pdk110_64
X86 (coarse3 n174 n171 n121 vdd vss) tx_mux_pdk110_64
X87 (coarse2 n175 n171 n120 vdd vss) tx_mux_pdk110_64
X88 (coarse1 n176 n171 n119 vdd vss) tx_mux_pdk110_64
X89 (coarse0 n177 n171 n118 vdd vss) tx_mux_pdk110_64
X90 (n117 n178 n179 n116 vdd vss) tx_mux_pdk110_64
X91 (coarse7 n180 n171 n125 vdd vss) tx_mux_pdk110_64
X92 (n137 n181 n165 n136 vdd vss) tx_mux_pdk110_64
X93 (dac5 n182 n183 n56 vdd vss) tx_mux_pdk110_64
X94 (n51 vdd n184 n50 vdd vss) tx_mux_pdk110_64
X95 (count_gate n185 n186 n52 vdd vss) tx_mux_pdk110_64
X96 (n54 vdd n187 n53 vdd vss) tx_mux_pdk110_64
X97 (count_reset n188 n189 n55 vdd vss) tx_mux_pdk110_64
X98 (n72 n190 n151 n71 vdd vss) tx_mux_pdk110_64
X99 (enable n191 n192 n73 vdd vss) tx_mux_pdk110_64
X100 (n85 n193 n145 n84 vdd vss) tx_mux_pdk110_64
X101 (range_error n194 n195 n86 vdd vss) tx_mux_pdk110_64
X102 (n88 n196 n197 n87 vdd vss) tx_mux_pdk110_64
X103 (state_out2 n198 n142 n91 vdd vss) tx_mux_pdk110_64
X104 (n97 n199 n139 n96 vdd vss) tx_mux_pdk110_64
X105 (n115 n200 n201 n114 vdd vss) tx_mux_pdk110_64
X106 (n202 n111 n203 n110 vdd vss) tx_mux_pdk110_64
X107 (n204 n109 n203 n108 vdd vss) tx_mux_pdk110_64
X108 (n205 n107 n203 n106 vdd vss) tx_mux_pdk110_64
X109 (n206 n105 n203 n104 vdd vss) tx_mux_pdk110_64
X110 (n207 n103 n203 n102 vdd vss) tx_mux_pdk110_64
X111 (n208 n101 n203 n100 vdd vss) tx_mux_pdk110_64
X112 (n209 n99 n203 n98 vdd vss) tx_mux_pdk110_64
X113 (n210 n113 n203 n112 vdd vss) tx_mux_pdk110_64
X114 (dac3 n211 vdd vss) pll_inv_pdk110_7
X115 (n212 n213 vdd vss) pll_inv_pdk110_7
X116 (n214 n215 vdd vss) pll_inv_pdk110_7
X117 (n216 n217 vdd vss) pll_inv_pdk110_7
X118 (n218 n219 vdd vss) pll_inv_pdk110_7
X119 (n220 n221 vdd vss) pll_inv_pdk110_7
X120 (n222 n223 vdd vss) pll_inv_pdk110_7
X121 (target_k0 n224 vdd vss) pll_inv_pdk110_7
X122 (state_out1 n225 vdd vss) pll_inv_pdk110_7
X123 (state_out0 n226 vdd vss) pll_inv_pdk110_7
X124 (n58 n227 vdd vss) pll_inv_pdk110_7
X125 (n97 n228 vdd vss) pll_inv_pdk110_7
X126 (state_out2 n229 vdd vss) pll_inv_pdk110_7
X127 (n107 n230 vdd vss) pll_inv_pdk110_7
X128 (n88 n231 vdd vss) pll_inv_pdk110_7
X129 (n232 n233 vdd vss) pll_inv_pdk110_7
X130 (n234 n235 vdd vss) pll_inv_pdk110_7
X131 (n236 n237 vdd vss) pll_inv_pdk110_7
X132 (n238 n239 vdd vss) pll_inv_pdk110_7
X133 (n240 n241 vdd vss) pll_inv_pdk110_7
X134 (n117 n242 vdd vss) pll_inv_pdk110_7
X135 (n243 n244 vdd vss) pll_inv_pdk110_7
X136 (measured3 n245 vdd vss) pll_inv_pdk110_7
X137 (measured2 n246 vdd vss) pll_inv_pdk110_7
X138 (n247 n248 vdd vss) pll_inv_pdk110_7
X139 (n249 n250 vdd vss) pll_inv_pdk110_7
X140 (n251 n252 vdd vss) pll_inv_pdk110_7
X141 (n253 n254 vdd vss) pll_inv_pdk110_7
X142 (n255 n256 vdd vss) pll_inv_pdk110_7
X143 (n257 n258 vdd vss) pll_inv_pdk110_7
X144 (n259 n260 vdd vss) pll_inv_pdk110_7
X145 (n261 n262 vdd vss) pll_inv_pdk110_7
X146 (n263 n264 vdd vss) pll_inv_pdk110_7
X147 (n51 n265 vdd vss) pll_inv_pdk110_7
X148 (n99 n266 vdd vss) pll_inv_pdk110_7
X149 (dac0 n267 vdd vss) pll_inv_pdk110_7
X150 (target_k2 n268 vdd vss) pll_inv_pdk110_7
X151 (n269 n270 vdd vss) pll_inv_pdk110_7
X152 (n271 n272 vdd vss) pll_inv_pdk110_7
X153 (n273 n274 vdd vss) pll_inv_pdk110_7
X154 (n275 n276 vdd vss) pll_inv_pdk110_7
X155 (n277 n278 vdd vss) pll_inv_pdk110_7
X156 (n279 n280 vdd vss) pll_inv_pdk110_7
X157 (n281 n282 vdd vss) pll_inv_pdk110_7
X158 (n283 n284 vdd vss) pll_inv_pdk110_7
X159 (n285 n286 vdd vss) pll_inv_pdk110_7
X160 (n287 n288 vdd vss) pll_inv_pdk110_7
X161 (n289 n290 vdd vss) pll_inv_pdk110_7
X162 (n291 n292 vdd vss) pll_inv_pdk110_7
X163 (n293 n294 vdd vss) pll_inv_pdk110_7
X164 (coarse7 n295 vdd vss) pll_inv_pdk110_7
X165 (coarse0 n296 vdd vss) pll_inv_pdk110_7
X166 (coarse0 n227 n297 vdd vss) tx_and_pdk110_47
X167 (coarse1 n298 n299 vdd vss) tx_and_pdk110_47
X168 (coarse2 n300 n301 vdd vss) tx_and_pdk110_47
X169 (coarse3 n302 n303 vdd vss) tx_and_pdk110_47
X170 (coarse4 n304 n305 vdd vss) tx_and_pdk110_47
X171 (coarse5 n306 n307 vdd vss) tx_and_pdk110_47
X172 (coarse6 n308 n309 vdd vss) tx_and_pdk110_47
X173 (coarse7 n310 n311 vdd vss) tx_and_pdk110_47
X174 (dac0 n227 n312 vdd vss) tx_and_pdk110_47
X175 (dac1 n298 n313 vdd vss) tx_and_pdk110_47
X176 (dac2 n300 n314 vdd vss) tx_and_pdk110_47
X177 (dac3 n302 n315 vdd vss) tx_and_pdk110_47
X178 (dac4 n304 n316 vdd vss) tx_and_pdk110_47
X179 (dac5 n306 n317 vdd vss) tx_and_pdk110_47
X180 (n105 n88 n318 vdd vss) tx_xor_pdk110_66
X181 (n107 n88 n319 vdd vss) tx_xor_pdk110_66
X182 (n109 n117 n320 vdd vss) tx_xor_pdk110_66
X183 (n111 n117 n321 vdd vss) tx_xor_pdk110_66
X184 (n322 n60 n323 vdd vss) tx_or_pdk110_67
X185 (n251 n62 n324 vdd vss) tx_or_pdk110_67
X186 (n325 n64 n326 vdd vss) tx_or_pdk110_67
X187 (n327 n66 n328 vdd vss) tx_or_pdk110_67
X188 (n329 n68 n330 vdd vss) tx_or_pdk110_67
X189 (n331 n70 n332 vdd vss) tx_or_pdk110_67
X190 (n333 n72 n334 vdd vss) tx_or_pdk110_67
X191 (n335 n60 n336 vdd vss) tx_or_pdk110_67
X192 (n337 n62 n338 vdd vss) tx_or_pdk110_67
X193 (n339 n64 n340 vdd vss) tx_or_pdk110_67
X194 (n341 n66 n342 vdd vss) tx_or_pdk110_67
X195 (n343 n68 n344 vdd vss) tx_or_pdk110_67
X196 (n254 n345 n346 vdd vss) tx_or_pdk110_67
X197 (n250 n347 n348 vdd vss) tx_or_pdk110_67
X198 (n349 n350 n351 vdd vss) tx_or_pdk110_67
X199 (n352 n353 n354 vdd vss) tx_or_pdk110_67
X200 (dac1 dac0 n355 vdd vss) tx_xor_pdk110_66
X201 (dac2 n356 n357 vdd vss) tx_xor_pdk110_66
X202 (dac4 n358 n359 vdd vss) tx_xor_pdk110_66
X203 (dac5 n360 n361 vdd vss) tx_xor_pdk110_66
X204 (n362 n363 n364 vdd vss) tx_xor_pdk110_66
X205 (n365 n366 n367 vdd vss) tx_xor_pdk110_66
X206 (n368 n369 n370 vdd vss) tx_xor_pdk110_66
X207 (n371 n372 n373 vdd vss) tx_xor_pdk110_66
X208 (n374 n375 n376 vdd vss) tx_xor_pdk110_66
X209 (n377 n378 n379 vdd vss) tx_xor_pdk110_66
X210 (n380 n381 n212 vdd vss) tx_xor_pdk110_66
X211 (n382 n383 n216 vdd vss) tx_xor_pdk110_66
X212 (n384 n385 n214 vdd vss) tx_xor_pdk110_66
X213 (n386 n387 n218 vdd vss) tx_xor_pdk110_66
X214 (n388 n389 n220 vdd vss) tx_xor_pdk110_66
X215 (n213 n390 n391 vdd vss) tx_xor_pdk110_66
X216 (n217 n392 n393 vdd vss) tx_xor_pdk110_66
X217 (n215 n394 n395 vdd vss) tx_xor_pdk110_66
X218 (n219 n396 n397 vdd vss) tx_xor_pdk110_66
X219 (n221 n398 n399 vdd vss) tx_xor_pdk110_66
X220 (n223 n400 n401 vdd vss) tx_xor_pdk110_66
X221 (n402 n403 n404 vdd vss) tx_xor_pdk110_66
X222 (n246 n405 n406 vdd vss) tx_xor_pdk110_66
X223 (n245 n407 n408 vdd vss) tx_xor_pdk110_66
X224 (n409 n410 n411 vdd vss) tx_xor_pdk110_66
X225 (n412 n413 n414 vdd vss) tx_xor_pdk110_66
X226 (n415 n416 n417 vdd vss) tx_xor_pdk110_66
X227 (n418 n419 n420 vdd vss) tx_xor_pdk110_66
X228 (n421 n422 n423 vdd vss) tx_xor_pdk110_66
X229 (n424 n425 n426 vdd vss) tx_xor_pdk110_66
X230 (n427 n428 n429 vdd vss) tx_xor_pdk110_66
X231 (n430 n431 n432 vdd vss) tx_xor_pdk110_66
X232 (n433 n434 n435 vdd vss) tx_xor_pdk110_66
X233 (n436 n437 n438 vdd vss) tx_xor_pdk110_66
X234 (n439 n440 n441 vdd vss) tx_xor_pdk110_66
X235 (n442 n443 n444 vdd vss) tx_xor_pdk110_66
X236 (n445 n446 n447 vdd vss) tx_xor_pdk110_66
X237 (n448 n449 n450 vdd vss) tx_xor_pdk110_66
X238 (n451 n452 n453 vdd vss) tx_xor_pdk110_66
X239 (n454 n455 n456 vdd vss) tx_xor_pdk110_66
X240 (n457 n458 n459 vdd vss) tx_xor_pdk110_66
X241 (target_k5 n460 n461 vdd vss) tx_xor_pdk110_66
X242 (target_k1 target_k0 n462 vdd vss) tx_xor_pdk110_66
X243 (n463 n464 n465 vdd vss) tx_xor_pdk110_66
X244 (n466 n467 n468 vdd vss) tx_xor_pdk110_66
X245 (n469 n470 n471 vdd vss) tx_xor_pdk110_66
X246 (target_k4 n472 n473 vdd vss) tx_xor_pdk110_66
X247 (target_k5 n474 n475 vdd vss) tx_xor_pdk110_66
X248 (n454 n476 n477 vdd vss) tx_xor_pdk110_66
X249 (n457 n478 n479 vdd vss) tx_xor_pdk110_66
X250 (target_k5 n480 n481 vdd vss) tx_xor_pdk110_66
X251 (n482 n449 n483 vdd vss) tx_xor_pdk110_66
X252 (n484 n485 n486 vdd vss) tx_xor_pdk110_66
X253 (n487 n488 n489 vdd vss) tx_xor_pdk110_66
X254 (n490 n491 n492 vdd vss) tx_xor_pdk110_66
X255 (n479 n493 n494 vdd vss) tx_xor_pdk110_66
X256 (n481 n495 n496 vdd vss) tx_xor_pdk110_66
X257 (n497 n498 n499 vdd vss) tx_xor_pdk110_66
X258 (n500 dac0 n501 vdd vss) tx_xor_pdk110_66
X259 (n211 n502 n503 vdd vss) tx_xor_pdk110_66
X260 (n504 n505 n506 vdd vss) tx_xor_pdk110_66
X261 (n507 n508 n509 vdd vss) tx_xor_pdk110_66
X262 (n510 n511 n512 vdd vss) tx_xor_pdk110_66
X263 (n325 n251 n513 vdd vss) tx_xor_pdk110_66
X264 (n327 n514 n515 vdd vss) tx_xor_pdk110_66
X265 (n329 n516 n517 vdd vss) tx_xor_pdk110_66
X266 (n331 n518 n519 vdd vss) tx_xor_pdk110_66
X267 (n333 n520 n521 vdd vss) tx_xor_pdk110_66
X268 (n522 n523 n524 vdd vss) tx_xor_pdk110_66
X269 (coarse1 coarse0 n525 vdd vss) tx_xor_pdk110_66
X270 (coarse2 n526 n527 vdd vss) tx_xor_pdk110_66
X271 (coarse3 n528 n529 vdd vss) tx_xor_pdk110_66
X272 (coarse4 n530 n531 vdd vss) tx_xor_pdk110_66
X273 (coarse5 n532 n533 vdd vss) tx_xor_pdk110_66
X274 (coarse6 n534 n535 vdd vss) tx_xor_pdk110_66
X275 (coarse7 n536 n537 vdd vss) tx_xor_pdk110_66
X276 (n538 coarse0 n539 vdd vss) tx_xor_pdk110_66
X277 (n540 n541 n542 vdd vss) tx_xor_pdk110_66
X278 (n543 n544 n545 vdd vss) tx_xor_pdk110_66
X279 (n546 n547 n548 vdd vss) tx_xor_pdk110_66
X280 (n549 n550 n551 vdd vss) tx_xor_pdk110_66
X281 (n552 n553 n554 vdd vss) tx_xor_pdk110_66
X282 (n295 n555 n556 vdd vss) tx_xor_pdk110_66
X283 (n95 n93 n557 vdd vss) tx_xor_pdk110_66
X284 (n97 n558 n559 vdd vss) tx_xor_pdk110_66
X285 (n560 n561 n562 vdd vss) tx_xor_pdk110_66
X286 (n563 n564 n565 vdd vss) tx_xor_pdk110_66
X287 (n566 n567 n568 vdd vss) tx_xor_pdk110_66
X288 (n569 n570 n571 vdd vss) tx_xor_pdk110_66
X289 (n572 n573 n574 vdd vss) tx_xor_pdk110_66
X290 (n575 n576 n577 vdd vss) tx_xor_pdk110_66
X291 (n578 n579 n580 vdd vss) tx_xor_pdk110_66
X292 (dac3 n581 n582 vdd vss) tx_xor_pdk110_66
X293 (n101 n99 n583 vdd vss) tx_xor_pdk110_66
X294 (n103 n584 n585 vdd vss) tx_xor_pdk110_66
X295 (n105 n586 n587 vdd vss) tx_xor_pdk110_66
X296 (n107 n588 n589 vdd vss) tx_xor_pdk110_66
X297 (n109 n590 n591 vdd vss) tx_xor_pdk110_66
X298 (n111 n592 n593 vdd vss) tx_xor_pdk110_66
X299 (n113 n594 n595 vdd vss) tx_xor_pdk110_66
X300 (n596 n356 n358 vdd vss) tx_and_pdk110_47
X301 (dac4 n358 n360 vdd vss) tx_and_pdk110_47
X302 (n267 n127 n363 vdd vss) tx_and_pdk110_47
X303 (n355 n129 n597 vdd vss) tx_and_pdk110_47
X304 (n357 n131 n598 vdd vss) tx_and_pdk110_47
X305 (n582 n133 n599 vdd vss) tx_and_pdk110_47
X306 (n359 n135 n600 vdd vss) tx_and_pdk110_47
X307 (n361 n137 n601 vdd vss) tx_and_pdk110_47
X308 (n355 n129 n362 vdd vss) tx_xor_pdk110_66
X309 (n357 n131 n365 vdd vss) tx_xor_pdk110_66
X310 (n582 n133 n368 vdd vss) tx_xor_pdk110_66
X311 (n359 n135 n371 vdd vss) tx_xor_pdk110_66
X312 (n361 n137 n374 vdd vss) tx_xor_pdk110_66
X313 (n600 n602 n375 vdd vss) tx_or_pdk110_67
X314 (n598 n603 n369 vdd vss) tx_or_pdk110_67
X315 (n365 n366 n603 vdd vss) tx_and_pdk110_47
X316 (n604 n605 n378 vdd vss) tx_or_pdk110_67
X317 (n606 n372 n605 vdd vss) tx_and_pdk110_47
X318 (n607 n608 n372 vdd vss) tx_or_pdk110_67
X319 (n609 n366 n608 vdd vss) tx_and_pdk110_47
X320 (n374 n371 n606 vdd vss) tx_and_pdk110_47
X321 (n601 n610 n604 vdd vss) tx_or_pdk110_67
X322 (n374 n600 n610 vdd vss) tx_and_pdk110_47
X323 (n368 n365 n609 vdd vss) tx_and_pdk110_47
X324 (n599 n611 n607 vdd vss) tx_or_pdk110_67
X325 (n368 n598 n611 vdd vss) tx_and_pdk110_47
X326 (n371 n372 n602 vdd vss) tx_and_pdk110_47
X327 (n597 n612 n366 vdd vss) tx_or_pdk110_67
X328 (n362 n363 n612 vdd vss) tx_and_pdk110_47
X329 (n75 dac0 n381 vdd vss) tx_and_pdk110_47
X330 (n77 dac1 n613 vdd vss) tx_and_pdk110_47
X331 (n79 dac2 n614 vdd vss) tx_and_pdk110_47
X332 (n81 dac3 n615 vdd vss) tx_and_pdk110_47
X333 (n83 dac4 n616 vdd vss) tx_and_pdk110_47
X334 (n85 dac5 n617 vdd vss) tx_and_pdk110_47
X335 (n75 dac0 n390 vdd vss) tx_xor_pdk110_66
X336 (n77 dac1 n380 vdd vss) tx_xor_pdk110_66
X337 (n79 dac2 n382 vdd vss) tx_xor_pdk110_66
X338 (n81 dac3 n384 vdd vss) tx_xor_pdk110_66
X339 (n83 dac4 n386 vdd vss) tx_xor_pdk110_66
X340 (n85 dac5 n388 vdd vss) tx_xor_pdk110_66
X341 (n616 n618 n389 vdd vss) tx_or_pdk110_67
X342 (n614 n619 n385 vdd vss) tx_or_pdk110_67
X343 (n382 n383 n619 vdd vss) tx_and_pdk110_47
X344 (n620 n621 n222 vdd vss) tx_or_pdk110_67
X345 (n622 n387 n621 vdd vss) tx_and_pdk110_47
X346 (n623 n624 n387 vdd vss) tx_or_pdk110_67
X347 (n625 n383 n624 vdd vss) tx_and_pdk110_47
X348 (n388 n386 n622 vdd vss) tx_and_pdk110_47
X349 (n617 n626 n620 vdd vss) tx_or_pdk110_67
X350 (n388 n616 n626 vdd vss) tx_and_pdk110_47
X351 (n384 n382 n625 vdd vss) tx_and_pdk110_47
X352 (n615 n627 n623 vdd vss) tx_or_pdk110_67
X353 (n384 n614 n627 vdd vss) tx_and_pdk110_47
X354 (n386 n387 n618 vdd vss) tx_and_pdk110_47
X355 (n613 n628 n383 vdd vss) tx_or_pdk110_67
X356 (n380 n381 n628 vdd vss) tx_and_pdk110_47
X357 (n218 n629 n398 vdd vss) tx_or_pdk110_67
X358 (n216 n630 n394 vdd vss) tx_or_pdk110_67
X359 (n217 n392 n630 vdd vss) tx_and_pdk110_47
X360 (n631 n632 n400 vdd vss) tx_or_pdk110_67
X361 (n633 n396 n632 vdd vss) tx_and_pdk110_47
X362 (n634 n635 n396 vdd vss) tx_or_pdk110_67
X363 (n636 n392 n635 vdd vss) tx_and_pdk110_47
X364 (n221 n219 n633 vdd vss) tx_and_pdk110_47
X365 (n220 n637 n631 vdd vss) tx_or_pdk110_67
X366 (n221 n218 n637 vdd vss) tx_and_pdk110_47
X367 (n215 n217 n636 vdd vss) tx_and_pdk110_47
X368 (n214 n638 n634 vdd vss) tx_or_pdk110_67
X369 (n215 n216 n638 vdd vss) tx_and_pdk110_47
X370 (n219 n396 n629 vdd vss) tx_and_pdk110_47
X371 (n212 n639 n392 vdd vss) tx_or_pdk110_67
X372 (n213 n390 n639 vdd vss) tx_and_pdk110_47
X373 (n640 n641 n642 vdd vss) tx_and_pdk110_47
X374 (n643 n644 n645 vdd vss) tx_and_pdk110_47
X375 (n646 n647 n648 vdd vss) tx_and_pdk110_47
X376 (n649 n650 n651 vdd vss) tx_and_pdk110_47
X377 (n652 n653 n654 vdd vss) tx_and_pdk110_47
X378 (n655 n656 n657 vdd vss) tx_and_pdk110_47
X379 (n658 n659 n660 vdd vss) tx_and_pdk110_47
X380 (n661 n662 n663 vdd vss) tx_and_pdk110_47
X381 (n664 n665 n666 vdd vss) tx_and_pdk110_47
X382 (n640 n641 n409 vdd vss) tx_xor_pdk110_66
X383 (n643 n644 n412 vdd vss) tx_xor_pdk110_66
X384 (n646 n647 n415 vdd vss) tx_xor_pdk110_66
X385 (n649 n650 n418 vdd vss) tx_xor_pdk110_66
X386 (n652 n653 n421 vdd vss) tx_xor_pdk110_66
X387 (n655 n656 n424 vdd vss) tx_xor_pdk110_66
X388 (n658 n659 n427 vdd vss) tx_xor_pdk110_66
X389 (n661 n662 n430 vdd vss) tx_xor_pdk110_66
X390 (n664 n665 n433 vdd vss) tx_xor_pdk110_66
X391 (n667 n668 n436 vdd vss) tx_xor_pdk110_66
X392 (n642 n669 n413 vdd vss) tx_or_pdk110_67
X393 (n409 n410 n669 vdd vss) tx_and_pdk110_47
X394 (n654 n670 n425 vdd vss) tx_or_pdk110_67
X395 (n246 n405 n407 vdd vss) tx_and_pdk110_47
X396 (n648 n671 n419 vdd vss) tx_or_pdk110_67
X397 (n427 n428 n672 vdd vss) tx_and_pdk110_47
X398 (n673 n674 n428 vdd vss) tx_or_pdk110_67
X399 (n675 n422 n674 vdd vss) tx_and_pdk110_47
X400 (n660 n672 n431 vdd vss) tx_or_pdk110_67
X401 (n676 n677 n416 vdd vss) tx_or_pdk110_67
X402 (n678 n410 n677 vdd vss) tx_and_pdk110_47
X403 (n415 n416 n671 vdd vss) tx_and_pdk110_47
X404 (n679 n680 n434 vdd vss) tx_or_pdk110_67
X405 (n681 n422 n680 vdd vss) tx_and_pdk110_47
X406 (n433 n434 n682 vdd vss) tx_and_pdk110_47
X407 (n683 n684 n422 vdd vss) tx_or_pdk110_67
X408 (n685 n410 n684 vdd vss) tx_and_pdk110_47
X409 (n686 n675 n681 vdd vss) tx_and_pdk110_47
X410 (n687 n688 n679 vdd vss) tx_or_pdk110_67
X411 (n686 n673 n688 vdd vss) tx_and_pdk110_47
X412 (n689 n678 n685 vdd vss) tx_and_pdk110_47
X413 (n690 n691 n683 vdd vss) tx_or_pdk110_67
X414 (n689 n676 n691 vdd vss) tx_and_pdk110_47
X415 (n666 n682 n437 vdd vss) tx_or_pdk110_67
X416 (n430 n427 n686 vdd vss) tx_and_pdk110_47
X417 (n663 n692 n687 vdd vss) tx_or_pdk110_67
X418 (n430 n660 n692 vdd vss) tx_and_pdk110_47
X419 (n424 n421 n675 vdd vss) tx_and_pdk110_47
X420 (n657 n693 n673 vdd vss) tx_or_pdk110_67
X421 (n424 n654 n693 vdd vss) tx_and_pdk110_47
X422 (n418 n415 n689 vdd vss) tx_and_pdk110_47
X423 (n651 n694 n690 vdd vss) tx_or_pdk110_67
X424 (n418 n648 n694 vdd vss) tx_and_pdk110_47
X425 (n412 n409 n678 vdd vss) tx_and_pdk110_47
X426 (n645 n695 n676 vdd vss) tx_or_pdk110_67
X427 (n412 n642 n695 vdd vss) tx_and_pdk110_47
X428 (n421 n422 n670 vdd vss) tx_and_pdk110_47
X429 (measured4 n696 n697 vdd vss) tx_and_pdk110_47
X430 (measured5 n698 n442 vdd vss) tx_xor_pdk110_66
X431 (measured7 n699 n504 vdd vss) tx_xor_pdk110_66
X432 (measured12 n700 n566 vdd vss) tx_xor_pdk110_66
X433 (measured5 n698 n701 vdd vss) tx_and_pdk110_47
X434 (measured11 n702 n703 vdd vss) tx_and_pdk110_47
X435 (measured12 n700 n704 vdd vss) tx_and_pdk110_47
X436 (measured11 n702 n510 vdd vss) tx_xor_pdk110_66
X437 (n705 n706 n564 vdd vss) tx_or_pdk110_67
X438 (n707 n708 n508 vdd vss) tx_or_pdk110_67
X439 (n709 n710 n511 vdd vss) tx_or_pdk110_67
X440 (n566 n567 n711 vdd vss) tx_and_pdk110_47
X441 (n712 n713 n561 vdd vss) tx_or_pdk110_67
X442 (n704 n711 n570 vdd vss) tx_or_pdk110_67
X443 (n714 n715 n440 vdd vss) tx_or_pdk110_67
X444 (n569 n566 n716 vdd vss) tx_and_pdk110_47
X445 (n703 n717 n718 vdd vss) tx_or_pdk110_67
X446 (n563 n560 n719 vdd vss) tx_and_pdk110_47
X447 (n720 n721 n707 vdd vss) tx_or_pdk110_67
X448 (n722 n723 n724 vdd vss) tx_or_pdk110_67
X449 (n442 n439 n725 vdd vss) tx_and_pdk110_47
X450 (n701 n726 n727 vdd vss) tx_or_pdk110_67
X451 (n245 measured2 n728 vdd vss) tx_and_pdk110_47
X452 (n560 n561 n706 vdd vss) tx_and_pdk110_47
X453 (target_k4 target_k5 n729 vdd vss) tx_and_pdk110_47
X454 (target_k1 target_k2 n448 vdd vss) tx_xor_pdk110_66
X455 (target_k2 target_k3 n451 vdd vss) tx_xor_pdk110_66
X456 (target_k3 target_k4 n454 vdd vss) tx_xor_pdk110_66
X457 (target_k4 target_k5 n457 vdd vss) tx_xor_pdk110_66
X458 (n730 n731 n458 vdd vss) tx_or_pdk110_67
X459 (n732 n733 n452 vdd vss) tx_or_pdk110_67
X460 (target_k5 n460 n734 vdd vss) tx_and_pdk110_47
X461 (n735 n736 n460 vdd vss) tx_or_pdk110_67
X462 (n737 n455 n736 vdd vss) tx_and_pdk110_47
X463 (n448 n449 n733 vdd vss) tx_and_pdk110_47
X464 (n738 n739 n455 vdd vss) tx_or_pdk110_67
X465 (n740 n449 n739 vdd vss) tx_and_pdk110_47
X466 (n457 n454 n737 vdd vss) tx_and_pdk110_47
X467 (n729 n741 n735 vdd vss) tx_or_pdk110_67
X468 (n457 n730 n741 vdd vss) tx_and_pdk110_47
X469 (n451 n448 n740 vdd vss) tx_and_pdk110_47
X470 (n742 n743 n738 vdd vss) tx_or_pdk110_67
X471 (n451 n732 n743 vdd vss) tx_and_pdk110_47
X472 (n454 n455 n731 vdd vss) tx_and_pdk110_47
X473 (target_k5 n744 n263 vdd vss) tx_or_pdk110_67
X474 (n745 n746 n744 vdd vss) tx_and_pdk110_47
X475 (n747 target_k4 n745 vdd vss) tx_and_pdk110_47
X476 (n745 n748 n749 vdd vss) tx_and_pdk110_47
X477 (target_k5 n749 n261 vdd vss) tx_or_pdk110_67
X478 (n750 n751 n748 vdd vss) tx_or_pdk110_67
X479 (n752 target_k1 n751 vdd vss) tx_and_pdk110_47
X480 (target_k3 n753 n750 vdd vss) tx_or_pdk110_67
X481 (n754 target_k2 n753 vdd vss) tx_and_pdk110_47
X482 (target_k0 target_k2 n464 vdd vss) tx_and_pdk110_47
X483 (target_k1 target_k3 n755 vdd vss) tx_and_pdk110_47
X484 (target_k2 target_k4 n756 vdd vss) tx_and_pdk110_47
X485 (target_k3 target_k5 n757 vdd vss) tx_and_pdk110_47
X486 (target_k0 target_k2 n758 vdd vss) tx_xor_pdk110_66
X487 (target_k1 target_k3 n463 vdd vss) tx_xor_pdk110_66
X488 (target_k2 target_k4 n466 vdd vss) tx_xor_pdk110_66
X489 (target_k3 target_k5 n469 vdd vss) tx_xor_pdk110_66
X490 (n756 n759 n470 vdd vss) tx_or_pdk110_67
X491 (target_k4 n472 n474 vdd vss) tx_and_pdk110_47
X492 (n760 n761 n472 vdd vss) tx_or_pdk110_67
X493 (n762 n467 n761 vdd vss) tx_and_pdk110_47
X494 (n763 n764 n765 vdd vss) tx_or_pdk110_67
X495 (n766 n467 n764 vdd vss) tx_and_pdk110_47
X496 (n729 n762 n766 vdd vss) tx_and_pdk110_47
X497 (n729 n760 n763 vdd vss) tx_and_pdk110_47
X498 (n469 n466 n762 vdd vss) tx_and_pdk110_47
X499 (n757 n767 n760 vdd vss) tx_or_pdk110_67
X500 (n469 n756 n767 vdd vss) tx_and_pdk110_47
X501 (n755 n768 n467 vdd vss) tx_or_pdk110_67
X502 (n463 n464 n768 vdd vss) tx_and_pdk110_47
X503 (n466 n467 n759 vdd vss) tx_and_pdk110_47
X504 (n769 n770 n771 vdd vss) tx_and_pdk110_47
X505 (n772 n771 n259 vdd vss) tx_or_pdk110_67
X506 (n742 n773 n770 vdd vss) tx_and_pdk110_47
X507 (target_k5 n745 n772 vdd vss) tx_or_pdk110_67
X508 (target_k1 n774 n773 vdd vss) tx_or_pdk110_67
X509 (target_k1 target_k2 n732 vdd vss) tx_and_pdk110_47
X510 (target_k3 target_k4 n730 vdd vss) tx_and_pdk110_47
X511 (n742 n775 n476 vdd vss) tx_or_pdk110_67
X512 (n457 n478 n776 vdd vss) tx_and_pdk110_47
X513 (n777 n778 n478 vdd vss) tx_or_pdk110_67
X514 (n779 n452 n778 vdd vss) tx_and_pdk110_47
X515 (n729 n776 n480 vdd vss) tx_or_pdk110_67
X516 (n780 n781 n497 vdd vss) tx_or_pdk110_67
X517 (n782 n452 n781 vdd vss) tx_and_pdk110_47
X518 (n783 n779 n782 vdd vss) tx_and_pdk110_47
X519 (n784 n785 n780 vdd vss) tx_or_pdk110_67
X520 (n783 n777 n785 vdd vss) tx_and_pdk110_47
X521 (target_k5 n457 n783 vdd vss) tx_and_pdk110_47
X522 (target_k5 n729 n784 vdd vss) tx_and_pdk110_47
X523 (n454 n451 n779 vdd vss) tx_and_pdk110_47
X524 (n730 n786 n777 vdd vss) tx_or_pdk110_67
X525 (n454 n742 n786 vdd vss) tx_and_pdk110_47
X526 (n451 n452 n775 vdd vss) tx_and_pdk110_47
X527 (n772 n787 n257 vdd vss) tx_or_pdk110_67
X528 (n769 n746 n787 vdd vss) tx_and_pdk110_47
X529 (n742 n788 n746 vdd vss) tx_or_pdk110_67
X530 (target_k0 target_k1 n449 vdd vss) tx_and_pdk110_47
X531 (n462 target_k2 n789 vdd vss) tx_and_pdk110_47
X532 (n450 target_k3 n790 vdd vss) tx_and_pdk110_47
X533 (n453 target_k4 n791 vdd vss) tx_and_pdk110_47
X534 (n477 target_k5 n792 vdd vss) tx_and_pdk110_47
X535 (n462 target_k2 n482 vdd vss) tx_xor_pdk110_66
X536 (n450 target_k3 n484 vdd vss) tx_xor_pdk110_66
X537 (n453 target_k4 n487 vdd vss) tx_xor_pdk110_66
X538 (n477 target_k5 n490 vdd vss) tx_xor_pdk110_66
X539 (n791 n793 n491 vdd vss) tx_or_pdk110_67
X540 (n789 n794 n485 vdd vss) tx_or_pdk110_67
X541 (n479 n493 n495 vdd vss) tx_and_pdk110_47
X542 (n795 n796 n493 vdd vss) tx_or_pdk110_67
X543 (n797 n488 n796 vdd vss) tx_and_pdk110_47
X544 (n482 n449 n794 vdd vss) tx_and_pdk110_47
X545 (n798 n799 n498 vdd vss) tx_or_pdk110_67
X546 (n800 n488 n799 vdd vss) tx_and_pdk110_47
X547 (n497 n498 n801 vdd vss) tx_and_pdk110_47
X548 (n802 n797 n800 vdd vss) tx_and_pdk110_47
X549 (n802 n795 n798 vdd vss) tx_and_pdk110_47
X550 (n803 n804 n488 vdd vss) tx_or_pdk110_67
X551 (n805 n449 n804 vdd vss) tx_and_pdk110_47
X552 (n481 n479 n802 vdd vss) tx_and_pdk110_47
X553 (n490 n487 n797 vdd vss) tx_and_pdk110_47
X554 (n792 n806 n795 vdd vss) tx_or_pdk110_67
X555 (n490 n791 n806 vdd vss) tx_and_pdk110_47
X556 (n484 n482 n805 vdd vss) tx_and_pdk110_47
X557 (n790 n807 n803 vdd vss) tx_or_pdk110_67
X558 (n484 n789 n807 vdd vss) tx_and_pdk110_47
X559 (n487 n488 n793 vdd vss) tx_and_pdk110_47
X560 (n808 n809 n255 vdd vss) tx_or_pdk110_67
X561 (n810 n358 n809 vdd vss) tx_and_pdk110_47
X562 (n578 n575 n810 vdd vss) tx_and_pdk110_47
X563 (dac5 n811 n808 vdd vss) tx_or_pdk110_67
X564 (n578 dac4 n811 vdd vss) tx_and_pdk110_47
X565 (n572 n573 n812 vdd vss) tx_and_pdk110_47
X566 (n813 n576 n253 vdd vss) tx_and_pdk110_47
X567 (n814 n573 n815 vdd vss) tx_and_pdk110_47
X568 (dac5 dac4 n813 vdd vss) tx_and_pdk110_47
X569 (measured8 n816 n705 vdd vss) tx_and_pdk110_47
X570 (measured9 n817 n720 vdd vss) tx_and_pdk110_47
X571 (measured10 n818 n709 vdd vss) tx_and_pdk110_47
X572 (measured8 n816 n560 vdd vss) tx_xor_pdk110_66
X573 (measured10 n818 n507 vdd vss) tx_xor_pdk110_66
X574 (n697 n819 n443 vdd vss) tx_or_pdk110_67
X575 (n820 n821 n505 vdd vss) tx_or_pdk110_67
X576 (n822 n823 n824 vdd vss) tx_or_pdk110_67
X577 (n716 n567 n823 vdd vss) tx_and_pdk110_47
X578 (n507 n508 n710 vdd vss) tx_and_pdk110_47
X579 (n719 n561 n708 vdd vss) tx_and_pdk110_47
X580 (n727 n825 n446 vdd vss) tx_or_pdk110_67
X581 (n725 n440 n825 vdd vss) tx_and_pdk110_47
X582 (n826 n719 n827 vdd vss) tx_and_pdk110_47
X583 (n718 n828 n829 vdd vss) tx_or_pdk110_67
X584 (n826 n707 n828 vdd vss) tx_and_pdk110_47
X585 (n830 n725 n831 vdd vss) tx_and_pdk110_47
X586 (n830 n727 n832 vdd vss) tx_and_pdk110_47
X587 (n833 n834 n822 vdd vss) tx_or_pdk110_67
X588 (n569 n704 n834 vdd vss) tx_and_pdk110_47
X589 (n504 n820 n723 vdd vss) tx_and_pdk110_47
X590 (n333 n520 n523 vdd vss) tx_and_pdk110_47
X591 (n329 n516 n518 vdd vss) tx_and_pdk110_47
X592 (n325 n251 n514 vdd vss) tx_and_pdk110_47
X593 (n835 n516 n249 vdd vss) tx_and_pdk110_47
X594 (n836 n251 n516 vdd vss) tx_and_pdk110_47
X595 (n522 n333 n837 vdd vss) tx_and_pdk110_47
X596 (n327 n325 n836 vdd vss) tx_and_pdk110_47
X597 (n838 n516 n520 vdd vss) tx_and_pdk110_47
X598 (coarse2 n526 n528 vdd vss) tx_and_pdk110_47
X599 (coarse4 n530 n532 vdd vss) tx_and_pdk110_47
X600 (n839 n530 n534 vdd vss) tx_and_pdk110_47
X601 (coarse6 n534 n536 vdd vss) tx_and_pdk110_47
X602 (n840 n526 n530 vdd vss) tx_and_pdk110_47
X603 (coarse5 coarse4 n839 vdd vss) tx_and_pdk110_47
X604 (coarse3 coarse2 n840 vdd vss) tx_and_pdk110_47
X605 (coarse1 coarse0 n526 vdd vss) tx_and_pdk110_47
X606 (coarse2 n841 n544 vdd vss) tx_or_pdk110_67
X607 (n540 n541 n841 vdd vss) tx_and_pdk110_47
X608 (n546 n547 n842 vdd vss) tx_and_pdk110_47
X609 (n843 n844 n553 vdd vss) tx_or_pdk110_67
X610 (n845 n547 n844 vdd vss) tx_and_pdk110_47
X611 (n552 n553 n846 vdd vss) tx_and_pdk110_47
X612 (coarse6 n846 n555 vdd vss) tx_or_pdk110_67
X613 (n847 n848 n547 vdd vss) tx_or_pdk110_67
X614 (n849 n541 n848 vdd vss) tx_and_pdk110_47
X615 (n549 n546 n845 vdd vss) tx_and_pdk110_47
X616 (coarse5 n850 n843 vdd vss) tx_or_pdk110_67
X617 (n549 coarse4 n850 vdd vss) tx_and_pdk110_47
X618 (n543 n540 n849 vdd vss) tx_and_pdk110_47
X619 (coarse3 n851 n847 vdd vss) tx_or_pdk110_67
X620 (n543 coarse2 n851 vdd vss) tx_and_pdk110_47
X621 (coarse4 n842 n550 vdd vss) tx_or_pdk110_67
X622 (coarse1 n852 n541 vdd vss) tx_or_pdk110_67
X623 (n538 coarse0 n852 vdd vss) tx_and_pdk110_47
X624 (n95 n93 n558 vdd vss) tx_and_pdk110_47
X625 (n853 n854 n247 vdd vss) tx_or_pdk110_67
X626 (n855 n856 n854 vdd vss) tx_and_pdk110_47
X627 (n857 n858 n853 vdd vss) tx_or_pdk110_67
X628 (n859 n860 n858 vdd vss) tx_and_pdk110_47
X629 (n861 n862 n856 vdd vss) tx_or_pdk110_67
X630 (n863 n864 n862 vdd vss) tx_and_pdk110_47
X631 (n865 n866 n860 vdd vss) tx_or_pdk110_67
X632 (n867 n868 n866 vdd vss) tx_and_pdk110_47
X633 (n869 n870 n861 vdd vss) tx_or_pdk110_67
X634 (n871 n872 n870 vdd vss) tx_and_pdk110_47
X635 (n873 n874 n864 vdd vss) tx_or_pdk110_67
X636 (n875 n876 n874 vdd vss) tx_and_pdk110_47
X637 (n271 n877 n857 vdd vss) tx_or_pdk110_67
X638 (n272 n273 n877 vdd vss) tx_and_pdk110_47
X639 (n275 n878 n865 vdd vss) tx_or_pdk110_67
X640 (n276 n277 n878 vdd vss) tx_and_pdk110_47
X641 (n280 n282 n879 vdd vss) tx_and_pdk110_47
X642 (n279 n880 n868 vdd vss) tx_or_pdk110_67
X643 (n280 n281 n880 vdd vss) tx_and_pdk110_47
X644 (n283 n881 n869 vdd vss) tx_or_pdk110_67
X645 (n284 n285 n881 vdd vss) tx_and_pdk110_47
X646 (n287 n882 n872 vdd vss) tx_or_pdk110_67
X647 (n288 n289 n882 vdd vss) tx_and_pdk110_47
X648 (n292 n294 n875 vdd vss) tx_and_pdk110_47
X649 (n291 n883 n873 vdd vss) tx_or_pdk110_67
X650 (n292 n293 n883 vdd vss) tx_and_pdk110_47
X651 (n269 n884 n876 vdd vss) tx_or_pdk110_67
X652 (n270 measured0 n884 vdd vss) tx_and_pdk110_47
X653 (measured6 n885 n820 vdd vss) tx_and_pdk110_47
X654 (measured7 n699 n722 vdd vss) tx_and_pdk110_47
X655 (measured13 n886 n833 vdd vss) tx_and_pdk110_47
X656 (measured4 n696 n439 vdd vss) tx_xor_pdk110_66
X657 (measured6 n885 n445 vdd vss) tx_xor_pdk110_66
X658 (measured9 n817 n563 vdd vss) tx_xor_pdk110_66
X659 (measured13 n886 n569 vdd vss) tx_xor_pdk110_66
X660 (n439 n440 n819 vdd vss) tx_and_pdk110_47
X661 (n445 n446 n821 vdd vss) tx_and_pdk110_47
X662 (n829 n887 n567 vdd vss) tx_or_pdk110_67
X663 (n827 n561 n887 vdd vss) tx_and_pdk110_47
X664 (n831 n440 n713 vdd vss) tx_and_pdk110_47
X665 (n724 n832 n712 vdd vss) tx_or_pdk110_67
X666 (n510 n507 n826 vdd vss) tx_and_pdk110_47
X667 (n510 n709 n717 vdd vss) tx_and_pdk110_47
X668 (n563 n705 n721 vdd vss) tx_and_pdk110_47
X669 (n504 n445 n830 vdd vss) tx_and_pdk110_47
X670 (n442 n697 n726 vdd vss) tx_and_pdk110_47
X671 (measured3 n728 n714 vdd vss) tx_or_pdk110_67
X672 (dac0 n888 n889 vdd vss) tx_and_pdk110_47
X673 (dac1 n890 n891 vdd vss) tx_and_pdk110_47
X674 (dac2 n892 n893 vdd vss) tx_and_pdk110_47
X675 (dac3 n894 n895 vdd vss) tx_and_pdk110_47
X676 (dac4 n896 n897 vdd vss) tx_and_pdk110_47
X677 (dac5 n898 n899 vdd vss) tx_and_pdk110_47
X678 (dac0 n888 n900 vdd vss) tx_xor_pdk110_66
X679 (dac1 n890 n901 vdd vss) tx_xor_pdk110_66
X680 (dac2 n892 n902 vdd vss) tx_xor_pdk110_66
X681 (dac3 n894 n903 vdd vss) tx_xor_pdk110_66
X682 (dac4 n896 n904 vdd vss) tx_xor_pdk110_66
X683 (dac5 n898 n905 vdd vss) tx_xor_pdk110_66
X684 (n906 n907 n908 vdd vss) tx_or_pdk110_67
X685 (n909 n910 n907 vdd vss) tx_and_pdk110_47
X686 (n911 n912 n910 vdd vss) tx_or_pdk110_67
X687 (n913 n914 n912 vdd vss) tx_and_pdk110_47
X688 (n905 n904 n909 vdd vss) tx_and_pdk110_47
X689 (n899 n915 n906 vdd vss) tx_or_pdk110_67
X690 (n905 n897 n915 vdd vss) tx_and_pdk110_47
X691 (n895 n916 n911 vdd vss) tx_or_pdk110_67
X692 (n903 n893 n916 vdd vss) tx_and_pdk110_47
X693 (n891 n917 n914 vdd vss) tx_or_pdk110_67
X694 (n901 n918 n917 vdd vss) tx_and_pdk110_47
X695 (n889 n900 n918 vdd vss) tx_or_pdk110_67
X696 (n575 n576 n919 vdd vss) tx_and_pdk110_47
X697 (dac4 n919 n579 vdd vss) tx_or_pdk110_67
X698 (n920 n815 n576 vdd vss) tx_or_pdk110_67
X699 (dac3 n921 n920 vdd vss) tx_or_pdk110_67
X700 (n211 dac2 n921 vdd vss) tx_and_pdk110_47
X701 (dac2 n812 n502 vdd vss) tx_or_pdk110_67
X702 (dac1 n922 n573 vdd vss) tx_or_pdk110_67
X703 (n500 dac0 n922 vdd vss) tx_and_pdk110_47
X704 (dac0 n923 n924 vdd vss) tx_and_pdk110_47
X705 (dac1 n925 n926 vdd vss) tx_and_pdk110_47
X706 (dac2 n927 n928 vdd vss) tx_and_pdk110_47
X707 (dac3 n929 n930 vdd vss) tx_and_pdk110_47
X708 (dac4 n931 n932 vdd vss) tx_and_pdk110_47
X709 (dac5 n933 n934 vdd vss) tx_and_pdk110_47
X710 (dac0 n923 n935 vdd vss) tx_xor_pdk110_66
X711 (dac1 n925 n936 vdd vss) tx_xor_pdk110_66
X712 (dac2 n927 n937 vdd vss) tx_xor_pdk110_66
X713 (dac3 n929 n938 vdd vss) tx_xor_pdk110_66
X714 (dac4 n931 n939 vdd vss) tx_xor_pdk110_66
X715 (dac5 n933 n940 vdd vss) tx_xor_pdk110_66
X716 (n941 n942 n943 vdd vss) tx_or_pdk110_67
X717 (n944 n945 n942 vdd vss) tx_and_pdk110_47
X718 (n946 n947 n945 vdd vss) tx_or_pdk110_67
X719 (n948 n949 n947 vdd vss) tx_and_pdk110_47
X720 (n940 n939 n944 vdd vss) tx_and_pdk110_47
X721 (n934 n950 n941 vdd vss) tx_or_pdk110_67
X722 (n940 n932 n950 vdd vss) tx_and_pdk110_47
X723 (n938 n937 n948 vdd vss) tx_and_pdk110_47
X724 (n930 n951 n946 vdd vss) tx_or_pdk110_67
X725 (n938 n928 n951 vdd vss) tx_and_pdk110_47
X726 (n926 n952 n949 vdd vss) tx_or_pdk110_67
X727 (n936 n953 n952 vdd vss) tx_and_pdk110_47
X728 (n924 n935 n953 vdd vss) tx_or_pdk110_67
X729 (dac2 n356 n581 vdd vss) tx_and_pdk110_47
X730 (n813 n358 n377 vdd vss) tx_and_pdk110_47
X731 (dac3 dac2 n596 vdd vss) tx_and_pdk110_47
X732 (dac1 dac0 n356 vdd vss) tx_and_pdk110_47
X733 (n103 n584 n586 vdd vss) tx_and_pdk110_47
X734 (n107 n588 n590 vdd vss) tx_and_pdk110_47
X735 (n954 n588 n592 vdd vss) tx_and_pdk110_47
X736 (n111 n592 n594 vdd vss) tx_and_pdk110_47
X737 (n955 n584 n588 vdd vss) tx_and_pdk110_47
X738 (n109 n107 n954 vdd vss) tx_and_pdk110_47
X739 (n105 n103 n955 vdd vss) tx_and_pdk110_47
X740 (n101 n99 n584 vdd vss) tx_and_pdk110_47
X741 (n956 n957 n958 vdd vss) tx_or_pdk110_67
X742 (n956 n237 n959 vdd vss) tx_or_pdk110_67
X743 (n956 n960 n961 vdd vss) tx_or_pdk110_67
X744 (n242 n265 n962 vdd vss) tx_or_pdk110_67
X745 (n231 n238 n963 vdd vss) tx_or_pdk110_67
X746 (n962 n963 n956 vdd vss) tx_or_pdk110_67
X747 (n956 n235 n964 vdd vss) tx_or_pdk110_67
X748 (n117 n265 n965 vdd vss) tx_or_pdk110_67
X749 (n965 n966 n967 vdd vss) tx_or_pdk110_67
X750 (n233 n117 n968 vdd vss) tx_and_pdk110_47
X751 (n238 n184 n969 vdd vss) tx_and_pdk110_47
X752 (n968 n970 n971 vdd vss) tx_and_pdk110_47
X753 (n971 n969 n187 vdd vss) tx_and_pdk110_47
X754 (n972 n973 n974 vdd vss) tx_and_pdk110_47
X755 (n974 n184 n151 vdd vss) tx_and_pdk110_47
X756 (n966 n242 n975 vdd vss) tx_or_pdk110_67
X757 (n265 n88 n976 vdd vss) tx_or_pdk110_67
X758 (n975 n976 n977 vdd vss) tx_or_pdk110_67
X759 (n977 n978 n979 vdd vss) tx_or_pdk110_67
X760 (n979 n159 n183 vdd vss) tx_and_pdk110_47
X761 (n962 n980 n972 vdd vss) tx_or_pdk110_67
X762 (n962 n231 n973 vdd vss) tx_or_pdk110_67
X763 (n981 n982 n983 vdd vss) tx_and_pdk110_47
X764 (n984 n985 n986 vdd vss) tx_and_pdk110_47
X765 (n987 n988 n989 vdd vss) tx_and_pdk110_47
X766 (n990 n991 n992 vdd vss) tx_and_pdk110_47
X767 (n993 n994 n995 vdd vss) tx_and_pdk110_47
X768 (n983 n986 n996 vdd vss) tx_and_pdk110_47
X769 (n989 n992 n997 vdd vss) tx_and_pdk110_47
X770 (n996 n997 n998 vdd vss) tx_and_pdk110_47
X771 (n998 n995 n192 vdd vss) tx_and_pdk110_47
X772 (n999 n1000 n994 vdd vss) tx_or_pdk110_67
X773 (n1001 n1002 n982 vdd vss) tx_or_pdk110_67
X774 (n351 n243 n1003 vdd vss) tx_or_pdk110_67
X775 (n1004 n1002 n984 vdd vss) tx_or_pdk110_67
X776 (n1005 n1002 n985 vdd vss) tx_or_pdk110_67
X777 (n237 n1002 n1006 vdd vss) tx_or_pdk110_67
X778 (n1007 n1006 n987 vdd vss) tx_or_pdk110_67
X779 (n1008 n1002 n988 vdd vss) tx_or_pdk110_67
X780 (n88 n1002 n990 vdd vss) tx_or_pdk110_67
X781 (n51 n1002 n991 vdd vss) tx_or_pdk110_67
X782 (n117 n1002 n993 vdd vss) tx_or_pdk110_67
X783 (n1009 n1010 n1011 vdd vss) tx_and_pdk110_47
X784 (n1012 n1013 n1014 vdd vss) tx_and_pdk110_47
X785 (n1011 n1014 n1015 vdd vss) tx_and_pdk110_47
X786 (n1015 n1016 n1017 vdd vss) tx_and_pdk110_47
X787 (n1017 n1018 n145 vdd vss) tx_and_pdk110_47
X788 (n1019 n233 n1013 vdd vss) tx_or_pdk110_67
X789 (n963 n241 n1009 vdd vss) tx_or_pdk110_67
X790 (n963 n351 n1010 vdd vss) tx_or_pdk110_67
X791 (n963 n237 n1012 vdd vss) tx_or_pdk110_67
X792 (n963 n960 n1020 vdd vss) tx_or_pdk110_67
X793 (n963 n235 n1021 vdd vss) tx_or_pdk110_67
X794 (n88 n966 n1022 vdd vss) tx_or_pdk110_67
X795 (n1001 n1004 n1023 vdd vss) tx_and_pdk110_47
X796 (n1005 n1024 n1025 vdd vss) tx_and_pdk110_47
X797 (n1008 n117 n1026 vdd vss) tx_and_pdk110_47
X798 (n51 n88 n970 vdd vss) tx_and_pdk110_47
X799 (n1023 n1025 n1027 vdd vss) tx_and_pdk110_47
X800 (n1026 n970 n1028 vdd vss) tx_and_pdk110_47
X801 (n1027 n1028 n1029 vdd vss) tx_and_pdk110_47
X802 (n1029 n184 n195 vdd vss) tx_and_pdk110_47
X803 (n239 n232 n1001 vdd vss) tx_or_pdk110_67
X804 (n1007 n1003 n1004 vdd vss) tx_or_pdk110_67
X805 (n238 n1030 n1007 vdd vss) tx_or_pdk110_67
X806 (n1031 n240 n1032 vdd vss) tx_or_pdk110_67
X807 (n1007 n1032 n1005 vdd vss) tx_or_pdk110_67
X808 (n1007 n237 n1024 vdd vss) tx_or_pdk110_67
X809 (n238 n235 n1008 vdd vss) tx_or_pdk110_67
X810 (n1033 n994 n1034 vdd vss) tx_and_pdk110_47
X811 (n1035 n1036 n1037 vdd vss) tx_and_pdk110_47
X812 (n1034 n1037 n1038 vdd vss) tx_and_pdk110_47
X813 (n1038 n1039 n142 vdd vss) tx_and_pdk110_47
X814 (n1040 n1041 n1035 vdd vss) tx_or_pdk110_67
X815 (n1042 n1043 n1036 vdd vss) tx_or_pdk110_67
X816 (n1044 n1045 n1039 vdd vss) tx_or_pdk110_67
X817 (n1013 n1020 n1046 vdd vss) tx_and_pdk110_47
X818 (n1021 n1022 n1047 vdd vss) tx_and_pdk110_47
X819 (n117 n51 n1048 vdd vss) tx_and_pdk110_47
X820 (n1046 n1047 n1049 vdd vss) tx_and_pdk110_47
X821 (n1048 n184 n197 vdd vss) tx_and_pdk110_47
X822 (n1049 n197 n139 vdd vss) tx_and_pdk110_47
X823 (n1020 n1021 n1050 vdd vss) tx_and_pdk110_47
X824 (n1022 n117 n1051 vdd vss) tx_and_pdk110_47
X825 (n51 n184 n1018 vdd vss) tx_and_pdk110_47
X826 (n1050 n1051 n1016 vdd vss) tx_and_pdk110_47
X827 (n1016 n1018 n201 vdd vss) tx_and_pdk110_47
X828 (n184 n1052 n203 vdd vss) tx_or_pdk110_67
X829 (n1052 n1053 n1054 vdd vss) tx_or_pdk110_67
X830 (n1054 n1055 n1056 vdd vss) tx_or_pdk110_67
X831 (n224 target_k1 n1057 vdd vss) tx_or_pdk110_67
X832 (target_k2 n754 n1058 vdd vss) tx_or_pdk110_67
X833 (target_k4 target_k5 n1059 vdd vss) tx_or_pdk110_67
X834 (n1057 n1058 n1060 vdd vss) tx_or_pdk110_67
X835 (n1060 n1059 n1061 vdd vss) tx_or_pdk110_67
X836 (n1062 n318 n1063 vdd vss) tx_or_pdk110_67
X837 (n319 n109 n1064 vdd vss) tx_or_pdk110_67
X838 (n1065 n1063 n1066 vdd vss) tx_or_pdk110_67
X839 (n1064 n1067 n1068 vdd vss) tx_or_pdk110_67
X840 (n1066 n1068 n1069 vdd vss) tx_or_pdk110_67
X841 (n230 n320 n1070 vdd vss) tx_or_pdk110_67
X842 (n321 n113 n1071 vdd vss) tx_or_pdk110_67
X843 (n1070 n1071 n1072 vdd vss) tx_or_pdk110_67
X844 (n1073 n1072 n1074 vdd vss) tx_or_pdk110_67
X845 (n99 n1075 n1076 vdd vss) tx_or_pdk110_67
X846 (n103 n105 n1077 vdd vss) tx_or_pdk110_67
X847 (n107 n109 n1078 vdd vss) tx_or_pdk110_67
X848 (n1076 n1077 n1079 vdd vss) tx_or_pdk110_67
X849 (n1078 n1067 n1080 vdd vss) tx_or_pdk110_67
X850 (n1079 n1080 n1081 vdd vss) tx_or_pdk110_67
X851 (n296 n538 n1082 vdd vss) tx_or_pdk110_67
X852 (n540 n543 n1083 vdd vss) tx_or_pdk110_67
X853 (n546 n549 n1084 vdd vss) tx_or_pdk110_67
X854 (n552 n295 n1085 vdd vss) tx_or_pdk110_67
X855 (n1082 n1083 n1086 vdd vss) tx_or_pdk110_67
X856 (n1084 n1085 n1087 vdd vss) tx_or_pdk110_67
X857 (n1086 n1087 n1088 vdd vss) tx_or_pdk110_67
X858 (n1089 n1090 n1091 vdd vss) tx_or_pdk110_67
X859 (n1091 n228 n960 vdd vss) tx_or_pdk110_67
X860 (n227 n60 n1092 vdd vss) tx_or_pdk110_67
X861 (n62 n64 n1093 vdd vss) tx_or_pdk110_67
X862 (n66 n68 n1094 vdd vss) tx_or_pdk110_67
X863 (n70 n72 n1095 vdd vss) tx_or_pdk110_67
X864 (n1092 n1093 n1096 vdd vss) tx_or_pdk110_67
X865 (n1094 n1095 n1097 vdd vss) tx_or_pdk110_67
X866 (n1096 n1097 n980 vdd vss) tx_or_pdk110_67
X867 (n266 n1075 n1065 vdd vss) tx_or_pdk110_67
X868 (n1062 n1098 n1099 vdd vss) tx_or_pdk110_67
X869 (n230 n109 n1100 vdd vss) tx_or_pdk110_67
X870 (n111 n113 n1067 vdd vss) tx_or_pdk110_67
X871 (n1065 n1099 n1073 vdd vss) tx_or_pdk110_67
X872 (n1100 n1067 n1101 vdd vss) tx_or_pdk110_67
X873 (n1073 n1101 n1102 vdd vss) tx_or_pdk110_67
X874 (n1103 n229 n1000 vdd vss) tx_or_pdk110_67
X875 (n1104 n229 n1033 vdd vss) tx_or_pdk110_67
X876 (state_out0 n225 n1105 vdd vss) tx_or_pdk110_67
X877 (n1105 state_out2 n1041 vdd vss) tx_or_pdk110_67
X878 (n226 state_out1 n1104 vdd vss) tx_or_pdk110_67
X879 (n1104 state_out2 n1043 vdd vss) tx_or_pdk110_67
X880 (n226 n225 n1106 vdd vss) tx_or_pdk110_67
X881 (n1106 state_out2 n1002 vdd vss) tx_or_pdk110_67
X882 (n1031 n350 n1107 vdd vss) tx_or_pdk110_67
X883 (n405 n715 n410 vdd vss) tx_and_pdk110_47
X884 (n410 n831 n1108 vdd vss) tx_and_pdk110_47
X885 (n827 n716 n1109 vdd vss) tx_and_pdk110_47
X886 (n264 n1110 n1111 vdd vss) tx_or_pdk110_67
X887 (n788 n745 n1110 vdd vss) tx_and_pdk110_47
X888 (n262 n1112 n1113 vdd vss) tx_or_pdk110_67
X889 (n224 target_k1 n1114 vdd vss) tx_and_pdk110_47
X890 (n268 n754 n752 vdd vss) tx_and_pdk110_47
X891 (n1114 n752 n1115 vdd vss) tx_and_pdk110_47
X892 (n1115 n745 n1112 vdd vss) tx_and_pdk110_47
X893 (n260 n1116 n1117 vdd vss) tx_or_pdk110_67
X894 (target_k0 n1118 n774 vdd vss) tx_and_pdk110_47
X895 (target_k2 target_k3 n742 vdd vss) tx_and_pdk110_47
X896 (n774 n742 n1119 vdd vss) tx_and_pdk110_47
X897 (n1119 n769 n1116 vdd vss) tx_and_pdk110_47
X898 (n258 n1120 n1121 vdd vss) tx_or_pdk110_67
X899 (n268 target_k3 n1122 vdd vss) tx_and_pdk110_47
X900 (n1123 n747 n769 vdd vss) tx_and_pdk110_47
X901 (n449 n1122 n788 vdd vss) tx_and_pdk110_47
X902 (n788 n769 n1120 vdd vss) tx_and_pdk110_47
X903 (n256 n809 n1124 vdd vss) tx_or_pdk110_67
X904 (n572 n211 n814 vdd vss) tx_and_pdk110_47
X905 (n922 n814 n1125 vdd vss) tx_and_pdk110_47
X906 (n1125 n813 n345 vdd vss) tx_and_pdk110_47
X907 (n1126 n345 n1127 vdd vss) tx_or_pdk110_67
X908 (n1128 n251 n1129 vdd vss) tx_and_pdk110_47
X909 (n329 n331 n838 vdd vss) tx_and_pdk110_47
X910 (n1129 n836 n1130 vdd vss) tx_and_pdk110_47
X911 (n838 n837 n835 vdd vss) tx_and_pdk110_47
X912 (n1130 n835 n347 vdd vss) tx_and_pdk110_47
X913 (n1131 n347 n1132 vdd vss) tx_or_pdk110_67
X914 (n290 n288 n1133 vdd vss) tx_and_pdk110_47
X915 (n286 n284 n871 vdd vss) tx_and_pdk110_47
X916 (n278 n276 n867 vdd vss) tx_and_pdk110_47
X917 (n274 n272 n859 vdd vss) tx_and_pdk110_47
X918 (n884 n875 n1134 vdd vss) tx_and_pdk110_47
X919 (n1133 n871 n863 vdd vss) tx_and_pdk110_47
X920 (n879 n867 n1135 vdd vss) tx_and_pdk110_47
X921 (n1134 n863 n1136 vdd vss) tx_and_pdk110_47
X922 (n1135 n859 n855 vdd vss) tx_and_pdk110_47
X923 (n1136 n855 n1137 vdd vss) tx_and_pdk110_47
X924 (n248 n1137 n236 vdd vss) tx_or_pdk110_67
X925 (n403 n402 n405 vdd vss) tx_and_pdk110_47
X926 (n246 n245 n715 vdd vss) tx_and_pdk110_47
X927 (n1108 n1109 n350 vdd vss) tx_and_pdk110_47
X928 (n900 n901 n1138 vdd vss) tx_and_pdk110_47
X929 (n902 n903 n913 vdd vss) tx_and_pdk110_47
X930 (n1138 n913 n1139 vdd vss) tx_and_pdk110_47
X931 (n1139 n909 n1140 vdd vss) tx_and_pdk110_47
X932 (n1141 n1140 n243 vdd vss) tx_or_pdk110_67
X933 (n935 n936 n1142 vdd vss) tx_and_pdk110_47
X934 (n1142 n948 n1143 vdd vss) tx_and_pdk110_47
X935 (n1143 n944 n353 vdd vss) tx_and_pdk110_47
X936 (n1144 n353 n240 vdd vss) tx_or_pdk110_67
X937 (n1145 n184 n179 vdd vss) tx_and_pdk110_47
X938 (n1146 n1147 n1148 vdd vss) tx_and_pdk110_47
X939 (n1149 n184 n1150 vdd vss) tx_and_pdk110_47
X940 (n1148 n1150 n171 vdd vss) tx_and_pdk110_47
X941 (n962 n233 n1146 vdd vss) tx_or_pdk110_67
X942 (n962 n238 n1147 vdd vss) tx_or_pdk110_67
X943 (n962 n88 n1149 vdd vss) tx_or_pdk110_67
X944 (n1151 n1152 n1153 vdd vss) tx_and_pdk110_47
X945 (n1153 n1014 n1154 vdd vss) tx_and_pdk110_47
X946 (n1154 n1016 n1155 vdd vss) tx_and_pdk110_47
X947 (n1155 n1018 n165 vdd vss) tx_and_pdk110_47
X948 (n963 n244 n1151 vdd vss) tx_or_pdk110_67
X949 (n963 n1031 n1152 vdd vss) tx_or_pdk110_67
X950 (n1145 n1156 n1157 vdd vss) tx_and_pdk110_47
X951 (n1158 n958 n1159 vdd vss) tx_and_pdk110_47
X952 (n959 n961 n1160 vdd vss) tx_and_pdk110_47
X953 (n964 n967 n1161 vdd vss) tx_and_pdk110_47
X954 (n1157 n1159 n1162 vdd vss) tx_and_pdk110_47
X955 (n1160 n1161 n1163 vdd vss) tx_and_pdk110_47
X956 (n1162 n1163 n1164 vdd vss) tx_and_pdk110_47
X957 (n1164 n184 n159 vdd vss) tx_and_pdk110_47
X958 (n51 n1165 n1145 vdd vss) tx_or_pdk110_67
X959 (n231 n239 n1019 vdd vss) tx_or_pdk110_67
X960 (n962 n1019 n1166 vdd vss) tx_or_pdk110_67
X961 (n1166 n233 n1156 vdd vss) tx_or_pdk110_67
X962 (n351 n244 n1167 vdd vss) tx_or_pdk110_67
X963 (n956 n1167 n1158 vdd vss) tx_or_pdk110_67
X964 (n1031 n241 n957 vdd vss) tx_or_pdk110_67
X965 (coarse0 coarse1 n1168 vdd vss) tx_or_pdk110_67
X966 (coarse2 coarse3 n1169 vdd vss) tx_or_pdk110_67
X967 (coarse4 coarse5 n1170 vdd vss) tx_or_pdk110_67
X968 (coarse6 coarse7 n1171 vdd vss) tx_or_pdk110_67
X969 (n1168 n1169 n1172 vdd vss) tx_or_pdk110_67
X970 (n1170 n1171 n1173 vdd vss) tx_or_pdk110_67
X971 (n1172 n1173 n1174 vdd vss) tx_or_pdk110_67
X972 (n1053 n1175 n1176 vdd vss) tx_or_pdk110_67
X973 (n1177 n1176 n1178 vdd vss) tx_or_pdk110_67
X974 (n1178 n203 n1179 vdd vss) tx_or_pdk110_67
X975 (n1180 n1181 n1182 vdd vss) tx_or_pdk110_67
X976 (n1183 n1184 n1185 vdd vss) tx_or_pdk110_67
X977 (n1182 n1185 n1186 vdd vss) tx_or_pdk110_67
X978 (n1187 n1188 n1189 vdd vss) tx_or_pdk110_67
X979 (n1190 n1191 n1192 vdd vss) tx_or_pdk110_67
X980 (n1189 n1192 n1193 vdd vss) tx_or_pdk110_67
X981 (n1194 n1195 n1196 vdd vss) tx_or_pdk110_67
X982 (n1197 n1198 n1199 vdd vss) tx_or_pdk110_67
X983 (n1196 n1199 n1200 vdd vss) tx_or_pdk110_67
X984 (n1201 n1202 n1203 vdd vss) tx_or_pdk110_67
X985 (n1204 n1205 n1206 vdd vss) tx_or_pdk110_67
X986 (n1203 n1206 n1207 vdd vss) tx_or_pdk110_67
X987 (n1208 n1209 n1210 vdd vss) tx_or_pdk110_67
X988 (n1211 n1212 n1213 vdd vss) tx_or_pdk110_67
X989 (n1210 n1213 n1214 vdd vss) tx_or_pdk110_67
X990 (n1215 n1216 n1217 vdd vss) tx_or_pdk110_67
X991 (n1218 n1219 n1220 vdd vss) tx_or_pdk110_67
X992 (n1217 n1220 n1221 vdd vss) tx_or_pdk110_67
X993 (n1222 n1223 n1224 vdd vss) tx_or_pdk110_67
X994 (n1225 n1226 n1227 vdd vss) tx_or_pdk110_67
X995 (n1224 n1227 n1228 vdd vss) tx_or_pdk110_67
X996 (n1229 n1230 n1231 vdd vss) tx_or_pdk110_67
X997 (n1232 n1233 n1234 vdd vss) tx_or_pdk110_67
X998 (n1231 n1234 n1235 vdd vss) tx_or_pdk110_67
X999 (n1052 n1175 n1236 vdd vss) tx_or_pdk110_67
X1000 (n184 n1053 n1237 vdd vss) tx_or_pdk110_67
X1001 (n1238 n1055 n1177 vdd vss) tx_or_pdk110_67
X1002 (n1236 n1237 n1239 vdd vss) tx_or_pdk110_67
X1003 (n1239 n1177 n1240 vdd vss) tx_or_pdk110_67
X1004 (n1241 n1242 n1243 vdd vss) tx_or_pdk110_67
X1005 (n1244 n1245 n1246 vdd vss) tx_or_pdk110_67
X1006 (n1247 n1243 n1248 vdd vss) tx_or_pdk110_67
X1007 (n1248 n1246 n1249 vdd vss) tx_or_pdk110_67
X1008 (n1250 n1251 n1252 vdd vss) tx_or_pdk110_67
X1009 (n1253 n1242 n1254 vdd vss) tx_or_pdk110_67
X1010 (n1254 n1252 n1255 vdd vss) tx_or_pdk110_67
X1011 (n1256 n1257 n1258 vdd vss) tx_or_pdk110_67
X1012 (n1244 n1251 n1259 vdd vss) tx_or_pdk110_67
X1013 (n1247 n1258 n1260 vdd vss) tx_or_pdk110_67
X1014 (n1260 n1259 n1261 vdd vss) tx_or_pdk110_67
X1015 (n1175 n184 n981 vdd vss) tx_or_pdk110_67
X1016 (n1262 n1263 n1264 vdd vss) tx_or_pdk110_67
X1017 (n1055 n203 n189 vdd vss) tx_or_pdk110_67
X1018 (n1265 n203 n1266 vdd vss) tx_or_pdk110_67
X1019 (n1238 n1056 n186 vdd vss) tx_or_pdk110_67
X1020 (state_out0 state_out1 n1103 vdd vss) tx_or_pdk110_67
X1021 (n1103 state_out2 n1045 vdd vss) tx_or_pdk110_67
X1022 (n1069 n1044 vdd vss) pll_inv_pdk110_7
X1023 (n1074 n1042 vdd vss) pll_inv_pdk110_7
X1024 (n1081 n1040 vdd vss) pll_inv_pdk110_7
X1025 (n1088 n1267 vdd vss) pll_inv_pdk110_7
X1026 (n1174 n1268 vdd vss) pll_inv_pdk110_7
X1027 (n960 n1030 vdd vss) pll_inv_pdk110_7
X1028 (n1102 n999 vdd vss) pll_inv_pdk110_7
X1029 (range_error n1269 vdd vss) pll_inv_pdk110_7
X1030 (n1000 n1175 vdd vss) pll_inv_pdk110_7
X1031 (n1033 n1052 vdd vss) pll_inv_pdk110_7
X1032 (n1041 n1053 vdd vss) pll_inv_pdk110_7
X1033 (n1043 n1238 vdd vss) pll_inv_pdk110_7
X1034 (n1045 n1055 vdd vss) pll_inv_pdk110_7
X1035 (n1002 n184 vdd vss) pll_inv_pdk110_7
X1036 (n1124 n1031 n1270 vdd vss) tx_and_pdk110_47
X1037 (n1127 n349 n1271 vdd vss) tx_and_pdk110_47
X1038 (n1270 n1271 n238 vdd vss) tx_or_pdk110_67
X1039 (n54 n1030 n1272 vdd vss) tx_or_pdk110_67
X1040 (n1270 n1267 n1273 vdd vss) tx_and_pdk110_47
X1041 (n1272 n1273 n1274 vdd vss) tx_or_pdk110_67
X1042 (n1271 n1268 n1275 vdd vss) tx_and_pdk110_47
X1043 (n1274 n1275 n232 vdd vss) tx_or_pdk110_67
X1044 (n236 n115 n234 vdd vss) tx_and_pdk110_47
X1045 (vss target_k0 n1111 n1276 vdd vss) tx_mux_pdk110_64
X1046 (target_k0 n462 n1111 n1277 vdd vss) tx_mux_pdk110_64
X1047 (target_k1 n450 n1111 n1278 vdd vss) tx_mux_pdk110_64
X1048 (target_k2 n453 n1111 n1279 vdd vss) tx_mux_pdk110_64
X1049 (target_k3 n456 n1111 n1280 vdd vss) tx_mux_pdk110_64
X1050 (target_k4 n459 n1111 n1281 vdd vss) tx_mux_pdk110_64
X1051 (target_k5 n461 n1111 n1282 vdd vss) tx_mux_pdk110_64
X1052 (vss n734 n1111 n1283 vdd vss) tx_mux_pdk110_64
X1053 (n1276 vss n1113 n1284 vdd vss) tx_mux_pdk110_64
X1054 (n1277 vss n1113 n1285 vdd vss) tx_mux_pdk110_64
X1055 (n1278 target_k0 n1113 n1286 vdd vss) tx_mux_pdk110_64
X1056 (n1279 target_k1 n1113 n1287 vdd vss) tx_mux_pdk110_64
X1057 (n1280 target_k2 n1113 n1288 vdd vss) tx_mux_pdk110_64
X1058 (n1281 target_k3 n1113 n1289 vdd vss) tx_mux_pdk110_64
X1059 (n1282 target_k4 n1113 n1290 vdd vss) tx_mux_pdk110_64
X1060 (n1283 target_k5 n1113 n1291 vdd vss) tx_mux_pdk110_64
X1061 (n1284 target_k0 n1117 n1292 vdd vss) tx_mux_pdk110_64
X1062 (n1285 target_k1 n1117 n1293 vdd vss) tx_mux_pdk110_64
X1063 (n1286 n758 n1117 n1294 vdd vss) tx_mux_pdk110_64
X1064 (n1287 n465 n1117 n1295 vdd vss) tx_mux_pdk110_64
X1065 (n1288 n468 n1117 n1296 vdd vss) tx_mux_pdk110_64
X1066 (n1289 n471 n1117 n1297 vdd vss) tx_mux_pdk110_64
X1067 (n1290 n473 n1117 n1298 vdd vss) tx_mux_pdk110_64
X1068 (n1291 n475 n1117 n1299 vdd vss) tx_mux_pdk110_64
X1069 (vss n765 n1117 n1300 vdd vss) tx_mux_pdk110_64
X1070 (n1292 vss n1121 n1301 vdd vss) tx_mux_pdk110_64
X1071 (n1293 target_k0 n1121 n1302 vdd vss) tx_mux_pdk110_64
X1072 (n1294 n462 n1121 n1303 vdd vss) tx_mux_pdk110_64
X1073 (n1295 n450 n1121 n1304 vdd vss) tx_mux_pdk110_64
X1074 (n1296 n453 n1121 n1305 vdd vss) tx_mux_pdk110_64
X1075 (n1297 n477 n1121 n1306 vdd vss) tx_mux_pdk110_64
X1076 (n1298 n479 n1121 n1307 vdd vss) tx_mux_pdk110_64
X1077 (n1299 n481 n1121 n1308 vdd vss) tx_mux_pdk110_64
X1078 (n1300 n497 n1121 n1309 vdd vss) tx_mux_pdk110_64
X1079 (target_k0 n1301 n1061 n1310 vdd vss) tx_mux_pdk110_64
X1080 (n462 n1302 n1061 n1311 vdd vss) tx_mux_pdk110_64
X1081 (n483 n1303 n1061 n1312 vdd vss) tx_mux_pdk110_64
X1082 (n486 n1304 n1061 n1313 vdd vss) tx_mux_pdk110_64
X1083 (n489 n1305 n1061 n1314 vdd vss) tx_mux_pdk110_64
X1084 (n492 n1306 n1061 n1315 vdd vss) tx_mux_pdk110_64
X1085 (n494 n1307 n1061 n1316 vdd vss) tx_mux_pdk110_64
X1086 (n496 n1308 n1061 n1317 vdd vss) tx_mux_pdk110_64
X1087 (n499 n1309 n1061 n1318 vdd vss) tx_mux_pdk110_64
X1088 (n801 vss n1061 n1319 vdd vss) tx_mux_pdk110_64
X1089 (n1310 vss n117 n640 vdd vss) tx_mux_pdk110_64
X1090 (n1311 vss n117 n643 vdd vss) tx_mux_pdk110_64
X1091 (n1312 n1310 n117 n646 vdd vss) tx_mux_pdk110_64
X1092 (n1313 n1311 n117 n649 vdd vss) tx_mux_pdk110_64
X1093 (n1314 n1312 n117 n652 vdd vss) tx_mux_pdk110_64
X1094 (n1315 n1313 n117 n655 vdd vss) tx_mux_pdk110_64
X1095 (n1316 n1314 n117 n658 vdd vss) tx_mux_pdk110_64
X1096 (n1317 n1315 n117 n661 vdd vss) tx_mux_pdk110_64
X1097 (n1318 n1316 n117 n664 vdd vss) tx_mux_pdk110_64
X1098 (n1319 n1317 n117 n667 vdd vss) tx_mux_pdk110_64
X1099 (n1031 n1107 n117 n978 vdd vss) tx_mux_pdk110_64
X1100 (n297 coarse0 n978 n322 vdd vss) tx_mux_pdk110_64
X1101 (n299 coarse1 n978 n251 vdd vss) tx_mux_pdk110_64
X1102 (n301 coarse2 n978 n325 vdd vss) tx_mux_pdk110_64
X1103 (n303 coarse3 n978 n327 vdd vss) tx_mux_pdk110_64
X1104 (n305 coarse4 n978 n329 vdd vss) tx_mux_pdk110_64
X1105 (n307 coarse5 n978 n331 vdd vss) tx_mux_pdk110_64
X1106 (n309 coarse6 n978 n333 vdd vss) tx_mux_pdk110_64
X1107 (n311 coarse7 n978 n522 vdd vss) tx_mux_pdk110_64
X1108 (dac0 n312 n978 n335 vdd vss) tx_mux_pdk110_64
X1109 (dac1 n313 n978 n337 vdd vss) tx_mux_pdk110_64
X1110 (dac2 n314 n978 n339 vdd vss) tx_mux_pdk110_64
X1111 (dac3 n315 n978 n341 vdd vss) tx_mux_pdk110_64
X1112 (dac4 n316 n978 n343 vdd vss) tx_mux_pdk110_64
X1113 (vss n317 n978 n1320 vdd vss) tx_mux_pdk110_64
X1114 (n404 measured1 n1107 n269 vdd vss) tx_mux_pdk110_64
X1115 (n406 measured2 n1107 n293 vdd vss) tx_mux_pdk110_64
X1116 (n408 measured3 n1107 n291 vdd vss) tx_mux_pdk110_64
X1117 (n411 n441 n1107 n289 vdd vss) tx_mux_pdk110_64
X1118 (n414 n444 n1107 n287 vdd vss) tx_mux_pdk110_64
X1119 (n417 n447 n1107 n285 vdd vss) tx_mux_pdk110_64
X1120 (n420 n506 n1107 n283 vdd vss) tx_mux_pdk110_64
X1121 (n423 n562 n1107 n281 vdd vss) tx_mux_pdk110_64
X1122 (n426 n565 n1107 n279 vdd vss) tx_mux_pdk110_64
X1123 (n429 n509 n1107 n277 vdd vss) tx_mux_pdk110_64
X1124 (n432 n512 n1107 n275 vdd vss) tx_mux_pdk110_64
X1125 (n435 n568 n1107 n273 vdd vss) tx_mux_pdk110_64
X1126 (n438 n571 n1107 n271 vdd vss) tx_mux_pdk110_64
X1127 (n322 vdd n1132 n1321 vdd vss) tx_mux_pdk110_64
X1128 (n252 vdd n1132 n1322 vdd vss) tx_mux_pdk110_64
X1129 (n513 vdd n1132 n1323 vdd vss) tx_mux_pdk110_64
X1130 (n515 vdd n1132 n1324 vdd vss) tx_mux_pdk110_64
X1131 (n517 vdd n1132 n1325 vdd vss) tx_mux_pdk110_64
X1132 (n519 vdd n1132 n1326 vdd vss) tx_mux_pdk110_64
X1133 (n521 vdd n1132 n1327 vdd vss) tx_mux_pdk110_64
X1134 (n524 vdd n1132 n1328 vdd vss) tx_mux_pdk110_64
X1135 (n539 n525 n1270 n1329 vdd vss) tx_mux_pdk110_64
X1136 (n542 n527 n1270 n1330 vdd vss) tx_mux_pdk110_64
X1137 (n545 n529 n1270 n1331 vdd vss) tx_mux_pdk110_64
X1138 (n548 n531 n1270 n1332 vdd vss) tx_mux_pdk110_64
X1139 (n551 n533 n1270 n1333 vdd vss) tx_mux_pdk110_64
X1140 (n554 n535 n1270 n1334 vdd vss) tx_mux_pdk110_64
X1141 (n556 n537 n1270 n1335 vdd vss) tx_mux_pdk110_64
X1142 (n267 vss n243 n1336 vdd vss) tx_mux_pdk110_64
X1143 (n501 vss n243 n1337 vdd vss) tx_mux_pdk110_64
X1144 (n574 vss n243 n1338 vdd vss) tx_mux_pdk110_64
X1145 (n503 vss n243 n1339 vdd vss) tx_mux_pdk110_64
X1146 (n577 vss n243 n1340 vdd vss) tx_mux_pdk110_64
X1147 (n580 vss n243 n1341 vdd vss) tx_mux_pdk110_64
X1148 (n1336 vss n351 n1342 vdd vss) tx_mux_pdk110_64
X1149 (n1337 vss n351 n1343 vdd vss) tx_mux_pdk110_64
X1150 (n1338 vss n351 n1344 vdd vss) tx_mux_pdk110_64
X1151 (n1339 vss n351 n1345 vdd vss) tx_mux_pdk110_64
X1152 (n1340 vss n351 n1346 vdd vss) tx_mux_pdk110_64
X1153 (n1341 vss n351 n1347 vdd vss) tx_mux_pdk110_64
X1154 (n1342 vss n236 n1348 vdd vss) tx_mux_pdk110_64
X1155 (n1343 vss n236 n1349 vdd vss) tx_mux_pdk110_64
X1156 (n1344 vss n236 n1350 vdd vss) tx_mux_pdk110_64
X1157 (n1345 vss n236 n1351 vdd vss) tx_mux_pdk110_64
X1158 (n1346 vss n236 n1352 vdd vss) tx_mux_pdk110_64
X1159 (n1347 vss n236 n1353 vdd vss) tx_mux_pdk110_64
X1160 (vss n1348 n960 n1354 vdd vss) tx_mux_pdk110_64
X1161 (vss n1349 n960 n1355 vdd vss) tx_mux_pdk110_64
X1162 (vss n1350 n960 n1356 vdd vss) tx_mux_pdk110_64
X1163 (vss n1351 n960 n1357 vdd vss) tx_mux_pdk110_64
X1164 (vss n1352 n960 n1358 vdd vss) tx_mux_pdk110_64
X1165 (vss n1353 n960 n1359 vdd vss) tx_mux_pdk110_64
X1166 (n1354 vss n234 n1360 vdd vss) tx_mux_pdk110_64
X1167 (n1355 vss n234 n1361 vdd vss) tx_mux_pdk110_64
X1168 (n1356 vss n234 n1362 vdd vss) tx_mux_pdk110_64
X1169 (n1357 vss n234 n1363 vdd vss) tx_mux_pdk110_64
X1170 (n1358 vss n234 n1364 vdd vss) tx_mux_pdk110_64
X1171 (n1359 vss n234 n1365 vdd vss) tx_mux_pdk110_64
X1172 (n1360 n1366 n238 n1367 vdd vss) tx_mux_pdk110_64
X1173 (n1361 n1368 n238 n1369 vdd vss) tx_mux_pdk110_64
X1174 (n1362 n1366 n238 n1370 vdd vss) tx_mux_pdk110_64
X1175 (n1363 n1368 n238 n1371 vdd vss) tx_mux_pdk110_64
X1176 (n1364 n1366 n238 n1372 vdd vss) tx_mux_pdk110_64
X1177 (n1365 n1366 n238 n1373 vdd vss) tx_mux_pdk110_64
X1178 (n1374 n1367 n88 n169 vdd vss) tx_mux_pdk110_64
X1179 (n1375 n1369 n88 n168 vdd vss) tx_mux_pdk110_64
X1180 (n1374 n1370 n88 n167 vdd vss) tx_mux_pdk110_64
X1181 (n1375 n1371 n88 n166 vdd vss) tx_mux_pdk110_64
X1182 (n1374 n1372 n88 n164 vdd vss) tx_mux_pdk110_64
X1183 (n1374 n1373 n88 n181 vdd vss) tx_mux_pdk110_64
X1184 (vdd vss n980 n1374 vdd vss) tx_mux_pdk110_64
X1185 (n267 vss n240 n1376 vdd vss) tx_mux_pdk110_64
X1186 (n355 vss n240 n1377 vdd vss) tx_mux_pdk110_64
X1187 (n357 vss n240 n1378 vdd vss) tx_mux_pdk110_64
X1188 (n582 vss n240 n1379 vdd vss) tx_mux_pdk110_64
X1189 (n359 vss n240 n1380 vdd vss) tx_mux_pdk110_64
X1190 (n361 vss n240 n1381 vdd vss) tx_mux_pdk110_64
X1191 (vss n1376 n351 n1382 vdd vss) tx_mux_pdk110_64
X1192 (vss n1377 n351 n1383 vdd vss) tx_mux_pdk110_64
X1193 (vss n1378 n351 n1384 vdd vss) tx_mux_pdk110_64
X1194 (vss n1379 n351 n1385 vdd vss) tx_mux_pdk110_64
X1195 (vss n1380 n351 n1386 vdd vss) tx_mux_pdk110_64
X1196 (vss n1381 n351 n1387 vdd vss) tx_mux_pdk110_64
X1197 (n1382 vss n236 n1388 vdd vss) tx_mux_pdk110_64
X1198 (n1383 vss n236 n1389 vdd vss) tx_mux_pdk110_64
X1199 (n1384 vss n236 n1390 vdd vss) tx_mux_pdk110_64
X1200 (n1385 vss n236 n1391 vdd vss) tx_mux_pdk110_64
X1201 (n1386 vss n236 n1392 vdd vss) tx_mux_pdk110_64
X1202 (n1387 vss n236 n1393 vdd vss) tx_mux_pdk110_64
X1203 (vss n1388 n960 n1394 vdd vss) tx_mux_pdk110_64
X1204 (vss n1389 n960 n1395 vdd vss) tx_mux_pdk110_64
X1205 (vss n1390 n960 n1396 vdd vss) tx_mux_pdk110_64
X1206 (vss n1391 n960 n1397 vdd vss) tx_mux_pdk110_64
X1207 (vss n1392 n960 n1398 vdd vss) tx_mux_pdk110_64
X1208 (vss n1393 n960 n1399 vdd vss) tx_mux_pdk110_64
X1209 (n1394 vss n234 n1400 vdd vss) tx_mux_pdk110_64
X1210 (n1395 vss n234 n1401 vdd vss) tx_mux_pdk110_64
X1211 (n1396 vss n234 n1402 vdd vss) tx_mux_pdk110_64
X1212 (n1397 vss n234 n1403 vdd vss) tx_mux_pdk110_64
X1213 (n1398 vss n234 n1404 vdd vss) tx_mux_pdk110_64
X1214 (n1399 vss n234 n1405 vdd vss) tx_mux_pdk110_64
X1215 (vdd vss n232 n1366 vdd vss) tx_mux_pdk110_64
X1216 (n1400 n1366 n238 n1406 vdd vss) tx_mux_pdk110_64
X1217 (n1401 n1366 n238 n1407 vdd vss) tx_mux_pdk110_64
X1218 (n1402 n1368 n238 n1408 vdd vss) tx_mux_pdk110_64
X1219 (n1403 n1366 n238 n1409 vdd vss) tx_mux_pdk110_64
X1220 (n1404 n1368 n238 n1410 vdd vss) tx_mux_pdk110_64
X1221 (n1405 n1368 n238 n1411 vdd vss) tx_mux_pdk110_64
X1222 (n1374 n1406 n88 n149 vdd vss) tx_mux_pdk110_64
X1223 (n1374 n1407 n88 n148 vdd vss) tx_mux_pdk110_64
X1224 (n1375 n1408 n88 n147 vdd vss) tx_mux_pdk110_64
X1225 (n1374 n1409 n88 n146 vdd vss) tx_mux_pdk110_64
X1226 (n1375 n1410 n88 n144 vdd vss) tx_mux_pdk110_64
X1227 (n1375 n1411 n88 n193 vdd vss) tx_mux_pdk110_64
X1228 (vss n1089 n960 n1412 vdd vss) tx_mux_pdk110_64
X1229 (vss n557 n960 n1413 vdd vss) tx_mux_pdk110_64
X1230 (vss n559 n960 n1414 vdd vss) tx_mux_pdk110_64
X1231 (n1412 vss n234 n1415 vdd vss) tx_mux_pdk110_64
X1232 (n1413 vss n234 n1416 vdd vss) tx_mux_pdk110_64
X1233 (n1414 vss n234 n1417 vdd vss) tx_mux_pdk110_64
X1234 (n1089 vss n232 n1418 vdd vss) tx_mux_pdk110_64
X1235 (n557 vss n232 n1419 vdd vss) tx_mux_pdk110_64
X1236 (n559 vss n232 n1420 vdd vss) tx_mux_pdk110_64
X1237 (n1415 n1418 n238 n1421 vdd vss) tx_mux_pdk110_64
X1238 (n1416 n1419 n238 n1422 vdd vss) tx_mux_pdk110_64
X1239 (n1417 n1420 n238 n1423 vdd vss) tx_mux_pdk110_64
X1240 (n1375 n1421 n88 n140 vdd vss) tx_mux_pdk110_64
X1241 (n1375 n1422 n88 n138 vdd vss) tx_mux_pdk110_64
X1242 (n1375 n1423 n88 n199 vdd vss) tx_mux_pdk110_64
X1243 (vss n236 n960 n1424 vdd vss) tx_mux_pdk110_64
X1244 (n1424 vss n234 n1425 vdd vss) tx_mux_pdk110_64
X1245 (n1425 vss n238 n1426 vdd vss) tx_mux_pdk110_64
X1246 (n1375 n1426 n88 n200 vdd vss) tx_mux_pdk110_64
X1247 (n966 vdd n88 n196 vdd vss) tx_mux_pdk110_64
X1248 (vss n60 n980 n1427 vdd vss) tx_mux_pdk110_64
X1249 (vss n62 n980 n1428 vdd vss) tx_mux_pdk110_64
X1250 (vss n64 n980 n1429 vdd vss) tx_mux_pdk110_64
X1251 (vss n66 n980 n1430 vdd vss) tx_mux_pdk110_64
X1252 (vss n68 n980 n1431 vdd vss) tx_mux_pdk110_64
X1253 (vss n70 n980 n1432 vdd vss) tx_mux_pdk110_64
X1254 (vss n72 n980 n1433 vdd vss) tx_mux_pdk110_64
X1255 (vss vss n980 n1434 vdd vss) tx_mux_pdk110_64
X1256 (n1427 vss n88 n1435 vdd vss) tx_mux_pdk110_64
X1257 (n1428 vss n88 n1436 vdd vss) tx_mux_pdk110_64
X1258 (n1429 vss n88 n1437 vdd vss) tx_mux_pdk110_64
X1259 (n1430 vss n88 n1438 vdd vss) tx_mux_pdk110_64
X1260 (n1431 vss n88 n1439 vdd vss) tx_mux_pdk110_64
X1261 (n1432 vss n88 n1440 vdd vss) tx_mux_pdk110_64
X1262 (n1433 vss n88 n1441 vdd vss) tx_mux_pdk110_64
X1263 (n1434 vss n88 n1442 vdd vss) tx_mux_pdk110_64
X1264 (vss n60 n980 n1443 vdd vss) tx_mux_pdk110_64
X1265 (vss n62 n980 n1444 vdd vss) tx_mux_pdk110_64
X1266 (vss n64 n980 n1445 vdd vss) tx_mux_pdk110_64
X1267 (vss n66 n980 n1446 vdd vss) tx_mux_pdk110_64
X1268 (vss n68 n980 n1447 vdd vss) tx_mux_pdk110_64
X1269 (vdd n70 n980 n1448 vdd vss) tx_mux_pdk110_64
X1270 (vss n72 n980 n1449 vdd vss) tx_mux_pdk110_64
X1271 (n1443 n1435 n117 n1450 vdd vss) tx_mux_pdk110_64
X1272 (n1444 n1436 n117 n1451 vdd vss) tx_mux_pdk110_64
X1273 (n1445 n1437 n117 n1452 vdd vss) tx_mux_pdk110_64
X1274 (n1446 n1438 n117 n1453 vdd vss) tx_mux_pdk110_64
X1275 (n1447 n1439 n117 n1454 vdd vss) tx_mux_pdk110_64
X1276 (n1448 n1440 n117 n1455 vdd vss) tx_mux_pdk110_64
X1277 (n1449 n1441 n117 n1456 vdd vss) tx_mux_pdk110_64
X1278 (vss n1442 n117 n1457 vdd vss) tx_mux_pdk110_64
X1279 (n978 n1165 vdd vss) pll_inv_pdk110_7
X1280 (vss n1450 n51 n157 vdd vss) tx_mux_pdk110_64
X1281 (vss n1451 n51 n156 vdd vss) tx_mux_pdk110_64
X1282 (vss n1452 n51 n155 vdd vss) tx_mux_pdk110_64
X1283 (vss n1453 n51 n154 vdd vss) tx_mux_pdk110_64
X1284 (vss n1454 n51 n153 vdd vss) tx_mux_pdk110_64
X1285 (n1165 n1455 n51 n152 vdd vss) tx_mux_pdk110_64
X1286 (vss n1456 n51 n150 vdd vss) tx_mux_pdk110_64
X1287 (n978 n1457 n51 n190 vdd vss) tx_mux_pdk110_64
X1288 (n980 n966 vdd vss) pll_inv_pdk110_7
X1289 (n966 vdd n117 n1458 vdd vss) tx_mux_pdk110_64
X1290 (n1459 n1458 n51 n178 vdd vss) tx_mux_pdk110_64
X1291 (vss n266 n1102 n1460 vdd vss) tx_mux_pdk110_64
X1292 (vss n583 n1102 n1461 vdd vss) tx_mux_pdk110_64
X1293 (vss n585 n1102 n1462 vdd vss) tx_mux_pdk110_64
X1294 (vss n587 n1102 n1463 vdd vss) tx_mux_pdk110_64
X1295 (vss n589 n1102 n1464 vdd vss) tx_mux_pdk110_64
X1296 (vss n591 n1102 n1465 vdd vss) tx_mux_pdk110_64
X1297 (vss n593 n1102 n1466 vdd vss) tx_mux_pdk110_64
X1298 (vss n595 n1102 n1467 vdd vss) tx_mux_pdk110_64
X1299 (vss n266 n1081 n1468 vdd vss) tx_mux_pdk110_64
X1300 (vss n583 n1081 n1469 vdd vss) tx_mux_pdk110_64
X1301 (vss n585 n1081 n1470 vdd vss) tx_mux_pdk110_64
X1302 (vss n587 n1081 n1471 vdd vss) tx_mux_pdk110_64
X1303 (vss n589 n1081 n1472 vdd vss) tx_mux_pdk110_64
X1304 (vss n591 n1081 n1473 vdd vss) tx_mux_pdk110_64
X1305 (vss n593 n1081 n1474 vdd vss) tx_mux_pdk110_64
X1306 (vss n595 n1081 n1475 vdd vss) tx_mux_pdk110_64
X1307 (vss n266 n1074 n1476 vdd vss) tx_mux_pdk110_64
X1308 (vss n583 n1074 n1477 vdd vss) tx_mux_pdk110_64
X1309 (vss n585 n1074 n1478 vdd vss) tx_mux_pdk110_64
X1310 (vss n587 n1074 n1479 vdd vss) tx_mux_pdk110_64
X1311 (vss n589 n1074 n1480 vdd vss) tx_mux_pdk110_64
X1312 (vss n591 n1074 n1481 vdd vss) tx_mux_pdk110_64
X1313 (vss n593 n1074 n1482 vdd vss) tx_mux_pdk110_64
X1314 (vss n595 n1074 n1483 vdd vss) tx_mux_pdk110_64
X1315 (vss n266 n1069 n1484 vdd vss) tx_mux_pdk110_64
X1316 (vss n583 n1069 n1485 vdd vss) tx_mux_pdk110_64
X1317 (vss n585 n1069 n1486 vdd vss) tx_mux_pdk110_64
X1318 (vss n587 n1069 n1487 vdd vss) tx_mux_pdk110_64
X1319 (vss n589 n1069 n1488 vdd vss) tx_mux_pdk110_64
X1320 (vss n591 n1069 n1489 vdd vss) tx_mux_pdk110_64
X1321 (vss n593 n1069 n1490 vdd vss) tx_mux_pdk110_64
X1322 (vss n595 n1069 n1491 vdd vss) tx_mux_pdk110_64
X1323 (vdd vss n1102 n1492 vdd vss) tx_mux_pdk110_64
X1324 (vss vss n1102 n1493 vdd vss) tx_mux_pdk110_64
X1325 (n243 n240 n351 n1494 vdd vss) tx_mux_pdk110_64
X1326 (n1494 vss n236 n1495 vdd vss) tx_mux_pdk110_64
X1327 (vdd n1495 n960 n1496 vdd vss) tx_mux_pdk110_64
X1328 (n1496 vss n234 n1497 vdd vss) tx_mux_pdk110_64
X1329 (n1496 vdd n234 n1498 vdd vss) tx_mux_pdk110_64
X1330 (n1497 n232 n238 n1499 vdd vss) tx_mux_pdk110_64
X1331 (n1498 n232 n238 n1500 vdd vss) tx_mux_pdk110_64
X1332 (vss n1499 n88 n1501 vdd vss) tx_mux_pdk110_64
X1333 (vss n1500 n88 n1502 vdd vss) tx_mux_pdk110_64
X1334 (vss n1501 n117 n1503 vdd vss) tx_mux_pdk110_64
X1335 (vss n1502 n117 n1504 vdd vss) tx_mux_pdk110_64
X1336 (vss n1503 n51 n1505 vdd vss) tx_mux_pdk110_64
X1337 (vss n1504 n51 n1506 vdd vss) tx_mux_pdk110_64
X1338 (vdd vss n1081 n1507 vdd vss) tx_mux_pdk110_64
X1339 (vss vss n1081 n1508 vdd vss) tx_mux_pdk110_64
X1340 (vss vss n1074 n1509 vdd vss) tx_mux_pdk110_64
X1341 (vdd vss n1074 n1510 vdd vss) tx_mux_pdk110_64
X1342 (vdd vss n1069 n1511 vdd vss) tx_mux_pdk110_64
X1343 (vss vss n1069 n1512 vdd vss) tx_mux_pdk110_64
X1344 (vss vdd n240 n1513 vdd vss) tx_mux_pdk110_64
X1345 (vss vdd n243 n1514 vdd vss) tx_mux_pdk110_64
X1346 (n1514 n1513 n351 n1515 vdd vss) tx_mux_pdk110_64
X1347 (n1515 vss n236 n1516 vdd vss) tx_mux_pdk110_64
X1348 (vdd n1516 n960 n1517 vdd vss) tx_mux_pdk110_64
X1349 (n1517 vss n234 n1518 vdd vss) tx_mux_pdk110_64
X1350 (vss vdd n232 n1519 vdd vss) tx_mux_pdk110_64
X1351 (n1518 n1519 n238 n194 vdd vss) tx_mux_pdk110_64
X1352 (n1269 vss n1102 n1520 vdd vss) tx_mux_pdk110_64
X1353 (vss vss n240 n1521 vdd vss) tx_mux_pdk110_64
X1354 (vss vss n243 n1522 vdd vss) tx_mux_pdk110_64
X1355 (n1522 n1521 n351 n1523 vdd vss) tx_mux_pdk110_64
X1356 (n1523 vss n236 n1524 vdd vss) tx_mux_pdk110_64
X1357 (vss n1524 n960 n1525 vdd vss) tx_mux_pdk110_64
X1358 (n1525 vss n234 n1526 vdd vss) tx_mux_pdk110_64
X1359 (vss vss n232 n1527 vdd vss) tx_mux_pdk110_64
X1360 (n1526 n1527 n238 n1528 vdd vss) tx_mux_pdk110_64
X1361 (vss n1528 n88 n1529 vdd vss) tx_mux_pdk110_64
X1362 (vss n1529 n117 n1530 vdd vss) tx_mux_pdk110_64
X1363 (vss n1530 n51 n1531 vdd vss) tx_mux_pdk110_64
X1364 (vss n336 n980 n1532 vdd vss) tx_mux_pdk110_64
X1365 (vss n338 n980 n1533 vdd vss) tx_mux_pdk110_64
X1366 (vss n340 n980 n1534 vdd vss) tx_mux_pdk110_64
X1367 (vss n342 n980 n1535 vdd vss) tx_mux_pdk110_64
X1368 (vss n344 n980 n1536 vdd vss) tx_mux_pdk110_64
X1369 (vdd n1320 n980 n1537 vdd vss) tx_mux_pdk110_64
X1370 (n364 vss n240 n1538 vdd vss) tx_mux_pdk110_64
X1371 (n367 vss n240 n1539 vdd vss) tx_mux_pdk110_64
X1372 (n370 vss n240 n1540 vdd vss) tx_mux_pdk110_64
X1373 (n373 vss n240 n1541 vdd vss) tx_mux_pdk110_64
X1374 (n376 vss n240 n1542 vdd vss) tx_mux_pdk110_64
X1375 (n379 vss n240 n1543 vdd vss) tx_mux_pdk110_64
X1376 (n391 vss n243 n1544 vdd vss) tx_mux_pdk110_64
X1377 (n393 vss n243 n1545 vdd vss) tx_mux_pdk110_64
X1378 (n395 vss n243 n1546 vdd vss) tx_mux_pdk110_64
X1379 (n397 vss n243 n1547 vdd vss) tx_mux_pdk110_64
X1380 (n399 vss n243 n1548 vdd vss) tx_mux_pdk110_64
X1381 (n401 vss n243 n1549 vdd vss) tx_mux_pdk110_64
X1382 (n1544 n1538 n351 n1550 vdd vss) tx_mux_pdk110_64
X1383 (n1545 n1539 n351 n1551 vdd vss) tx_mux_pdk110_64
X1384 (n1546 n1540 n351 n1552 vdd vss) tx_mux_pdk110_64
X1385 (n1547 n1541 n351 n1553 vdd vss) tx_mux_pdk110_64
X1386 (n1548 n1542 n351 n1554 vdd vss) tx_mux_pdk110_64
X1387 (n1549 n1543 n351 n1555 vdd vss) tx_mux_pdk110_64
X1388 (n1550 vss n236 n1556 vdd vss) tx_mux_pdk110_64
X1389 (n1551 vss n236 n1557 vdd vss) tx_mux_pdk110_64
X1390 (n1552 vss n236 n1558 vdd vss) tx_mux_pdk110_64
X1391 (n1553 vss n236 n1559 vdd vss) tx_mux_pdk110_64
X1392 (n1554 vss n236 n1560 vdd vss) tx_mux_pdk110_64
X1393 (n1555 vss n236 n1561 vdd vss) tx_mux_pdk110_64
X1394 (vss n1556 n960 n1562 vdd vss) tx_mux_pdk110_64
X1395 (vss n1557 n960 n1563 vdd vss) tx_mux_pdk110_64
X1396 (vss n1558 n960 n1564 vdd vss) tx_mux_pdk110_64
X1397 (vss n1559 n960 n1565 vdd vss) tx_mux_pdk110_64
X1398 (vss n1560 n960 n1566 vdd vss) tx_mux_pdk110_64
X1399 (vss n1561 n960 n1567 vdd vss) tx_mux_pdk110_64
X1400 (n1562 vss n234 n1568 vdd vss) tx_mux_pdk110_64
X1401 (n1563 vss n234 n1569 vdd vss) tx_mux_pdk110_64
X1402 (n1564 vss n234 n1570 vdd vss) tx_mux_pdk110_64
X1403 (n1565 vss n234 n1571 vdd vss) tx_mux_pdk110_64
X1404 (n1566 vss n234 n1572 vdd vss) tx_mux_pdk110_64
X1405 (n1567 vss n234 n1573 vdd vss) tx_mux_pdk110_64
X1406 (vss vss n232 n1368 vdd vss) tx_mux_pdk110_64
X1407 (n1568 n1368 n238 n1574 vdd vss) tx_mux_pdk110_64
X1408 (n1569 n1368 n238 n1575 vdd vss) tx_mux_pdk110_64
X1409 (n1570 n1368 n238 n1576 vdd vss) tx_mux_pdk110_64
X1410 (n1571 n1368 n238 n1577 vdd vss) tx_mux_pdk110_64
X1411 (n1572 n1368 n238 n1578 vdd vss) tx_mux_pdk110_64
X1412 (n1573 n1366 n238 n1579 vdd vss) tx_mux_pdk110_64
X1413 (n1532 n1574 n88 n1580 vdd vss) tx_mux_pdk110_64
X1414 (n1533 n1575 n88 n1581 vdd vss) tx_mux_pdk110_64
X1415 (n1534 n1576 n88 n1582 vdd vss) tx_mux_pdk110_64
X1416 (n1535 n1577 n88 n1583 vdd vss) tx_mux_pdk110_64
X1417 (n1536 n1578 n88 n1584 vdd vss) tx_mux_pdk110_64
X1418 (n1537 n1579 n88 n1585 vdd vss) tx_mux_pdk110_64
X1419 (vss vss n980 n1375 vdd vss) tx_mux_pdk110_64
X1420 (n1375 n1580 n117 n1586 vdd vss) tx_mux_pdk110_64
X1421 (n1375 n1581 n117 n1587 vdd vss) tx_mux_pdk110_64
X1422 (n1375 n1582 n117 n1588 vdd vss) tx_mux_pdk110_64
X1423 (n1375 n1583 n117 n1589 vdd vss) tx_mux_pdk110_64
X1424 (n1375 n1584 n117 n1590 vdd vss) tx_mux_pdk110_64
X1425 (n1374 n1585 n117 n1591 vdd vss) tx_mux_pdk110_64
X1426 (vss vss n978 n1592 vdd vss) tx_mux_pdk110_64
X1427 (vdd vss n978 n1459 vdd vss) tx_mux_pdk110_64
X1428 (n1592 n1586 n51 n163 vdd vss) tx_mux_pdk110_64
X1429 (n1592 n1587 n51 n162 vdd vss) tx_mux_pdk110_64
X1430 (n1592 n1588 n51 n161 vdd vss) tx_mux_pdk110_64
X1431 (n1592 n1589 n51 n160 vdd vss) tx_mux_pdk110_64
X1432 (n1592 n1590 n51 n158 vdd vss) tx_mux_pdk110_64
X1433 (n1459 n1591 n51 n182 vdd vss) tx_mux_pdk110_64
X1434 (n296 vss n232 n1593 vdd vss) tx_mux_pdk110_64
X1435 (n1329 vss n232 n1594 vdd vss) tx_mux_pdk110_64
X1436 (n1330 vss n232 n1595 vdd vss) tx_mux_pdk110_64
X1437 (n1331 vss n232 n1596 vdd vss) tx_mux_pdk110_64
X1438 (n1332 vss n232 n1597 vdd vss) tx_mux_pdk110_64
X1439 (n1333 vss n232 n1598 vdd vss) tx_mux_pdk110_64
X1440 (n1334 vss n232 n1599 vdd vss) tx_mux_pdk110_64
X1441 (n1335 vss n232 n1600 vdd vss) tx_mux_pdk110_64
X1442 (vss n1593 n238 n1601 vdd vss) tx_mux_pdk110_64
X1443 (vss n1594 n238 n1602 vdd vss) tx_mux_pdk110_64
X1444 (vss n1595 n238 n1603 vdd vss) tx_mux_pdk110_64
X1445 (vss n1596 n238 n1604 vdd vss) tx_mux_pdk110_64
X1446 (vss n1597 n238 n1605 vdd vss) tx_mux_pdk110_64
X1447 (vss n1598 n238 n1606 vdd vss) tx_mux_pdk110_64
X1448 (vss n1599 n238 n1607 vdd vss) tx_mux_pdk110_64
X1449 (vss n1600 n238 n1608 vdd vss) tx_mux_pdk110_64
X1450 (vss n1601 n88 n1609 vdd vss) tx_mux_pdk110_64
X1451 (vss n1602 n88 n1610 vdd vss) tx_mux_pdk110_64
X1452 (vss n1603 n88 n1611 vdd vss) tx_mux_pdk110_64
X1453 (vss n1604 n88 n1612 vdd vss) tx_mux_pdk110_64
X1454 (vss n1605 n88 n1613 vdd vss) tx_mux_pdk110_64
X1455 (vss n1606 n88 n1614 vdd vss) tx_mux_pdk110_64
X1456 (vss n1607 n88 n1615 vdd vss) tx_mux_pdk110_64
X1457 (vss n1608 n88 n1616 vdd vss) tx_mux_pdk110_64
X1458 (n1321 n323 n980 n1617 vdd vss) tx_mux_pdk110_64
X1459 (n1322 n324 n980 n1618 vdd vss) tx_mux_pdk110_64
X1460 (n1323 n326 n980 n1619 vdd vss) tx_mux_pdk110_64
X1461 (n1324 n328 n980 n1620 vdd vss) tx_mux_pdk110_64
X1462 (n1325 n330 n980 n1621 vdd vss) tx_mux_pdk110_64
X1463 (n1326 n332 n980 n1622 vdd vss) tx_mux_pdk110_64
X1464 (n1327 n334 n980 n1623 vdd vss) tx_mux_pdk110_64
X1465 (n1328 n522 n980 n1624 vdd vss) tx_mux_pdk110_64
X1466 (n1617 n1609 n117 n1625 vdd vss) tx_mux_pdk110_64
X1467 (n1618 n1610 n117 n1626 vdd vss) tx_mux_pdk110_64
X1468 (n1619 n1611 n117 n1627 vdd vss) tx_mux_pdk110_64
X1469 (n1620 n1612 n117 n1628 vdd vss) tx_mux_pdk110_64
X1470 (n1621 n1613 n117 n1629 vdd vss) tx_mux_pdk110_64
X1471 (n1622 n1614 n117 n1630 vdd vss) tx_mux_pdk110_64
X1472 (n1623 n1615 n117 n1631 vdd vss) tx_mux_pdk110_64
X1473 (n1624 n1616 n117 n1632 vdd vss) tx_mux_pdk110_64
X1474 (vss n1625 n51 n177 vdd vss) tx_mux_pdk110_64
X1475 (vss n1626 n51 n176 vdd vss) tx_mux_pdk110_64
X1476 (vss n1627 n51 n175 vdd vss) tx_mux_pdk110_64
X1477 (vss n1628 n51 n174 vdd vss) tx_mux_pdk110_64
X1478 (vss n1629 n51 n173 vdd vss) tx_mux_pdk110_64
X1479 (vss n1630 n51 n172 vdd vss) tx_mux_pdk110_64
X1480 (vss n1631 n51 n170 vdd vss) tx_mux_pdk110_64
X1481 (n978 n1632 n51 n180 vdd vss) tx_mux_pdk110_64
X1482 (n1484 n1055 n1180 vdd vss) tx_and_pdk110_47
X1483 (n1476 n1238 n1181 vdd vss) tx_and_pdk110_47
X1484 (n1468 n1053 n1183 vdd vss) tx_and_pdk110_47
X1485 (n1460 n1175 n1184 vdd vss) tx_and_pdk110_47
X1486 (n1485 n1055 n1187 vdd vss) tx_and_pdk110_47
X1487 (n1477 n1238 n1188 vdd vss) tx_and_pdk110_47
X1488 (n1469 n1053 n1190 vdd vss) tx_and_pdk110_47
X1489 (n1461 n1175 n1191 vdd vss) tx_and_pdk110_47
X1490 (n1486 n1055 n1194 vdd vss) tx_and_pdk110_47
X1491 (n1478 n1238 n1195 vdd vss) tx_and_pdk110_47
X1492 (n1470 n1053 n1197 vdd vss) tx_and_pdk110_47
X1493 (n1462 n1175 n1198 vdd vss) tx_and_pdk110_47
X1494 (n1487 n1055 n1201 vdd vss) tx_and_pdk110_47
X1495 (n1479 n1238 n1202 vdd vss) tx_and_pdk110_47
X1496 (n1471 n1053 n1204 vdd vss) tx_and_pdk110_47
X1497 (n1463 n1175 n1205 vdd vss) tx_and_pdk110_47
X1498 (n1488 n1055 n1208 vdd vss) tx_and_pdk110_47
X1499 (n1480 n1238 n1209 vdd vss) tx_and_pdk110_47
X1500 (n1472 n1053 n1211 vdd vss) tx_and_pdk110_47
X1501 (n1464 n1175 n1212 vdd vss) tx_and_pdk110_47
X1502 (n1489 n1055 n1215 vdd vss) tx_and_pdk110_47
X1503 (n1481 n1238 n1216 vdd vss) tx_and_pdk110_47
X1504 (n1473 n1053 n1218 vdd vss) tx_and_pdk110_47
X1505 (n1465 n1175 n1219 vdd vss) tx_and_pdk110_47
X1506 (n1490 n1055 n1222 vdd vss) tx_and_pdk110_47
X1507 (n1482 n1238 n1223 vdd vss) tx_and_pdk110_47
X1508 (n1474 n1053 n1225 vdd vss) tx_and_pdk110_47
X1509 (n1466 n1175 n1226 vdd vss) tx_and_pdk110_47
X1510 (n1491 n1055 n1229 vdd vss) tx_and_pdk110_47
X1511 (n1483 n1238 n1230 vdd vss) tx_and_pdk110_47
X1512 (n1475 n1053 n1232 vdd vss) tx_and_pdk110_47
X1513 (n1467 n1175 n1233 vdd vss) tx_and_pdk110_47
X1514 (n1505 n184 n1241 vdd vss) tx_and_pdk110_47
X1515 (n1511 n1055 n1245 vdd vss) tx_and_pdk110_47
X1516 (n1493 n1175 n1253 vdd vss) tx_and_pdk110_47
X1517 (n1507 n1053 n1242 vdd vss) tx_and_pdk110_47
X1518 (n1510 n1238 n1250 vdd vss) tx_and_pdk110_47
X1519 (n1492 n1175 n1247 vdd vss) tx_and_pdk110_47
X1520 (n1506 n184 n1256 vdd vss) tx_and_pdk110_47
X1521 (n1508 n1053 n1257 vdd vss) tx_and_pdk110_47
X1522 (n1509 n1238 n1244 vdd vss) tx_and_pdk110_47
X1523 (n1512 n1055 n1251 vdd vss) tx_and_pdk110_47
X1524 (n1520 n1175 n1262 vdd vss) tx_and_pdk110_47
X1525 (n1531 n184 n1263 vdd vss) tx_and_pdk110_47
X1526 (n1069 n1055 n1265 vdd vss) tx_and_pdk110_47
X1527 (n68 n306 vdd vss) pll_inv_pdk110_7
X1528 (n70 n308 vdd vss) pll_inv_pdk110_7
X1529 (n72 n310 vdd vss) pll_inv_pdk110_7
X1530 (n60 n298 vdd vss) pll_inv_pdk110_7
X1531 (n62 n300 vdd vss) pll_inv_pdk110_7
X1532 (n64 n302 vdd vss) pll_inv_pdk110_7
X1533 (n66 n304 vdd vss) pll_inv_pdk110_7
X1534 (n351 n1031 vdd vss) pll_inv_pdk110_7
X1535 (n346 n1126 vdd vss) pll_inv_pdk110_7
X1536 (n348 n1131 vdd vss) pll_inv_pdk110_7
X1537 (n824 n349 vdd vss) pll_inv_pdk110_7
X1538 (n908 n1141 vdd vss) pll_inv_pdk110_7
X1539 (n354 n1144 vdd vss) pll_inv_pdk110_7
X1540 (n943 n352 vdd vss) pll_inv_pdk110_7
X1541 (n127 n923 vdd vss) pll_inv_pdk110_7
X1542 (n129 n925 vdd vss) pll_inv_pdk110_7
X1543 (n131 n927 vdd vss) pll_inv_pdk110_7
X1544 (n135 n931 vdd vss) pll_inv_pdk110_7
X1545 (n137 n933 vdd vss) pll_inv_pdk110_7
X1546 (dac1 n500 vdd vss) pll_inv_pdk110_7
X1547 (dac5 n578 vdd vss) pll_inv_pdk110_7
X1548 (measured0 n403 vdd vss) pll_inv_pdk110_7
X1549 (measured1 n402 vdd vss) pll_inv_pdk110_7
X1550 (measured4 n641 vdd vss) pll_inv_pdk110_7
X1551 (measured5 n644 vdd vss) pll_inv_pdk110_7
X1552 (measured6 n647 vdd vss) pll_inv_pdk110_7
X1553 (measured7 n650 vdd vss) pll_inv_pdk110_7
X1554 (measured8 n653 vdd vss) pll_inv_pdk110_7
X1555 (measured9 n656 vdd vss) pll_inv_pdk110_7
X1556 (measured10 n659 vdd vss) pll_inv_pdk110_7
X1557 (measured11 n662 vdd vss) pll_inv_pdk110_7
X1558 (measured12 n665 vdd vss) pll_inv_pdk110_7
X1559 (measured13 n668 vdd vss) pll_inv_pdk110_7
X1560 (n646 n885 vdd vss) pll_inv_pdk110_7
X1561 (n649 n699 vdd vss) pll_inv_pdk110_7
X1562 (n652 n816 vdd vss) pll_inv_pdk110_7
X1563 (n655 n817 vdd vss) pll_inv_pdk110_7
X1564 (n658 n818 vdd vss) pll_inv_pdk110_7
X1565 (n664 n700 vdd vss) pll_inv_pdk110_7
X1566 (target_k3 n754 vdd vss) pll_inv_pdk110_7
X1567 (target_k4 n1123 vdd vss) pll_inv_pdk110_7
X1568 (target_k5 n747 vdd vss) pll_inv_pdk110_7
X1569 (target_k1 n1118 vdd vss) pll_inv_pdk110_7
X1570 (n643 n698 vdd vss) pll_inv_pdk110_7
X1571 (n322 n1128 vdd vss) pll_inv_pdk110_7
X1572 (coarse1 n538 vdd vss) pll_inv_pdk110_7
X1573 (coarse2 n540 vdd vss) pll_inv_pdk110_7
X1574 (coarse3 n543 vdd vss) pll_inv_pdk110_7
X1575 (coarse4 n546 vdd vss) pll_inv_pdk110_7
X1576 (coarse5 n549 vdd vss) pll_inv_pdk110_7
X1577 (coarse6 n552 vdd vss) pll_inv_pdk110_7
X1578 (n93 n1089 vdd vss) pll_inv_pdk110_7
X1579 (n95 n1090 vdd vss) pll_inv_pdk110_7
X1580 (n640 n696 vdd vss) pll_inv_pdk110_7
X1581 (n661 n702 vdd vss) pll_inv_pdk110_7
X1582 (n667 n886 vdd vss) pll_inv_pdk110_7
X1583 (n75 n888 vdd vss) pll_inv_pdk110_7
X1584 (n77 n890 vdd vss) pll_inv_pdk110_7
X1585 (n79 n892 vdd vss) pll_inv_pdk110_7
X1586 (n81 n894 vdd vss) pll_inv_pdk110_7
X1587 (n83 n896 vdd vss) pll_inv_pdk110_7
X1588 (n85 n898 vdd vss) pll_inv_pdk110_7
X1589 (n133 n929 vdd vss) pll_inv_pdk110_7
X1590 (dac2 n572 vdd vss) pll_inv_pdk110_7
X1591 (dac4 n575 vdd vss) pll_inv_pdk110_7
X1592 (n101 n1075 vdd vss) pll_inv_pdk110_7
X1593 (n103 n1062 vdd vss) pll_inv_pdk110_7
X1594 (n105 n1098 vdd vss) pll_inv_pdk110_7
X1595 (vss n1186 n1179 n209 vdd vss) tx_mux_pdk110_64
X1596 (vss n1193 n1179 n208 vdd vss) tx_mux_pdk110_64
X1597 (vss n1200 n1179 n207 vdd vss) tx_mux_pdk110_64
X1598 (vss n1207 n1179 n206 vdd vss) tx_mux_pdk110_64
X1599 (vss n1214 n1179 n205 vdd vss) tx_mux_pdk110_64
X1600 (vss n1221 n1179 n204 vdd vss) tx_mux_pdk110_64
X1601 (vss n1228 n1179 n202 vdd vss) tx_mux_pdk110_64
X1602 (vss n1235 n1179 n210 vdd vss) tx_mux_pdk110_64
X1603 (vss n1249 n1240 n143 vdd vss) tx_mux_pdk110_64
X1604 (vss n1255 n1240 n141 vdd vss) tx_mux_pdk110_64
X1605 (vss n1261 n1240 n198 vdd vss) tx_mux_pdk110_64
X1606 (vss n1264 n981 n191 vdd vss) tx_mux_pdk110_64
X1607 (vss n1266 n189 n188 vdd vss) tx_mux_pdk110_64
X1608 (vss n1238 n186 n185 vdd vss) tx_mux_pdk110_64
ends tx_fll_recenter109_v14_pdk110_69
