simulator lang=spectre
subckt ring_inv_latch_v14_pdk110_34 (d ck ckb qb vdd vss)
XT (d x ck ckb vdd vss) pll_tg_pdk110_16
XO (x qb vdd vss) pll_inv_pdk110_27
XFI (qb fb vdd vss) pll_inv_pdk110_29
XFB (fb x ckb ck vdd vss) pll_tg_pdk110_35
ends ring_inv_latch_v14_pdk110_34
