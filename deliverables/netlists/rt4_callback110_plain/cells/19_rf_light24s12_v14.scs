simulator lang=spectre
subckt rf_light24s12_v14_pdk110_19 (rf clk vdd vss)
C0 (rf g0) capacitor c=4e-12
R0 (g0 clk) resistor r=20000
X0 (g0 clk vdd vss) pll_inv_pdk110_20
ends rf_light24s12_v14_pdk110_19
