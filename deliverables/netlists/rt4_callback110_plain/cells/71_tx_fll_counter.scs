simulator lang=spectre
subckt tx_fll_counter_pdk110_71 (clk gate reset q0 q1 q2 q3 q4 q5 q6 q7 q8 q9 q10 q11 q12 q13 vdd vss)
XCI (clk clkb vdd vss) pll_inv_pdk110_59
XGE (gate clkb clk safe_gate vdd vss) pll_latch_pdk110_72
XG (clk safe_gate gclk vdd vss) tx_and_pdk110_47
XF0 (gclk reset q0 qb0 vdd vss) tx_tff_pdk110_73
XF1 (qb0 reset q1 qb1 vdd vss) tx_tff_pdk110_73
XF2 (qb1 reset q2 qb2 vdd vss) tx_tff_pdk110_73
XF3 (qb2 reset q3 qb3 vdd vss) tx_tff_pdk110_73
XF4 (qb3 reset q4 qb4 vdd vss) tx_tff_pdk110_73
XF5 (qb4 reset q5 qb5 vdd vss) tx_tff_pdk110_73
XF6 (qb5 reset q6 qb6 vdd vss) tx_tff_pdk110_73
XF7 (qb6 reset q7 qb7 vdd vss) tx_tff_pdk110_73
XF8 (qb7 reset q8 qb8 vdd vss) tx_tff_pdk110_73
XF9 (qb8 reset q9 qb9 vdd vss) tx_tff_pdk110_73
XF10 (qb9 reset q10 qb10 vdd vss) tx_tff_pdk110_73
XF11 (qb10 reset q11 qb11 vdd vss) tx_tff_pdk110_73
XF12 (qb11 reset q12 qb12 vdd vss) tx_tff_pdk110_73
XF13 (qb12 reset q13 qb13 vdd vss) tx_tff_pdk110_73
ends tx_fll_counter_pdk110_71
