simulator lang=spectre
subckt tx_fll_snapshot_pdk110_74 (gate d0 d1 d2 d3 d4 d5 d6 d7 d8 d9 d10 d11 d12 d13 q0 q1 q2 q3 q4 q5 q6 q7 q8 q9 q10 q11 q12 q13 vdd vss)
XI (gate openb vdd vss) pll_inv_pdk110_12
XB (openb hold vdd vss) pll_inv_pdk110_12
XL0 (d0 openb hold q0 vdd vss) pll_latch_pdk110_72
XL1 (d1 openb hold q1 vdd vss) pll_latch_pdk110_72
XL2 (d2 openb hold q2 vdd vss) pll_latch_pdk110_72
XL3 (d3 openb hold q3 vdd vss) pll_latch_pdk110_72
XL4 (d4 openb hold q4 vdd vss) pll_latch_pdk110_72
XL5 (d5 openb hold q5 vdd vss) pll_latch_pdk110_72
XL6 (d6 openb hold q6 vdd vss) pll_latch_pdk110_72
XL7 (d7 openb hold q7 vdd vss) pll_latch_pdk110_72
XL8 (d8 openb hold q8 vdd vss) pll_latch_pdk110_72
XL9 (d9 openb hold q9 vdd vss) pll_latch_pdk110_72
XL10 (d10 openb hold q10 vdd vss) pll_latch_pdk110_72
XL11 (d11 openb hold q11 vdd vss) pll_latch_pdk110_72
XL12 (d12 openb hold q12 vdd vss) pll_latch_pdk110_72
XL13 (d13 openb hold q13 vdd vss) pll_latch_pdk110_72
ends tx_fll_snapshot_pdk110_74
