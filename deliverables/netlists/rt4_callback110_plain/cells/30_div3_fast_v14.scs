simulator lang=spectre
subckt div3_fast_v14_pdk110_30 (clk out vdd vss)
XC (clk clkb vdd vss) pll_inv_pdk110_31
XN (q0 q1 d0 vdd vss) nor_fast_v14_pdk110_32
X0 (d0 clk clkb q0 vdd vss) ff_static_fast_v14_pdk110_33
X1 (q0 clk clkb q1 vdd vss) ff_static_fast_v14_pdk110_33
XB0 (q1 ob vdd vss) pll_inv_pdk110_29
XB1 (ob out vdd vss) pll_inv_pdk110_27
ends div3_fast_v14_pdk110_30
