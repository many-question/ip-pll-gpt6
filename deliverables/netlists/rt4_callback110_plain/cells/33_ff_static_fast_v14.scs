simulator lang=spectre
subckt ff_static_fast_v14_pdk110_33 (d clk clkb q vdd vss)
XM (d clkb clk qm vdd vss) ring_inv_latch_v14_pdk110_34
XS (qm clk clkb q vdd vss) ring_inv_latch_v14_pdk110_34
ends ff_static_fast_v14_pdk110_33
