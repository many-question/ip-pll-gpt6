simulator lang=spectre
subckt tx_inductor_pi_pdk110_3 (p n sub)
RW (p x) resistor r=6.822430344006023
LW (x n) inductor l=2e-09
CW (p n) capacitor c=2e-14
COXP (p sp) capacitor c=8.000000000000001e-14
COXN (n sn) capacitor c=8.000000000000001e-14
RSP (sp sub) resistor r=300
RSN (sn sub) resistor r=300
CSP (sp sub) capacitor c=5e-14
CSN (sn sub) capacitor c=5e-14
ends tx_inductor_pi_pdk110_3
