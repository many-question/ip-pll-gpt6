simulator lang=spectre
subckt tx_and_pdk110_47 (a b y vdd vss)
XN (a b n vdd vss) pll_nand2_pdk110_15
XI (n y vdd vss) pll_inv_pdk110_48
ends tx_and_pdk110_47
