simulator lang=spectre
subckt ring_sync_singlephase_v14_pdk110_42 (d clk clkb load loadb init q vdd vss)
XDATA (d din loadb load vdd vss) pll_tg_pdk110_43
XINIT (init din load loadb vdd vss) pll_tg_pdk110_43
XF (din clk clkb q vdd vss) ff_singlephase_v14_pdk110_44
ends ring_sync_singlephase_v14_pdk110_42
