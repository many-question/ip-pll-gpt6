// Inductor pi | frozen callback110 / recenter109 | RNL 0.3
// @RNL(type="header") { @VERSION("0.3"); @USE-PACKAGE(name="rnl-std-fill") {} }
simulator lang=spectre
subckt tx_inductor_pi_pdk110_3 (p n sub)
RW (p x) resistor r=6.822430344006023
LW (x n) inductor l=2e-09
CW (p n) capacitor c=2e-14
COXP (p sp) capacitor c=8.000000000000001e-14
COXN (n sn) capacitor c=8.000000000000001e-14
RSP (sp sub) resistor r=300
RSN (sn sub) resistor r=300
CSP (sp sub) capacitor c=5e-14
CSN (sn sub) capacitor c=5e-14
// @RNL(author="functional-compact127") {
// $CELL = @DEFINE-SYMBOL {
// @LINE {(-6, -4) (6, -4) (6, 4) (-6, 4) (-6, -4)};
// @LINE {(-4, 1.5) (-3.96593, 1.68117) (-3.86603, 1.85) (-3.70711, 1.99497) (-3.5, 2.10622) (-3.25882, 2.17615) (-3, 2.2) (-2.74118, 2.17615) (-2.5, 2.10622) (-2.29289, 1.99497) (-2.13397, 1.85) (-2.03407, 1.68117) (-2, 1.5)};
// @LINE {(-2, 1.5) (-1.96593, 1.68117) (-1.86603, 1.85) (-1.70711, 1.99497) (-1.5, 2.10622) (-1.25882, 2.17615) (-1, 2.2) (-0.741181, 2.17615) (-0.5, 2.10622) (-0.292893, 1.99497) (-0.133975, 1.85) (-0.0340742, 1.68117) (0, 1.5)};
// @LINE {(0, 1.5) (0.0340742, 1.68117) (0.133975, 1.85) (0.292893, 1.99497) (0.5, 2.10622) (0.741181, 2.17615) (1, 2.2) (1.25882, 2.17615) (1.5, 2.10622) (1.70711, 1.99497) (1.86603, 1.85) (1.96593, 1.68117) (2, 1.5)};
// @LINE {(-4, 1.5) (-4, 0.5)};
// @LINE {(2, 1.5) (4, 1.5) (4, 0.5)};
// @LINE {(-4, 0.5) (-4, -1)};
// @LINE {(-5.5, -1) (-2.5, -1)};
// @LINE {(-5.5, -2) (-2.5, -2)};
// @LINE {(-4, -2) (-4, -3.5)};
// @LINE {(4, 0.5) (4, -1)};
// @LINE {(2.5, -1) (5.5, -1)};
// @LINE {(2.5, -2) (5.5, -2)};
// @LINE {(4, -2) (4, -3.5)};
// (-8, 0) @PIN(terminal="p", direction="left");
// @LINE {(-8, 0) (-6, 0)};
// (-5.4, 0) @TEXT("p", size=0.7, halign="start");
// (8, 0) @PIN(terminal="n", direction="right");
// @LINE {(8, 0) (6, 0)};
// (5.4, 0) @TEXT("n", size=0.7, halign="end");
// (0, -6) @PIN(terminal="sub", direction="down");
// @LINE {(0, -6) (0, -4)};
// ? @TEXT("${name}", key="name", size=1, halign="middle") => @PLACE(8, 7.5);
// (0, 3.1) @TEXT("Inductor pi", size=0.85, halign="middle");
// };
// # @SET-SYMBOL $CELL;
// #RW @PLACE(-18, 16) => @ORIENT("R90");
// #RW @SET-SYMBOL $RESISTOR;
// #RW @TEXT("6.8224", key="value", dx=3, dy=-1, size=0.8, halign="start");
// #RW @TEXT("RW", key="name", dx=3, dy=1, size=0.9, halign="start");
// #LW @PLACE(12, 16) => @ORIENT("R90");
// #LW @SET-SYMBOL $INDUCTOR;
// #LW @TEXT("2n", key="value", dx=3, dy=-1, size=0.8, halign="start");
// #LW @TEXT("LW", key="name", dx=3, dy=1, size=0.9, halign="start");
// #CW @PLACE(-3, 34) => @ORIENT("R90");
// #CW @SET-SYMBOL $CAPACITOR;
// #CW @TEXT("20f", key="value", dx=3, dy=-1, size=0.8, halign="start");
// #CW @TEXT("CW", key="name", dx=3, dy=1, size=0.9, halign="start");
// #COXP @PLACE(-35, 0) => @ORIENT("R0");
// #COXP @SET-SYMBOL $CAPACITOR;
// #COXP @TEXT("80f", key="value", dx=3, dy=-1, size=0.8, halign="start");
// #COXP @TEXT("COXP", key="name", dx=3, dy=1, size=0.9, halign="start");
// #COXN @PLACE(35, 0) => @ORIENT("R0");
// #COXN @SET-SYMBOL $CAPACITOR;
// #COXN @TEXT("80f", key="value", dx=3, dy=-1, size=0.8, halign="start");
// #COXN @TEXT("COXN", key="name", dx=3, dy=1, size=0.9, halign="start");
// #RSP @PLACE(-45, -15) => @ORIENT("R0");
// #RSP @SET-SYMBOL $RESISTOR;
// #RSP @TEXT("300", key="value", dx=3, dy=-1, size=0.8, halign="start");
// #RSP @TEXT("RSP", key="name", dx=3, dy=1, size=0.9, halign="start");
// #CSP @PLACE(-25, -15) => @ORIENT("R0");
// #CSP @SET-SYMBOL $CAPACITOR;
// #CSP @TEXT("50f", key="value", dx=3, dy=-1, size=0.8, halign="start");
// #CSP @TEXT("CSP", key="name", dx=3, dy=1, size=0.9, halign="start");
// #RSN @PLACE(25, -15) => @ORIENT("R0");
// #RSN @SET-SYMBOL $RESISTOR;
// #RSN @TEXT("300", key="value", dx=3, dy=-1, size=0.8, halign="start");
// #RSN @TEXT("RSN", key="name", dx=3, dy=1, size=0.9, halign="start");
// #CSN @PLACE(45, -15) => @ORIENT("R0");
// #CSN @SET-SYMBOL $CAPACITOR;
// #CSN @TEXT("50f", key="value", dx=3, dy=-1, size=0.8, halign="start");
// #CSN @TEXT("CSN", key="name", dx=3, dy=1, size=0.9, halign="start");
// &x @WIRE(mode="straight") {#RW:2 #LW:1};
// %p = (-35, 16);
// &p @WIRE(mode="straight") {#RW:1 %p #COXP:1};
// &p @WIRE(mode="straight") {%p (-35, 34) #CW:1};
// $JUNCTION @ATTACH %p;
// %n = (35, 16);
// &n @WIRE(mode="straight") {#LW:2 %n #COXN:1};
// &n @WIRE(mode="straight") {%n (35, 34) #CW:2};
// $JUNCTION @ATTACH %n;
// %sp = (-35, -7);
// &sp @WIRE(mode="straight") {#COXP:2 %sp};
// &sp @WIRE(mode="straight") {%sp (-45, -7) #RSP:1};
// &sp @WIRE(mode="straight") {%sp (-25, -7) #CSP:1};
// $JUNCTION @ATTACH %sp;
// %sn = (35, -7);
// &sn @WIRE(mode="straight") {#COXN:2 %sn};
// &sn @WIRE(mode="straight") {%sn (25, -7) #RSN:1};
// &sn @WIRE(mode="straight") {%sn (45, -7) #CSN:1};
// $JUNCTION @ATTACH %sn;
// %t1 = $IO_PORT @ATTACH &sub => @PLACE(-49, -20) => @ORIENT("R0");
// %t1 @TEXT("sub", key="name", size=0.75);
// &sub @WIRE(mode="straight") {#RSP:2 (-45, -20) %t1:p};
// %t2 = $IO_PORT @ATTACH &sub => @PLACE(-29, -20) => @ORIENT("R0");
// %t2 @TEXT("sub", key="name", size=0.75);
// &sub @WIRE(mode="straight") {#CSP:2 (-25, -20) %t2:p};
// %t3 = $IO_PORT @ATTACH &sub => @PLACE(21, -20) => @ORIENT("R0");
// %t3 @TEXT("sub", key="name", size=0.75);
// &sub @WIRE(mode="straight") {#RSN:2 (25, -20) %t3:p};
// %t4 = $IO_PORT @ATTACH &sub => @PLACE(41, -20) => @ORIENT("R0");
// %t4 @TEXT("sub", key="name", size=0.75);
// &sub @WIRE(mode="straight") {#CSN:2 (45, -20) %t4:p};
// %t5 = $IO_PORT @ATTACH &p => @PLACE(-23, 16) => @ORIENT("R0");
// %t5 @TEXT("p", key="name", size=0.75);
// &p @WIRE(mode="straight") {#RW:1 %t5:p};
// %t6 = $IO_PORT @ATTACH &n => @PLACE(17, 16) => @ORIENT("MY");
// %t6 @TEXT("n", key="name", size=0.75);
// &n @WIRE(mode="straight") {#LW:2 %t6:p};
// (-53, 56) @TEXT("03  Inductor pi | 9 instances", size=1.2, halign="start");
// }
ends tx_inductor_pi_pdk110_3
