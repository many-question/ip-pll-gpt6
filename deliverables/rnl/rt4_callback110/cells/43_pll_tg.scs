// TG | frozen callback110 / recenter109 | RNL 0.3
// @RNL(type="header") { @VERSION("0.3"); @USE-PACKAGE(name="rnl-std-fill") {} }
simulator lang=spectre
subckt pll_tg_pdk110_43 (a b on off vdd vss)
MN (a on b vss) nch w=2e-06 l=1.8e-07 ad=9.599999999999999e-13 as=9.599999999999999e-13 pd=4.96e-06 ps=4.96e-06 nrd=0.135 nrs=0.135 sa=4.8e-07 sb=4.8e-07 sd=5.4e-07 sca=0 scb=0 scc=0
MP (a off b vdd) pch w=4e-06 l=1.8e-07 ad=1.92e-12 as=1.92e-12 pd=8.960000000000001e-06 ps=8.960000000000001e-06 nrd=0.0675 nrs=0.0675 sa=4.8e-07 sb=4.8e-07 sd=5.4e-07 sca=0 scb=0 scc=0
// @RNL(author="functional-compact127") {
// $CELL = @DEFINE-SYMBOL {
// @LINE {(-6, -8) (6, -8) (6, 8) (-6, 8) (-6, -8)};
// @LINE {(-2.7, 0) (-2.71022, 0.0776457) (-2.74019, 0.15) (-2.78787, 0.212132) (-2.85, 0.259808) (-2.92235, 0.289778) (-3, 0.3) (-3.07765, 0.289778) (-3.15, 0.259808) (-3.21213, 0.212132) (-3.25981, 0.15) (-3.28978, 0.0776457) (-3.3, 3.67394e-17) (-3.28978, -0.0776457) (-3.25981, -0.15) (-3.21213, -0.212132) (-3.15, -0.259808) (-3.07765, -0.289778) (-3, -0.3) (-2.92235, -0.289778) (-2.85, -0.259808) (-2.78787, -0.212132) (-2.74019, -0.15) (-2.71022, -0.0776457) (-2.7, -7.34788e-17)};
// @LINE {(3.3, 0) (3.28978, 0.0776457) (3.25981, 0.15) (3.21213, 0.212132) (3.15, 0.259808) (3.07765, 0.289778) (3, 0.3) (2.92235, 0.289778) (2.85, 0.259808) (2.78787, 0.212132) (2.74019, 0.15) (2.71022, 0.0776457) (2.7, 3.67394e-17) (2.71022, -0.0776457) (2.74019, -0.15) (2.78787, -0.212132) (2.85, -0.259808) (2.92235, -0.289778) (3, -0.3) (3.07765, -0.289778) (3.15, -0.259808) (3.21213, -0.212132) (3.25981, -0.15) (3.28978, -0.0776457) (3.3, -7.34788e-17)};
// @LINE {(-2.7, 0) (2.5, 1.7)};
// (0, -3) @TEXT("SW", size=0.85, halign="middle");
// (-8, 4) @PIN(terminal="a", direction="left");
// @LINE {(-8, 4) (-6, 4)};
// (-5.4, 4) @TEXT("a", size=0.7, halign="start");
// (-8, 0) @PIN(terminal="on", direction="left");
// @LINE {(-8, 0) (-6, 0)};
// (-5.4, 0) @TEXT("on", size=0.7, halign="start");
// (-8, -4) @PIN(terminal="off", direction="left");
// @LINE {(-8, -4) (-6, -4)};
// (-5.4, -4) @TEXT("off", size=0.7, halign="start");
// (8, 0) @PIN(terminal="b", direction="right");
// @LINE {(8, 0) (6, 0)};
// (5.4, 0) @TEXT("b", size=0.7, halign="end");
// (0, 10) @PIN(terminal="vdd", direction="up");
// @LINE {(0, 10) (0, 8)};
// (0, -10) @PIN(terminal="vss", direction="down");
// @LINE {(0, -10) (0, -8)};
// ? @TEXT("${name}", key="name", size=1, halign="middle") => @PLACE(8, 11.5);
// (0, 7.1) @TEXT("TG", size=0.85, halign="middle");
// };
// # @SET-SYMBOL $CELL;
// #MP @PLACE(13, 0) => @ORIENT("R0");
// #MP @SET-SYMBOL $PMOS_4TERM;
// #MP @TEXT("MP", key="name", dx=5, dy=1.5, size=0.9, halign="start");
// #MP @TEXT("4u / 180n", key="model", dx=5, dy=-1.5, size=0.75, halign="start");
// #MN @PLACE(-12, 0) => @ORIENT("R0");
// #MN @SET-SYMBOL $NMOS_4TERM;
// #MN @TEXT("MN", key="name", dx=5, dy=1.5, size=0.9, halign="start");
// #MN @TEXT("2u / 180n", key="model", dx=5, dy=-1.5, size=0.75, halign="start");
// %t1 = $IO_PORT @ATTACH &a => @PLACE(9, -5) => @ORIENT("R0");
// %t1 @TEXT("a", key="name", size=0.75);
// &a @WIRE(mode="straight") {#MP:1 (13, -5) %t1:p};
// %t2 = $IO_PORT @ATTACH &off => @PLACE(7, 0) => @ORIENT("R0");
// %t2 @TEXT("off", key="name", size=0.75);
// &off @WIRE(mode="straight") {#MP:2 %t2:p};
// %t3 = $IO_PORT @ATTACH &b => @PLACE(9, 5) => @ORIENT("R0");
// %t3 @TEXT("b", key="name", size=0.75);
// &b @WIRE(mode="straight") {#MP:3 (13, 5) %t3:p};
// %t4 = $IO_PORT @ATTACH &vdd => @PLACE(17, 0) => @ORIENT("MY");
// %t4 @TEXT("vdd", key="name", size=0.75);
// &vdd @WIRE(mode="straight") {#MP:4 %t4:p};
// %t5 = $IO_PORT @ATTACH &a => @PLACE(-16, 5) => @ORIENT("R0");
// %t5 @TEXT("a", key="name", size=0.75);
// &a @WIRE(mode="straight") {#MN:1 (-12, 5) %t5:p};
// %t6 = $IO_PORT @ATTACH &on => @PLACE(-18, 0) => @ORIENT("R0");
// %t6 @TEXT("on", key="name", size=0.75);
// &on @WIRE(mode="straight") {#MN:2 %t6:p};
// %t7 = $IO_PORT @ATTACH &b => @PLACE(-16, -5) => @ORIENT("R0");
// %t7 @TEXT("b", key="name", size=0.75);
// &b @WIRE(mode="straight") {#MN:3 (-12, -5) %t7:p};
// %t8 = $IO_PORT @ATTACH &vss => @PLACE(-8, 0) => @ORIENT("MY");
// %t8 @TEXT("vss", key="name", size=0.75);
// &vss @WIRE(mode="straight") {#MN:4 %t8:p};
// (-23, 24) @TEXT("43  TG | 2 instances", size=1.2, halign="start");
// }
ends pll_tg_pdk110_43
