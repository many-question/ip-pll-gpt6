// XOR2 | frozen callback110 / recenter109 | RNL 0.3
// @RNL(type="header") { @VERSION("0.3"); @USE-PACKAGE(name="rnl-std-fill") {} }
simulator lang=spectre
subckt tx_xor_pdk110_66 (a b y vdd vss)
XI (a ab vdd vss) pll_inv_pdk110_48
XM (a ab b y vdd vss) tx_mux_pdk110_64
// @RNL(author="functional-compact127") {
// $CELL = @DEFINE-SYMBOL {
// @LINE {(-5, 4) (-2.5, 4) (-0.4, 3.5) (1.5, 2.5) (4, 0) (1.5, -2.5) (-0.4, -3.5) (-2.5, -4) (-5, -4) (-3.8, -2) (-3.4, 0) (-3.8, 2) (-5, 4)};
// @LINE {(-6, 4) (-4.8, 2) (-4.4, 0) (-4.8, -2) (-6, -4)};
// (-8, 2) @PIN(terminal="a", direction="left");
// @LINE {(-8, 2) (-4, 2)};
// (-8, -2) @PIN(terminal="b", direction="left");
// @LINE {(-8, -2) (-4, -2)};
// (8, 0) @PIN(terminal="y", direction="right");
// @LINE {(8, 0) (4, 0)};
// (0, 8) @PIN(terminal="vdd", direction="up");
// @LINE {(0, 8) (0, 3.4)};
// (0, -8) @PIN(terminal="vss", direction="down");
// @LINE {(0, -8) (0, -3.4)};
// ? @TEXT("${name}", key="name", size=1, halign="middle") => @PLACE(8, 9.5);
// };
// # @SET-SYMBOL $CELL;
// #XI @PLACE(0, 0) => @ORIENT("R0");
// #XM @PLACE(28, 0) => @ORIENT("R0");
// &ab @WIRE(mode="straight") {#XI:2 (14, 0) (14, 0) #XM:2};
// %t1 = $IO_PORT @ATTACH &a => @PLACE(-11, 0) => @ORIENT("R0");
// %t1 @TEXT("a", key="name", size=0.75);
// &a @WIRE(mode="straight") {#XI:1 %t1:p};
// %t2 = $SUPPLY @ATTACH &vdd => @PLACE(0, 9);
// &vdd @WIRE(mode="straight") {#XI:3 %t2:p};
// %t3 = $GROUND @ATTACH &vss => @PLACE(0, -9);
// &vss @WIRE(mode="straight") {#XI:4 %t3:p};
// %t4 = $IO_PORT @ATTACH &a => @PLACE(18, 4) => @ORIENT("R0");
// %t4 @TEXT("a", key="name", size=0.75);
// &a @WIRE(mode="straight") {#XM:1 %t4:p};
// %t5 = $IO_PORT @ATTACH &b => @PLACE(18, -4) => @ORIENT("R0");
// %t5 @TEXT("b", key="name", size=0.75);
// &b @WIRE(mode="straight") {#XM:3 %t5:p};
// %t6 = $IO_PORT @ATTACH &y => @PLACE(39, 0) => @ORIENT("MY");
// %t6 @TEXT("y", key="name", size=0.75);
// &y @WIRE(mode="straight") {#XM:4 %t6:p};
// %t7 = $SUPPLY @ATTACH &vdd => @PLACE(28, 13);
// &vdd @WIRE(mode="straight") {#XM:5 %t7:p};
// %t8 = $GROUND @ATTACH &vss => @PLACE(28, -13);
// &vss @WIRE(mode="straight") {#XM:6 %t8:p};
// (-16, 32) @TEXT("66  XOR2 | 2 instances", size=1.2, halign="start");
// }
ends tx_xor_pdk110_66
