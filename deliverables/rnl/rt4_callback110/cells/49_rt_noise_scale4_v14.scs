// RT4 retimer | frozen callback110 / recenter109 | RNL 0.3
// @RNL(type="header") { @VERSION("0.3"); @USE-PACKAGE(name="rnl-std-fill") {} }
simulator lang=spectre
subckt rt_noise_scale4_v14_pdk110_49 (data clk out vdd vss)
XFF (data clk qb vdd vss) rtcomb_ff_v13_pdk110_50
X0 (qb ob vdd vss) pll_inv_pdk110_51
X1 (ob out vdd vss) pll_inv_pdk110_52
// @RNL(author="manual-schematic126") {
// $CELL = @DEFINE-SYMBOL {
// @LINE {(-6, 6) (6, 6) (6, -6) (-6, -6) (-6, 6)};
// (-8, 2) @PIN(terminal="data", direction="left");
// @LINE {(-8, 2) (-6, 2)};
// (-5.4, 2) @TEXT("data", size=0.7, halign="start");
// (-8, -2) @PIN(terminal="clk", direction="left");
// @LINE {(-8, -2) (-6, -2)};
// (-5.4, -2) @TEXT("clk", size=0.7, halign="start");
// (8, 0) @PIN(terminal="out", direction="right");
// @LINE {(8, 0) (6, 0)};
// (5.4, 0) @TEXT("out", size=0.7, halign="end");
// (0, 8) @PIN(terminal="vdd", direction="up");
// @LINE {(0, 8) (0, 6)};
// (0, -8) @PIN(terminal="vss", direction="down");
// @LINE {(0, -8) (0, -6)};
// ? @TEXT("${name}", key="name", size=1, halign="middle") => @PLACE(8, 9.5);
// (0, 5.1) @TEXT("RT4 retimer", size=0.85, halign="middle");
// };
// # @SET-SYMBOL $CELL;
// #XFF @PLACE(0, 0) => @ORIENT("R0");
// #X0 @PLACE(40, 0) => @ORIENT("R0");
// #X1 @PLACE(80, 0) => @ORIENT("R0");
// &qb @WIRE(mode="straight") {#XFF:3 (20, 0) (20, 0) #X0:1};
// &ob @WIRE(mode="straight") {#X0:2 #X1:1};
// %t1 = $IO_PORT @ATTACH &data => @PLACE(-11, 2) => @ORIENT("R0");
// %t1 @TEXT("data", key="name", size=0.75);
// &data @WIRE(mode="straight") {#XFF:1 %t1:p};
// %t2 = $IO_PORT @ATTACH &clk => @PLACE(-11, -2) => @ORIENT("R0");
// %t2 @TEXT("clk", key="name", size=0.75);
// &clk @WIRE(mode="straight") {#XFF:2 %t2:p};
// %t3 = $SUPPLY @ATTACH &vdd => @PLACE(0, 11);
// &vdd @WIRE(mode="straight") {#XFF:4 %t3:p};
// %t4 = $GROUND @ATTACH &vss => @PLACE(0, -11);
// &vss @WIRE(mode="straight") {#XFF:5 %t4:p};
// %t5 = $SUPPLY @ATTACH &vdd => @PLACE(40, 9);
// &vdd @WIRE(mode="straight") {#X0:3 %t5:p};
// %t6 = $GROUND @ATTACH &vss => @PLACE(40, -9);
// &vss @WIRE(mode="straight") {#X0:4 %t6:p};
// %t7 = $IO_PORT @ATTACH &out => @PLACE(91, 0) => @ORIENT("MY");
// %t7 @TEXT("out", key="name", size=0.75);
// &out @WIRE(mode="straight") {#X1:2 %t7:p};
// %t8 = $SUPPLY @ATTACH &vdd => @PLACE(80, 9);
// &vdd @WIRE(mode="straight") {#X1:3 %t8:p};
// %t9 = $GROUND @ATTACH &vss => @PLACE(80, -9);
// &vss @WIRE(mode="straight") {#X1:4 %t9:p};
// (-16, 30) @TEXT("49  RT4 retimer | 3 instances", size=1.2, halign="start");
// }
ends rt_noise_scale4_v14_pdk110_49
