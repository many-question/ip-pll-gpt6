// LC VCO | frozen callback110 / recenter109 | RNL 0.3
// @RNL(type="header") { @VERSION("0.3"); @USE-PACKAGE(name="rnl-std-fill") {} }
simulator lang=spectre
subckt lc_vco_physical_v14_pdk110_1 (vp vn ctrl b0 b1 b2 b3 b4 b5 b6 b7 vdd vss)
XL (vp vn b3 b4 b5 b6 b7 vdd vss) lc_core_physical_v14_pdk110_2
XBP (vp b0 b1 b2 b3 b4 b5 b6 b7 vdd vss) tx_cap_bank_switched_v4_pdk110_4
XBN (vn b0 b1 b2 b3 b4 b5 b6 b7 vdd vss) tx_cap_bank_switched_v4_pdk110_4
CVP (vp ctrl) nmoscap lr=2e-06 wr=4.5e-06 mr=1
CVN (vn ctrl) nmoscap lr=2e-06 wr=4.5e-06 mr=1
// @RNL(author="functional-compact127") {
// $CELL = @DEFINE-SYMBOL {
// @LINE {(-12, -20) (12, -20) (12, 20) (-12, 20) (-12, -20)};
// @LINE {(-4, 2) (-3.75, 2.39018) (-3.5, 2.76537) (-3.25, 3.11114) (-3, 3.41421) (-2.75, 3.66294) (-2.5, 3.84776) (-2.25, 3.96157) (-2, 4) (-1.75, 3.96157) (-1.5, 3.84776) (-1.25, 3.66294) (-1, 3.41421) (-0.75, 3.11114) (-0.5, 2.76537) (-0.25, 2.39018) (0, 2) (0.25, 1.60982) (0.5, 1.23463) (0.75, 0.88886) (1, 0.585786) (1.25, 0.337061) (1.5, 0.152241) (1.75, 0.0384294) (2, 0) (2.25, 0.0384294) (2.5, 0.152241) (2.75, 0.337061) (3, 0.585786) (3.25, 0.88886) (3.5, 1.23463) (3.75, 1.60982) (4, 2)};
// @LINE {(-4, -2) (-4, -5) (4, -5) (4, -2)};
// @LINE {(0, -3) (0, -4.5)};
// @LINE {(-1.5, -4.5) (1.5, -4.5)};
// @LINE {(-1.5, -5.5) (1.5, -5.5)};
// @LINE {(0, -5.5) (0, -7)};
// (0, 6) @TEXT("LC", size=1.1, halign="middle");
// (0, -9) @TEXT("tune", size=0.9, halign="middle");
// (-14, 16) @PIN(terminal="ctrl", direction="left");
// @LINE {(-14, 16) (-12, 16)};
// (-11.4, 16) @TEXT("ctrl", size=0.7, halign="start");
// (-14, 12) @PIN(terminal="b0", direction="left");
// @LINE {(-14, 12) (-12, 12)};
// (-11.4, 12) @TEXT("b0", size=0.7, halign="start");
// (-14, 8) @PIN(terminal="b1", direction="left");
// @LINE {(-14, 8) (-12, 8)};
// (-11.4, 8) @TEXT("b1", size=0.7, halign="start");
// (-14, 4) @PIN(terminal="b2", direction="left");
// @LINE {(-14, 4) (-12, 4)};
// (-11.4, 4) @TEXT("b2", size=0.7, halign="start");
// (-14, 0) @PIN(terminal="b3", direction="left");
// @LINE {(-14, 0) (-12, 0)};
// (-11.4, 0) @TEXT("b3", size=0.7, halign="start");
// (-14, -4) @PIN(terminal="b4", direction="left");
// @LINE {(-14, -4) (-12, -4)};
// (-11.4, -4) @TEXT("b4", size=0.7, halign="start");
// (-14, -8) @PIN(terminal="b5", direction="left");
// @LINE {(-14, -8) (-12, -8)};
// (-11.4, -8) @TEXT("b5", size=0.7, halign="start");
// (-14, -12) @PIN(terminal="b6", direction="left");
// @LINE {(-14, -12) (-12, -12)};
// (-11.4, -12) @TEXT("b6", size=0.7, halign="start");
// (-14, -16) @PIN(terminal="b7", direction="left");
// @LINE {(-14, -16) (-12, -16)};
// (-11.4, -16) @TEXT("b7", size=0.7, halign="start");
// (14, 2) @PIN(terminal="vp", direction="right");
// @LINE {(14, 2) (12, 2)};
// (11.4, 2) @TEXT("vp", size=0.7, halign="end");
// (14, -2) @PIN(terminal="vn", direction="right");
// @LINE {(14, -2) (12, -2)};
// (11.4, -2) @TEXT("vn", size=0.7, halign="end");
// (0, 22) @PIN(terminal="vdd", direction="up");
// @LINE {(0, 22) (0, 20)};
// (0, -22) @PIN(terminal="vss", direction="down");
// @LINE {(0, -22) (0, -20)};
// ? @TEXT("${name}", key="name", size=1, halign="middle") => @PLACE(14, 23.5);
// (0, 19.1) @TEXT("LC VCO", size=0.85, halign="middle");
// };
// # @SET-SYMBOL $CELL;
// #XL @PLACE(-25, 10) => @ORIENT("R0");
// #XBP @PLACE(-85, -30) => @ORIENT("R0");
// #XBN @PLACE(35, -30) => @ORIENT("R0");
// #CVP @PLACE(-52, 40) => @ORIENT("R90");
// #CVP @SET-SYMBOL $CAPACITOR;
// #CVP @TEXT("NMOSCAP 4.5u x 2u", key="value", dx=3, dy=-1, size=0.8, halign="start");
// #CVP @TEXT("CVP", key="name", dx=3, dy=1, size=0.9, halign="start");
// #CVN @PLACE(2, 40) => @ORIENT("R90");
// #CVN @SET-SYMBOL $CAPACITOR;
// #CVN @TEXT("NMOSCAP 4.5u x 2u", key="value", dx=3, dy=-1, size=0.8, halign="start");
// #CVN @TEXT("CVN", key="name", dx=3, dy=1, size=0.9, halign="start");
// %t1 = $IO_PORT @ATTACH &vp => @PLACE(-9, 12) => @ORIENT("MY");
// %t1 @TEXT("vp", key="name", size=0.75);
// &vp @WIRE(mode="straight") {#XL:1 %t1:p};
// %t2 = $IO_PORT @ATTACH &vn => @PLACE(-9, 8) => @ORIENT("MY");
// %t2 @TEXT("vn", key="name", size=0.75);
// &vn @WIRE(mode="straight") {#XL:2 %t2:p};
// %t3 = $IO_PORT @ATTACH &b3 => @PLACE(-41, 18) => @ORIENT("R0");
// %t3 @TEXT("b3", key="name", size=0.75);
// &b3 @WIRE(mode="straight") {#XL:3 %t3:p};
// %t4 = $IO_PORT @ATTACH &b4 => @PLACE(-41, 14) => @ORIENT("R0");
// %t4 @TEXT("b4", key="name", size=0.75);
// &b4 @WIRE(mode="straight") {#XL:4 %t4:p};
// %t5 = $IO_PORT @ATTACH &b5 => @PLACE(-41, 10) => @ORIENT("R0");
// %t5 @TEXT("b5", key="name", size=0.75);
// &b5 @WIRE(mode="straight") {#XL:5 %t5:p};
// %t6 = $IO_PORT @ATTACH &b6 => @PLACE(-41, 6) => @ORIENT("R0");
// %t6 @TEXT("b6", key="name", size=0.75);
// &b6 @WIRE(mode="straight") {#XL:6 %t6:p};
// %t7 = $IO_PORT @ATTACH &b7 => @PLACE(-41, 2) => @ORIENT("R0");
// %t7 @TEXT("b7", key="name", size=0.75);
// &b7 @WIRE(mode="straight") {#XL:7 %t7:p};
// %t8 = $SUPPLY @ATTACH &vdd => @PLACE(-25, 27);
// &vdd @WIRE(mode="straight") {#XL:8 %t8:p};
// %t9 = $GROUND @ATTACH &vss => @PLACE(-25, -7);
// &vss @WIRE(mode="straight") {#XL:9 %t9:p};
// %t10 = $IO_PORT @ATTACH &vp => @PLACE(-69, -30) => @ORIENT("MY");
// %t10 @TEXT("vp", key="name", size=0.75);
// &vp @WIRE(mode="straight") {#XBP:1 %t10:p};
// %t11 = $IO_PORT @ATTACH &b0 => @PLACE(-102, -16) => @ORIENT("R0");
// %t11 @TEXT("b0", key="name", size=0.75);
// &b0 @WIRE(mode="straight") {#XBP:2 %t11:p};
// %t12 = $IO_PORT @ATTACH &b1 => @PLACE(-102, -20) => @ORIENT("R0");
// %t12 @TEXT("b1", key="name", size=0.75);
// &b1 @WIRE(mode="straight") {#XBP:3 %t12:p};
// %t13 = $IO_PORT @ATTACH &b2 => @PLACE(-102, -24) => @ORIENT("R0");
// %t13 @TEXT("b2", key="name", size=0.75);
// &b2 @WIRE(mode="straight") {#XBP:4 %t13:p};
// %t14 = $IO_PORT @ATTACH &b3 => @PLACE(-102, -28) => @ORIENT("R0");
// %t14 @TEXT("b3", key="name", size=0.75);
// &b3 @WIRE(mode="straight") {#XBP:5 %t14:p};
// %t15 = $IO_PORT @ATTACH &b4 => @PLACE(-102, -32) => @ORIENT("R0");
// %t15 @TEXT("b4", key="name", size=0.75);
// &b4 @WIRE(mode="straight") {#XBP:6 %t15:p};
// %t16 = $IO_PORT @ATTACH &b5 => @PLACE(-102, -36) => @ORIENT("R0");
// %t16 @TEXT("b5", key="name", size=0.75);
// &b5 @WIRE(mode="straight") {#XBP:7 %t16:p};
// %t17 = $IO_PORT @ATTACH &b6 => @PLACE(-102, -40) => @ORIENT("R0");
// %t17 @TEXT("b6", key="name", size=0.75);
// &b6 @WIRE(mode="straight") {#XBP:8 %t17:p};
// %t18 = $IO_PORT @ATTACH &b7 => @PLACE(-102, -44) => @ORIENT("R0");
// %t18 @TEXT("b7", key="name", size=0.75);
// &b7 @WIRE(mode="straight") {#XBP:9 %t18:p};
// %t19 = $SUPPLY @ATTACH &vdd => @PLACE(-85, -7);
// &vdd @WIRE(mode="straight") {#XBP:10 %t19:p};
// %t20 = $GROUND @ATTACH &vss => @PLACE(-85, -53);
// &vss @WIRE(mode="straight") {#XBP:11 %t20:p};
// %t21 = $IO_PORT @ATTACH &vn => @PLACE(52, -30) => @ORIENT("MY");
// %t21 @TEXT("vn", key="name", size=0.75);
// &vn @WIRE(mode="straight") {#XBN:1 %t21:p};
// %t22 = $IO_PORT @ATTACH &b0 => @PLACE(19, -16) => @ORIENT("R0");
// %t22 @TEXT("b0", key="name", size=0.75);
// &b0 @WIRE(mode="straight") {#XBN:2 %t22:p};
// %t23 = $IO_PORT @ATTACH &b1 => @PLACE(19, -20) => @ORIENT("R0");
// %t23 @TEXT("b1", key="name", size=0.75);
// &b1 @WIRE(mode="straight") {#XBN:3 %t23:p};
// %t24 = $IO_PORT @ATTACH &b2 => @PLACE(19, -24) => @ORIENT("R0");
// %t24 @TEXT("b2", key="name", size=0.75);
// &b2 @WIRE(mode="straight") {#XBN:4 %t24:p};
// %t25 = $IO_PORT @ATTACH &b3 => @PLACE(19, -28) => @ORIENT("R0");
// %t25 @TEXT("b3", key="name", size=0.75);
// &b3 @WIRE(mode="straight") {#XBN:5 %t25:p};
// %t26 = $IO_PORT @ATTACH &b4 => @PLACE(19, -32) => @ORIENT("R0");
// %t26 @TEXT("b4", key="name", size=0.75);
// &b4 @WIRE(mode="straight") {#XBN:6 %t26:p};
// %t27 = $IO_PORT @ATTACH &b5 => @PLACE(19, -36) => @ORIENT("R0");
// %t27 @TEXT("b5", key="name", size=0.75);
// &b5 @WIRE(mode="straight") {#XBN:7 %t27:p};
// %t28 = $IO_PORT @ATTACH &b6 => @PLACE(19, -40) => @ORIENT("R0");
// %t28 @TEXT("b6", key="name", size=0.75);
// &b6 @WIRE(mode="straight") {#XBN:8 %t28:p};
// %t29 = $IO_PORT @ATTACH &b7 => @PLACE(19, -44) => @ORIENT("R0");
// %t29 @TEXT("b7", key="name", size=0.75);
// &b7 @WIRE(mode="straight") {#XBN:9 %t29:p};
// %t30 = $SUPPLY @ATTACH &vdd => @PLACE(35, -7);
// &vdd @WIRE(mode="straight") {#XBN:10 %t30:p};
// %t31 = $GROUND @ATTACH &vss => @PLACE(35, -53);
// &vss @WIRE(mode="straight") {#XBN:11 %t31:p};
// %t32 = $IO_PORT @ATTACH &vp => @PLACE(-57, 40) => @ORIENT("R0");
// %t32 @TEXT("vp", key="name", size=0.75);
// &vp @WIRE(mode="straight") {#CVP:1 %t32:p};
// %t33 = $IO_PORT @ATTACH &ctrl => @PLACE(-47, 40) => @ORIENT("MY");
// %t33 @TEXT("ctrl", key="name", size=0.75);
// &ctrl @WIRE(mode="straight") {#CVP:2 %t33:p};
// %t34 = $IO_PORT @ATTACH &vn => @PLACE(-3, 40) => @ORIENT("R0");
// %t34 @TEXT("vn", key="name", size=0.75);
// &vn @WIRE(mode="straight") {#CVN:1 %t34:p};
// %t35 = $IO_PORT @ATTACH &ctrl => @PLACE(7, 40) => @ORIENT("MY");
// %t35 @TEXT("ctrl", key="name", size=0.75);
// &ctrl @WIRE(mode="straight") {#CVN:2 %t35:p};
// (-107, 62) @TEXT("01  LC VCO | 5 instances", size=1.2, halign="start");
// }
ends lc_vco_physical_v14_pdk110_1
