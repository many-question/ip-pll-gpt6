// Ring tail | frozen callback110 / recenter109 | RNL 0.3
// @RNL(type="header") { @VERSION("0.3"); @USE-PACKAGE(name="rnl-std-fill") {} }
simulator lang=spectre
subckt ring_tail_singlephase_v14_pdk110_46 (d clk clkb load loadb init selected q vdd vss)
XEN (loadb selected dopen vdd vss) tx_and_pdk110_47
XI (dopen dclose vdd vss) pll_inv_pdk110_7
XDATA (d din dopen dclose vdd vss) pll_tg_pdk110_43
XINIT (init din load loadb vdd vss) pll_tg_pdk110_43
RKEEP (din vss) resistor r=10000000
XF (din clk clkb q vdd vss) ff_singlephase_v14_pdk110_44
// @RNL(author="functional-compact127") {
// $CELL = @DEFINE-SYMBOL {
// @LINE {(-12, -16) (12, -16) (12, 16) (-12, 16) (-12, -16)};
// (-2, 1) @TEXT("D", size=1.15, halign="middle");
// (2, 1) @TEXT("Q", size=1.15, halign="middle");
// @LINE {(-2, -1) (2, -1)};
// @LINE {(0.946901, -0.424689) (2, -1) (0.946901, -1.57531)};
// (0, -3) @TEXT("FF", size=0.8, halign="middle");
// @LINE {(-12, 9) (-10.5, 8) (-12, 7)};
// (-14, 12) @PIN(terminal="d", direction="left");
// @LINE {(-14, 12) (-12, 12)};
// (-11.4, 12) @TEXT("d", size=0.7, halign="start");
// (-14, 8) @PIN(terminal="clk", direction="left");
// @LINE {(-14, 8) (-12, 8)};
// (-11.4, 8) @TEXT("clk", size=0.7, halign="start");
// (-14, 4) @PIN(terminal="clkb", direction="left");
// @LINE {(-14, 4) (-12, 4)};
// (-11.4, 4) @TEXT("clkb", size=0.7, halign="start");
// (-14, 0) @PIN(terminal="load", direction="left");
// @LINE {(-14, 0) (-12, 0)};
// (-11.4, 0) @TEXT("load", size=0.7, halign="start");
// (-14, -4) @PIN(terminal="loadb", direction="left");
// @LINE {(-14, -4) (-12, -4)};
// (-11.4, -4) @TEXT("loadb", size=0.7, halign="start");
// (-14, -8) @PIN(terminal="init", direction="left");
// @LINE {(-14, -8) (-12, -8)};
// (-11.4, -8) @TEXT("init", size=0.7, halign="start");
// (-14, -12) @PIN(terminal="selected", direction="left");
// @LINE {(-14, -12) (-12, -12)};
// (-11.4, -12) @TEXT("selected", size=0.7, halign="start");
// (14, 0) @PIN(terminal="q", direction="right");
// @LINE {(14, 0) (12, 0)};
// (11.4, 0) @TEXT("q", size=0.7, halign="end");
// (0, 18) @PIN(terminal="vdd", direction="up");
// @LINE {(0, 18) (0, 16)};
// (0, -18) @PIN(terminal="vss", direction="down");
// @LINE {(0, -18) (0, -16)};
// ? @TEXT("${name}", key="name", size=1, halign="middle") => @PLACE(14, 19.5);
// (0, 15.1) @TEXT("Ring tail", size=0.85, halign="middle");
// };
// # @SET-SYMBOL $CELL;
// #XEN @PLACE(-45, 33) => @ORIENT("R0");
// #XI @PLACE(-17, 33) => @ORIENT("R0");
// #XDATA @PLACE(-12, 0) => @ORIENT("R0");
// #XINIT @PLACE(-12, -35) => @ORIENT("R0");
// #XF @PLACE(35, 0) => @ORIENT("R0");
// #RKEEP @PLACE(10, -35) => @ORIENT("R0");
// #RKEEP @SET-SYMBOL $RESISTOR;
// #RKEEP @TEXT("10M", key="value", dx=3, dy=-1, size=0.8, halign="start");
// #RKEEP @TEXT("RKEEP", key="name", dx=3, dy=1, size=0.9, halign="start");
// &din @WIRE(mode="straight") {#XDATA:2 (10, 0) (10, 4) #XF:1};
// &din @WIRE(mode="straight") {#XINIT:2 (10, -35) (10, 4) #XF:1};
// %t1 = $IO_PORT @ATTACH &loadb => @PLACE(-56, 35) => @ORIENT("R0");
// %t1 @TEXT("loadb", key="name", size=0.75);
// &loadb @WIRE(mode="straight") {#XEN:1 %t1:p};
// %t2 = $IO_PORT @ATTACH &selected => @PLACE(-56, 31) => @ORIENT("R0");
// %t2 @TEXT("selected", key="name", size=0.75);
// &selected @WIRE(mode="straight") {#XEN:2 %t2:p};
// %t3 = $IO_PORT @ATTACH &dopen => @PLACE(-35, 33) => @ORIENT("MY");
// %t3 @TEXT("dopen", key="name", size=0.75);
// &dopen @WIRE(mode="straight") {#XEN:3 %t3:p};
// %t4 = $SUPPLY @ATTACH &vdd => @PLACE(-45, 44);
// &vdd @WIRE(mode="straight") {#XEN:4 %t4:p};
// %t5 = $GROUND @ATTACH &vss => @PLACE(-45, 22);
// &vss @WIRE(mode="straight") {#XEN:5 %t5:p};
// %t6 = $IO_PORT @ATTACH &dopen => @PLACE(-27, 33) => @ORIENT("R0");
// %t6 @TEXT("dopen", key="name", size=0.75);
// &dopen @WIRE(mode="straight") {#XI:1 %t6:p};
// %t7 = $IO_PORT @ATTACH &dclose => @PLACE(-6, 33) => @ORIENT("MY");
// %t7 @TEXT("dclose", key="name", size=0.75);
// &dclose @WIRE(mode="straight") {#XI:2 %t7:p};
// %t8 = $SUPPLY @ATTACH &vdd => @PLACE(-17, 42);
// &vdd @WIRE(mode="straight") {#XI:3 %t8:p};
// %t9 = $GROUND @ATTACH &vss => @PLACE(-17, 24);
// &vss @WIRE(mode="straight") {#XI:4 %t9:p};
// %t10 = $IO_PORT @ATTACH &d => @PLACE(-23, 4) => @ORIENT("R0");
// %t10 @TEXT("d", key="name", size=0.75);
// &d @WIRE(mode="straight") {#XDATA:1 %t10:p};
// %t11 = $IO_PORT @ATTACH &dopen => @PLACE(-23, 0) => @ORIENT("R0");
// %t11 @TEXT("dopen", key="name", size=0.75);
// &dopen @WIRE(mode="straight") {#XDATA:3 %t11:p};
// %t12 = $IO_PORT @ATTACH &dclose => @PLACE(-23, -4) => @ORIENT("R0");
// %t12 @TEXT("dclose", key="name", size=0.75);
// &dclose @WIRE(mode="straight") {#XDATA:4 %t12:p};
// %t13 = $SUPPLY @ATTACH &vdd => @PLACE(-12, 13);
// &vdd @WIRE(mode="straight") {#XDATA:5 %t13:p};
// %t14 = $GROUND @ATTACH &vss => @PLACE(-12, -13);
// &vss @WIRE(mode="straight") {#XDATA:6 %t14:p};
// %t15 = $IO_PORT @ATTACH &init => @PLACE(-23, -31) => @ORIENT("R0");
// %t15 @TEXT("init", key="name", size=0.75);
// &init @WIRE(mode="straight") {#XINIT:1 %t15:p};
// %t16 = $IO_PORT @ATTACH &load => @PLACE(-23, -35) => @ORIENT("R0");
// %t16 @TEXT("load", key="name", size=0.75);
// &load @WIRE(mode="straight") {#XINIT:3 %t16:p};
// %t17 = $IO_PORT @ATTACH &loadb => @PLACE(-23, -39) => @ORIENT("R0");
// %t17 @TEXT("loadb", key="name", size=0.75);
// &loadb @WIRE(mode="straight") {#XINIT:4 %t17:p};
// %t18 = $SUPPLY @ATTACH &vdd => @PLACE(-12, -22);
// &vdd @WIRE(mode="straight") {#XINIT:5 %t18:p};
// %t19 = $GROUND @ATTACH &vss => @PLACE(-12, -48);
// &vss @WIRE(mode="straight") {#XINIT:6 %t19:p};
// %t20 = $IO_PORT @ATTACH &clk => @PLACE(25, 0) => @ORIENT("R0");
// %t20 @TEXT("clk", key="name", size=0.75);
// &clk @WIRE(mode="straight") {#XF:2 %t20:p};
// %t21 = $IO_PORT @ATTACH &clkb => @PLACE(25, -4) => @ORIENT("R0");
// %t21 @TEXT("clkb", key="name", size=0.75);
// &clkb @WIRE(mode="straight") {#XF:3 %t21:p};
// %t22 = $IO_PORT @ATTACH &q => @PLACE(46, 0) => @ORIENT("MY");
// %t22 @TEXT("q", key="name", size=0.75);
// &q @WIRE(mode="straight") {#XF:4 %t22:p};
// %t23 = $SUPPLY @ATTACH &vdd => @PLACE(35, 13);
// &vdd @WIRE(mode="straight") {#XF:5 %t23:p};
// %t24 = $GROUND @ATTACH &vss => @PLACE(35, -13);
// &vss @WIRE(mode="straight") {#XF:6 %t24:p};
// %t25 = $IO_PORT @ATTACH &din => @PLACE(6, -30) => @ORIENT("R0");
// %t25 @TEXT("din", key="name", size=0.75);
// &din @WIRE(mode="straight") {#RKEEP:1 (10, -30) %t25:p};
// %t26 = $GROUND @ATTACH &vss => @PLACE(10, -40);
// &vss @WIRE(mode="straight") {#RKEEP:2 %t26:p};
// (-61, 63) @TEXT("46  Ring tail | 6 instances", size=1.2, halign="start");
// }
ends ring_tail_singlephase_v14_pdk110_46
