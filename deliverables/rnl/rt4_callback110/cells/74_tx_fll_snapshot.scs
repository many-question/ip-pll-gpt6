// Snapshot | frozen callback110 / recenter109 | RNL 0.3
// @RNL(type="header") { @VERSION("0.3"); @USE-PACKAGE(name="rnl-std-fill") {} }
simulator lang=spectre
subckt tx_fll_snapshot_pdk110_74 (gate d0 d1 d2 d3 d4 d5 d6 d7 d8 d9 d10 d11 d12 d13 q0 q1 q2 q3 q4 q5 q6 q7 q8 q9 q10 q11 q12 q13 vdd vss)
XI (gate openb vdd vss) pll_inv_pdk110_12
XB (openb hold vdd vss) pll_inv_pdk110_12
XL0 (d0 openb hold q0 vdd vss) pll_latch_pdk110_72
XL1 (d1 openb hold q1 vdd vss) pll_latch_pdk110_72
XL2 (d2 openb hold q2 vdd vss) pll_latch_pdk110_72
XL3 (d3 openb hold q3 vdd vss) pll_latch_pdk110_72
XL4 (d4 openb hold q4 vdd vss) pll_latch_pdk110_72
XL5 (d5 openb hold q5 vdd vss) pll_latch_pdk110_72
XL6 (d6 openb hold q6 vdd vss) pll_latch_pdk110_72
XL7 (d7 openb hold q7 vdd vss) pll_latch_pdk110_72
XL8 (d8 openb hold q8 vdd vss) pll_latch_pdk110_72
XL9 (d9 openb hold q9 vdd vss) pll_latch_pdk110_72
XL10 (d10 openb hold q10 vdd vss) pll_latch_pdk110_72
XL11 (d11 openb hold q11 vdd vss) pll_latch_pdk110_72
XL12 (d12 openb hold q12 vdd vss) pll_latch_pdk110_72
XL13 (d13 openb hold q13 vdd vss) pll_latch_pdk110_72
// @RNL(author="functional-compact127") {
// $CELL = @DEFINE-SYMBOL {
// @LINE {(-18, -32) (18, -32) (18, 32) (-18, 32) (-18, -32)};
// @LINE {(-4.1, -3) (-1.9, -3) (-1.9, 3) (-4.1, 3) (-4.1, -3)};
// @LINE {(-1.1, -3) (1.1, -3) (1.1, 3) (-1.1, 3) (-1.1, -3)};
// @LINE {(1.9, -3) (4.1, -3) (4.1, 3) (1.9, 3) (1.9, -3)};
// (0, 6) @TEXT("HOLD", size=1, halign="middle");
// (0, -6) @TEXT("14-bit", size=1, halign="middle");
// (-20, 28) @PIN(terminal="gate", direction="left");
// @LINE {(-20, 28) (-18, 28)};
// (-17.4, 28) @TEXT("gate", size=0.7, halign="start");
// (-20, 24) @PIN(terminal="d0", direction="left");
// @LINE {(-20, 24) (-18, 24)};
// (-17.4, 24) @TEXT("d0", size=0.7, halign="start");
// (-20, 20) @PIN(terminal="d1", direction="left");
// @LINE {(-20, 20) (-18, 20)};
// (-17.4, 20) @TEXT("d1", size=0.7, halign="start");
// (-20, 16) @PIN(terminal="d2", direction="left");
// @LINE {(-20, 16) (-18, 16)};
// (-17.4, 16) @TEXT("d2", size=0.7, halign="start");
// (-20, 12) @PIN(terminal="d3", direction="left");
// @LINE {(-20, 12) (-18, 12)};
// (-17.4, 12) @TEXT("d3", size=0.7, halign="start");
// (-20, 8) @PIN(terminal="d4", direction="left");
// @LINE {(-20, 8) (-18, 8)};
// (-17.4, 8) @TEXT("d4", size=0.7, halign="start");
// (-20, 4) @PIN(terminal="d5", direction="left");
// @LINE {(-20, 4) (-18, 4)};
// (-17.4, 4) @TEXT("d5", size=0.7, halign="start");
// (-20, 0) @PIN(terminal="d6", direction="left");
// @LINE {(-20, 0) (-18, 0)};
// (-17.4, 0) @TEXT("d6", size=0.7, halign="start");
// (-20, -4) @PIN(terminal="d7", direction="left");
// @LINE {(-20, -4) (-18, -4)};
// (-17.4, -4) @TEXT("d7", size=0.7, halign="start");
// (-20, -8) @PIN(terminal="d8", direction="left");
// @LINE {(-20, -8) (-18, -8)};
// (-17.4, -8) @TEXT("d8", size=0.7, halign="start");
// (-20, -12) @PIN(terminal="d9", direction="left");
// @LINE {(-20, -12) (-18, -12)};
// (-17.4, -12) @TEXT("d9", size=0.7, halign="start");
// (-20, -16) @PIN(terminal="d10", direction="left");
// @LINE {(-20, -16) (-18, -16)};
// (-17.4, -16) @TEXT("d10", size=0.7, halign="start");
// (-20, -20) @PIN(terminal="d11", direction="left");
// @LINE {(-20, -20) (-18, -20)};
// (-17.4, -20) @TEXT("d11", size=0.7, halign="start");
// (-20, -24) @PIN(terminal="d12", direction="left");
// @LINE {(-20, -24) (-18, -24)};
// (-17.4, -24) @TEXT("d12", size=0.7, halign="start");
// (-20, -28) @PIN(terminal="d13", direction="left");
// @LINE {(-20, -28) (-18, -28)};
// (-17.4, -28) @TEXT("d13", size=0.7, halign="start");
// (20, 26) @PIN(terminal="q0", direction="right");
// @LINE {(20, 26) (18, 26)};
// (17.4, 26) @TEXT("q0", size=0.7, halign="end");
// (20, 22) @PIN(terminal="q1", direction="right");
// @LINE {(20, 22) (18, 22)};
// (17.4, 22) @TEXT("q1", size=0.7, halign="end");
// (20, 18) @PIN(terminal="q2", direction="right");
// @LINE {(20, 18) (18, 18)};
// (17.4, 18) @TEXT("q2", size=0.7, halign="end");
// (20, 14) @PIN(terminal="q3", direction="right");
// @LINE {(20, 14) (18, 14)};
// (17.4, 14) @TEXT("q3", size=0.7, halign="end");
// (20, 10) @PIN(terminal="q4", direction="right");
// @LINE {(20, 10) (18, 10)};
// (17.4, 10) @TEXT("q4", size=0.7, halign="end");
// (20, 6) @PIN(terminal="q5", direction="right");
// @LINE {(20, 6) (18, 6)};
// (17.4, 6) @TEXT("q5", size=0.7, halign="end");
// (20, 2) @PIN(terminal="q6", direction="right");
// @LINE {(20, 2) (18, 2)};
// (17.4, 2) @TEXT("q6", size=0.7, halign="end");
// (20, -2) @PIN(terminal="q7", direction="right");
// @LINE {(20, -2) (18, -2)};
// (17.4, -2) @TEXT("q7", size=0.7, halign="end");
// (20, -6) @PIN(terminal="q8", direction="right");
// @LINE {(20, -6) (18, -6)};
// (17.4, -6) @TEXT("q8", size=0.7, halign="end");
// (20, -10) @PIN(terminal="q9", direction="right");
// @LINE {(20, -10) (18, -10)};
// (17.4, -10) @TEXT("q9", size=0.7, halign="end");
// (20, -14) @PIN(terminal="q10", direction="right");
// @LINE {(20, -14) (18, -14)};
// (17.4, -14) @TEXT("q10", size=0.7, halign="end");
// (20, -18) @PIN(terminal="q11", direction="right");
// @LINE {(20, -18) (18, -18)};
// (17.4, -18) @TEXT("q11", size=0.7, halign="end");
// (20, -22) @PIN(terminal="q12", direction="right");
// @LINE {(20, -22) (18, -22)};
// (17.4, -22) @TEXT("q12", size=0.7, halign="end");
// (20, -26) @PIN(terminal="q13", direction="right");
// @LINE {(20, -26) (18, -26)};
// (17.4, -26) @TEXT("q13", size=0.7, halign="end");
// (0, 34) @PIN(terminal="vdd", direction="up");
// @LINE {(0, 34) (0, 32)};
// (0, -34) @PIN(terminal="vss", direction="down");
// @LINE {(0, -34) (0, -32)};
// ? @TEXT("${name}", key="name", size=1, halign="middle") => @PLACE(20, 35.5);
// (0, 31.1) @TEXT("Snapshot", size=0.85, halign="middle");
// };
// # @SET-SYMBOL $CELL;
// #XI @PLACE(0, 20) => @ORIENT("R0");
// #XB @PLACE(28, 20) => @ORIENT("R0");
// #XL0 @PLACE(0, -11) => @ORIENT("R0");
// #XL1 @PLACE(33, -11) => @ORIENT("R0");
// #XL2 @PLACE(63, -11) => @ORIENT("R0");
// #XL3 @PLACE(93, -11) => @ORIENT("R0");
// #XL4 @PLACE(123, -11) => @ORIENT("R0");
// #XL5 @PLACE(153, -11) => @ORIENT("R0");
// #XL6 @PLACE(183, -11) => @ORIENT("R0");
// #XL7 @PLACE(0, -50) => @ORIENT("R0");
// #XL8 @PLACE(33, -50) => @ORIENT("R0");
// #XL9 @PLACE(63, -50) => @ORIENT("R0");
// #XL10 @PLACE(93, -50) => @ORIENT("R0");
// #XL11 @PLACE(123, -50) => @ORIENT("R0");
// #XL12 @PLACE(153, -50) => @ORIENT("R0");
// #XL13 @PLACE(183, -50) => @ORIENT("R0");
// &openb @WIRE(mode="straight") {#XI:2 #XB:1};
// %t1 = $IO_PORT @ATTACH &gate => @PLACE(-11, 20) => @ORIENT("R0");
// %t1 @TEXT("gate", key="name", size=0.75);
// &gate @WIRE(mode="straight") {#XI:1 %t1:p};
// %t2 = $SUPPLY @ATTACH &vdd => @PLACE(0, 29);
// &vdd @WIRE(mode="straight") {#XI:3 %t2:p};
// %t3 = $GROUND @ATTACH &vss => @PLACE(0, 11);
// &vss @WIRE(mode="straight") {#XI:4 %t3:p};
// %t4 = $IO_PORT @ATTACH &hold => @PLACE(39, 20) => @ORIENT("MY");
// %t4 @TEXT("hold", key="name", size=0.75);
// &hold @WIRE(mode="straight") {#XB:2 %t4:p};
// %t5 = $SUPPLY @ATTACH &vdd => @PLACE(28, 29);
// &vdd @WIRE(mode="straight") {#XB:3 %t5:p};
// %t6 = $GROUND @ATTACH &vss => @PLACE(28, 11);
// &vss @WIRE(mode="straight") {#XB:4 %t6:p};
// %t7 = $IO_PORT @ATTACH &d0 => @PLACE(-11, -7) => @ORIENT("R0");
// %t7 @TEXT("d0", key="name", size=0.75);
// &d0 @WIRE(mode="straight") {#XL0:1 %t7:p};
// %t8 = $IO_PORT @ATTACH &openb => @PLACE(-11, -11) => @ORIENT("R0");
// %t8 @TEXT("openb", key="name", size=0.75);
// &openb @WIRE(mode="straight") {#XL0:2 %t8:p};
// %t9 = $IO_PORT @ATTACH &hold => @PLACE(-11, -15) => @ORIENT("R0");
// %t9 @TEXT("hold", key="name", size=0.75);
// &hold @WIRE(mode="straight") {#XL0:3 %t9:p};
// %t10 = $IO_PORT @ATTACH &q0 => @PLACE(10, -11) => @ORIENT("MY");
// %t10 @TEXT("q0", key="name", size=0.75);
// &q0 @WIRE(mode="straight") {#XL0:4 %t10:p};
// %t11 = $SUPPLY @ATTACH &vdd => @PLACE(0, 2);
// &vdd @WIRE(mode="straight") {#XL0:5 %t11:p};
// %t12 = $GROUND @ATTACH &vss => @PLACE(0, -24);
// &vss @WIRE(mode="straight") {#XL0:6 %t12:p};
// %t13 = $IO_PORT @ATTACH &d1 => @PLACE(22, -7) => @ORIENT("R0");
// %t13 @TEXT("d1", key="name", size=0.75);
// &d1 @WIRE(mode="straight") {#XL1:1 %t13:p};
// %t14 = $IO_PORT @ATTACH &openb => @PLACE(22, -11) => @ORIENT("R0");
// %t14 @TEXT("openb", key="name", size=0.75);
// &openb @WIRE(mode="straight") {#XL1:2 %t14:p};
// %t15 = $IO_PORT @ATTACH &hold => @PLACE(22, -15) => @ORIENT("R0");
// %t15 @TEXT("hold", key="name", size=0.75);
// &hold @WIRE(mode="straight") {#XL1:3 %t15:p};
// %t16 = $IO_PORT @ATTACH &q1 => @PLACE(43, -11) => @ORIENT("MY");
// %t16 @TEXT("q1", key="name", size=0.75);
// &q1 @WIRE(mode="straight") {#XL1:4 %t16:p};
// %t17 = $SUPPLY @ATTACH &vdd => @PLACE(33, 2);
// &vdd @WIRE(mode="straight") {#XL1:5 %t17:p};
// %t18 = $GROUND @ATTACH &vss => @PLACE(33, -24);
// &vss @WIRE(mode="straight") {#XL1:6 %t18:p};
// %t19 = $IO_PORT @ATTACH &d2 => @PLACE(53, -7) => @ORIENT("R0");
// %t19 @TEXT("d2", key="name", size=0.75);
// &d2 @WIRE(mode="straight") {#XL2:1 %t19:p};
// %t20 = $IO_PORT @ATTACH &openb => @PLACE(53, -11) => @ORIENT("R0");
// %t20 @TEXT("openb", key="name", size=0.75);
// &openb @WIRE(mode="straight") {#XL2:2 %t20:p};
// %t21 = $IO_PORT @ATTACH &hold => @PLACE(53, -15) => @ORIENT("R0");
// %t21 @TEXT("hold", key="name", size=0.75);
// &hold @WIRE(mode="straight") {#XL2:3 %t21:p};
// %t22 = $IO_PORT @ATTACH &q2 => @PLACE(73, -11) => @ORIENT("MY");
// %t22 @TEXT("q2", key="name", size=0.75);
// &q2 @WIRE(mode="straight") {#XL2:4 %t22:p};
// %t23 = $SUPPLY @ATTACH &vdd => @PLACE(63, 2);
// &vdd @WIRE(mode="straight") {#XL2:5 %t23:p};
// %t24 = $GROUND @ATTACH &vss => @PLACE(63, -24);
// &vss @WIRE(mode="straight") {#XL2:6 %t24:p};
// %t25 = $IO_PORT @ATTACH &d3 => @PLACE(83, -7) => @ORIENT("R0");
// %t25 @TEXT("d3", key="name", size=0.75);
// &d3 @WIRE(mode="straight") {#XL3:1 %t25:p};
// %t26 = $IO_PORT @ATTACH &openb => @PLACE(83, -11) => @ORIENT("R0");
// %t26 @TEXT("openb", key="name", size=0.75);
// &openb @WIRE(mode="straight") {#XL3:2 %t26:p};
// %t27 = $IO_PORT @ATTACH &hold => @PLACE(83, -15) => @ORIENT("R0");
// %t27 @TEXT("hold", key="name", size=0.75);
// &hold @WIRE(mode="straight") {#XL3:3 %t27:p};
// %t28 = $IO_PORT @ATTACH &q3 => @PLACE(103, -11) => @ORIENT("MY");
// %t28 @TEXT("q3", key="name", size=0.75);
// &q3 @WIRE(mode="straight") {#XL3:4 %t28:p};
// %t29 = $SUPPLY @ATTACH &vdd => @PLACE(93, 2);
// &vdd @WIRE(mode="straight") {#XL3:5 %t29:p};
// %t30 = $GROUND @ATTACH &vss => @PLACE(93, -24);
// &vss @WIRE(mode="straight") {#XL3:6 %t30:p};
// %t31 = $IO_PORT @ATTACH &d4 => @PLACE(113, -7) => @ORIENT("R0");
// %t31 @TEXT("d4", key="name", size=0.75);
// &d4 @WIRE(mode="straight") {#XL4:1 %t31:p};
// %t32 = $IO_PORT @ATTACH &openb => @PLACE(113, -11) => @ORIENT("R0");
// %t32 @TEXT("openb", key="name", size=0.75);
// &openb @WIRE(mode="straight") {#XL4:2 %t32:p};
// %t33 = $IO_PORT @ATTACH &hold => @PLACE(113, -15) => @ORIENT("R0");
// %t33 @TEXT("hold", key="name", size=0.75);
// &hold @WIRE(mode="straight") {#XL4:3 %t33:p};
// %t34 = $IO_PORT @ATTACH &q4 => @PLACE(133, -11) => @ORIENT("MY");
// %t34 @TEXT("q4", key="name", size=0.75);
// &q4 @WIRE(mode="straight") {#XL4:4 %t34:p};
// %t35 = $SUPPLY @ATTACH &vdd => @PLACE(123, 2);
// &vdd @WIRE(mode="straight") {#XL4:5 %t35:p};
// %t36 = $GROUND @ATTACH &vss => @PLACE(123, -24);
// &vss @WIRE(mode="straight") {#XL4:6 %t36:p};
// %t37 = $IO_PORT @ATTACH &d5 => @PLACE(143, -7) => @ORIENT("R0");
// %t37 @TEXT("d5", key="name", size=0.75);
// &d5 @WIRE(mode="straight") {#XL5:1 %t37:p};
// %t38 = $IO_PORT @ATTACH &openb => @PLACE(143, -11) => @ORIENT("R0");
// %t38 @TEXT("openb", key="name", size=0.75);
// &openb @WIRE(mode="straight") {#XL5:2 %t38:p};
// %t39 = $IO_PORT @ATTACH &hold => @PLACE(143, -15) => @ORIENT("R0");
// %t39 @TEXT("hold", key="name", size=0.75);
// &hold @WIRE(mode="straight") {#XL5:3 %t39:p};
// %t40 = $IO_PORT @ATTACH &q5 => @PLACE(163, -11) => @ORIENT("MY");
// %t40 @TEXT("q5", key="name", size=0.75);
// &q5 @WIRE(mode="straight") {#XL5:4 %t40:p};
// %t41 = $SUPPLY @ATTACH &vdd => @PLACE(153, 2);
// &vdd @WIRE(mode="straight") {#XL5:5 %t41:p};
// %t42 = $GROUND @ATTACH &vss => @PLACE(153, -24);
// &vss @WIRE(mode="straight") {#XL5:6 %t42:p};
// %t43 = $IO_PORT @ATTACH &d6 => @PLACE(173, -7) => @ORIENT("R0");
// %t43 @TEXT("d6", key="name", size=0.75);
// &d6 @WIRE(mode="straight") {#XL6:1 %t43:p};
// %t44 = $IO_PORT @ATTACH &openb => @PLACE(173, -11) => @ORIENT("R0");
// %t44 @TEXT("openb", key="name", size=0.75);
// &openb @WIRE(mode="straight") {#XL6:2 %t44:p};
// %t45 = $IO_PORT @ATTACH &hold => @PLACE(173, -15) => @ORIENT("R0");
// %t45 @TEXT("hold", key="name", size=0.75);
// &hold @WIRE(mode="straight") {#XL6:3 %t45:p};
// %t46 = $IO_PORT @ATTACH &q6 => @PLACE(194, -11) => @ORIENT("MY");
// %t46 @TEXT("q6", key="name", size=0.75);
// &q6 @WIRE(mode="straight") {#XL6:4 %t46:p};
// %t47 = $SUPPLY @ATTACH &vdd => @PLACE(183, 2);
// &vdd @WIRE(mode="straight") {#XL6:5 %t47:p};
// %t48 = $GROUND @ATTACH &vss => @PLACE(183, -24);
// &vss @WIRE(mode="straight") {#XL6:6 %t48:p};
// %t49 = $IO_PORT @ATTACH &d7 => @PLACE(-11, -46) => @ORIENT("R0");
// %t49 @TEXT("d7", key="name", size=0.75);
// &d7 @WIRE(mode="straight") {#XL7:1 %t49:p};
// %t50 = $IO_PORT @ATTACH &openb => @PLACE(-11, -50) => @ORIENT("R0");
// %t50 @TEXT("openb", key="name", size=0.75);
// &openb @WIRE(mode="straight") {#XL7:2 %t50:p};
// %t51 = $IO_PORT @ATTACH &hold => @PLACE(-11, -54) => @ORIENT("R0");
// %t51 @TEXT("hold", key="name", size=0.75);
// &hold @WIRE(mode="straight") {#XL7:3 %t51:p};
// %t52 = $IO_PORT @ATTACH &q7 => @PLACE(10, -50) => @ORIENT("MY");
// %t52 @TEXT("q7", key="name", size=0.75);
// &q7 @WIRE(mode="straight") {#XL7:4 %t52:p};
// %t53 = $SUPPLY @ATTACH &vdd => @PLACE(0, -37);
// &vdd @WIRE(mode="straight") {#XL7:5 %t53:p};
// %t54 = $GROUND @ATTACH &vss => @PLACE(0, -63);
// &vss @WIRE(mode="straight") {#XL7:6 %t54:p};
// %t55 = $IO_PORT @ATTACH &d8 => @PLACE(22, -46) => @ORIENT("R0");
// %t55 @TEXT("d8", key="name", size=0.75);
// &d8 @WIRE(mode="straight") {#XL8:1 %t55:p};
// %t56 = $IO_PORT @ATTACH &openb => @PLACE(22, -50) => @ORIENT("R0");
// %t56 @TEXT("openb", key="name", size=0.75);
// &openb @WIRE(mode="straight") {#XL8:2 %t56:p};
// %t57 = $IO_PORT @ATTACH &hold => @PLACE(22, -54) => @ORIENT("R0");
// %t57 @TEXT("hold", key="name", size=0.75);
// &hold @WIRE(mode="straight") {#XL8:3 %t57:p};
// %t58 = $IO_PORT @ATTACH &q8 => @PLACE(43, -50) => @ORIENT("MY");
// %t58 @TEXT("q8", key="name", size=0.75);
// &q8 @WIRE(mode="straight") {#XL8:4 %t58:p};
// %t59 = $SUPPLY @ATTACH &vdd => @PLACE(33, -37);
// &vdd @WIRE(mode="straight") {#XL8:5 %t59:p};
// %t60 = $GROUND @ATTACH &vss => @PLACE(33, -63);
// &vss @WIRE(mode="straight") {#XL8:6 %t60:p};
// %t61 = $IO_PORT @ATTACH &d9 => @PLACE(53, -46) => @ORIENT("R0");
// %t61 @TEXT("d9", key="name", size=0.75);
// &d9 @WIRE(mode="straight") {#XL9:1 %t61:p};
// %t62 = $IO_PORT @ATTACH &openb => @PLACE(53, -50) => @ORIENT("R0");
// %t62 @TEXT("openb", key="name", size=0.75);
// &openb @WIRE(mode="straight") {#XL9:2 %t62:p};
// %t63 = $IO_PORT @ATTACH &hold => @PLACE(53, -54) => @ORIENT("R0");
// %t63 @TEXT("hold", key="name", size=0.75);
// &hold @WIRE(mode="straight") {#XL9:3 %t63:p};
// %t64 = $IO_PORT @ATTACH &q9 => @PLACE(73, -50) => @ORIENT("MY");
// %t64 @TEXT("q9", key="name", size=0.75);
// &q9 @WIRE(mode="straight") {#XL9:4 %t64:p};
// %t65 = $SUPPLY @ATTACH &vdd => @PLACE(63, -37);
// &vdd @WIRE(mode="straight") {#XL9:5 %t65:p};
// %t66 = $GROUND @ATTACH &vss => @PLACE(63, -63);
// &vss @WIRE(mode="straight") {#XL9:6 %t66:p};
// %t67 = $IO_PORT @ATTACH &d10 => @PLACE(83, -46) => @ORIENT("R0");
// %t67 @TEXT("d10", key="name", size=0.75);
// &d10 @WIRE(mode="straight") {#XL10:1 %t67:p};
// %t68 = $IO_PORT @ATTACH &openb => @PLACE(83, -50) => @ORIENT("R0");
// %t68 @TEXT("openb", key="name", size=0.75);
// &openb @WIRE(mode="straight") {#XL10:2 %t68:p};
// %t69 = $IO_PORT @ATTACH &hold => @PLACE(83, -54) => @ORIENT("R0");
// %t69 @TEXT("hold", key="name", size=0.75);
// &hold @WIRE(mode="straight") {#XL10:3 %t69:p};
// %t70 = $IO_PORT @ATTACH &q10 => @PLACE(103, -50) => @ORIENT("MY");
// %t70 @TEXT("q10", key="name", size=0.75);
// &q10 @WIRE(mode="straight") {#XL10:4 %t70:p};
// %t71 = $SUPPLY @ATTACH &vdd => @PLACE(93, -37);
// &vdd @WIRE(mode="straight") {#XL10:5 %t71:p};
// %t72 = $GROUND @ATTACH &vss => @PLACE(93, -63);
// &vss @WIRE(mode="straight") {#XL10:6 %t72:p};
// %t73 = $IO_PORT @ATTACH &d11 => @PLACE(113, -46) => @ORIENT("R0");
// %t73 @TEXT("d11", key="name", size=0.75);
// &d11 @WIRE(mode="straight") {#XL11:1 %t73:p};
// %t74 = $IO_PORT @ATTACH &openb => @PLACE(113, -50) => @ORIENT("R0");
// %t74 @TEXT("openb", key="name", size=0.75);
// &openb @WIRE(mode="straight") {#XL11:2 %t74:p};
// %t75 = $IO_PORT @ATTACH &hold => @PLACE(113, -54) => @ORIENT("R0");
// %t75 @TEXT("hold", key="name", size=0.75);
// &hold @WIRE(mode="straight") {#XL11:3 %t75:p};
// %t76 = $IO_PORT @ATTACH &q11 => @PLACE(133, -50) => @ORIENT("MY");
// %t76 @TEXT("q11", key="name", size=0.75);
// &q11 @WIRE(mode="straight") {#XL11:4 %t76:p};
// %t77 = $SUPPLY @ATTACH &vdd => @PLACE(123, -37);
// &vdd @WIRE(mode="straight") {#XL11:5 %t77:p};
// %t78 = $GROUND @ATTACH &vss => @PLACE(123, -63);
// &vss @WIRE(mode="straight") {#XL11:6 %t78:p};
// %t79 = $IO_PORT @ATTACH &d12 => @PLACE(143, -46) => @ORIENT("R0");
// %t79 @TEXT("d12", key="name", size=0.75);
// &d12 @WIRE(mode="straight") {#XL12:1 %t79:p};
// %t80 = $IO_PORT @ATTACH &openb => @PLACE(143, -50) => @ORIENT("R0");
// %t80 @TEXT("openb", key="name", size=0.75);
// &openb @WIRE(mode="straight") {#XL12:2 %t80:p};
// %t81 = $IO_PORT @ATTACH &hold => @PLACE(143, -54) => @ORIENT("R0");
// %t81 @TEXT("hold", key="name", size=0.75);
// &hold @WIRE(mode="straight") {#XL12:3 %t81:p};
// %t82 = $IO_PORT @ATTACH &q12 => @PLACE(163, -50) => @ORIENT("MY");
// %t82 @TEXT("q12", key="name", size=0.75);
// &q12 @WIRE(mode="straight") {#XL12:4 %t82:p};
// %t83 = $SUPPLY @ATTACH &vdd => @PLACE(153, -37);
// &vdd @WIRE(mode="straight") {#XL12:5 %t83:p};
// %t84 = $GROUND @ATTACH &vss => @PLACE(153, -63);
// &vss @WIRE(mode="straight") {#XL12:6 %t84:p};
// %t85 = $IO_PORT @ATTACH &d13 => @PLACE(173, -46) => @ORIENT("R0");
// %t85 @TEXT("d13", key="name", size=0.75);
// &d13 @WIRE(mode="straight") {#XL13:1 %t85:p};
// %t86 = $IO_PORT @ATTACH &openb => @PLACE(173, -50) => @ORIENT("R0");
// %t86 @TEXT("openb", key="name", size=0.75);
// &openb @WIRE(mode="straight") {#XL13:2 %t86:p};
// %t87 = $IO_PORT @ATTACH &hold => @PLACE(173, -54) => @ORIENT("R0");
// %t87 @TEXT("hold", key="name", size=0.75);
// &hold @WIRE(mode="straight") {#XL13:3 %t87:p};
// %t88 = $IO_PORT @ATTACH &q13 => @PLACE(194, -50) => @ORIENT("MY");
// %t88 @TEXT("q13", key="name", size=0.75);
// &q13 @WIRE(mode="straight") {#XL13:4 %t88:p};
// %t89 = $SUPPLY @ATTACH &vdd => @PLACE(183, -37);
// &vdd @WIRE(mode="straight") {#XL13:5 %t89:p};
// %t90 = $GROUND @ATTACH &vss => @PLACE(183, -63);
// &vss @WIRE(mode="straight") {#XL13:6 %t90:p};
// (-16, 48) @TEXT("74  Snapshot | 16 instances", size=1.2, halign="start");
// }
ends tx_fll_snapshot_pdk110_74
