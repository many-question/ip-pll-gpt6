// NOR2 | frozen callback110 / recenter109 | RNL 0.3
// @RNL(type="header") { @VERSION("0.3"); @USE-PACKAGE(name="rnl-std-fill") {} }
simulator lang=spectre
subckt pll_nor2_pdk110_68 (a b y vdd vss)
MP0 (p a vdd vdd) pch w=4e-06 l=1.8e-07 ad=1.92e-12 as=1.92e-12 pd=8.960000000000001e-06 ps=8.960000000000001e-06 nrd=0.0675 nrs=0.0675 sa=4.8e-07 sb=4.8e-07 sd=5.4e-07 sca=0 scb=0 scc=0
MP1 (y b p vdd) pch w=4e-06 l=1.8e-07 ad=1.92e-12 as=1.92e-12 pd=8.960000000000001e-06 ps=8.960000000000001e-06 nrd=0.0675 nrs=0.0675 sa=4.8e-07 sb=4.8e-07 sd=5.4e-07 sca=0 scb=0 scc=0
MN0 (y a vss vss) nch w=1e-06 l=1.8e-07 ad=4.8e-13 as=4.8e-13 pd=2.96e-06 ps=2.96e-06 nrd=0.27 nrs=0.27 sa=4.8e-07 sb=4.8e-07 sd=5.4e-07 sca=0 scb=0 scc=0
MN1 (y b vss vss) nch w=1e-06 l=1.8e-07 ad=4.8e-13 as=4.8e-13 pd=2.96e-06 ps=2.96e-06 nrd=0.27 nrs=0.27 sa=4.8e-07 sb=4.8e-07 sd=5.4e-07 sca=0 scb=0 scc=0
// @RNL(author="manual-schematic126") {
// $CELL = @DEFINE-SYMBOL {
// @LINE {(-6, 6) (6, 6) (6, -6) (-6, -6) (-6, 6)};
// (-8, 2) @PIN(terminal="a", direction="left");
// @LINE {(-8, 2) (-6, 2)};
// (-5.4, 2) @TEXT("a", size=0.7, halign="start");
// (-8, -2) @PIN(terminal="b", direction="left");
// @LINE {(-8, -2) (-6, -2)};
// (-5.4, -2) @TEXT("b", size=0.7, halign="start");
// (8, 0) @PIN(terminal="y", direction="right");
// @LINE {(8, 0) (6, 0)};
// (5.4, 0) @TEXT("y", size=0.7, halign="end");
// (0, 8) @PIN(terminal="vdd", direction="up");
// @LINE {(0, 8) (0, 6)};
// (0, -8) @PIN(terminal="vss", direction="down");
// @LINE {(0, -8) (0, -6)};
// ? @TEXT("${name}", key="name", size=1, halign="middle") => @PLACE(8, 9.5);
// (0, 5.1) @TEXT("NOR2", size=0.85, halign="middle");
// };
// # @SET-SYMBOL $CELL;
// #MP0 @PLACE(0, 30) => @ORIENT("R0");
// #MP0 @SET-SYMBOL $PMOS_4TERM;
// #MP0 @TEXT("MP0", key="name", dx=5, dy=1.5, size=0.9, halign="start");
// #MP0 @TEXT("4u / 180n", key="model", dx=5, dy=-1.5, size=0.75, halign="start");
// #MP1 @PLACE(0, 16) => @ORIENT("R0");
// #MP1 @SET-SYMBOL $PMOS_4TERM;
// #MP1 @TEXT("MP1", key="name", dx=5, dy=1.5, size=0.9, halign="start");
// #MP1 @TEXT("4u / 180n", key="model", dx=5, dy=-1.5, size=0.75, halign="start");
// #MN0 @PLACE(-14, -4) => @ORIENT("R0");
// #MN0 @SET-SYMBOL $NMOS_4TERM;
// #MN0 @TEXT("MN0", key="name", dx=5, dy=1.5, size=0.9, halign="start");
// #MN0 @TEXT("1u / 180n", key="model", dx=5, dy=-1.5, size=0.75, halign="start");
// #MN1 @PLACE(14, -4) => @ORIENT("R0");
// #MN1 @SET-SYMBOL $NMOS_4TERM;
// #MN1 @TEXT("MN1", key="name", dx=5, dy=1.5, size=0.9, halign="start");
// #MN1 @TEXT("1u / 180n", key="model", dx=5, dy=-1.5, size=0.75, halign="start");
// &p @WIRE(mode="straight") {#MP0:1 #MP1:3};
// %o = (0, 6);
// &y @WIRE(mode="straight") {#MP1:1 %o (-14, 6) #MN0:1};
// &y @WIRE(mode="straight") {%o (14, 6) #MN1:1};
// $JUNCTION @ATTACH %o;
// %t1 = $IO_PORT @ATTACH &a => @PLACE(-6, 30) => @ORIENT("R0");
// %t1 @TEXT("a", key="name", size=0.75);
// &a @WIRE(mode="straight") {#MP0:2 %t1:p};
// %t2 = $SUPPLY @ATTACH &vdd => @PLACE(0, 35);
// &vdd @WIRE(mode="straight") {#MP0:3 %t2:p};
// %t3 = $IO_PORT @ATTACH &vdd => @PLACE(4, 30) => @ORIENT("MY");
// %t3 @TEXT("vdd", key="name", size=0.75);
// &vdd @WIRE(mode="straight") {#MP0:4 %t3:p};
// %t4 = $IO_PORT @ATTACH &b => @PLACE(-6, 16) => @ORIENT("R0");
// %t4 @TEXT("b", key="name", size=0.75);
// &b @WIRE(mode="straight") {#MP1:2 %t4:p};
// %t5 = $IO_PORT @ATTACH &vdd => @PLACE(4, 16) => @ORIENT("MY");
// %t5 @TEXT("vdd", key="name", size=0.75);
// &vdd @WIRE(mode="straight") {#MP1:4 %t5:p};
// %t6 = $IO_PORT @ATTACH &a => @PLACE(-20, -4) => @ORIENT("R0");
// %t6 @TEXT("a", key="name", size=0.75);
// &a @WIRE(mode="straight") {#MN0:2 %t6:p};
// %t7 = $GROUND @ATTACH &vss => @PLACE(-14, -9);
// &vss @WIRE(mode="straight") {#MN0:3 %t7:p};
// %t8 = $IO_PORT @ATTACH &vss => @PLACE(-10, -4) => @ORIENT("MY");
// %t8 @TEXT("vss", key="name", size=0.75);
// &vss @WIRE(mode="straight") {#MN0:4 %t8:p};
// %t9 = $IO_PORT @ATTACH &b => @PLACE(8, -4) => @ORIENT("R0");
// %t9 @TEXT("b", key="name", size=0.75);
// &b @WIRE(mode="straight") {#MN1:2 %t9:p};
// %t10 = $GROUND @ATTACH &vss => @PLACE(14, -9);
// &vss @WIRE(mode="straight") {#MN1:3 %t10:p};
// %t11 = $IO_PORT @ATTACH &vss => @PLACE(18, -4) => @ORIENT("MY");
// %t11 @TEXT("vss", key="name", size=0.75);
// &vss @WIRE(mode="straight") {#MN1:4 %t11:p};
// %t12 = $IO_PORT @ATTACH &y => @PLACE(-4, 11) => @ORIENT("R0");
// %t12 @TEXT("y", key="name", size=0.75);
// &y @WIRE(mode="straight") {#MP1:1 (0, 11) %t12:p};
// (-25, 54) @TEXT("68  NOR2 | 4 instances", size=1.2, halign="start");
// }
ends pll_nor2_pdk110_68
