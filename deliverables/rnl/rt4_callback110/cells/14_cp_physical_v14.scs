// Charge pump | frozen callback110 / recenter109 | RNL 0.3
// @RNL(type="header") { @VERSION("0.3"); @USE-PACKAGE(name="rnl-std-fill") {} }
simulator lang=spectre
subckt cp_physical_v14_pdk110_14 (hp hn pulse enable out vdd vss)
RREF (vdd nb) resistor r=24000
MB (nb nb vss vss) nch w=9.999999999999999e-06 l=1e-06 ad=4.8e-12 as=4.8e-12 pd=2.096e-05 ps=2.096e-05 nrd=0.027 nrs=0.027 sa=4.8e-07 sb=4.8e-07 sd=5.4e-07 sca=0 scb=0 scc=0
XG (pulse enable gateb vdd vss) pll_nand2_pdk110_15
XGI (gateb gate vdd vss) pll_inv_pdk110_7
XT (nb ng gate gateb vdd vss) pll_tg_pdk110_16
MOFF (ng gateb vss vss) nch w=1e-06 l=1.8e-07 ad=4.8e-13 as=4.8e-13 pd=2.96e-06 ps=2.96e-06 nrd=0.27 nrs=0.27 sa=4.8e-07 sb=4.8e-07 sd=5.4e-07 sca=0 scb=0 scc=0
MT (tail ng vss vss) nch w=9.999999999999999e-06 l=1e-06 ad=4.8e-12 as=4.8e-12 pd=2.096e-05 ps=2.096e-05 nrd=0.027 nrs=0.027 sa=4.8e-07 sb=4.8e-07 sd=5.4e-07 sca=0 scb=0 scc=0
MIP (out hp tail vss) nch w=8e-06 l=1e-06 ad=3.84e-12 as=3.84e-12 pd=1.696e-05 ps=1.696e-05 nrd=0.03375 nrs=0.03375 sa=4.8e-07 sb=4.8e-07 sd=5.4e-07 sca=0 scb=0 scc=0
MIN (mir hn tail vss) nch w=8e-06 l=1e-06 ad=3.84e-12 as=3.84e-12 pd=1.696e-05 ps=1.696e-05 nrd=0.03375 nrs=0.03375 sa=4.8e-07 sb=4.8e-07 sd=5.4e-07 sca=0 scb=0 scc=0
MPD (mir mir vdd vdd) pch w=4e-06 l=1e-06 ad=1.92e-12 as=1.92e-12 pd=8.960000000000001e-06 ps=8.960000000000001e-06 nrd=0.0675 nrs=0.0675 sa=4.8e-07 sb=4.8e-07 sd=5.4e-07 sca=0 scb=0 scc=0
MPO (out mir vdd vdd) pch w=4e-06 l=1e-06 ad=1.92e-12 as=1.92e-12 pd=8.960000000000001e-06 ps=8.960000000000001e-06 nrd=0.0675 nrs=0.0675 sa=4.8e-07 sb=4.8e-07 sd=5.4e-07 sca=0 scb=0 scc=0
// @RNL(author="functional-compact127") {
// $CELL = @DEFINE-SYMBOL {
// @LINE {(-6, -10) (6, -10) (6, 10) (-6, 10) (-6, -10)};
// @LINE {(3, 1) (2.89778, 1.77646) (2.59808, 2.5) (2.12132, 3.12132) (1.5, 3.59808) (0.776457, 3.89778) (1.83697e-16, 4) (-0.776457, 3.89778) (-1.5, 3.59808) (-2.12132, 3.12132) (-2.59808, 2.5) (-2.89778, 1.77646) (-3, 1) (-2.89778, 0.223543) (-2.59808, -0.5) (-2.12132, -1.12132) (-1.5, -1.59808) (-0.776457, -1.89778) (-5.51091e-16, -2) (0.776457, -1.89778) (1.5, -1.59808) (2.12132, -1.12132) (2.59808, -0.5) (2.89778, 0.223543) (3, 1)};
// @LINE {(-1, -1) (-1, 3)};
// @LINE {(-1.57531, 1.9469) (-1, 3) (-0.424689, 1.9469)};
// @LINE {(1, 3) (1, -1)};
// @LINE {(1.57531, 0.0530991) (1, -1) (0.424689, 0.0530991)};
// (0, 6) @TEXT("gm", size=1.1, halign="middle");
// (0, -5) @TEXT("I = gm dV", size=0.8, halign="middle");
// (-8, 6) @PIN(terminal="hp", direction="left");
// @LINE {(-8, 6) (-6, 6)};
// (-5.4, 6) @TEXT("hp", size=0.7, halign="start");
// (-8, 2) @PIN(terminal="hn", direction="left");
// @LINE {(-8, 2) (-6, 2)};
// (-5.4, 2) @TEXT("hn", size=0.7, halign="start");
// (-8, -2) @PIN(terminal="pulse", direction="left");
// @LINE {(-8, -2) (-6, -2)};
// (-5.4, -2) @TEXT("pulse", size=0.7, halign="start");
// (-8, -6) @PIN(terminal="enable", direction="left");
// @LINE {(-8, -6) (-6, -6)};
// (-5.4, -6) @TEXT("enable", size=0.7, halign="start");
// (8, 0) @PIN(terminal="out", direction="right");
// @LINE {(8, 0) (6, 0)};
// (5.4, 0) @TEXT("out", size=0.7, halign="end");
// (0, 12) @PIN(terminal="vdd", direction="up");
// @LINE {(0, 12) (0, 10)};
// (0, -12) @PIN(terminal="vss", direction="down");
// @LINE {(0, -12) (0, -10)};
// ? @TEXT("${name}", key="name", size=1, halign="middle") => @PLACE(8, 13.5);
// (0, 9.1) @TEXT("Charge pump", size=0.85, halign="middle");
// };
// # @SET-SYMBOL $CELL;
// #RREF @PLACE(-100, 12) => @ORIENT("R0");
// #RREF @SET-SYMBOL $RESISTOR;
// #RREF @TEXT("24k", key="value", dx=3, dy=-1, size=0.8, halign="start");
// #RREF @TEXT("RREF", key="name", dx=3, dy=1, size=0.9, halign="start");
// #MB @PLACE(-100, -12) => @ORIENT("R0");
// #MB @SET-SYMBOL $NMOS_4TERM;
// #MB @TEXT("MB", key="name", dx=5, dy=1.5, size=0.9, halign="start");
// #MB @TEXT("10u / 1u", key="model", dx=5, dy=-1.5, size=0.75, halign="start");
// #XG @PLACE(-68, 33) => @ORIENT("R0");
// #XGI @PLACE(-39, 33) => @ORIENT("R0");
// #XT @PLACE(-68, -12) => @ORIENT("R0");
// #MOFF @PLACE(-46, -12) => @ORIENT("R0");
// #MOFF @SET-SYMBOL $NMOS_4TERM;
// #MOFF @TEXT("MOFF", key="name", dx=5, dy=1.5, size=0.9, halign="start");
// #MOFF @TEXT("1u / 180n", key="model", dx=5, dy=-1.5, size=0.75, halign="start");
// #MT @PLACE(-9, -12) => @ORIENT("R0");
// #MT @SET-SYMBOL $NMOS_4TERM;
// #MT @TEXT("MT", key="name", dx=5, dy=1.5, size=0.9, halign="start");
// #MT @TEXT("10u / 1u", key="model", dx=5, dy=-1.5, size=0.75, halign="start");
// #MIP @PLACE(-24, 10) => @ORIENT("R0");
// #MIP @SET-SYMBOL $NMOS_4TERM;
// #MIP @TEXT("MIP", key="name", dx=5, dy=1.5, size=0.9, halign="start");
// #MIP @TEXT("8u / 1u", key="model", dx=5, dy=-1.5, size=0.75, halign="start");
// #MIN @PLACE(18, 10) => @ORIENT("MY");
// #MIN @SET-SYMBOL $NMOS_4TERM;
// #MIN @TEXT("MIN", key="name", dx=5, dy=1.5, size=0.9, halign="start");
// #MIN @TEXT("8u / 1u", key="model", dx=5, dy=-1.5, size=0.75, halign="start");
// #MPO @PLACE(-24, 30) => @ORIENT("R0");
// #MPO @SET-SYMBOL $PMOS_4TERM;
// #MPO @TEXT("MPO", key="name", dx=5, dy=1.5, size=0.9, halign="start");
// #MPO @TEXT("4u / 1u", key="model", dx=5, dy=-1.5, size=0.75, halign="start");
// #MPD @PLACE(18, 30) => @ORIENT("R0");
// #MPD @SET-SYMBOL $PMOS_4TERM;
// #MPD @TEXT("MPD", key="name", dx=5, dy=1.5, size=0.9, halign="start");
// #MPD @TEXT("4u / 1u", key="model", dx=5, dy=-1.5, size=0.75, halign="start");
// %tail = (-9, 0);
// &tail @WIRE(mode="straight") {#MIP:3 (-24, 0) %tail (18, 0) #MIN:3};
// &tail @WIRE(mode="straight") {%tail #MT:1};
// $JUNCTION @ATTACH %tail;
// &out @WIRE(mode="straight") {#MPO:1 #MIP:1};
// &mir @WIRE(mode="straight") {#MPD:1 #MIN:1};
// &mir @WIRE(mode="straight") {#MPD:2 (12, 30) (12, 22) (18, 22) #MPD:1};
// &mir @WIRE(mode="straight") {#MPO:2 (-30, 30) (-30, 22) (18, 22) #MIN:1};
// &nb @WIRE(mode="straight") {#RREF:2 #MB:1};
// %t1 = $SUPPLY @ATTACH &vdd => @PLACE(-100, 17);
// &vdd @WIRE(mode="straight") {#RREF:1 %t1:p};
// %t2 = $IO_PORT @ATTACH &nb => @PLACE(-106, -12) => @ORIENT("R0");
// %t2 @TEXT("nb", key="name", size=0.75);
// &nb @WIRE(mode="straight") {#MB:2 %t2:p};
// %t3 = $GROUND @ATTACH &vss => @PLACE(-100, -17);
// &vss @WIRE(mode="straight") {#MB:3 %t3:p};
// %t4 = $IO_PORT @ATTACH &vss => @PLACE(-96, -12) => @ORIENT("MY");
// %t4 @TEXT("vss", key="name", size=0.75);
// &vss @WIRE(mode="straight") {#MB:4 %t4:p};
// %t5 = $IO_PORT @ATTACH &pulse => @PLACE(-78, 35) => @ORIENT("R0");
// %t5 @TEXT("pulse", key="name", size=0.75);
// &pulse @WIRE(mode="straight") {#XG:1 %t5:p};
// %t6 = $IO_PORT @ATTACH &enable => @PLACE(-78, 31) => @ORIENT("R0");
// %t6 @TEXT("enable", key="name", size=0.75);
// &enable @WIRE(mode="straight") {#XG:2 %t6:p};
// %t7 = $IO_PORT @ATTACH &gateb => @PLACE(-58, 33) => @ORIENT("MY");
// %t7 @TEXT("gateb", key="name", size=0.75);
// &gateb @WIRE(mode="straight") {#XG:3 %t7:p};
// %t8 = $SUPPLY @ATTACH &vdd => @PLACE(-68, 44);
// &vdd @WIRE(mode="straight") {#XG:4 %t8:p};
// %t9 = $GROUND @ATTACH &vss => @PLACE(-68, 22);
// &vss @WIRE(mode="straight") {#XG:5 %t9:p};
// %t10 = $IO_PORT @ATTACH &gateb => @PLACE(-50, 33) => @ORIENT("R0");
// %t10 @TEXT("gateb", key="name", size=0.75);
// &gateb @WIRE(mode="straight") {#XGI:1 %t10:p};
// %t11 = $IO_PORT @ATTACH &gate => @PLACE(-28, 33) => @ORIENT("MY");
// %t11 @TEXT("gate", key="name", size=0.75);
// &gate @WIRE(mode="straight") {#XGI:2 %t11:p};
// %t12 = $SUPPLY @ATTACH &vdd => @PLACE(-39, 42);
// &vdd @WIRE(mode="straight") {#XGI:3 %t12:p};
// %t13 = $GROUND @ATTACH &vss => @PLACE(-39, 24);
// &vss @WIRE(mode="straight") {#XGI:4 %t13:p};
// %t14 = $IO_PORT @ATTACH &nb => @PLACE(-78, -8) => @ORIENT("R0");
// %t14 @TEXT("nb", key="name", size=0.75);
// &nb @WIRE(mode="straight") {#XT:1 %t14:p};
// %t15 = $IO_PORT @ATTACH &ng => @PLACE(-58, -12) => @ORIENT("MY");
// %t15 @TEXT("ng", key="name", size=0.75);
// &ng @WIRE(mode="straight") {#XT:2 %t15:p};
// %t16 = $IO_PORT @ATTACH &gate => @PLACE(-78, -12) => @ORIENT("R0");
// %t16 @TEXT("gate", key="name", size=0.75);
// &gate @WIRE(mode="straight") {#XT:3 %t16:p};
// %t17 = $IO_PORT @ATTACH &gateb => @PLACE(-78, -16) => @ORIENT("R0");
// %t17 @TEXT("gateb", key="name", size=0.75);
// &gateb @WIRE(mode="straight") {#XT:4 %t17:p};
// %t18 = $SUPPLY @ATTACH &vdd => @PLACE(-68, 1);
// &vdd @WIRE(mode="straight") {#XT:5 %t18:p};
// %t19 = $GROUND @ATTACH &vss => @PLACE(-68, -25);
// &vss @WIRE(mode="straight") {#XT:6 %t19:p};
// %t20 = $IO_PORT @ATTACH &ng => @PLACE(-50, -7) => @ORIENT("R0");
// %t20 @TEXT("ng", key="name", size=0.75);
// &ng @WIRE(mode="straight") {#MOFF:1 (-46, -7) %t20:p};
// %t21 = $IO_PORT @ATTACH &gateb => @PLACE(-52, -12) => @ORIENT("R0");
// %t21 @TEXT("gateb", key="name", size=0.75);
// &gateb @WIRE(mode="straight") {#MOFF:2 %t21:p};
// %t22 = $GROUND @ATTACH &vss => @PLACE(-46, -17);
// &vss @WIRE(mode="straight") {#MOFF:3 %t22:p};
// %t23 = $IO_PORT @ATTACH &vss => @PLACE(-42, -12) => @ORIENT("MY");
// %t23 @TEXT("vss", key="name", size=0.75);
// &vss @WIRE(mode="straight") {#MOFF:4 %t23:p};
// %t24 = $IO_PORT @ATTACH &ng => @PLACE(-15, -12) => @ORIENT("R0");
// %t24 @TEXT("ng", key="name", size=0.75);
// &ng @WIRE(mode="straight") {#MT:2 %t24:p};
// %t25 = $GROUND @ATTACH &vss => @PLACE(-9, -17);
// &vss @WIRE(mode="straight") {#MT:3 %t25:p};
// %t26 = $IO_PORT @ATTACH &vss => @PLACE(-5, -12) => @ORIENT("MY");
// %t26 @TEXT("vss", key="name", size=0.75);
// &vss @WIRE(mode="straight") {#MT:4 %t26:p};
// %t27 = $IO_PORT @ATTACH &hp => @PLACE(-30, 10) => @ORIENT("R0");
// %t27 @TEXT("hp", key="name", size=0.75);
// &hp @WIRE(mode="straight") {#MIP:2 %t27:p};
// %t28 = $IO_PORT @ATTACH &vss => @PLACE(-20, 10) => @ORIENT("MY");
// %t28 @TEXT("vss", key="name", size=0.75);
// &vss @WIRE(mode="straight") {#MIP:4 %t28:p};
// %t29 = $IO_PORT @ATTACH &hn => @PLACE(24, 10) => @ORIENT("MY");
// %t29 @TEXT("hn", key="name", size=0.75);
// &hn @WIRE(mode="straight") {#MIN:2 %t29:p};
// %t30 = $IO_PORT @ATTACH &vss => @PLACE(14, 10) => @ORIENT("R0");
// %t30 @TEXT("vss", key="name", size=0.75);
// &vss @WIRE(mode="straight") {#MIN:4 %t30:p};
// %t31 = $SUPPLY @ATTACH &vdd => @PLACE(-24, 35);
// &vdd @WIRE(mode="straight") {#MPO:3 %t31:p};
// %t32 = $IO_PORT @ATTACH &vdd => @PLACE(-20, 30) => @ORIENT("MY");
// %t32 @TEXT("vdd", key="name", size=0.75);
// &vdd @WIRE(mode="straight") {#MPO:4 %t32:p};
// %t33 = $SUPPLY @ATTACH &vdd => @PLACE(18, 35);
// &vdd @WIRE(mode="straight") {#MPD:3 %t33:p};
// %t34 = $IO_PORT @ATTACH &vdd => @PLACE(22, 30) => @ORIENT("MY");
// %t34 @TEXT("vdd", key="name", size=0.75);
// &vdd @WIRE(mode="straight") {#MPD:4 %t34:p};
// %t35 = $IO_PORT @ATTACH &out => @PLACE(-28, 15) => @ORIENT("R0");
// %t35 @TEXT("out", key="name", size=0.75);
// &out @WIRE(mode="straight") {#MIP:1 (-24, 15) %t35:p};
// (-111, 63) @TEXT("14  Charge pump | 11 instances", size=1.2, halign="start");
// }
ends cp_physical_v14_pdk110_14
