// Supervisor | frozen callback110 / recenter109 | RNL 0.3
// @RNL(type="header") { @VERSION("0.3"); @USE-PACKAGE(name="rnl-std-fill") {} }
simulator lang=spectre
subckt tx_pll_supervisor_capture_v14_pdk110_77 (refclk reset cfg_ready fll_enable range_error phase_good frequency_good pll_enable qualified restart fault vdd vss)
X0 (n13 refclk reset n14 vdd vss) tx_dff_r0_pdk110_58
X1 (n15 refclk reset n16 vdd vss) tx_dff_r0_pdk110_58
X2 (n17 refclk reset n18 vdd vss) tx_dff_r0_pdk110_58
X3 (n19 refclk reset restart vdd vss) tx_dff_r0_pdk110_58
X4 (n20 refclk reset n21 vdd vss) tx_dff_r0_pdk110_58
X5 (n22 refclk reset n23 vdd vss) tx_dff_r0_pdk110_58
X6 (n24 refclk reset n25 vdd vss) tx_dff_r0_pdk110_58
X7 (n26 refclk reset n27 vdd vss) tx_dff_r0_pdk110_58
X8 (n28 refclk reset qualified vdd vss) tx_dff_r0_pdk110_58
X9 (n29 refclk reset n30 vdd vss) tx_dff_r0_pdk110_58
X10 (n31 refclk reset n32 vdd vss) tx_dff_r0_pdk110_58
X11 (n33 refclk reset n34 vdd vss) tx_dff_r0_pdk110_58
X12 (n35 refclk reset n36 vdd vss) tx_dff_r0_pdk110_58
X13 (n37 refclk reset n38 vdd vss) tx_dff_r0_pdk110_58
X14 (n39 refclk reset n40 vdd vss) tx_dff_r0_pdk110_58
X15 (n41 refclk reset fault vdd vss) tx_dff_r0_pdk110_58
X16 (n42 refclk reset n43 vdd vss) tx_dff_r0_pdk110_58
X17 (n44 refclk reset n45 vdd vss) tx_dff_r0_pdk110_58
X18 (n46 refclk reset n47 vdd vss) tx_dff_r0_pdk110_58
X19 (n48 refclk reset n49 vdd vss) tx_dff_r0_pdk110_58
X20 (n50 refclk reset n51 vdd vss) tx_dff_r0_pdk110_58
X21 (n52 refclk reset n53 vdd vss) tx_dff_r0_pdk110_58
X22 (n54 refclk reset n55 vdd vss) tx_dff_r0_pdk110_58
X23 (n56 refclk reset n57 vdd vss) tx_dff_r0_pdk110_58
X24 (n58 refclk reset n59 vdd vss) tx_dff_r0_pdk110_58
X25 (n38 n60 n61 n37 vdd vss) tx_mux_pdk110_64
X26 (n36 n62 n61 n35 vdd vss) tx_mux_pdk110_64
X27 (n34 n63 n61 n33 vdd vss) tx_mux_pdk110_64
X28 (n32 n64 n61 n31 vdd vss) tx_mux_pdk110_64
X29 (n30 n65 n61 n29 vdd vss) tx_mux_pdk110_64
X30 (n25 n66 n67 n24 vdd vss) tx_mux_pdk110_64
X31 (n23 n68 n67 n22 vdd vss) tx_mux_pdk110_64
X32 (n21 n69 n67 n20 vdd vss) tx_mux_pdk110_64
X33 (n16 n70 n71 n15 vdd vss) tx_mux_pdk110_64
X34 (n14 n72 n71 n13 vdd vss) tx_mux_pdk110_64
X35 (n18 n73 n71 n17 vdd vss) tx_mux_pdk110_64
X36 (restart n74 n75 n19 vdd vss) tx_mux_pdk110_64
X37 (n27 n76 n67 n26 vdd vss) tx_mux_pdk110_64
X38 (qualified n77 n78 n28 vdd vss) tx_mux_pdk110_64
X39 (n40 n79 n61 n39 vdd vss) tx_mux_pdk110_64
X40 (fault n80 n81 n41 vdd vss) tx_mux_pdk110_64
X41 (n14 n82 vdd vss) pll_inv_pdk110_7
X42 (n30 n83 vdd vss) pll_inv_pdk110_7
X43 (n43 n84 vdd vss) pll_inv_pdk110_7
X44 (n36 n85 vdd vss) pll_inv_pdk110_7
X45 (n59 n86 vdd vss) pll_inv_pdk110_7
X46 (n25 n87 vdd vss) pll_inv_pdk110_7
X47 (n23 n88 vdd vss) pll_inv_pdk110_7
X48 (n21 n89 vdd vss) pll_inv_pdk110_7
X49 (cfg_ready n90 vdd vss) pll_inv_pdk110_7
X50 (qualified n91 vdd vss) pll_inv_pdk110_7
X51 (fll_enable n92 vdd vss) pll_inv_pdk110_7
X52 (n93 n94 vdd vss) pll_inv_pdk110_7
X53 (restart n95 vdd vss) pll_inv_pdk110_7
X54 (range_error n96 vdd vss) pll_inv_pdk110_7
X55 (n51 n97 n98 vdd vss) tx_and_pdk110_47
X56 (n47 n99 n100 vdd vss) tx_and_pdk110_47
X57 (n55 n101 n102 vdd vss) tx_and_pdk110_47
X58 (n103 n97 n101 vdd vss) tx_and_pdk110_47
X59 (n104 n97 n105 vdd vss) tx_and_pdk110_47
X60 (n106 n103 n104 vdd vss) tx_and_pdk110_47
X61 (n107 n99 n97 vdd vss) tx_and_pdk110_47
X62 (n57 n55 n106 vdd vss) tx_and_pdk110_47
X63 (n53 n51 n103 vdd vss) tx_and_pdk110_47
X64 (n49 n47 n107 vdd vss) tx_and_pdk110_47
X65 (n45 n43 n99 vdd vss) tx_and_pdk110_47
X66 (n34 n108 n109 vdd vss) tx_and_pdk110_47
X67 (n38 n110 n111 vdd vss) tx_and_pdk110_47
X68 (n112 n108 n110 vdd vss) tx_and_pdk110_47
X69 (n36 n34 n112 vdd vss) tx_and_pdk110_47
X70 (n32 n30 n108 vdd vss) tx_and_pdk110_47
X71 (n16 n14 n113 vdd vss) tx_and_pdk110_47
X72 (n23 n21 n114 vdd vss) tx_xor_pdk110_66
X73 (n25 n115 n116 vdd vss) tx_xor_pdk110_66
X74 (n27 n117 n118 vdd vss) tx_xor_pdk110_66
X75 (n45 n43 n119 vdd vss) tx_xor_pdk110_66
X76 (n47 n99 n120 vdd vss) tx_xor_pdk110_66
X77 (n49 n100 n121 vdd vss) tx_xor_pdk110_66
X78 (n51 n97 n122 vdd vss) tx_xor_pdk110_66
X79 (n53 n98 n123 vdd vss) tx_xor_pdk110_66
X80 (n55 n101 n124 vdd vss) tx_xor_pdk110_66
X81 (n57 n102 n125 vdd vss) tx_xor_pdk110_66
X82 (n59 n105 n126 vdd vss) tx_xor_pdk110_66
X83 (n32 n30 n127 vdd vss) tx_xor_pdk110_66
X84 (n34 n108 n128 vdd vss) tx_xor_pdk110_66
X85 (n36 n109 n129 vdd vss) tx_xor_pdk110_66
X86 (n38 n110 n130 vdd vss) tx_xor_pdk110_66
X87 (n40 n111 n131 vdd vss) tx_xor_pdk110_66
X88 (n16 n14 n132 vdd vss) tx_xor_pdk110_66
X89 (n18 n113 n133 vdd vss) tx_xor_pdk110_66
X90 (n25 n115 n117 vdd vss) tx_and_pdk110_47
X91 (n23 n21 n115 vdd vss) tx_and_pdk110_47
X92 (n134 n78 n71 vdd vss) tx_and_pdk110_47
X93 (range_error qualified n135 vdd vss) tx_or_pdk110_67
X94 (n93 n136 n137 vdd vss) tx_or_pdk110_67
X95 (n138 n135 n139 vdd vss) tx_or_pdk110_67
X96 (n139 n137 n134 vdd vss) tx_or_pdk110_67
X97 (n90 n96 n75 vdd vss) tx_or_pdk110_67
X98 (n140 n141 n142 vdd vss) tx_and_pdk110_47
X99 (n143 n75 n144 vdd vss) tx_and_pdk110_47
X100 (n142 n144 n145 vdd vss) tx_and_pdk110_47
X101 (n145 n146 n67 vdd vss) tx_and_pdk110_47
X102 (n147 n136 n148 vdd vss) tx_or_pdk110_67
X103 (n149 n148 n140 vdd vss) tx_or_pdk110_67
X104 (n90 restart n149 vdd vss) tx_or_pdk110_67
X105 (n149 n150 n141 vdd vss) tx_or_pdk110_67
X106 (n90 qualified n151 vdd vss) tx_or_pdk110_67
X107 (restart n136 n152 vdd vss) tx_or_pdk110_67
X108 (n151 n152 n143 vdd vss) tx_or_pdk110_67
X109 (n90 fll_enable n153 vdd vss) tx_or_pdk110_67
X110 (n153 restart n146 vdd vss) tx_or_pdk110_67
X111 (n90 range_error n81 vdd vss) tx_or_pdk110_67
X112 (n81 n95 n78 vdd vss) tx_or_pdk110_67
X113 (n78 n154 n61 vdd vss) tx_and_pdk110_47
X114 (n90 n92 n138 vdd vss) tx_or_pdk110_67
X115 (range_error n91 n155 vdd vss) tx_or_pdk110_67
X116 (n94 n136 n150 vdd vss) tx_or_pdk110_67
X117 (n138 n155 n156 vdd vss) tx_or_pdk110_67
X118 (n156 n150 n154 vdd vss) tx_or_pdk110_67
X119 (n89 n88 n157 vdd vss) tx_or_pdk110_67
X120 (n87 n27 n158 vdd vss) tx_or_pdk110_67
X121 (n157 n158 n159 vdd vss) tx_or_pdk110_67
X122 (n82 n160 n161 vdd vss) tx_or_pdk110_67
X123 (n161 n18 n162 vdd vss) tx_or_pdk110_67
X124 (n84 n163 n164 vdd vss) tx_or_pdk110_67
X125 (n165 n166 n167 vdd vss) tx_or_pdk110_67
X126 (n168 n169 n170 vdd vss) tx_or_pdk110_67
X127 (n171 n172 n173 vdd vss) tx_or_pdk110_67
X128 (n164 n167 n174 vdd vss) tx_or_pdk110_67
X129 (n170 n173 n175 vdd vss) tx_or_pdk110_67
X130 (n174 n175 n176 vdd vss) tx_or_pdk110_67
X131 (n176 n86 n177 vdd vss) tx_or_pdk110_67
X132 (n83 n178 n179 vdd vss) tx_or_pdk110_67
X133 (n180 n85 n181 vdd vss) tx_or_pdk110_67
X134 (n182 n40 n183 vdd vss) tx_or_pdk110_67
X135 (n179 n181 n184 vdd vss) tx_or_pdk110_67
X136 (n184 n183 n185 vdd vss) tx_or_pdk110_67
X137 (reset n186 vdd vss) pll_inv_pdk110_7
X138 (n177 n187 vdd vss) pll_inv_pdk110_7
X139 (n188 n189 vdd vss) pll_inv_pdk110_7
X140 (phase_good frequency_good n93 vdd vss) tx_and_pdk110_47
X141 (cfg_ready fll_enable n190 vdd vss) tx_and_pdk110_47
X142 (n190 n96 n191 vdd vss) tx_and_pdk110_47
X143 (n191 n95 n192 vdd vss) tx_and_pdk110_47
X144 (n192 n186 pll_enable vdd vss) tx_and_pdk110_47
X145 (n91 n187 n193 vdd vss) tx_and_pdk110_47
X146 (n93 n194 n188 vdd vss) tx_and_pdk110_47
X147 (n193 n189 n136 vdd vss) tx_and_pdk110_47
X148 (n84 vss qualified n195 vdd vss) tx_mux_pdk110_64
X149 (n119 vss qualified n196 vdd vss) tx_mux_pdk110_64
X150 (n120 vss qualified n197 vdd vss) tx_mux_pdk110_64
X151 (n121 vss qualified n198 vdd vss) tx_mux_pdk110_64
X152 (n122 vss qualified n199 vdd vss) tx_mux_pdk110_64
X153 (n123 vss qualified n200 vdd vss) tx_mux_pdk110_64
X154 (n124 vss qualified n201 vdd vss) tx_mux_pdk110_64
X155 (n125 vss qualified n202 vdd vss) tx_mux_pdk110_64
X156 (n126 vss qualified n203 vdd vss) tx_mux_pdk110_64
X157 (vss n195 n185 n204 vdd vss) tx_mux_pdk110_64
X158 (vss n196 n185 n205 vdd vss) tx_mux_pdk110_64
X159 (vss n197 n185 n206 vdd vss) tx_mux_pdk110_64
X160 (vss n198 n185 n207 vdd vss) tx_mux_pdk110_64
X161 (vss n199 n185 n208 vdd vss) tx_mux_pdk110_64
X162 (vss n200 n185 n209 vdd vss) tx_mux_pdk110_64
X163 (vss n201 n185 n210 vdd vss) tx_mux_pdk110_64
X164 (vss n202 n185 n211 vdd vss) tx_mux_pdk110_64
X165 (vss n203 n185 n212 vdd vss) tx_mux_pdk110_64
X166 (n204 n195 qualified n213 vdd vss) tx_mux_pdk110_64
X167 (n205 n196 qualified n214 vdd vss) tx_mux_pdk110_64
X168 (n206 n197 qualified n215 vdd vss) tx_mux_pdk110_64
X169 (n207 n198 qualified n216 vdd vss) tx_mux_pdk110_64
X170 (n208 n199 qualified n217 vdd vss) tx_mux_pdk110_64
X171 (n209 n200 qualified n218 vdd vss) tx_mux_pdk110_64
X172 (n210 n201 qualified n219 vdd vss) tx_mux_pdk110_64
X173 (n211 n202 qualified n220 vdd vss) tx_mux_pdk110_64
X174 (n212 n203 qualified n221 vdd vss) tx_mux_pdk110_64
X175 (n195 n213 n93 n222 vdd vss) tx_mux_pdk110_64
X176 (n196 n214 n93 n223 vdd vss) tx_mux_pdk110_64
X177 (n197 n215 n93 n224 vdd vss) tx_mux_pdk110_64
X178 (n198 n216 n93 n225 vdd vss) tx_mux_pdk110_64
X179 (n199 n217 n93 n226 vdd vss) tx_mux_pdk110_64
X180 (n200 n218 n93 n227 vdd vss) tx_mux_pdk110_64
X181 (n201 n219 n93 n228 vdd vss) tx_mux_pdk110_64
X182 (n202 n220 n93 n229 vdd vss) tx_mux_pdk110_64
X183 (n203 n221 n93 n230 vdd vss) tx_mux_pdk110_64
X184 (n222 vss n136 n231 vdd vss) tx_mux_pdk110_64
X185 (n223 vss n136 n232 vdd vss) tx_mux_pdk110_64
X186 (n224 vss n136 n233 vdd vss) tx_mux_pdk110_64
X187 (n225 vss n136 n234 vdd vss) tx_mux_pdk110_64
X188 (n226 vss n136 n235 vdd vss) tx_mux_pdk110_64
X189 (n227 vss n136 n236 vdd vss) tx_mux_pdk110_64
X190 (n228 vss n136 n237 vdd vss) tx_mux_pdk110_64
X191 (n229 vss n136 n238 vdd vss) tx_mux_pdk110_64
X192 (n230 vss n136 n239 vdd vss) tx_mux_pdk110_64
X193 (vss n231 fll_enable n240 vdd vss) tx_mux_pdk110_64
X194 (vss n232 fll_enable n241 vdd vss) tx_mux_pdk110_64
X195 (vss n233 fll_enable n242 vdd vss) tx_mux_pdk110_64
X196 (vss n234 fll_enable n243 vdd vss) tx_mux_pdk110_64
X197 (vss n235 fll_enable n244 vdd vss) tx_mux_pdk110_64
X198 (vss n236 fll_enable n245 vdd vss) tx_mux_pdk110_64
X199 (vss n237 fll_enable n246 vdd vss) tx_mux_pdk110_64
X200 (vss n238 fll_enable n247 vdd vss) tx_mux_pdk110_64
X201 (vss n239 fll_enable n248 vdd vss) tx_mux_pdk110_64
X202 (n240 vss restart n249 vdd vss) tx_mux_pdk110_64
X203 (n241 vss restart n250 vdd vss) tx_mux_pdk110_64
X204 (n242 vss restart n251 vdd vss) tx_mux_pdk110_64
X205 (n243 vss restart n252 vdd vss) tx_mux_pdk110_64
X206 (n244 vss restart n253 vdd vss) tx_mux_pdk110_64
X207 (n245 vss restart n254 vdd vss) tx_mux_pdk110_64
X208 (n246 vss restart n255 vdd vss) tx_mux_pdk110_64
X209 (n247 vss restart n256 vdd vss) tx_mux_pdk110_64
X210 (n248 vss restart n257 vdd vss) tx_mux_pdk110_64
X211 (n249 vss range_error n258 vdd vss) tx_mux_pdk110_64
X212 (n250 vss range_error n259 vdd vss) tx_mux_pdk110_64
X213 (n251 vss range_error n260 vdd vss) tx_mux_pdk110_64
X214 (n252 vss range_error n261 vdd vss) tx_mux_pdk110_64
X215 (n253 vss range_error n262 vdd vss) tx_mux_pdk110_64
X216 (n254 vss range_error n263 vdd vss) tx_mux_pdk110_64
X217 (n255 vss range_error n264 vdd vss) tx_mux_pdk110_64
X218 (n256 vss range_error n265 vdd vss) tx_mux_pdk110_64
X219 (n257 vss range_error n266 vdd vss) tx_mux_pdk110_64
X220 (vss n258 cfg_ready n42 vdd vss) tx_mux_pdk110_64
X221 (vss n259 cfg_ready n44 vdd vss) tx_mux_pdk110_64
X222 (vss n260 cfg_ready n46 vdd vss) tx_mux_pdk110_64
X223 (vss n261 cfg_ready n48 vdd vss) tx_mux_pdk110_64
X224 (vss n262 cfg_ready n50 vdd vss) tx_mux_pdk110_64
X225 (vss n263 cfg_ready n52 vdd vss) tx_mux_pdk110_64
X226 (vss n264 cfg_ready n54 vdd vss) tx_mux_pdk110_64
X227 (vss n265 cfg_ready n56 vdd vss) tx_mux_pdk110_64
X228 (vss n266 cfg_ready n58 vdd vss) tx_mux_pdk110_64
X229 (vss vss n162 n267 vdd vss) tx_mux_pdk110_64
X230 (vss n267 qualified n268 vdd vss) tx_mux_pdk110_64
X231 (n268 vss n93 n269 vdd vss) tx_mux_pdk110_64
X232 (n269 vss n136 n270 vdd vss) tx_mux_pdk110_64
X233 (vss n270 fll_enable n271 vdd vss) tx_mux_pdk110_64
X234 (vss n89 n159 n272 vdd vss) tx_mux_pdk110_64
X235 (vss n114 n159 n273 vdd vss) tx_mux_pdk110_64
X236 (vss n116 n159 n274 vdd vss) tx_mux_pdk110_64
X237 (vss n118 n159 n275 vdd vss) tx_mux_pdk110_64
X238 (n271 n272 restart n276 vdd vss) tx_mux_pdk110_64
X239 (n271 n273 restart n277 vdd vss) tx_mux_pdk110_64
X240 (n271 n274 restart n278 vdd vss) tx_mux_pdk110_64
X241 (n271 n275 restart n279 vdd vss) tx_mux_pdk110_64
X242 (n276 vss range_error n280 vdd vss) tx_mux_pdk110_64
X243 (n277 vss range_error n281 vdd vss) tx_mux_pdk110_64
X244 (n278 vss range_error n282 vdd vss) tx_mux_pdk110_64
X245 (n279 vss range_error n283 vdd vss) tx_mux_pdk110_64
X246 (vss n280 cfg_ready n69 vdd vss) tx_mux_pdk110_64
X247 (vss n281 cfg_ready n68 vdd vss) tx_mux_pdk110_64
X248 (vss n282 cfg_ready n66 vdd vss) tx_mux_pdk110_64
X249 (vss n283 cfg_ready n76 vdd vss) tx_mux_pdk110_64
X250 (vss n82 n162 n284 vdd vss) tx_mux_pdk110_64
X251 (vss n132 n162 n285 vdd vss) tx_mux_pdk110_64
X252 (vss n133 n162 n286 vdd vss) tx_mux_pdk110_64
X253 (vss n284 qualified n287 vdd vss) tx_mux_pdk110_64
X254 (vss n285 qualified n288 vdd vss) tx_mux_pdk110_64
X255 (vss n286 qualified n289 vdd vss) tx_mux_pdk110_64
X256 (n287 vss n93 n290 vdd vss) tx_mux_pdk110_64
X257 (n288 vss n93 n291 vdd vss) tx_mux_pdk110_64
X258 (n289 vss n93 n292 vdd vss) tx_mux_pdk110_64
X259 (n290 vss n136 n293 vdd vss) tx_mux_pdk110_64
X260 (n291 vss n136 n294 vdd vss) tx_mux_pdk110_64
X261 (n292 vss n136 n295 vdd vss) tx_mux_pdk110_64
X262 (vss n293 fll_enable n296 vdd vss) tx_mux_pdk110_64
X263 (vss n294 fll_enable n297 vdd vss) tx_mux_pdk110_64
X264 (vss n295 fll_enable n298 vdd vss) tx_mux_pdk110_64
X265 (n296 vss restart n299 vdd vss) tx_mux_pdk110_64
X266 (n297 vss restart n300 vdd vss) tx_mux_pdk110_64
X267 (n298 vss restart n301 vdd vss) tx_mux_pdk110_64
X268 (n299 vss range_error n302 vdd vss) tx_mux_pdk110_64
X269 (n300 vss range_error n303 vdd vss) tx_mux_pdk110_64
X270 (n301 vss range_error n304 vdd vss) tx_mux_pdk110_64
X271 (vss n302 cfg_ready n72 vdd vss) tx_mux_pdk110_64
X272 (vss n303 cfg_ready n70 vdd vss) tx_mux_pdk110_64
X273 (vss n304 cfg_ready n73 vdd vss) tx_mux_pdk110_64
X274 (vss n83 n185 n305 vdd vss) tx_mux_pdk110_64
X275 (vss n127 n185 n306 vdd vss) tx_mux_pdk110_64
X276 (vss n128 n185 n307 vdd vss) tx_mux_pdk110_64
X277 (vss n129 n185 n308 vdd vss) tx_mux_pdk110_64
X278 (vss n130 n185 n309 vdd vss) tx_mux_pdk110_64
X279 (vss n131 n185 n310 vdd vss) tx_mux_pdk110_64
X280 (n305 vss qualified n311 vdd vss) tx_mux_pdk110_64
X281 (n306 vss qualified n312 vdd vss) tx_mux_pdk110_64
X282 (n307 vss qualified n313 vdd vss) tx_mux_pdk110_64
X283 (n308 vss qualified n314 vdd vss) tx_mux_pdk110_64
X284 (n309 vss qualified n315 vdd vss) tx_mux_pdk110_64
X285 (n310 vss qualified n316 vdd vss) tx_mux_pdk110_64
X286 (vss n311 n93 n317 vdd vss) tx_mux_pdk110_64
X287 (vss n312 n93 n318 vdd vss) tx_mux_pdk110_64
X288 (vss n313 n93 n319 vdd vss) tx_mux_pdk110_64
X289 (vss n314 n93 n320 vdd vss) tx_mux_pdk110_64
X290 (vss n315 n93 n321 vdd vss) tx_mux_pdk110_64
X291 (vss n316 n93 n322 vdd vss) tx_mux_pdk110_64
X292 (n317 vss n136 n323 vdd vss) tx_mux_pdk110_64
X293 (n318 vss n136 n324 vdd vss) tx_mux_pdk110_64
X294 (n319 vss n136 n325 vdd vss) tx_mux_pdk110_64
X295 (n320 vss n136 n326 vdd vss) tx_mux_pdk110_64
X296 (n321 vss n136 n327 vdd vss) tx_mux_pdk110_64
X297 (n322 vss n136 n328 vdd vss) tx_mux_pdk110_64
X298 (vss n323 fll_enable n329 vdd vss) tx_mux_pdk110_64
X299 (vss n324 fll_enable n330 vdd vss) tx_mux_pdk110_64
X300 (vss n325 fll_enable n331 vdd vss) tx_mux_pdk110_64
X301 (vss n326 fll_enable n332 vdd vss) tx_mux_pdk110_64
X302 (vss n327 fll_enable n333 vdd vss) tx_mux_pdk110_64
X303 (vss n328 fll_enable n334 vdd vss) tx_mux_pdk110_64
X304 (n329 vss restart n335 vdd vss) tx_mux_pdk110_64
X305 (n330 vss restart n336 vdd vss) tx_mux_pdk110_64
X306 (n331 vss restart n337 vdd vss) tx_mux_pdk110_64
X307 (n332 vss restart n338 vdd vss) tx_mux_pdk110_64
X308 (n333 vss restart n339 vdd vss) tx_mux_pdk110_64
X309 (n334 vss restart n340 vdd vss) tx_mux_pdk110_64
X310 (n335 vss range_error n341 vdd vss) tx_mux_pdk110_64
X311 (n336 vss range_error n342 vdd vss) tx_mux_pdk110_64
X312 (n337 vss range_error n343 vdd vss) tx_mux_pdk110_64
X313 (n338 vss range_error n344 vdd vss) tx_mux_pdk110_64
X314 (n339 vss range_error n345 vdd vss) tx_mux_pdk110_64
X315 (n340 vss range_error n346 vdd vss) tx_mux_pdk110_64
X316 (vss n341 cfg_ready n65 vdd vss) tx_mux_pdk110_64
X317 (vss n342 cfg_ready n64 vdd vss) tx_mux_pdk110_64
X318 (vss n343 cfg_ready n63 vdd vss) tx_mux_pdk110_64
X319 (vss n344 cfg_ready n62 vdd vss) tx_mux_pdk110_64
X320 (vss n345 cfg_ready n60 vdd vss) tx_mux_pdk110_64
X321 (vss n346 cfg_ready n79 vdd vss) tx_mux_pdk110_64
X322 (vss vdd range_error n347 vdd vss) tx_mux_pdk110_64
X323 (vss n347 cfg_ready n80 vdd vss) tx_mux_pdk110_64
X324 (n162 n147 vdd vss) pll_inv_pdk110_7
X325 (vss n147 qualified n348 vdd vss) tx_mux_pdk110_64
X326 (n348 vss n93 n349 vdd vss) tx_mux_pdk110_64
X327 (n349 vdd n136 n350 vdd vss) tx_mux_pdk110_64
X328 (vss n350 fll_enable n351 vdd vss) tx_mux_pdk110_64
X329 (n351 n159 restart n352 vdd vss) tx_mux_pdk110_64
X330 (n352 vss range_error n353 vdd vss) tx_mux_pdk110_64
X331 (vss n353 cfg_ready n74 vdd vss) tx_mux_pdk110_64
X332 (vss n162 qualified n354 vdd vss) tx_mux_pdk110_64
X333 (n185 n194 vdd vss) pll_inv_pdk110_7
X334 (n194 vdd qualified n355 vdd vss) tx_mux_pdk110_64
X335 (n354 n355 n93 n356 vdd vss) tx_mux_pdk110_64
X336 (n356 vss n136 n357 vdd vss) tx_mux_pdk110_64
X337 (vss n357 fll_enable n358 vdd vss) tx_mux_pdk110_64
X338 (n358 vss restart n359 vdd vss) tx_mux_pdk110_64
X339 (n359 vss range_error n360 vdd vss) tx_mux_pdk110_64
X340 (vss n360 cfg_ready n77 vdd vss) tx_mux_pdk110_64
X341 (n45 n163 vdd vss) pll_inv_pdk110_7
X342 (n47 n165 vdd vss) pll_inv_pdk110_7
X343 (n49 n166 vdd vss) pll_inv_pdk110_7
X344 (n51 n168 vdd vss) pll_inv_pdk110_7
X345 (n53 n169 vdd vss) pll_inv_pdk110_7
X346 (n55 n171 vdd vss) pll_inv_pdk110_7
X347 (n57 n172 vdd vss) pll_inv_pdk110_7
X348 (n32 n178 vdd vss) pll_inv_pdk110_7
X349 (n34 n180 vdd vss) pll_inv_pdk110_7
X350 (n38 n182 vdd vss) pll_inv_pdk110_7
X351 (n16 n160 vdd vss) pll_inv_pdk110_7
// @RNL(author="functional-compact127") {
// $CELL = @DEFINE-SYMBOL {
// @LINE {(-12, -16) (12, -16) (12, 16) (-12, 16) (-12, -16)};
// @LINE {(-4, 2) (4, 2) (4, 6) (-4, 6) (-4, 2)};
// (0, 4) @TEXT("QUAL", size=0.9, halign="middle");
// @LINE {(0, 2) (0, -2)};
// @LINE {(0.575311, -0.946901) (0, -2) (-0.575311, -0.946901)};
// (0, -4) @TEXT("EN", size=1.1, halign="middle");
// (0, -8) @TEXT("restart", size=0.85, halign="middle");
// (-14, 12) @PIN(terminal="refclk", direction="left");
// @LINE {(-14, 12) (-12, 12)};
// (-11.4, 12) @TEXT("refclk", size=0.7, halign="start");
// (-14, 8) @PIN(terminal="reset", direction="left");
// @LINE {(-14, 8) (-12, 8)};
// (-11.4, 8) @TEXT("reset", size=0.7, halign="start");
// (-14, 4) @PIN(terminal="cfg_ready", direction="left");
// @LINE {(-14, 4) (-12, 4)};
// (-11.4, 4) @TEXT("cfg_ready", size=0.7, halign="start");
// (-14, 0) @PIN(terminal="fll_enable", direction="left");
// @LINE {(-14, 0) (-12, 0)};
// (-11.4, 0) @TEXT("fll_enable", size=0.7, halign="start");
// (-14, -4) @PIN(terminal="range_error", direction="left");
// @LINE {(-14, -4) (-12, -4)};
// (-11.4, -4) @TEXT("range_error", size=0.7, halign="start");
// (-14, -8) @PIN(terminal="phase_good", direction="left");
// @LINE {(-14, -8) (-12, -8)};
// (-11.4, -8) @TEXT("phase_good", size=0.7, halign="start");
// (-14, -12) @PIN(terminal="frequency_good", direction="left");
// @LINE {(-14, -12) (-12, -12)};
// (-11.4, -12) @TEXT("frequency_good", size=0.7, halign="start");
// (14, 6) @PIN(terminal="pll_enable", direction="right");
// @LINE {(14, 6) (12, 6)};
// (11.4, 6) @TEXT("pll_enable", size=0.7, halign="end");
// (14, 2) @PIN(terminal="qualified", direction="right");
// @LINE {(14, 2) (12, 2)};
// (11.4, 2) @TEXT("qualified", size=0.7, halign="end");
// (14, -2) @PIN(terminal="restart", direction="right");
// @LINE {(14, -2) (12, -2)};
// (11.4, -2) @TEXT("restart", size=0.7, halign="end");
// (14, -6) @PIN(terminal="fault", direction="right");
// @LINE {(14, -6) (12, -6)};
// (11.4, -6) @TEXT("fault", size=0.7, halign="end");
// (0, 18) @PIN(terminal="vdd", direction="up");
// @LINE {(0, 18) (0, 16)};
// (0, -18) @PIN(terminal="vss", direction="down");
// @LINE {(0, -18) (0, -16)};
// ? @TEXT("${name}", key="name", size=1, halign="middle") => @PLACE(14, 19.5);
// (0, 15.1) @TEXT("Supervisor", size=0.85, halign="middle");
// };
// # @SET-SYMBOL $CELL;
// #X0 @PLACE(0, -60) => @ORIENT("R0");
// (-25, -46) @TEXT("Panel 01 | X0 - X23", size=1.1, halign="start");
// #X1 @PLACE(40, -60) => @ORIENT("R0");
// #X2 @PLACE(80, -60) => @ORIENT("R0");
// #X3 @PLACE(120, -60) => @ORIENT("R0");
// #X4 @PLACE(0, -95) => @ORIENT("R0");
// #X5 @PLACE(40, -95) => @ORIENT("R0");
// #X6 @PLACE(80, -95) => @ORIENT("R0");
// #X7 @PLACE(120, -95) => @ORIENT("R0");
// #X8 @PLACE(0, -130) => @ORIENT("R0");
// #X9 @PLACE(40, -130) => @ORIENT("R0");
// #X10 @PLACE(80, -130) => @ORIENT("R0");
// #X11 @PLACE(120, -130) => @ORIENT("R0");
// #X12 @PLACE(0, -165) => @ORIENT("R0");
// #X13 @PLACE(40, -165) => @ORIENT("R0");
// #X14 @PLACE(80, -165) => @ORIENT("R0");
// #X15 @PLACE(120, -165) => @ORIENT("R0");
// #X16 @PLACE(0, -200) => @ORIENT("R0");
// #X17 @PLACE(40, -200) => @ORIENT("R0");
// #X18 @PLACE(80, -200) => @ORIENT("R0");
// #X19 @PLACE(120, -200) => @ORIENT("R0");
// #X20 @PLACE(0, -235) => @ORIENT("R0");
// #X21 @PLACE(40, -235) => @ORIENT("R0");
// #X22 @PLACE(80, -235) => @ORIENT("R0");
// #X23 @PLACE(120, -235) => @ORIENT("R0");
// #X24 @PLACE(168, -60) => @ORIENT("R0");
// (152, -46) @TEXT("Panel 02 | X24 - X47", size=1.1, halign="start");
// #X25 @PLACE(208, -60) => @ORIENT("R0");
// #X26 @PLACE(248, -60) => @ORIENT("R0");
// #X27 @PLACE(288, -60) => @ORIENT("R0");
// #X28 @PLACE(168, -95) => @ORIENT("R0");
// #X29 @PLACE(208, -95) => @ORIENT("R0");
// #X30 @PLACE(248, -95) => @ORIENT("R0");
// #X31 @PLACE(288, -95) => @ORIENT("R0");
// #X32 @PLACE(168, -130) => @ORIENT("R0");
// #X33 @PLACE(208, -130) => @ORIENT("R0");
// #X34 @PLACE(248, -130) => @ORIENT("R0");
// #X35 @PLACE(288, -130) => @ORIENT("R0");
// #X36 @PLACE(168, -165) => @ORIENT("R0");
// #X37 @PLACE(208, -165) => @ORIENT("R0");
// #X38 @PLACE(248, -165) => @ORIENT("R0");
// #X39 @PLACE(288, -165) => @ORIENT("R0");
// #X40 @PLACE(168, -200) => @ORIENT("R0");
// #X41 @PLACE(208, -200) => @ORIENT("R0");
// #X42 @PLACE(248, -200) => @ORIENT("R0");
// #X43 @PLACE(288, -200) => @ORIENT("R0");
// #X44 @PLACE(168, -235) => @ORIENT("R0");
// #X45 @PLACE(208, -235) => @ORIENT("R0");
// #X46 @PLACE(248, -235) => @ORIENT("R0");
// #X47 @PLACE(288, -235) => @ORIENT("R0");
// #X48 @PLACE(336, -60) => @ORIENT("R0");
// (320, -46) @TEXT("Panel 03 | X48 - X71", size=1.1, halign="start");
// #X49 @PLACE(376, -60) => @ORIENT("R0");
// #X50 @PLACE(416, -60) => @ORIENT("R0");
// #X51 @PLACE(456, -60) => @ORIENT("R0");
// #X52 @PLACE(336, -95) => @ORIENT("R0");
// #X53 @PLACE(376, -95) => @ORIENT("R0");
// #X54 @PLACE(416, -95) => @ORIENT("R0");
// #X55 @PLACE(456, -95) => @ORIENT("R0");
// #X56 @PLACE(336, -130) => @ORIENT("R0");
// #X57 @PLACE(376, -130) => @ORIENT("R0");
// #X58 @PLACE(416, -130) => @ORIENT("R0");
// #X59 @PLACE(456, -130) => @ORIENT("R0");
// #X60 @PLACE(336, -165) => @ORIENT("R0");
// #X61 @PLACE(376, -165) => @ORIENT("R0");
// #X62 @PLACE(416, -165) => @ORIENT("R0");
// #X63 @PLACE(456, -165) => @ORIENT("R0");
// #X64 @PLACE(336, -200) => @ORIENT("R0");
// #X65 @PLACE(376, -200) => @ORIENT("R0");
// #X66 @PLACE(416, -200) => @ORIENT("R0");
// #X67 @PLACE(456, -200) => @ORIENT("R0");
// #X68 @PLACE(336, -235) => @ORIENT("R0");
// #X69 @PLACE(376, -235) => @ORIENT("R0");
// #X70 @PLACE(416, -235) => @ORIENT("R0");
// #X71 @PLACE(456, -235) => @ORIENT("R0");
// #X72 @PLACE(504, -60) => @ORIENT("R0");
// (488, -46) @TEXT("Panel 04 | X72 - X95", size=1.1, halign="start");
// #X73 @PLACE(544, -60) => @ORIENT("R0");
// #X74 @PLACE(584, -60) => @ORIENT("R0");
// #X75 @PLACE(624, -60) => @ORIENT("R0");
// #X76 @PLACE(504, -95) => @ORIENT("R0");
// #X77 @PLACE(544, -95) => @ORIENT("R0");
// #X78 @PLACE(584, -95) => @ORIENT("R0");
// #X79 @PLACE(624, -95) => @ORIENT("R0");
// #X80 @PLACE(504, -130) => @ORIENT("R0");
// #X81 @PLACE(544, -130) => @ORIENT("R0");
// #X82 @PLACE(584, -130) => @ORIENT("R0");
// #X83 @PLACE(624, -130) => @ORIENT("R0");
// #X84 @PLACE(504, -165) => @ORIENT("R0");
// #X85 @PLACE(544, -165) => @ORIENT("R0");
// #X86 @PLACE(584, -165) => @ORIENT("R0");
// #X87 @PLACE(624, -165) => @ORIENT("R0");
// #X88 @PLACE(504, -200) => @ORIENT("R0");
// #X89 @PLACE(544, -200) => @ORIENT("R0");
// #X90 @PLACE(584, -200) => @ORIENT("R0");
// #X91 @PLACE(624, -200) => @ORIENT("R0");
// #X92 @PLACE(504, -235) => @ORIENT("R0");
// #X93 @PLACE(544, -235) => @ORIENT("R0");
// #X94 @PLACE(584, -235) => @ORIENT("R0");
// #X95 @PLACE(624, -235) => @ORIENT("R0");
// #X96 @PLACE(0, -280) => @ORIENT("R0");
// (-25, -266) @TEXT("Panel 05 | X96 - X119", size=1.1, halign="start");
// #X97 @PLACE(40, -280) => @ORIENT("R0");
// #X98 @PLACE(80, -280) => @ORIENT("R0");
// #X99 @PLACE(120, -280) => @ORIENT("R0");
// #X100 @PLACE(0, -315) => @ORIENT("R0");
// #X101 @PLACE(40, -315) => @ORIENT("R0");
// #X102 @PLACE(80, -315) => @ORIENT("R0");
// #X103 @PLACE(120, -315) => @ORIENT("R0");
// #X104 @PLACE(0, -350) => @ORIENT("R0");
// #X105 @PLACE(40, -350) => @ORIENT("R0");
// #X106 @PLACE(80, -350) => @ORIENT("R0");
// #X107 @PLACE(120, -350) => @ORIENT("R0");
// #X108 @PLACE(0, -385) => @ORIENT("R0");
// #X109 @PLACE(40, -385) => @ORIENT("R0");
// #X110 @PLACE(80, -385) => @ORIENT("R0");
// #X111 @PLACE(120, -385) => @ORIENT("R0");
// #X112 @PLACE(0, -420) => @ORIENT("R0");
// #X113 @PLACE(40, -420) => @ORIENT("R0");
// #X114 @PLACE(80, -420) => @ORIENT("R0");
// #X115 @PLACE(120, -420) => @ORIENT("R0");
// #X116 @PLACE(0, -455) => @ORIENT("R0");
// #X117 @PLACE(40, -455) => @ORIENT("R0");
// #X118 @PLACE(80, -455) => @ORIENT("R0");
// #X119 @PLACE(120, -455) => @ORIENT("R0");
// #X120 @PLACE(168, -280) => @ORIENT("R0");
// (152, -266) @TEXT("Panel 06 | X120 - X143", size=1.1, halign="start");
// #X121 @PLACE(208, -280) => @ORIENT("R0");
// #X122 @PLACE(248, -280) => @ORIENT("R0");
// #X123 @PLACE(288, -280) => @ORIENT("R0");
// #X124 @PLACE(168, -315) => @ORIENT("R0");
// #X125 @PLACE(208, -315) => @ORIENT("R0");
// #X126 @PLACE(248, -315) => @ORIENT("R0");
// #X127 @PLACE(288, -315) => @ORIENT("R0");
// #X128 @PLACE(168, -350) => @ORIENT("R0");
// #X129 @PLACE(208, -350) => @ORIENT("R0");
// #X130 @PLACE(248, -350) => @ORIENT("R0");
// #X131 @PLACE(288, -350) => @ORIENT("R0");
// #X132 @PLACE(168, -385) => @ORIENT("R0");
// #X133 @PLACE(208, -385) => @ORIENT("R0");
// #X134 @PLACE(248, -385) => @ORIENT("R0");
// #X135 @PLACE(288, -385) => @ORIENT("R0");
// #X136 @PLACE(168, -420) => @ORIENT("R0");
// #X137 @PLACE(208, -420) => @ORIENT("R0");
// #X138 @PLACE(248, -420) => @ORIENT("R0");
// #X139 @PLACE(288, -420) => @ORIENT("R0");
// #X140 @PLACE(168, -455) => @ORIENT("R0");
// #X141 @PLACE(208, -455) => @ORIENT("R0");
// #X142 @PLACE(248, -455) => @ORIENT("R0");
// #X143 @PLACE(288, -455) => @ORIENT("R0");
// #X144 @PLACE(336, -280) => @ORIENT("R0");
// (320, -266) @TEXT("Panel 07 | X144 - X167", size=1.1, halign="start");
// #X145 @PLACE(376, -280) => @ORIENT("R0");
// #X146 @PLACE(416, -280) => @ORIENT("R0");
// #X147 @PLACE(456, -280) => @ORIENT("R0");
// #X148 @PLACE(336, -315) => @ORIENT("R0");
// #X149 @PLACE(376, -315) => @ORIENT("R0");
// #X150 @PLACE(416, -315) => @ORIENT("R0");
// #X151 @PLACE(456, -315) => @ORIENT("R0");
// #X152 @PLACE(336, -350) => @ORIENT("R0");
// #X153 @PLACE(376, -350) => @ORIENT("R0");
// #X154 @PLACE(416, -350) => @ORIENT("R0");
// #X155 @PLACE(456, -350) => @ORIENT("R0");
// #X156 @PLACE(336, -385) => @ORIENT("R0");
// #X157 @PLACE(376, -385) => @ORIENT("R0");
// #X158 @PLACE(416, -385) => @ORIENT("R0");
// #X159 @PLACE(456, -385) => @ORIENT("R0");
// #X160 @PLACE(336, -420) => @ORIENT("R0");
// #X161 @PLACE(376, -420) => @ORIENT("R0");
// #X162 @PLACE(416, -420) => @ORIENT("R0");
// #X163 @PLACE(456, -420) => @ORIENT("R0");
// #X164 @PLACE(336, -455) => @ORIENT("R0");
// #X165 @PLACE(376, -455) => @ORIENT("R0");
// #X166 @PLACE(416, -455) => @ORIENT("R0");
// #X167 @PLACE(456, -455) => @ORIENT("R0");
// #X168 @PLACE(504, -280) => @ORIENT("R0");
// (488, -266) @TEXT("Panel 08 | X168 - X191", size=1.1, halign="start");
// #X169 @PLACE(544, -280) => @ORIENT("R0");
// #X170 @PLACE(584, -280) => @ORIENT("R0");
// #X171 @PLACE(624, -280) => @ORIENT("R0");
// #X172 @PLACE(504, -315) => @ORIENT("R0");
// #X173 @PLACE(544, -315) => @ORIENT("R0");
// #X174 @PLACE(584, -315) => @ORIENT("R0");
// #X175 @PLACE(624, -315) => @ORIENT("R0");
// #X176 @PLACE(504, -350) => @ORIENT("R0");
// #X177 @PLACE(544, -350) => @ORIENT("R0");
// #X178 @PLACE(584, -350) => @ORIENT("R0");
// #X179 @PLACE(624, -350) => @ORIENT("R0");
// #X180 @PLACE(504, -385) => @ORIENT("R0");
// #X181 @PLACE(544, -385) => @ORIENT("R0");
// #X182 @PLACE(584, -385) => @ORIENT("R0");
// #X183 @PLACE(624, -385) => @ORIENT("R0");
// #X184 @PLACE(504, -420) => @ORIENT("R0");
// #X185 @PLACE(544, -420) => @ORIENT("R0");
// #X186 @PLACE(584, -420) => @ORIENT("R0");
// #X187 @PLACE(624, -420) => @ORIENT("R0");
// #X188 @PLACE(504, -455) => @ORIENT("R0");
// #X189 @PLACE(544, -455) => @ORIENT("R0");
// #X190 @PLACE(584, -455) => @ORIENT("R0");
// #X191 @PLACE(624, -455) => @ORIENT("R0");
// #X192 @PLACE(0, -500) => @ORIENT("R0");
// (-25, -486) @TEXT("Panel 09 | X192 - X215", size=1.1, halign="start");
// #X193 @PLACE(40, -500) => @ORIENT("R0");
// #X194 @PLACE(80, -500) => @ORIENT("R0");
// #X195 @PLACE(120, -500) => @ORIENT("R0");
// #X196 @PLACE(0, -535) => @ORIENT("R0");
// #X197 @PLACE(40, -535) => @ORIENT("R0");
// #X198 @PLACE(80, -535) => @ORIENT("R0");
// #X199 @PLACE(120, -535) => @ORIENT("R0");
// #X200 @PLACE(0, -570) => @ORIENT("R0");
// #X201 @PLACE(40, -570) => @ORIENT("R0");
// #X202 @PLACE(80, -570) => @ORIENT("R0");
// #X203 @PLACE(120, -570) => @ORIENT("R0");
// #X204 @PLACE(0, -605) => @ORIENT("R0");
// #X205 @PLACE(40, -605) => @ORIENT("R0");
// #X206 @PLACE(80, -605) => @ORIENT("R0");
// #X207 @PLACE(120, -605) => @ORIENT("R0");
// #X208 @PLACE(0, -640) => @ORIENT("R0");
// #X209 @PLACE(40, -640) => @ORIENT("R0");
// #X210 @PLACE(80, -640) => @ORIENT("R0");
// #X211 @PLACE(120, -640) => @ORIENT("R0");
// #X212 @PLACE(0, -675) => @ORIENT("R0");
// #X213 @PLACE(40, -675) => @ORIENT("R0");
// #X214 @PLACE(80, -675) => @ORIENT("R0");
// #X215 @PLACE(120, -675) => @ORIENT("R0");
// #X216 @PLACE(168, -500) => @ORIENT("R0");
// (152, -486) @TEXT("Panel 10 | X216 - X239", size=1.1, halign="start");
// #X217 @PLACE(208, -500) => @ORIENT("R0");
// #X218 @PLACE(248, -500) => @ORIENT("R0");
// #X219 @PLACE(288, -500) => @ORIENT("R0");
// #X220 @PLACE(168, -535) => @ORIENT("R0");
// #X221 @PLACE(208, -535) => @ORIENT("R0");
// #X222 @PLACE(248, -535) => @ORIENT("R0");
// #X223 @PLACE(288, -535) => @ORIENT("R0");
// #X224 @PLACE(168, -570) => @ORIENT("R0");
// #X225 @PLACE(208, -570) => @ORIENT("R0");
// #X226 @PLACE(248, -570) => @ORIENT("R0");
// #X227 @PLACE(288, -570) => @ORIENT("R0");
// #X228 @PLACE(168, -605) => @ORIENT("R0");
// #X229 @PLACE(208, -605) => @ORIENT("R0");
// #X230 @PLACE(248, -605) => @ORIENT("R0");
// #X231 @PLACE(288, -605) => @ORIENT("R0");
// #X232 @PLACE(168, -640) => @ORIENT("R0");
// #X233 @PLACE(208, -640) => @ORIENT("R0");
// #X234 @PLACE(248, -640) => @ORIENT("R0");
// #X235 @PLACE(288, -640) => @ORIENT("R0");
// #X236 @PLACE(168, -675) => @ORIENT("R0");
// #X237 @PLACE(208, -675) => @ORIENT("R0");
// #X238 @PLACE(248, -675) => @ORIENT("R0");
// #X239 @PLACE(288, -675) => @ORIENT("R0");
// #X240 @PLACE(336, -500) => @ORIENT("R0");
// (320, -486) @TEXT("Panel 11 | X240 - X263", size=1.1, halign="start");
// #X241 @PLACE(376, -500) => @ORIENT("R0");
// #X242 @PLACE(416, -500) => @ORIENT("R0");
// #X243 @PLACE(456, -500) => @ORIENT("R0");
// #X244 @PLACE(336, -535) => @ORIENT("R0");
// #X245 @PLACE(376, -535) => @ORIENT("R0");
// #X246 @PLACE(416, -535) => @ORIENT("R0");
// #X247 @PLACE(456, -535) => @ORIENT("R0");
// #X248 @PLACE(336, -570) => @ORIENT("R0");
// #X249 @PLACE(376, -570) => @ORIENT("R0");
// #X250 @PLACE(416, -570) => @ORIENT("R0");
// #X251 @PLACE(456, -570) => @ORIENT("R0");
// #X252 @PLACE(336, -605) => @ORIENT("R0");
// #X253 @PLACE(376, -605) => @ORIENT("R0");
// #X254 @PLACE(416, -605) => @ORIENT("R0");
// #X255 @PLACE(456, -605) => @ORIENT("R0");
// #X256 @PLACE(336, -640) => @ORIENT("R0");
// #X257 @PLACE(376, -640) => @ORIENT("R0");
// #X258 @PLACE(416, -640) => @ORIENT("R0");
// #X259 @PLACE(456, -640) => @ORIENT("R0");
// #X260 @PLACE(336, -675) => @ORIENT("R0");
// #X261 @PLACE(376, -675) => @ORIENT("R0");
// #X262 @PLACE(416, -675) => @ORIENT("R0");
// #X263 @PLACE(456, -675) => @ORIENT("R0");
// #X264 @PLACE(504, -500) => @ORIENT("R0");
// (488, -486) @TEXT("Panel 12 | X264 - X287", size=1.1, halign="start");
// #X265 @PLACE(544, -500) => @ORIENT("R0");
// #X266 @PLACE(584, -500) => @ORIENT("R0");
// #X267 @PLACE(624, -500) => @ORIENT("R0");
// #X268 @PLACE(504, -535) => @ORIENT("R0");
// #X269 @PLACE(544, -535) => @ORIENT("R0");
// #X270 @PLACE(584, -535) => @ORIENT("R0");
// #X271 @PLACE(624, -535) => @ORIENT("R0");
// #X272 @PLACE(504, -570) => @ORIENT("R0");
// #X273 @PLACE(544, -570) => @ORIENT("R0");
// #X274 @PLACE(584, -570) => @ORIENT("R0");
// #X275 @PLACE(624, -570) => @ORIENT("R0");
// #X276 @PLACE(504, -605) => @ORIENT("R0");
// #X277 @PLACE(544, -605) => @ORIENT("R0");
// #X278 @PLACE(584, -605) => @ORIENT("R0");
// #X279 @PLACE(624, -605) => @ORIENT("R0");
// #X280 @PLACE(504, -640) => @ORIENT("R0");
// #X281 @PLACE(544, -640) => @ORIENT("R0");
// #X282 @PLACE(584, -640) => @ORIENT("R0");
// #X283 @PLACE(624, -640) => @ORIENT("R0");
// #X284 @PLACE(504, -675) => @ORIENT("R0");
// #X285 @PLACE(544, -675) => @ORIENT("R0");
// #X286 @PLACE(584, -675) => @ORIENT("R0");
// #X287 @PLACE(624, -675) => @ORIENT("R0");
// #X288 @PLACE(0, -720) => @ORIENT("R0");
// (-25, -706) @TEXT("Panel 13 | X288 - X311", size=1.1, halign="start");
// #X289 @PLACE(40, -720) => @ORIENT("R0");
// #X290 @PLACE(80, -720) => @ORIENT("R0");
// #X291 @PLACE(120, -720) => @ORIENT("R0");
// #X292 @PLACE(0, -755) => @ORIENT("R0");
// #X293 @PLACE(40, -755) => @ORIENT("R0");
// #X294 @PLACE(80, -755) => @ORIENT("R0");
// #X295 @PLACE(120, -755) => @ORIENT("R0");
// #X296 @PLACE(0, -790) => @ORIENT("R0");
// #X297 @PLACE(40, -790) => @ORIENT("R0");
// #X298 @PLACE(80, -790) => @ORIENT("R0");
// #X299 @PLACE(120, -790) => @ORIENT("R0");
// #X300 @PLACE(0, -825) => @ORIENT("R0");
// #X301 @PLACE(40, -825) => @ORIENT("R0");
// #X302 @PLACE(80, -825) => @ORIENT("R0");
// #X303 @PLACE(120, -825) => @ORIENT("R0");
// #X304 @PLACE(0, -860) => @ORIENT("R0");
// #X305 @PLACE(40, -860) => @ORIENT("R0");
// #X306 @PLACE(80, -860) => @ORIENT("R0");
// #X307 @PLACE(120, -860) => @ORIENT("R0");
// #X308 @PLACE(0, -895) => @ORIENT("R0");
// #X309 @PLACE(40, -895) => @ORIENT("R0");
// #X310 @PLACE(80, -895) => @ORIENT("R0");
// #X311 @PLACE(120, -895) => @ORIENT("R0");
// #X312 @PLACE(168, -720) => @ORIENT("R0");
// (152, -706) @TEXT("Panel 14 | X312 - X335", size=1.1, halign="start");
// #X313 @PLACE(208, -720) => @ORIENT("R0");
// #X314 @PLACE(248, -720) => @ORIENT("R0");
// #X315 @PLACE(288, -720) => @ORIENT("R0");
// #X316 @PLACE(168, -755) => @ORIENT("R0");
// #X317 @PLACE(208, -755) => @ORIENT("R0");
// #X318 @PLACE(248, -755) => @ORIENT("R0");
// #X319 @PLACE(288, -755) => @ORIENT("R0");
// #X320 @PLACE(168, -790) => @ORIENT("R0");
// #X321 @PLACE(208, -790) => @ORIENT("R0");
// #X322 @PLACE(248, -790) => @ORIENT("R0");
// #X323 @PLACE(288, -790) => @ORIENT("R0");
// #X324 @PLACE(168, -825) => @ORIENT("R0");
// #X325 @PLACE(208, -825) => @ORIENT("R0");
// #X326 @PLACE(248, -825) => @ORIENT("R0");
// #X327 @PLACE(288, -825) => @ORIENT("R0");
// #X328 @PLACE(168, -860) => @ORIENT("R0");
// #X329 @PLACE(208, -860) => @ORIENT("R0");
// #X330 @PLACE(248, -860) => @ORIENT("R0");
// #X331 @PLACE(288, -860) => @ORIENT("R0");
// #X332 @PLACE(168, -895) => @ORIENT("R0");
// #X333 @PLACE(208, -895) => @ORIENT("R0");
// #X334 @PLACE(248, -895) => @ORIENT("R0");
// #X335 @PLACE(288, -895) => @ORIENT("R0");
// #X336 @PLACE(336, -720) => @ORIENT("R0");
// (320, -706) @TEXT("Panel 15 | X336 - X351", size=1.1, halign="start");
// #X337 @PLACE(376, -720) => @ORIENT("R0");
// #X338 @PLACE(416, -720) => @ORIENT("R0");
// #X339 @PLACE(456, -720) => @ORIENT("R0");
// #X340 @PLACE(336, -755) => @ORIENT("R0");
// #X341 @PLACE(376, -755) => @ORIENT("R0");
// #X342 @PLACE(416, -755) => @ORIENT("R0");
// #X343 @PLACE(456, -755) => @ORIENT("R0");
// #X344 @PLACE(336, -790) => @ORIENT("R0");
// #X345 @PLACE(376, -790) => @ORIENT("R0");
// #X346 @PLACE(416, -790) => @ORIENT("R0");
// #X347 @PLACE(456, -790) => @ORIENT("R0");
// #X348 @PLACE(336, -825) => @ORIENT("R0");
// #X349 @PLACE(376, -825) => @ORIENT("R0");
// #X350 @PLACE(416, -825) => @ORIENT("R0");
// #X351 @PLACE(456, -825) => @ORIENT("R0");
// %t1 = $IO_PORT @ATTACH &n13 => @PLACE(-11, -56) => @ORIENT("R0");
// %t1 @TEXT("n13", key="name", size=0.75);
// &n13 @WIRE(mode="straight") {#X0:1 %t1:p};
// %t2 = $IO_PORT @ATTACH &refclk => @PLACE(-11, -60) => @ORIENT("R0");
// %t2 @TEXT("refclk", key="name", size=0.75);
// &refclk @WIRE(mode="straight") {#X0:2 %t2:p};
// %t3 = $IO_PORT @ATTACH &reset => @PLACE(-11, -64) => @ORIENT("R0");
// %t3 @TEXT("reset", key="name", size=0.75);
// &reset @WIRE(mode="straight") {#X0:3 %t3:p};
// %t4 = $IO_PORT @ATTACH &n14 => @PLACE(10, -60) => @ORIENT("MY");
// %t4 @TEXT("n14", key="name", size=0.75);
// &n14 @WIRE(mode="straight") {#X0:4 %t4:p};
// %t5 = $SUPPLY @ATTACH &vdd => @PLACE(0, -47);
// &vdd @WIRE(mode="straight") {#X0:5 %t5:p};
// %t6 = $GROUND @ATTACH &vss => @PLACE(0, -73);
// &vss @WIRE(mode="straight") {#X0:6 %t6:p};
// %t7 = $IO_PORT @ATTACH &n15 => @PLACE(30, -56) => @ORIENT("R0");
// %t7 @TEXT("n15", key="name", size=0.75);
// &n15 @WIRE(mode="straight") {#X1:1 %t7:p};
// %t8 = $IO_PORT @ATTACH &refclk => @PLACE(30, -60) => @ORIENT("R0");
// %t8 @TEXT("refclk", key="name", size=0.75);
// &refclk @WIRE(mode="straight") {#X1:2 %t8:p};
// %t9 = $IO_PORT @ATTACH &reset => @PLACE(30, -64) => @ORIENT("R0");
// %t9 @TEXT("reset", key="name", size=0.75);
// &reset @WIRE(mode="straight") {#X1:3 %t9:p};
// %t10 = $IO_PORT @ATTACH &n16 => @PLACE(50, -60) => @ORIENT("MY");
// %t10 @TEXT("n16", key="name", size=0.75);
// &n16 @WIRE(mode="straight") {#X1:4 %t10:p};
// %t11 = $SUPPLY @ATTACH &vdd => @PLACE(40, -47);
// &vdd @WIRE(mode="straight") {#X1:5 %t11:p};
// %t12 = $GROUND @ATTACH &vss => @PLACE(40, -73);
// &vss @WIRE(mode="straight") {#X1:6 %t12:p};
// %t13 = $IO_PORT @ATTACH &n17 => @PLACE(70, -56) => @ORIENT("R0");
// %t13 @TEXT("n17", key="name", size=0.75);
// &n17 @WIRE(mode="straight") {#X2:1 %t13:p};
// %t14 = $IO_PORT @ATTACH &refclk => @PLACE(70, -60) => @ORIENT("R0");
// %t14 @TEXT("refclk", key="name", size=0.75);
// &refclk @WIRE(mode="straight") {#X2:2 %t14:p};
// %t15 = $IO_PORT @ATTACH &reset => @PLACE(70, -64) => @ORIENT("R0");
// %t15 @TEXT("reset", key="name", size=0.75);
// &reset @WIRE(mode="straight") {#X2:3 %t15:p};
// %t16 = $IO_PORT @ATTACH &n18 => @PLACE(90, -60) => @ORIENT("MY");
// %t16 @TEXT("n18", key="name", size=0.75);
// &n18 @WIRE(mode="straight") {#X2:4 %t16:p};
// %t17 = $SUPPLY @ATTACH &vdd => @PLACE(80, -47);
// &vdd @WIRE(mode="straight") {#X2:5 %t17:p};
// %t18 = $GROUND @ATTACH &vss => @PLACE(80, -73);
// &vss @WIRE(mode="straight") {#X2:6 %t18:p};
// %t19 = $IO_PORT @ATTACH &n19 => @PLACE(110, -56) => @ORIENT("R0");
// %t19 @TEXT("n19", key="name", size=0.75);
// &n19 @WIRE(mode="straight") {#X3:1 %t19:p};
// %t20 = $IO_PORT @ATTACH &refclk => @PLACE(110, -60) => @ORIENT("R0");
// %t20 @TEXT("refclk", key="name", size=0.75);
// &refclk @WIRE(mode="straight") {#X3:2 %t20:p};
// %t21 = $IO_PORT @ATTACH &reset => @PLACE(110, -64) => @ORIENT("R0");
// %t21 @TEXT("reset", key="name", size=0.75);
// &reset @WIRE(mode="straight") {#X3:3 %t21:p};
// %t22 = $IO_PORT @ATTACH &restart => @PLACE(130, -60) => @ORIENT("MY");
// %t22 @TEXT("restart", key="name", size=0.75);
// &restart @WIRE(mode="straight") {#X3:4 %t22:p};
// %t23 = $SUPPLY @ATTACH &vdd => @PLACE(120, -47);
// &vdd @WIRE(mode="straight") {#X3:5 %t23:p};
// %t24 = $GROUND @ATTACH &vss => @PLACE(120, -73);
// &vss @WIRE(mode="straight") {#X3:6 %t24:p};
// %t25 = $IO_PORT @ATTACH &n20 => @PLACE(-11, -91) => @ORIENT("R0");
// %t25 @TEXT("n20", key="name", size=0.75);
// &n20 @WIRE(mode="straight") {#X4:1 %t25:p};
// %t26 = $IO_PORT @ATTACH &refclk => @PLACE(-11, -95) => @ORIENT("R0");
// %t26 @TEXT("refclk", key="name", size=0.75);
// &refclk @WIRE(mode="straight") {#X4:2 %t26:p};
// %t27 = $IO_PORT @ATTACH &reset => @PLACE(-11, -99) => @ORIENT("R0");
// %t27 @TEXT("reset", key="name", size=0.75);
// &reset @WIRE(mode="straight") {#X4:3 %t27:p};
// %t28 = $IO_PORT @ATTACH &n21 => @PLACE(10, -95) => @ORIENT("MY");
// %t28 @TEXT("n21", key="name", size=0.75);
// &n21 @WIRE(mode="straight") {#X4:4 %t28:p};
// %t29 = $SUPPLY @ATTACH &vdd => @PLACE(0, -82);
// &vdd @WIRE(mode="straight") {#X4:5 %t29:p};
// %t30 = $GROUND @ATTACH &vss => @PLACE(0, -108);
// &vss @WIRE(mode="straight") {#X4:6 %t30:p};
// %t31 = $IO_PORT @ATTACH &n22 => @PLACE(30, -91) => @ORIENT("R0");
// %t31 @TEXT("n22", key="name", size=0.75);
// &n22 @WIRE(mode="straight") {#X5:1 %t31:p};
// %t32 = $IO_PORT @ATTACH &refclk => @PLACE(30, -95) => @ORIENT("R0");
// %t32 @TEXT("refclk", key="name", size=0.75);
// &refclk @WIRE(mode="straight") {#X5:2 %t32:p};
// %t33 = $IO_PORT @ATTACH &reset => @PLACE(30, -99) => @ORIENT("R0");
// %t33 @TEXT("reset", key="name", size=0.75);
// &reset @WIRE(mode="straight") {#X5:3 %t33:p};
// %t34 = $IO_PORT @ATTACH &n23 => @PLACE(50, -95) => @ORIENT("MY");
// %t34 @TEXT("n23", key="name", size=0.75);
// &n23 @WIRE(mode="straight") {#X5:4 %t34:p};
// %t35 = $SUPPLY @ATTACH &vdd => @PLACE(40, -82);
// &vdd @WIRE(mode="straight") {#X5:5 %t35:p};
// %t36 = $GROUND @ATTACH &vss => @PLACE(40, -108);
// &vss @WIRE(mode="straight") {#X5:6 %t36:p};
// %t37 = $IO_PORT @ATTACH &n24 => @PLACE(70, -91) => @ORIENT("R0");
// %t37 @TEXT("n24", key="name", size=0.75);
// &n24 @WIRE(mode="straight") {#X6:1 %t37:p};
// %t38 = $IO_PORT @ATTACH &refclk => @PLACE(70, -95) => @ORIENT("R0");
// %t38 @TEXT("refclk", key="name", size=0.75);
// &refclk @WIRE(mode="straight") {#X6:2 %t38:p};
// %t39 = $IO_PORT @ATTACH &reset => @PLACE(70, -99) => @ORIENT("R0");
// %t39 @TEXT("reset", key="name", size=0.75);
// &reset @WIRE(mode="straight") {#X6:3 %t39:p};
// %t40 = $IO_PORT @ATTACH &n25 => @PLACE(90, -95) => @ORIENT("MY");
// %t40 @TEXT("n25", key="name", size=0.75);
// &n25 @WIRE(mode="straight") {#X6:4 %t40:p};
// %t41 = $SUPPLY @ATTACH &vdd => @PLACE(80, -82);
// &vdd @WIRE(mode="straight") {#X6:5 %t41:p};
// %t42 = $GROUND @ATTACH &vss => @PLACE(80, -108);
// &vss @WIRE(mode="straight") {#X6:6 %t42:p};
// %t43 = $IO_PORT @ATTACH &n26 => @PLACE(110, -91) => @ORIENT("R0");
// %t43 @TEXT("n26", key="name", size=0.75);
// &n26 @WIRE(mode="straight") {#X7:1 %t43:p};
// %t44 = $IO_PORT @ATTACH &refclk => @PLACE(110, -95) => @ORIENT("R0");
// %t44 @TEXT("refclk", key="name", size=0.75);
// &refclk @WIRE(mode="straight") {#X7:2 %t44:p};
// %t45 = $IO_PORT @ATTACH &reset => @PLACE(110, -99) => @ORIENT("R0");
// %t45 @TEXT("reset", key="name", size=0.75);
// &reset @WIRE(mode="straight") {#X7:3 %t45:p};
// %t46 = $IO_PORT @ATTACH &n27 => @PLACE(130, -95) => @ORIENT("MY");
// %t46 @TEXT("n27", key="name", size=0.75);
// &n27 @WIRE(mode="straight") {#X7:4 %t46:p};
// %t47 = $SUPPLY @ATTACH &vdd => @PLACE(120, -82);
// &vdd @WIRE(mode="straight") {#X7:5 %t47:p};
// %t48 = $GROUND @ATTACH &vss => @PLACE(120, -108);
// &vss @WIRE(mode="straight") {#X7:6 %t48:p};
// %t49 = $IO_PORT @ATTACH &n28 => @PLACE(-11, -126) => @ORIENT("R0");
// %t49 @TEXT("n28", key="name", size=0.75);
// &n28 @WIRE(mode="straight") {#X8:1 %t49:p};
// %t50 = $IO_PORT @ATTACH &refclk => @PLACE(-11, -130) => @ORIENT("R0");
// %t50 @TEXT("refclk", key="name", size=0.75);
// &refclk @WIRE(mode="straight") {#X8:2 %t50:p};
// %t51 = $IO_PORT @ATTACH &reset => @PLACE(-11, -134) => @ORIENT("R0");
// %t51 @TEXT("reset", key="name", size=0.75);
// &reset @WIRE(mode="straight") {#X8:3 %t51:p};
// %t52 = $IO_PORT @ATTACH &qualified => @PLACE(10, -130) => @ORIENT("MY");
// %t52 @TEXT("qualified", key="name", size=0.75);
// &qualified @WIRE(mode="straight") {#X8:4 %t52:p};
// %t53 = $SUPPLY @ATTACH &vdd => @PLACE(0, -117);
// &vdd @WIRE(mode="straight") {#X8:5 %t53:p};
// %t54 = $GROUND @ATTACH &vss => @PLACE(0, -143);
// &vss @WIRE(mode="straight") {#X8:6 %t54:p};
// %t55 = $IO_PORT @ATTACH &n29 => @PLACE(30, -126) => @ORIENT("R0");
// %t55 @TEXT("n29", key="name", size=0.75);
// &n29 @WIRE(mode="straight") {#X9:1 %t55:p};
// %t56 = $IO_PORT @ATTACH &refclk => @PLACE(30, -130) => @ORIENT("R0");
// %t56 @TEXT("refclk", key="name", size=0.75);
// &refclk @WIRE(mode="straight") {#X9:2 %t56:p};
// %t57 = $IO_PORT @ATTACH &reset => @PLACE(30, -134) => @ORIENT("R0");
// %t57 @TEXT("reset", key="name", size=0.75);
// &reset @WIRE(mode="straight") {#X9:3 %t57:p};
// %t58 = $IO_PORT @ATTACH &n30 => @PLACE(50, -130) => @ORIENT("MY");
// %t58 @TEXT("n30", key="name", size=0.75);
// &n30 @WIRE(mode="straight") {#X9:4 %t58:p};
// %t59 = $SUPPLY @ATTACH &vdd => @PLACE(40, -117);
// &vdd @WIRE(mode="straight") {#X9:5 %t59:p};
// %t60 = $GROUND @ATTACH &vss => @PLACE(40, -143);
// &vss @WIRE(mode="straight") {#X9:6 %t60:p};
// %t61 = $IO_PORT @ATTACH &n31 => @PLACE(70, -126) => @ORIENT("R0");
// %t61 @TEXT("n31", key="name", size=0.75);
// &n31 @WIRE(mode="straight") {#X10:1 %t61:p};
// %t62 = $IO_PORT @ATTACH &refclk => @PLACE(70, -130) => @ORIENT("R0");
// %t62 @TEXT("refclk", key="name", size=0.75);
// &refclk @WIRE(mode="straight") {#X10:2 %t62:p};
// %t63 = $IO_PORT @ATTACH &reset => @PLACE(70, -134) => @ORIENT("R0");
// %t63 @TEXT("reset", key="name", size=0.75);
// &reset @WIRE(mode="straight") {#X10:3 %t63:p};
// %t64 = $IO_PORT @ATTACH &n32 => @PLACE(90, -130) => @ORIENT("MY");
// %t64 @TEXT("n32", key="name", size=0.75);
// &n32 @WIRE(mode="straight") {#X10:4 %t64:p};
// %t65 = $SUPPLY @ATTACH &vdd => @PLACE(80, -117);
// &vdd @WIRE(mode="straight") {#X10:5 %t65:p};
// %t66 = $GROUND @ATTACH &vss => @PLACE(80, -143);
// &vss @WIRE(mode="straight") {#X10:6 %t66:p};
// %t67 = $IO_PORT @ATTACH &n33 => @PLACE(110, -126) => @ORIENT("R0");
// %t67 @TEXT("n33", key="name", size=0.75);
// &n33 @WIRE(mode="straight") {#X11:1 %t67:p};
// %t68 = $IO_PORT @ATTACH &refclk => @PLACE(110, -130) => @ORIENT("R0");
// %t68 @TEXT("refclk", key="name", size=0.75);
// &refclk @WIRE(mode="straight") {#X11:2 %t68:p};
// %t69 = $IO_PORT @ATTACH &reset => @PLACE(110, -134) => @ORIENT("R0");
// %t69 @TEXT("reset", key="name", size=0.75);
// &reset @WIRE(mode="straight") {#X11:3 %t69:p};
// %t70 = $IO_PORT @ATTACH &n34 => @PLACE(130, -130) => @ORIENT("MY");
// %t70 @TEXT("n34", key="name", size=0.75);
// &n34 @WIRE(mode="straight") {#X11:4 %t70:p};
// %t71 = $SUPPLY @ATTACH &vdd => @PLACE(120, -117);
// &vdd @WIRE(mode="straight") {#X11:5 %t71:p};
// %t72 = $GROUND @ATTACH &vss => @PLACE(120, -143);
// &vss @WIRE(mode="straight") {#X11:6 %t72:p};
// %t73 = $IO_PORT @ATTACH &n35 => @PLACE(-11, -161) => @ORIENT("R0");
// %t73 @TEXT("n35", key="name", size=0.75);
// &n35 @WIRE(mode="straight") {#X12:1 %t73:p};
// %t74 = $IO_PORT @ATTACH &refclk => @PLACE(-11, -165) => @ORIENT("R0");
// %t74 @TEXT("refclk", key="name", size=0.75);
// &refclk @WIRE(mode="straight") {#X12:2 %t74:p};
// %t75 = $IO_PORT @ATTACH &reset => @PLACE(-11, -169) => @ORIENT("R0");
// %t75 @TEXT("reset", key="name", size=0.75);
// &reset @WIRE(mode="straight") {#X12:3 %t75:p};
// %t76 = $IO_PORT @ATTACH &n36 => @PLACE(10, -165) => @ORIENT("MY");
// %t76 @TEXT("n36", key="name", size=0.75);
// &n36 @WIRE(mode="straight") {#X12:4 %t76:p};
// %t77 = $SUPPLY @ATTACH &vdd => @PLACE(0, -152);
// &vdd @WIRE(mode="straight") {#X12:5 %t77:p};
// %t78 = $GROUND @ATTACH &vss => @PLACE(0, -178);
// &vss @WIRE(mode="straight") {#X12:6 %t78:p};
// %t79 = $IO_PORT @ATTACH &n37 => @PLACE(30, -161) => @ORIENT("R0");
// %t79 @TEXT("n37", key="name", size=0.75);
// &n37 @WIRE(mode="straight") {#X13:1 %t79:p};
// %t80 = $IO_PORT @ATTACH &refclk => @PLACE(30, -165) => @ORIENT("R0");
// %t80 @TEXT("refclk", key="name", size=0.75);
// &refclk @WIRE(mode="straight") {#X13:2 %t80:p};
// %t81 = $IO_PORT @ATTACH &reset => @PLACE(30, -169) => @ORIENT("R0");
// %t81 @TEXT("reset", key="name", size=0.75);
// &reset @WIRE(mode="straight") {#X13:3 %t81:p};
// %t82 = $IO_PORT @ATTACH &n38 => @PLACE(50, -165) => @ORIENT("MY");
// %t82 @TEXT("n38", key="name", size=0.75);
// &n38 @WIRE(mode="straight") {#X13:4 %t82:p};
// %t83 = $SUPPLY @ATTACH &vdd => @PLACE(40, -152);
// &vdd @WIRE(mode="straight") {#X13:5 %t83:p};
// %t84 = $GROUND @ATTACH &vss => @PLACE(40, -178);
// &vss @WIRE(mode="straight") {#X13:6 %t84:p};
// %t85 = $IO_PORT @ATTACH &n39 => @PLACE(70, -161) => @ORIENT("R0");
// %t85 @TEXT("n39", key="name", size=0.75);
// &n39 @WIRE(mode="straight") {#X14:1 %t85:p};
// %t86 = $IO_PORT @ATTACH &refclk => @PLACE(70, -165) => @ORIENT("R0");
// %t86 @TEXT("refclk", key="name", size=0.75);
// &refclk @WIRE(mode="straight") {#X14:2 %t86:p};
// %t87 = $IO_PORT @ATTACH &reset => @PLACE(70, -169) => @ORIENT("R0");
// %t87 @TEXT("reset", key="name", size=0.75);
// &reset @WIRE(mode="straight") {#X14:3 %t87:p};
// %t88 = $IO_PORT @ATTACH &n40 => @PLACE(90, -165) => @ORIENT("MY");
// %t88 @TEXT("n40", key="name", size=0.75);
// &n40 @WIRE(mode="straight") {#X14:4 %t88:p};
// %t89 = $SUPPLY @ATTACH &vdd => @PLACE(80, -152);
// &vdd @WIRE(mode="straight") {#X14:5 %t89:p};
// %t90 = $GROUND @ATTACH &vss => @PLACE(80, -178);
// &vss @WIRE(mode="straight") {#X14:6 %t90:p};
// %t91 = $IO_PORT @ATTACH &n41 => @PLACE(110, -161) => @ORIENT("R0");
// %t91 @TEXT("n41", key="name", size=0.75);
// &n41 @WIRE(mode="straight") {#X15:1 %t91:p};
// %t92 = $IO_PORT @ATTACH &refclk => @PLACE(110, -165) => @ORIENT("R0");
// %t92 @TEXT("refclk", key="name", size=0.75);
// &refclk @WIRE(mode="straight") {#X15:2 %t92:p};
// %t93 = $IO_PORT @ATTACH &reset => @PLACE(110, -169) => @ORIENT("R0");
// %t93 @TEXT("reset", key="name", size=0.75);
// &reset @WIRE(mode="straight") {#X15:3 %t93:p};
// %t94 = $IO_PORT @ATTACH &fault => @PLACE(130, -165) => @ORIENT("MY");
// %t94 @TEXT("fault", key="name", size=0.75);
// &fault @WIRE(mode="straight") {#X15:4 %t94:p};
// %t95 = $SUPPLY @ATTACH &vdd => @PLACE(120, -152);
// &vdd @WIRE(mode="straight") {#X15:5 %t95:p};
// %t96 = $GROUND @ATTACH &vss => @PLACE(120, -178);
// &vss @WIRE(mode="straight") {#X15:6 %t96:p};
// %t97 = $IO_PORT @ATTACH &n42 => @PLACE(-11, -196) => @ORIENT("R0");
// %t97 @TEXT("n42", key="name", size=0.75);
// &n42 @WIRE(mode="straight") {#X16:1 %t97:p};
// %t98 = $IO_PORT @ATTACH &refclk => @PLACE(-11, -200) => @ORIENT("R0");
// %t98 @TEXT("refclk", key="name", size=0.75);
// &refclk @WIRE(mode="straight") {#X16:2 %t98:p};
// %t99 = $IO_PORT @ATTACH &reset => @PLACE(-11, -204) => @ORIENT("R0");
// %t99 @TEXT("reset", key="name", size=0.75);
// &reset @WIRE(mode="straight") {#X16:3 %t99:p};
// %t100 = $IO_PORT @ATTACH &n43 => @PLACE(10, -200) => @ORIENT("MY");
// %t100 @TEXT("n43", key="name", size=0.75);
// &n43 @WIRE(mode="straight") {#X16:4 %t100:p};
// %t101 = $SUPPLY @ATTACH &vdd => @PLACE(0, -187);
// &vdd @WIRE(mode="straight") {#X16:5 %t101:p};
// %t102 = $GROUND @ATTACH &vss => @PLACE(0, -213);
// &vss @WIRE(mode="straight") {#X16:6 %t102:p};
// %t103 = $IO_PORT @ATTACH &n44 => @PLACE(30, -196) => @ORIENT("R0");
// %t103 @TEXT("n44", key="name", size=0.75);
// &n44 @WIRE(mode="straight") {#X17:1 %t103:p};
// %t104 = $IO_PORT @ATTACH &refclk => @PLACE(30, -200) => @ORIENT("R0");
// %t104 @TEXT("refclk", key="name", size=0.75);
// &refclk @WIRE(mode="straight") {#X17:2 %t104:p};
// %t105 = $IO_PORT @ATTACH &reset => @PLACE(30, -204) => @ORIENT("R0");
// %t105 @TEXT("reset", key="name", size=0.75);
// &reset @WIRE(mode="straight") {#X17:3 %t105:p};
// %t106 = $IO_PORT @ATTACH &n45 => @PLACE(50, -200) => @ORIENT("MY");
// %t106 @TEXT("n45", key="name", size=0.75);
// &n45 @WIRE(mode="straight") {#X17:4 %t106:p};
// %t107 = $SUPPLY @ATTACH &vdd => @PLACE(40, -187);
// &vdd @WIRE(mode="straight") {#X17:5 %t107:p};
// %t108 = $GROUND @ATTACH &vss => @PLACE(40, -213);
// &vss @WIRE(mode="straight") {#X17:6 %t108:p};
// %t109 = $IO_PORT @ATTACH &n46 => @PLACE(70, -196) => @ORIENT("R0");
// %t109 @TEXT("n46", key="name", size=0.75);
// &n46 @WIRE(mode="straight") {#X18:1 %t109:p};
// %t110 = $IO_PORT @ATTACH &refclk => @PLACE(70, -200) => @ORIENT("R0");
// %t110 @TEXT("refclk", key="name", size=0.75);
// &refclk @WIRE(mode="straight") {#X18:2 %t110:p};
// %t111 = $IO_PORT @ATTACH &reset => @PLACE(70, -204) => @ORIENT("R0");
// %t111 @TEXT("reset", key="name", size=0.75);
// &reset @WIRE(mode="straight") {#X18:3 %t111:p};
// %t112 = $IO_PORT @ATTACH &n47 => @PLACE(90, -200) => @ORIENT("MY");
// %t112 @TEXT("n47", key="name", size=0.75);
// &n47 @WIRE(mode="straight") {#X18:4 %t112:p};
// %t113 = $SUPPLY @ATTACH &vdd => @PLACE(80, -187);
// &vdd @WIRE(mode="straight") {#X18:5 %t113:p};
// %t114 = $GROUND @ATTACH &vss => @PLACE(80, -213);
// &vss @WIRE(mode="straight") {#X18:6 %t114:p};
// %t115 = $IO_PORT @ATTACH &n48 => @PLACE(110, -196) => @ORIENT("R0");
// %t115 @TEXT("n48", key="name", size=0.75);
// &n48 @WIRE(mode="straight") {#X19:1 %t115:p};
// %t116 = $IO_PORT @ATTACH &refclk => @PLACE(110, -200) => @ORIENT("R0");
// %t116 @TEXT("refclk", key="name", size=0.75);
// &refclk @WIRE(mode="straight") {#X19:2 %t116:p};
// %t117 = $IO_PORT @ATTACH &reset => @PLACE(110, -204) => @ORIENT("R0");
// %t117 @TEXT("reset", key="name", size=0.75);
// &reset @WIRE(mode="straight") {#X19:3 %t117:p};
// %t118 = $IO_PORT @ATTACH &n49 => @PLACE(130, -200) => @ORIENT("MY");
// %t118 @TEXT("n49", key="name", size=0.75);
// &n49 @WIRE(mode="straight") {#X19:4 %t118:p};
// %t119 = $SUPPLY @ATTACH &vdd => @PLACE(120, -187);
// &vdd @WIRE(mode="straight") {#X19:5 %t119:p};
// %t120 = $GROUND @ATTACH &vss => @PLACE(120, -213);
// &vss @WIRE(mode="straight") {#X19:6 %t120:p};
// %t121 = $IO_PORT @ATTACH &n50 => @PLACE(-11, -231) => @ORIENT("R0");
// %t121 @TEXT("n50", key="name", size=0.75);
// &n50 @WIRE(mode="straight") {#X20:1 %t121:p};
// %t122 = $IO_PORT @ATTACH &refclk => @PLACE(-11, -235) => @ORIENT("R0");
// %t122 @TEXT("refclk", key="name", size=0.75);
// &refclk @WIRE(mode="straight") {#X20:2 %t122:p};
// %t123 = $IO_PORT @ATTACH &reset => @PLACE(-11, -239) => @ORIENT("R0");
// %t123 @TEXT("reset", key="name", size=0.75);
// &reset @WIRE(mode="straight") {#X20:3 %t123:p};
// %t124 = $IO_PORT @ATTACH &n51 => @PLACE(10, -235) => @ORIENT("MY");
// %t124 @TEXT("n51", key="name", size=0.75);
// &n51 @WIRE(mode="straight") {#X20:4 %t124:p};
// %t125 = $SUPPLY @ATTACH &vdd => @PLACE(0, -222);
// &vdd @WIRE(mode="straight") {#X20:5 %t125:p};
// %t126 = $GROUND @ATTACH &vss => @PLACE(0, -248);
// &vss @WIRE(mode="straight") {#X20:6 %t126:p};
// %t127 = $IO_PORT @ATTACH &n52 => @PLACE(30, -231) => @ORIENT("R0");
// %t127 @TEXT("n52", key="name", size=0.75);
// &n52 @WIRE(mode="straight") {#X21:1 %t127:p};
// %t128 = $IO_PORT @ATTACH &refclk => @PLACE(30, -235) => @ORIENT("R0");
// %t128 @TEXT("refclk", key="name", size=0.75);
// &refclk @WIRE(mode="straight") {#X21:2 %t128:p};
// %t129 = $IO_PORT @ATTACH &reset => @PLACE(30, -239) => @ORIENT("R0");
// %t129 @TEXT("reset", key="name", size=0.75);
// &reset @WIRE(mode="straight") {#X21:3 %t129:p};
// %t130 = $IO_PORT @ATTACH &n53 => @PLACE(50, -235) => @ORIENT("MY");
// %t130 @TEXT("n53", key="name", size=0.75);
// &n53 @WIRE(mode="straight") {#X21:4 %t130:p};
// %t131 = $SUPPLY @ATTACH &vdd => @PLACE(40, -222);
// &vdd @WIRE(mode="straight") {#X21:5 %t131:p};
// %t132 = $GROUND @ATTACH &vss => @PLACE(40, -248);
// &vss @WIRE(mode="straight") {#X21:6 %t132:p};
// %t133 = $IO_PORT @ATTACH &n54 => @PLACE(70, -231) => @ORIENT("R0");
// %t133 @TEXT("n54", key="name", size=0.75);
// &n54 @WIRE(mode="straight") {#X22:1 %t133:p};
// %t134 = $IO_PORT @ATTACH &refclk => @PLACE(70, -235) => @ORIENT("R0");
// %t134 @TEXT("refclk", key="name", size=0.75);
// &refclk @WIRE(mode="straight") {#X22:2 %t134:p};
// %t135 = $IO_PORT @ATTACH &reset => @PLACE(70, -239) => @ORIENT("R0");
// %t135 @TEXT("reset", key="name", size=0.75);
// &reset @WIRE(mode="straight") {#X22:3 %t135:p};
// %t136 = $IO_PORT @ATTACH &n55 => @PLACE(90, -235) => @ORIENT("MY");
// %t136 @TEXT("n55", key="name", size=0.75);
// &n55 @WIRE(mode="straight") {#X22:4 %t136:p};
// %t137 = $SUPPLY @ATTACH &vdd => @PLACE(80, -222);
// &vdd @WIRE(mode="straight") {#X22:5 %t137:p};
// %t138 = $GROUND @ATTACH &vss => @PLACE(80, -248);
// &vss @WIRE(mode="straight") {#X22:6 %t138:p};
// %t139 = $IO_PORT @ATTACH &n56 => @PLACE(110, -231) => @ORIENT("R0");
// %t139 @TEXT("n56", key="name", size=0.75);
// &n56 @WIRE(mode="straight") {#X23:1 %t139:p};
// %t140 = $IO_PORT @ATTACH &refclk => @PLACE(110, -235) => @ORIENT("R0");
// %t140 @TEXT("refclk", key="name", size=0.75);
// &refclk @WIRE(mode="straight") {#X23:2 %t140:p};
// %t141 = $IO_PORT @ATTACH &reset => @PLACE(110, -239) => @ORIENT("R0");
// %t141 @TEXT("reset", key="name", size=0.75);
// &reset @WIRE(mode="straight") {#X23:3 %t141:p};
// %t142 = $IO_PORT @ATTACH &n57 => @PLACE(130, -235) => @ORIENT("MY");
// %t142 @TEXT("n57", key="name", size=0.75);
// &n57 @WIRE(mode="straight") {#X23:4 %t142:p};
// %t143 = $SUPPLY @ATTACH &vdd => @PLACE(120, -222);
// &vdd @WIRE(mode="straight") {#X23:5 %t143:p};
// %t144 = $GROUND @ATTACH &vss => @PLACE(120, -248);
// &vss @WIRE(mode="straight") {#X23:6 %t144:p};
// %t145 = $IO_PORT @ATTACH &n58 => @PLACE(158, -56) => @ORIENT("R0");
// %t145 @TEXT("n58", key="name", size=0.75);
// &n58 @WIRE(mode="straight") {#X24:1 %t145:p};
// %t146 = $IO_PORT @ATTACH &refclk => @PLACE(158, -60) => @ORIENT("R0");
// %t146 @TEXT("refclk", key="name", size=0.75);
// &refclk @WIRE(mode="straight") {#X24:2 %t146:p};
// %t147 = $IO_PORT @ATTACH &reset => @PLACE(158, -64) => @ORIENT("R0");
// %t147 @TEXT("reset", key="name", size=0.75);
// &reset @WIRE(mode="straight") {#X24:3 %t147:p};
// %t148 = $IO_PORT @ATTACH &n59 => @PLACE(178, -60) => @ORIENT("MY");
// %t148 @TEXT("n59", key="name", size=0.75);
// &n59 @WIRE(mode="straight") {#X24:4 %t148:p};
// %t149 = $SUPPLY @ATTACH &vdd => @PLACE(168, -47);
// &vdd @WIRE(mode="straight") {#X24:5 %t149:p};
// %t150 = $GROUND @ATTACH &vss => @PLACE(168, -73);
// &vss @WIRE(mode="straight") {#X24:6 %t150:p};
// %t151 = $IO_PORT @ATTACH &n38 => @PLACE(198, -56) => @ORIENT("R0");
// %t151 @TEXT("n38", key="name", size=0.75);
// &n38 @WIRE(mode="straight") {#X25:1 %t151:p};
// %t152 = $IO_PORT @ATTACH &n60 => @PLACE(198, -60) => @ORIENT("R0");
// %t152 @TEXT("n60", key="name", size=0.75);
// &n60 @WIRE(mode="straight") {#X25:2 %t152:p};
// %t153 = $IO_PORT @ATTACH &n61 => @PLACE(198, -64) => @ORIENT("R0");
// %t153 @TEXT("n61", key="name", size=0.75);
// &n61 @WIRE(mode="straight") {#X25:3 %t153:p};
// %t154 = $IO_PORT @ATTACH &n37 => @PLACE(218, -60) => @ORIENT("MY");
// %t154 @TEXT("n37", key="name", size=0.75);
// &n37 @WIRE(mode="straight") {#X25:4 %t154:p};
// %t155 = $SUPPLY @ATTACH &vdd => @PLACE(208, -47);
// &vdd @WIRE(mode="straight") {#X25:5 %t155:p};
// %t156 = $GROUND @ATTACH &vss => @PLACE(208, -73);
// &vss @WIRE(mode="straight") {#X25:6 %t156:p};
// %t157 = $IO_PORT @ATTACH &n36 => @PLACE(238, -56) => @ORIENT("R0");
// %t157 @TEXT("n36", key="name", size=0.75);
// &n36 @WIRE(mode="straight") {#X26:1 %t157:p};
// %t158 = $IO_PORT @ATTACH &n62 => @PLACE(238, -60) => @ORIENT("R0");
// %t158 @TEXT("n62", key="name", size=0.75);
// &n62 @WIRE(mode="straight") {#X26:2 %t158:p};
// %t159 = $IO_PORT @ATTACH &n61 => @PLACE(238, -64) => @ORIENT("R0");
// %t159 @TEXT("n61", key="name", size=0.75);
// &n61 @WIRE(mode="straight") {#X26:3 %t159:p};
// %t160 = $IO_PORT @ATTACH &n35 => @PLACE(258, -60) => @ORIENT("MY");
// %t160 @TEXT("n35", key="name", size=0.75);
// &n35 @WIRE(mode="straight") {#X26:4 %t160:p};
// %t161 = $SUPPLY @ATTACH &vdd => @PLACE(248, -47);
// &vdd @WIRE(mode="straight") {#X26:5 %t161:p};
// %t162 = $GROUND @ATTACH &vss => @PLACE(248, -73);
// &vss @WIRE(mode="straight") {#X26:6 %t162:p};
// %t163 = $IO_PORT @ATTACH &n34 => @PLACE(278, -56) => @ORIENT("R0");
// %t163 @TEXT("n34", key="name", size=0.75);
// &n34 @WIRE(mode="straight") {#X27:1 %t163:p};
// %t164 = $IO_PORT @ATTACH &n63 => @PLACE(278, -60) => @ORIENT("R0");
// %t164 @TEXT("n63", key="name", size=0.75);
// &n63 @WIRE(mode="straight") {#X27:2 %t164:p};
// %t165 = $IO_PORT @ATTACH &n61 => @PLACE(278, -64) => @ORIENT("R0");
// %t165 @TEXT("n61", key="name", size=0.75);
// &n61 @WIRE(mode="straight") {#X27:3 %t165:p};
// %t166 = $IO_PORT @ATTACH &n33 => @PLACE(298, -60) => @ORIENT("MY");
// %t166 @TEXT("n33", key="name", size=0.75);
// &n33 @WIRE(mode="straight") {#X27:4 %t166:p};
// %t167 = $SUPPLY @ATTACH &vdd => @PLACE(288, -47);
// &vdd @WIRE(mode="straight") {#X27:5 %t167:p};
// %t168 = $GROUND @ATTACH &vss => @PLACE(288, -73);
// &vss @WIRE(mode="straight") {#X27:6 %t168:p};
// %t169 = $IO_PORT @ATTACH &n32 => @PLACE(158, -91) => @ORIENT("R0");
// %t169 @TEXT("n32", key="name", size=0.75);
// &n32 @WIRE(mode="straight") {#X28:1 %t169:p};
// %t170 = $IO_PORT @ATTACH &n64 => @PLACE(158, -95) => @ORIENT("R0");
// %t170 @TEXT("n64", key="name", size=0.75);
// &n64 @WIRE(mode="straight") {#X28:2 %t170:p};
// %t171 = $IO_PORT @ATTACH &n61 => @PLACE(158, -99) => @ORIENT("R0");
// %t171 @TEXT("n61", key="name", size=0.75);
// &n61 @WIRE(mode="straight") {#X28:3 %t171:p};
// %t172 = $IO_PORT @ATTACH &n31 => @PLACE(178, -95) => @ORIENT("MY");
// %t172 @TEXT("n31", key="name", size=0.75);
// &n31 @WIRE(mode="straight") {#X28:4 %t172:p};
// %t173 = $SUPPLY @ATTACH &vdd => @PLACE(168, -82);
// &vdd @WIRE(mode="straight") {#X28:5 %t173:p};
// %t174 = $GROUND @ATTACH &vss => @PLACE(168, -108);
// &vss @WIRE(mode="straight") {#X28:6 %t174:p};
// %t175 = $IO_PORT @ATTACH &n30 => @PLACE(198, -91) => @ORIENT("R0");
// %t175 @TEXT("n30", key="name", size=0.75);
// &n30 @WIRE(mode="straight") {#X29:1 %t175:p};
// %t176 = $IO_PORT @ATTACH &n65 => @PLACE(198, -95) => @ORIENT("R0");
// %t176 @TEXT("n65", key="name", size=0.75);
// &n65 @WIRE(mode="straight") {#X29:2 %t176:p};
// %t177 = $IO_PORT @ATTACH &n61 => @PLACE(198, -99) => @ORIENT("R0");
// %t177 @TEXT("n61", key="name", size=0.75);
// &n61 @WIRE(mode="straight") {#X29:3 %t177:p};
// %t178 = $IO_PORT @ATTACH &n29 => @PLACE(218, -95) => @ORIENT("MY");
// %t178 @TEXT("n29", key="name", size=0.75);
// &n29 @WIRE(mode="straight") {#X29:4 %t178:p};
// %t179 = $SUPPLY @ATTACH &vdd => @PLACE(208, -82);
// &vdd @WIRE(mode="straight") {#X29:5 %t179:p};
// %t180 = $GROUND @ATTACH &vss => @PLACE(208, -108);
// &vss @WIRE(mode="straight") {#X29:6 %t180:p};
// %t181 = $IO_PORT @ATTACH &n25 => @PLACE(238, -91) => @ORIENT("R0");
// %t181 @TEXT("n25", key="name", size=0.75);
// &n25 @WIRE(mode="straight") {#X30:1 %t181:p};
// %t182 = $IO_PORT @ATTACH &n66 => @PLACE(238, -95) => @ORIENT("R0");
// %t182 @TEXT("n66", key="name", size=0.75);
// &n66 @WIRE(mode="straight") {#X30:2 %t182:p};
// %t183 = $IO_PORT @ATTACH &n67 => @PLACE(238, -99) => @ORIENT("R0");
// %t183 @TEXT("n67", key="name", size=0.75);
// &n67 @WIRE(mode="straight") {#X30:3 %t183:p};
// %t184 = $IO_PORT @ATTACH &n24 => @PLACE(258, -95) => @ORIENT("MY");
// %t184 @TEXT("n24", key="name", size=0.75);
// &n24 @WIRE(mode="straight") {#X30:4 %t184:p};
// %t185 = $SUPPLY @ATTACH &vdd => @PLACE(248, -82);
// &vdd @WIRE(mode="straight") {#X30:5 %t185:p};
// %t186 = $GROUND @ATTACH &vss => @PLACE(248, -108);
// &vss @WIRE(mode="straight") {#X30:6 %t186:p};
// %t187 = $IO_PORT @ATTACH &n23 => @PLACE(278, -91) => @ORIENT("R0");
// %t187 @TEXT("n23", key="name", size=0.75);
// &n23 @WIRE(mode="straight") {#X31:1 %t187:p};
// %t188 = $IO_PORT @ATTACH &n68 => @PLACE(278, -95) => @ORIENT("R0");
// %t188 @TEXT("n68", key="name", size=0.75);
// &n68 @WIRE(mode="straight") {#X31:2 %t188:p};
// %t189 = $IO_PORT @ATTACH &n67 => @PLACE(278, -99) => @ORIENT("R0");
// %t189 @TEXT("n67", key="name", size=0.75);
// &n67 @WIRE(mode="straight") {#X31:3 %t189:p};
// %t190 = $IO_PORT @ATTACH &n22 => @PLACE(298, -95) => @ORIENT("MY");
// %t190 @TEXT("n22", key="name", size=0.75);
// &n22 @WIRE(mode="straight") {#X31:4 %t190:p};
// %t191 = $SUPPLY @ATTACH &vdd => @PLACE(288, -82);
// &vdd @WIRE(mode="straight") {#X31:5 %t191:p};
// %t192 = $GROUND @ATTACH &vss => @PLACE(288, -108);
// &vss @WIRE(mode="straight") {#X31:6 %t192:p};
// %t193 = $IO_PORT @ATTACH &n21 => @PLACE(158, -126) => @ORIENT("R0");
// %t193 @TEXT("n21", key="name", size=0.75);
// &n21 @WIRE(mode="straight") {#X32:1 %t193:p};
// %t194 = $IO_PORT @ATTACH &n69 => @PLACE(158, -130) => @ORIENT("R0");
// %t194 @TEXT("n69", key="name", size=0.75);
// &n69 @WIRE(mode="straight") {#X32:2 %t194:p};
// %t195 = $IO_PORT @ATTACH &n67 => @PLACE(158, -134) => @ORIENT("R0");
// %t195 @TEXT("n67", key="name", size=0.75);
// &n67 @WIRE(mode="straight") {#X32:3 %t195:p};
// %t196 = $IO_PORT @ATTACH &n20 => @PLACE(178, -130) => @ORIENT("MY");
// %t196 @TEXT("n20", key="name", size=0.75);
// &n20 @WIRE(mode="straight") {#X32:4 %t196:p};
// %t197 = $SUPPLY @ATTACH &vdd => @PLACE(168, -117);
// &vdd @WIRE(mode="straight") {#X32:5 %t197:p};
// %t198 = $GROUND @ATTACH &vss => @PLACE(168, -143);
// &vss @WIRE(mode="straight") {#X32:6 %t198:p};
// %t199 = $IO_PORT @ATTACH &n16 => @PLACE(198, -126) => @ORIENT("R0");
// %t199 @TEXT("n16", key="name", size=0.75);
// &n16 @WIRE(mode="straight") {#X33:1 %t199:p};
// %t200 = $IO_PORT @ATTACH &n70 => @PLACE(198, -130) => @ORIENT("R0");
// %t200 @TEXT("n70", key="name", size=0.75);
// &n70 @WIRE(mode="straight") {#X33:2 %t200:p};
// %t201 = $IO_PORT @ATTACH &n71 => @PLACE(198, -134) => @ORIENT("R0");
// %t201 @TEXT("n71", key="name", size=0.75);
// &n71 @WIRE(mode="straight") {#X33:3 %t201:p};
// %t202 = $IO_PORT @ATTACH &n15 => @PLACE(218, -130) => @ORIENT("MY");
// %t202 @TEXT("n15", key="name", size=0.75);
// &n15 @WIRE(mode="straight") {#X33:4 %t202:p};
// %t203 = $SUPPLY @ATTACH &vdd => @PLACE(208, -117);
// &vdd @WIRE(mode="straight") {#X33:5 %t203:p};
// %t204 = $GROUND @ATTACH &vss => @PLACE(208, -143);
// &vss @WIRE(mode="straight") {#X33:6 %t204:p};
// %t205 = $IO_PORT @ATTACH &n14 => @PLACE(238, -126) => @ORIENT("R0");
// %t205 @TEXT("n14", key="name", size=0.75);
// &n14 @WIRE(mode="straight") {#X34:1 %t205:p};
// %t206 = $IO_PORT @ATTACH &n72 => @PLACE(238, -130) => @ORIENT("R0");
// %t206 @TEXT("n72", key="name", size=0.75);
// &n72 @WIRE(mode="straight") {#X34:2 %t206:p};
// %t207 = $IO_PORT @ATTACH &n71 => @PLACE(238, -134) => @ORIENT("R0");
// %t207 @TEXT("n71", key="name", size=0.75);
// &n71 @WIRE(mode="straight") {#X34:3 %t207:p};
// %t208 = $IO_PORT @ATTACH &n13 => @PLACE(258, -130) => @ORIENT("MY");
// %t208 @TEXT("n13", key="name", size=0.75);
// &n13 @WIRE(mode="straight") {#X34:4 %t208:p};
// %t209 = $SUPPLY @ATTACH &vdd => @PLACE(248, -117);
// &vdd @WIRE(mode="straight") {#X34:5 %t209:p};
// %t210 = $GROUND @ATTACH &vss => @PLACE(248, -143);
// &vss @WIRE(mode="straight") {#X34:6 %t210:p};
// %t211 = $IO_PORT @ATTACH &n18 => @PLACE(278, -126) => @ORIENT("R0");
// %t211 @TEXT("n18", key="name", size=0.75);
// &n18 @WIRE(mode="straight") {#X35:1 %t211:p};
// %t212 = $IO_PORT @ATTACH &n73 => @PLACE(278, -130) => @ORIENT("R0");
// %t212 @TEXT("n73", key="name", size=0.75);
// &n73 @WIRE(mode="straight") {#X35:2 %t212:p};
// %t213 = $IO_PORT @ATTACH &n71 => @PLACE(278, -134) => @ORIENT("R0");
// %t213 @TEXT("n71", key="name", size=0.75);
// &n71 @WIRE(mode="straight") {#X35:3 %t213:p};
// %t214 = $IO_PORT @ATTACH &n17 => @PLACE(298, -130) => @ORIENT("MY");
// %t214 @TEXT("n17", key="name", size=0.75);
// &n17 @WIRE(mode="straight") {#X35:4 %t214:p};
// %t215 = $SUPPLY @ATTACH &vdd => @PLACE(288, -117);
// &vdd @WIRE(mode="straight") {#X35:5 %t215:p};
// %t216 = $GROUND @ATTACH &vss => @PLACE(288, -143);
// &vss @WIRE(mode="straight") {#X35:6 %t216:p};
// %t217 = $IO_PORT @ATTACH &restart => @PLACE(158, -161) => @ORIENT("R0");
// %t217 @TEXT("restart", key="name", size=0.75);
// &restart @WIRE(mode="straight") {#X36:1 %t217:p};
// %t218 = $IO_PORT @ATTACH &n74 => @PLACE(158, -165) => @ORIENT("R0");
// %t218 @TEXT("n74", key="name", size=0.75);
// &n74 @WIRE(mode="straight") {#X36:2 %t218:p};
// %t219 = $IO_PORT @ATTACH &n75 => @PLACE(158, -169) => @ORIENT("R0");
// %t219 @TEXT("n75", key="name", size=0.75);
// &n75 @WIRE(mode="straight") {#X36:3 %t219:p};
// %t220 = $IO_PORT @ATTACH &n19 => @PLACE(178, -165) => @ORIENT("MY");
// %t220 @TEXT("n19", key="name", size=0.75);
// &n19 @WIRE(mode="straight") {#X36:4 %t220:p};
// %t221 = $SUPPLY @ATTACH &vdd => @PLACE(168, -152);
// &vdd @WIRE(mode="straight") {#X36:5 %t221:p};
// %t222 = $GROUND @ATTACH &vss => @PLACE(168, -178);
// &vss @WIRE(mode="straight") {#X36:6 %t222:p};
// %t223 = $IO_PORT @ATTACH &n27 => @PLACE(198, -161) => @ORIENT("R0");
// %t223 @TEXT("n27", key="name", size=0.75);
// &n27 @WIRE(mode="straight") {#X37:1 %t223:p};
// %t224 = $IO_PORT @ATTACH &n76 => @PLACE(198, -165) => @ORIENT("R0");
// %t224 @TEXT("n76", key="name", size=0.75);
// &n76 @WIRE(mode="straight") {#X37:2 %t224:p};
// %t225 = $IO_PORT @ATTACH &n67 => @PLACE(198, -169) => @ORIENT("R0");
// %t225 @TEXT("n67", key="name", size=0.75);
// &n67 @WIRE(mode="straight") {#X37:3 %t225:p};
// %t226 = $IO_PORT @ATTACH &n26 => @PLACE(218, -165) => @ORIENT("MY");
// %t226 @TEXT("n26", key="name", size=0.75);
// &n26 @WIRE(mode="straight") {#X37:4 %t226:p};
// %t227 = $SUPPLY @ATTACH &vdd => @PLACE(208, -152);
// &vdd @WIRE(mode="straight") {#X37:5 %t227:p};
// %t228 = $GROUND @ATTACH &vss => @PLACE(208, -178);
// &vss @WIRE(mode="straight") {#X37:6 %t228:p};
// %t229 = $IO_PORT @ATTACH &qualified => @PLACE(238, -161) => @ORIENT("R0");
// %t229 @TEXT("qualified", key="name", size=0.75);
// &qualified @WIRE(mode="straight") {#X38:1 %t229:p};
// %t230 = $IO_PORT @ATTACH &n77 => @PLACE(238, -165) => @ORIENT("R0");
// %t230 @TEXT("n77", key="name", size=0.75);
// &n77 @WIRE(mode="straight") {#X38:2 %t230:p};
// %t231 = $IO_PORT @ATTACH &n78 => @PLACE(238, -169) => @ORIENT("R0");
// %t231 @TEXT("n78", key="name", size=0.75);
// &n78 @WIRE(mode="straight") {#X38:3 %t231:p};
// %t232 = $IO_PORT @ATTACH &n28 => @PLACE(258, -165) => @ORIENT("MY");
// %t232 @TEXT("n28", key="name", size=0.75);
// &n28 @WIRE(mode="straight") {#X38:4 %t232:p};
// %t233 = $SUPPLY @ATTACH &vdd => @PLACE(248, -152);
// &vdd @WIRE(mode="straight") {#X38:5 %t233:p};
// %t234 = $GROUND @ATTACH &vss => @PLACE(248, -178);
// &vss @WIRE(mode="straight") {#X38:6 %t234:p};
// %t235 = $IO_PORT @ATTACH &n40 => @PLACE(278, -161) => @ORIENT("R0");
// %t235 @TEXT("n40", key="name", size=0.75);
// &n40 @WIRE(mode="straight") {#X39:1 %t235:p};
// %t236 = $IO_PORT @ATTACH &n79 => @PLACE(278, -165) => @ORIENT("R0");
// %t236 @TEXT("n79", key="name", size=0.75);
// &n79 @WIRE(mode="straight") {#X39:2 %t236:p};
// %t237 = $IO_PORT @ATTACH &n61 => @PLACE(278, -169) => @ORIENT("R0");
// %t237 @TEXT("n61", key="name", size=0.75);
// &n61 @WIRE(mode="straight") {#X39:3 %t237:p};
// %t238 = $IO_PORT @ATTACH &n39 => @PLACE(298, -165) => @ORIENT("MY");
// %t238 @TEXT("n39", key="name", size=0.75);
// &n39 @WIRE(mode="straight") {#X39:4 %t238:p};
// %t239 = $SUPPLY @ATTACH &vdd => @PLACE(288, -152);
// &vdd @WIRE(mode="straight") {#X39:5 %t239:p};
// %t240 = $GROUND @ATTACH &vss => @PLACE(288, -178);
// &vss @WIRE(mode="straight") {#X39:6 %t240:p};
// %t241 = $IO_PORT @ATTACH &fault => @PLACE(158, -196) => @ORIENT("R0");
// %t241 @TEXT("fault", key="name", size=0.75);
// &fault @WIRE(mode="straight") {#X40:1 %t241:p};
// %t242 = $IO_PORT @ATTACH &n80 => @PLACE(158, -200) => @ORIENT("R0");
// %t242 @TEXT("n80", key="name", size=0.75);
// &n80 @WIRE(mode="straight") {#X40:2 %t242:p};
// %t243 = $IO_PORT @ATTACH &n81 => @PLACE(158, -204) => @ORIENT("R0");
// %t243 @TEXT("n81", key="name", size=0.75);
// &n81 @WIRE(mode="straight") {#X40:3 %t243:p};
// %t244 = $IO_PORT @ATTACH &n41 => @PLACE(178, -200) => @ORIENT("MY");
// %t244 @TEXT("n41", key="name", size=0.75);
// &n41 @WIRE(mode="straight") {#X40:4 %t244:p};
// %t245 = $SUPPLY @ATTACH &vdd => @PLACE(168, -187);
// &vdd @WIRE(mode="straight") {#X40:5 %t245:p};
// %t246 = $GROUND @ATTACH &vss => @PLACE(168, -213);
// &vss @WIRE(mode="straight") {#X40:6 %t246:p};
// %t247 = $IO_PORT @ATTACH &n14 => @PLACE(198, -200) => @ORIENT("R0");
// %t247 @TEXT("n14", key="name", size=0.75);
// &n14 @WIRE(mode="straight") {#X41:1 %t247:p};
// %t248 = $IO_PORT @ATTACH &n82 => @PLACE(218, -200) => @ORIENT("MY");
// %t248 @TEXT("n82", key="name", size=0.75);
// &n82 @WIRE(mode="straight") {#X41:2 %t248:p};
// %t249 = $SUPPLY @ATTACH &vdd => @PLACE(208, -191);
// &vdd @WIRE(mode="straight") {#X41:3 %t249:p};
// %t250 = $GROUND @ATTACH &vss => @PLACE(208, -209);
// &vss @WIRE(mode="straight") {#X41:4 %t250:p};
// %t251 = $IO_PORT @ATTACH &n30 => @PLACE(238, -200) => @ORIENT("R0");
// %t251 @TEXT("n30", key="name", size=0.75);
// &n30 @WIRE(mode="straight") {#X42:1 %t251:p};
// %t252 = $IO_PORT @ATTACH &n83 => @PLACE(258, -200) => @ORIENT("MY");
// %t252 @TEXT("n83", key="name", size=0.75);
// &n83 @WIRE(mode="straight") {#X42:2 %t252:p};
// %t253 = $SUPPLY @ATTACH &vdd => @PLACE(248, -191);
// &vdd @WIRE(mode="straight") {#X42:3 %t253:p};
// %t254 = $GROUND @ATTACH &vss => @PLACE(248, -209);
// &vss @WIRE(mode="straight") {#X42:4 %t254:p};
// %t255 = $IO_PORT @ATTACH &n43 => @PLACE(278, -200) => @ORIENT("R0");
// %t255 @TEXT("n43", key="name", size=0.75);
// &n43 @WIRE(mode="straight") {#X43:1 %t255:p};
// %t256 = $IO_PORT @ATTACH &n84 => @PLACE(298, -200) => @ORIENT("MY");
// %t256 @TEXT("n84", key="name", size=0.75);
// &n84 @WIRE(mode="straight") {#X43:2 %t256:p};
// %t257 = $SUPPLY @ATTACH &vdd => @PLACE(288, -191);
// &vdd @WIRE(mode="straight") {#X43:3 %t257:p};
// %t258 = $GROUND @ATTACH &vss => @PLACE(288, -209);
// &vss @WIRE(mode="straight") {#X43:4 %t258:p};
// %t259 = $IO_PORT @ATTACH &n36 => @PLACE(158, -235) => @ORIENT("R0");
// %t259 @TEXT("n36", key="name", size=0.75);
// &n36 @WIRE(mode="straight") {#X44:1 %t259:p};
// %t260 = $IO_PORT @ATTACH &n85 => @PLACE(178, -235) => @ORIENT("MY");
// %t260 @TEXT("n85", key="name", size=0.75);
// &n85 @WIRE(mode="straight") {#X44:2 %t260:p};
// %t261 = $SUPPLY @ATTACH &vdd => @PLACE(168, -226);
// &vdd @WIRE(mode="straight") {#X44:3 %t261:p};
// %t262 = $GROUND @ATTACH &vss => @PLACE(168, -244);
// &vss @WIRE(mode="straight") {#X44:4 %t262:p};
// %t263 = $IO_PORT @ATTACH &n59 => @PLACE(198, -235) => @ORIENT("R0");
// %t263 @TEXT("n59", key="name", size=0.75);
// &n59 @WIRE(mode="straight") {#X45:1 %t263:p};
// %t264 = $IO_PORT @ATTACH &n86 => @PLACE(218, -235) => @ORIENT("MY");
// %t264 @TEXT("n86", key="name", size=0.75);
// &n86 @WIRE(mode="straight") {#X45:2 %t264:p};
// %t265 = $SUPPLY @ATTACH &vdd => @PLACE(208, -226);
// &vdd @WIRE(mode="straight") {#X45:3 %t265:p};
// %t266 = $GROUND @ATTACH &vss => @PLACE(208, -244);
// &vss @WIRE(mode="straight") {#X45:4 %t266:p};
// %t267 = $IO_PORT @ATTACH &n25 => @PLACE(238, -235) => @ORIENT("R0");
// %t267 @TEXT("n25", key="name", size=0.75);
// &n25 @WIRE(mode="straight") {#X46:1 %t267:p};
// %t268 = $IO_PORT @ATTACH &n87 => @PLACE(258, -235) => @ORIENT("MY");
// %t268 @TEXT("n87", key="name", size=0.75);
// &n87 @WIRE(mode="straight") {#X46:2 %t268:p};
// %t269 = $SUPPLY @ATTACH &vdd => @PLACE(248, -226);
// &vdd @WIRE(mode="straight") {#X46:3 %t269:p};
// %t270 = $GROUND @ATTACH &vss => @PLACE(248, -244);
// &vss @WIRE(mode="straight") {#X46:4 %t270:p};
// %t271 = $IO_PORT @ATTACH &n23 => @PLACE(278, -235) => @ORIENT("R0");
// %t271 @TEXT("n23", key="name", size=0.75);
// &n23 @WIRE(mode="straight") {#X47:1 %t271:p};
// %t272 = $IO_PORT @ATTACH &n88 => @PLACE(298, -235) => @ORIENT("MY");
// %t272 @TEXT("n88", key="name", size=0.75);
// &n88 @WIRE(mode="straight") {#X47:2 %t272:p};
// %t273 = $SUPPLY @ATTACH &vdd => @PLACE(288, -226);
// &vdd @WIRE(mode="straight") {#X47:3 %t273:p};
// %t274 = $GROUND @ATTACH &vss => @PLACE(288, -244);
// &vss @WIRE(mode="straight") {#X47:4 %t274:p};
// %t275 = $IO_PORT @ATTACH &n21 => @PLACE(326, -60) => @ORIENT("R0");
// %t275 @TEXT("n21", key="name", size=0.75);
// &n21 @WIRE(mode="straight") {#X48:1 %t275:p};
// %t276 = $IO_PORT @ATTACH &n89 => @PLACE(346, -60) => @ORIENT("MY");
// %t276 @TEXT("n89", key="name", size=0.75);
// &n89 @WIRE(mode="straight") {#X48:2 %t276:p};
// %t277 = $SUPPLY @ATTACH &vdd => @PLACE(336, -51);
// &vdd @WIRE(mode="straight") {#X48:3 %t277:p};
// %t278 = $GROUND @ATTACH &vss => @PLACE(336, -69);
// &vss @WIRE(mode="straight") {#X48:4 %t278:p};
// %t279 = $IO_PORT @ATTACH &cfg_ready => @PLACE(366, -60) => @ORIENT("R0");
// %t279 @TEXT("cfg_ready", key="name", size=0.75);
// &cfg_ready @WIRE(mode="straight") {#X49:1 %t279:p};
// %t280 = $IO_PORT @ATTACH &n90 => @PLACE(386, -60) => @ORIENT("MY");
// %t280 @TEXT("n90", key="name", size=0.75);
// &n90 @WIRE(mode="straight") {#X49:2 %t280:p};
// %t281 = $SUPPLY @ATTACH &vdd => @PLACE(376, -51);
// &vdd @WIRE(mode="straight") {#X49:3 %t281:p};
// %t282 = $GROUND @ATTACH &vss => @PLACE(376, -69);
// &vss @WIRE(mode="straight") {#X49:4 %t282:p};
// %t283 = $IO_PORT @ATTACH &qualified => @PLACE(406, -60) => @ORIENT("R0");
// %t283 @TEXT("qualified", key="name", size=0.75);
// &qualified @WIRE(mode="straight") {#X50:1 %t283:p};
// %t284 = $IO_PORT @ATTACH &n91 => @PLACE(426, -60) => @ORIENT("MY");
// %t284 @TEXT("n91", key="name", size=0.75);
// &n91 @WIRE(mode="straight") {#X50:2 %t284:p};
// %t285 = $SUPPLY @ATTACH &vdd => @PLACE(416, -51);
// &vdd @WIRE(mode="straight") {#X50:3 %t285:p};
// %t286 = $GROUND @ATTACH &vss => @PLACE(416, -69);
// &vss @WIRE(mode="straight") {#X50:4 %t286:p};
// %t287 = $IO_PORT @ATTACH &fll_enable => @PLACE(446, -60) => @ORIENT("R0");
// %t287 @TEXT("fll_enable", key="name", size=0.75);
// &fll_enable @WIRE(mode="straight") {#X51:1 %t287:p};
// %t288 = $IO_PORT @ATTACH &n92 => @PLACE(466, -60) => @ORIENT("MY");
// %t288 @TEXT("n92", key="name", size=0.75);
// &n92 @WIRE(mode="straight") {#X51:2 %t288:p};
// %t289 = $SUPPLY @ATTACH &vdd => @PLACE(456, -51);
// &vdd @WIRE(mode="straight") {#X51:3 %t289:p};
// %t290 = $GROUND @ATTACH &vss => @PLACE(456, -69);
// &vss @WIRE(mode="straight") {#X51:4 %t290:p};
// %t291 = $IO_PORT @ATTACH &n93 => @PLACE(326, -95) => @ORIENT("R0");
// %t291 @TEXT("n93", key="name", size=0.75);
// &n93 @WIRE(mode="straight") {#X52:1 %t291:p};
// %t292 = $IO_PORT @ATTACH &n94 => @PLACE(346, -95) => @ORIENT("MY");
// %t292 @TEXT("n94", key="name", size=0.75);
// &n94 @WIRE(mode="straight") {#X52:2 %t292:p};
// %t293 = $SUPPLY @ATTACH &vdd => @PLACE(336, -86);
// &vdd @WIRE(mode="straight") {#X52:3 %t293:p};
// %t294 = $GROUND @ATTACH &vss => @PLACE(336, -104);
// &vss @WIRE(mode="straight") {#X52:4 %t294:p};
// %t295 = $IO_PORT @ATTACH &restart => @PLACE(366, -95) => @ORIENT("R0");
// %t295 @TEXT("restart", key="name", size=0.75);
// &restart @WIRE(mode="straight") {#X53:1 %t295:p};
// %t296 = $IO_PORT @ATTACH &n95 => @PLACE(386, -95) => @ORIENT("MY");
// %t296 @TEXT("n95", key="name", size=0.75);
// &n95 @WIRE(mode="straight") {#X53:2 %t296:p};
// %t297 = $SUPPLY @ATTACH &vdd => @PLACE(376, -86);
// &vdd @WIRE(mode="straight") {#X53:3 %t297:p};
// %t298 = $GROUND @ATTACH &vss => @PLACE(376, -104);
// &vss @WIRE(mode="straight") {#X53:4 %t298:p};
// %t299 = $IO_PORT @ATTACH &range_error => @PLACE(406, -95) => @ORIENT("R0");
// %t299 @TEXT("range_error", key="name", size=0.75);
// &range_error @WIRE(mode="straight") {#X54:1 %t299:p};
// %t300 = $IO_PORT @ATTACH &n96 => @PLACE(426, -95) => @ORIENT("MY");
// %t300 @TEXT("n96", key="name", size=0.75);
// &n96 @WIRE(mode="straight") {#X54:2 %t300:p};
// %t301 = $SUPPLY @ATTACH &vdd => @PLACE(416, -86);
// &vdd @WIRE(mode="straight") {#X54:3 %t301:p};
// %t302 = $GROUND @ATTACH &vss => @PLACE(416, -104);
// &vss @WIRE(mode="straight") {#X54:4 %t302:p};
// %t303 = $IO_PORT @ATTACH &n51 => @PLACE(446, -93) => @ORIENT("R0");
// %t303 @TEXT("n51", key="name", size=0.75);
// &n51 @WIRE(mode="straight") {#X55:1 %t303:p};
// %t304 = $IO_PORT @ATTACH &n97 => @PLACE(446, -97) => @ORIENT("R0");
// %t304 @TEXT("n97", key="name", size=0.75);
// &n97 @WIRE(mode="straight") {#X55:2 %t304:p};
// %t305 = $IO_PORT @ATTACH &n98 => @PLACE(466, -95) => @ORIENT("MY");
// %t305 @TEXT("n98", key="name", size=0.75);
// &n98 @WIRE(mode="straight") {#X55:3 %t305:p};
// %t306 = $SUPPLY @ATTACH &vdd => @PLACE(456, -84);
// &vdd @WIRE(mode="straight") {#X55:4 %t306:p};
// %t307 = $GROUND @ATTACH &vss => @PLACE(456, -106);
// &vss @WIRE(mode="straight") {#X55:5 %t307:p};
// %t308 = $IO_PORT @ATTACH &n47 => @PLACE(326, -128) => @ORIENT("R0");
// %t308 @TEXT("n47", key="name", size=0.75);
// &n47 @WIRE(mode="straight") {#X56:1 %t308:p};
// %t309 = $IO_PORT @ATTACH &n99 => @PLACE(326, -132) => @ORIENT("R0");
// %t309 @TEXT("n99", key="name", size=0.75);
// &n99 @WIRE(mode="straight") {#X56:2 %t309:p};
// %t310 = $IO_PORT @ATTACH &n100 => @PLACE(346, -130) => @ORIENT("MY");
// %t310 @TEXT("n100", key="name", size=0.75);
// &n100 @WIRE(mode="straight") {#X56:3 %t310:p};
// %t311 = $SUPPLY @ATTACH &vdd => @PLACE(336, -119);
// &vdd @WIRE(mode="straight") {#X56:4 %t311:p};
// %t312 = $GROUND @ATTACH &vss => @PLACE(336, -141);
// &vss @WIRE(mode="straight") {#X56:5 %t312:p};
// %t313 = $IO_PORT @ATTACH &n55 => @PLACE(366, -128) => @ORIENT("R0");
// %t313 @TEXT("n55", key="name", size=0.75);
// &n55 @WIRE(mode="straight") {#X57:1 %t313:p};
// %t314 = $IO_PORT @ATTACH &n101 => @PLACE(366, -132) => @ORIENT("R0");
// %t314 @TEXT("n101", key="name", size=0.75);
// &n101 @WIRE(mode="straight") {#X57:2 %t314:p};
// %t315 = $IO_PORT @ATTACH &n102 => @PLACE(386, -130) => @ORIENT("MY");
// %t315 @TEXT("n102", key="name", size=0.75);
// &n102 @WIRE(mode="straight") {#X57:3 %t315:p};
// %t316 = $SUPPLY @ATTACH &vdd => @PLACE(376, -119);
// &vdd @WIRE(mode="straight") {#X57:4 %t316:p};
// %t317 = $GROUND @ATTACH &vss => @PLACE(376, -141);
// &vss @WIRE(mode="straight") {#X57:5 %t317:p};
// %t318 = $IO_PORT @ATTACH &n103 => @PLACE(406, -128) => @ORIENT("R0");
// %t318 @TEXT("n103", key="name", size=0.75);
// &n103 @WIRE(mode="straight") {#X58:1 %t318:p};
// %t319 = $IO_PORT @ATTACH &n97 => @PLACE(406, -132) => @ORIENT("R0");
// %t319 @TEXT("n97", key="name", size=0.75);
// &n97 @WIRE(mode="straight") {#X58:2 %t319:p};
// %t320 = $IO_PORT @ATTACH &n101 => @PLACE(426, -130) => @ORIENT("MY");
// %t320 @TEXT("n101", key="name", size=0.75);
// &n101 @WIRE(mode="straight") {#X58:3 %t320:p};
// %t321 = $SUPPLY @ATTACH &vdd => @PLACE(416, -119);
// &vdd @WIRE(mode="straight") {#X58:4 %t321:p};
// %t322 = $GROUND @ATTACH &vss => @PLACE(416, -141);
// &vss @WIRE(mode="straight") {#X58:5 %t322:p};
// %t323 = $IO_PORT @ATTACH &n104 => @PLACE(446, -128) => @ORIENT("R0");
// %t323 @TEXT("n104", key="name", size=0.75);
// &n104 @WIRE(mode="straight") {#X59:1 %t323:p};
// %t324 = $IO_PORT @ATTACH &n97 => @PLACE(446, -132) => @ORIENT("R0");
// %t324 @TEXT("n97", key="name", size=0.75);
// &n97 @WIRE(mode="straight") {#X59:2 %t324:p};
// %t325 = $IO_PORT @ATTACH &n105 => @PLACE(466, -130) => @ORIENT("MY");
// %t325 @TEXT("n105", key="name", size=0.75);
// &n105 @WIRE(mode="straight") {#X59:3 %t325:p};
// %t326 = $SUPPLY @ATTACH &vdd => @PLACE(456, -119);
// &vdd @WIRE(mode="straight") {#X59:4 %t326:p};
// %t327 = $GROUND @ATTACH &vss => @PLACE(456, -141);
// &vss @WIRE(mode="straight") {#X59:5 %t327:p};
// %t328 = $IO_PORT @ATTACH &n106 => @PLACE(326, -163) => @ORIENT("R0");
// %t328 @TEXT("n106", key="name", size=0.75);
// &n106 @WIRE(mode="straight") {#X60:1 %t328:p};
// %t329 = $IO_PORT @ATTACH &n103 => @PLACE(326, -167) => @ORIENT("R0");
// %t329 @TEXT("n103", key="name", size=0.75);
// &n103 @WIRE(mode="straight") {#X60:2 %t329:p};
// %t330 = $IO_PORT @ATTACH &n104 => @PLACE(346, -165) => @ORIENT("MY");
// %t330 @TEXT("n104", key="name", size=0.75);
// &n104 @WIRE(mode="straight") {#X60:3 %t330:p};
// %t331 = $SUPPLY @ATTACH &vdd => @PLACE(336, -154);
// &vdd @WIRE(mode="straight") {#X60:4 %t331:p};
// %t332 = $GROUND @ATTACH &vss => @PLACE(336, -176);
// &vss @WIRE(mode="straight") {#X60:5 %t332:p};
// %t333 = $IO_PORT @ATTACH &n107 => @PLACE(366, -163) => @ORIENT("R0");
// %t333 @TEXT("n107", key="name", size=0.75);
// &n107 @WIRE(mode="straight") {#X61:1 %t333:p};
// %t334 = $IO_PORT @ATTACH &n99 => @PLACE(366, -167) => @ORIENT("R0");
// %t334 @TEXT("n99", key="name", size=0.75);
// &n99 @WIRE(mode="straight") {#X61:2 %t334:p};
// %t335 = $IO_PORT @ATTACH &n97 => @PLACE(386, -165) => @ORIENT("MY");
// %t335 @TEXT("n97", key="name", size=0.75);
// &n97 @WIRE(mode="straight") {#X61:3 %t335:p};
// %t336 = $SUPPLY @ATTACH &vdd => @PLACE(376, -154);
// &vdd @WIRE(mode="straight") {#X61:4 %t336:p};
// %t337 = $GROUND @ATTACH &vss => @PLACE(376, -176);
// &vss @WIRE(mode="straight") {#X61:5 %t337:p};
// %t338 = $IO_PORT @ATTACH &n57 => @PLACE(406, -163) => @ORIENT("R0");
// %t338 @TEXT("n57", key="name", size=0.75);
// &n57 @WIRE(mode="straight") {#X62:1 %t338:p};
// %t339 = $IO_PORT @ATTACH &n55 => @PLACE(406, -167) => @ORIENT("R0");
// %t339 @TEXT("n55", key="name", size=0.75);
// &n55 @WIRE(mode="straight") {#X62:2 %t339:p};
// %t340 = $IO_PORT @ATTACH &n106 => @PLACE(426, -165) => @ORIENT("MY");
// %t340 @TEXT("n106", key="name", size=0.75);
// &n106 @WIRE(mode="straight") {#X62:3 %t340:p};
// %t341 = $SUPPLY @ATTACH &vdd => @PLACE(416, -154);
// &vdd @WIRE(mode="straight") {#X62:4 %t341:p};
// %t342 = $GROUND @ATTACH &vss => @PLACE(416, -176);
// &vss @WIRE(mode="straight") {#X62:5 %t342:p};
// %t343 = $IO_PORT @ATTACH &n53 => @PLACE(446, -163) => @ORIENT("R0");
// %t343 @TEXT("n53", key="name", size=0.75);
// &n53 @WIRE(mode="straight") {#X63:1 %t343:p};
// %t344 = $IO_PORT @ATTACH &n51 => @PLACE(446, -167) => @ORIENT("R0");
// %t344 @TEXT("n51", key="name", size=0.75);
// &n51 @WIRE(mode="straight") {#X63:2 %t344:p};
// %t345 = $IO_PORT @ATTACH &n103 => @PLACE(466, -165) => @ORIENT("MY");
// %t345 @TEXT("n103", key="name", size=0.75);
// &n103 @WIRE(mode="straight") {#X63:3 %t345:p};
// %t346 = $SUPPLY @ATTACH &vdd => @PLACE(456, -154);
// &vdd @WIRE(mode="straight") {#X63:4 %t346:p};
// %t347 = $GROUND @ATTACH &vss => @PLACE(456, -176);
// &vss @WIRE(mode="straight") {#X63:5 %t347:p};
// %t348 = $IO_PORT @ATTACH &n49 => @PLACE(326, -198) => @ORIENT("R0");
// %t348 @TEXT("n49", key="name", size=0.75);
// &n49 @WIRE(mode="straight") {#X64:1 %t348:p};
// %t349 = $IO_PORT @ATTACH &n47 => @PLACE(326, -202) => @ORIENT("R0");
// %t349 @TEXT("n47", key="name", size=0.75);
// &n47 @WIRE(mode="straight") {#X64:2 %t349:p};
// %t350 = $IO_PORT @ATTACH &n107 => @PLACE(346, -200) => @ORIENT("MY");
// %t350 @TEXT("n107", key="name", size=0.75);
// &n107 @WIRE(mode="straight") {#X64:3 %t350:p};
// %t351 = $SUPPLY @ATTACH &vdd => @PLACE(336, -189);
// &vdd @WIRE(mode="straight") {#X64:4 %t351:p};
// %t352 = $GROUND @ATTACH &vss => @PLACE(336, -211);
// &vss @WIRE(mode="straight") {#X64:5 %t352:p};
// %t353 = $IO_PORT @ATTACH &n45 => @PLACE(366, -198) => @ORIENT("R0");
// %t353 @TEXT("n45", key="name", size=0.75);
// &n45 @WIRE(mode="straight") {#X65:1 %t353:p};
// %t354 = $IO_PORT @ATTACH &n43 => @PLACE(366, -202) => @ORIENT("R0");
// %t354 @TEXT("n43", key="name", size=0.75);
// &n43 @WIRE(mode="straight") {#X65:2 %t354:p};
// %t355 = $IO_PORT @ATTACH &n99 => @PLACE(386, -200) => @ORIENT("MY");
// %t355 @TEXT("n99", key="name", size=0.75);
// &n99 @WIRE(mode="straight") {#X65:3 %t355:p};
// %t356 = $SUPPLY @ATTACH &vdd => @PLACE(376, -189);
// &vdd @WIRE(mode="straight") {#X65:4 %t356:p};
// %t357 = $GROUND @ATTACH &vss => @PLACE(376, -211);
// &vss @WIRE(mode="straight") {#X65:5 %t357:p};
// %t358 = $IO_PORT @ATTACH &n34 => @PLACE(406, -198) => @ORIENT("R0");
// %t358 @TEXT("n34", key="name", size=0.75);
// &n34 @WIRE(mode="straight") {#X66:1 %t358:p};
// %t359 = $IO_PORT @ATTACH &n108 => @PLACE(406, -202) => @ORIENT("R0");
// %t359 @TEXT("n108", key="name", size=0.75);
// &n108 @WIRE(mode="straight") {#X66:2 %t359:p};
// %t360 = $IO_PORT @ATTACH &n109 => @PLACE(426, -200) => @ORIENT("MY");
// %t360 @TEXT("n109", key="name", size=0.75);
// &n109 @WIRE(mode="straight") {#X66:3 %t360:p};
// %t361 = $SUPPLY @ATTACH &vdd => @PLACE(416, -189);
// &vdd @WIRE(mode="straight") {#X66:4 %t361:p};
// %t362 = $GROUND @ATTACH &vss => @PLACE(416, -211);
// &vss @WIRE(mode="straight") {#X66:5 %t362:p};
// %t363 = $IO_PORT @ATTACH &n38 => @PLACE(446, -198) => @ORIENT("R0");
// %t363 @TEXT("n38", key="name", size=0.75);
// &n38 @WIRE(mode="straight") {#X67:1 %t363:p};
// %t364 = $IO_PORT @ATTACH &n110 => @PLACE(446, -202) => @ORIENT("R0");
// %t364 @TEXT("n110", key="name", size=0.75);
// &n110 @WIRE(mode="straight") {#X67:2 %t364:p};
// %t365 = $IO_PORT @ATTACH &n111 => @PLACE(466, -200) => @ORIENT("MY");
// %t365 @TEXT("n111", key="name", size=0.75);
// &n111 @WIRE(mode="straight") {#X67:3 %t365:p};
// %t366 = $SUPPLY @ATTACH &vdd => @PLACE(456, -189);
// &vdd @WIRE(mode="straight") {#X67:4 %t366:p};
// %t367 = $GROUND @ATTACH &vss => @PLACE(456, -211);
// &vss @WIRE(mode="straight") {#X67:5 %t367:p};
// %t368 = $IO_PORT @ATTACH &n112 => @PLACE(326, -233) => @ORIENT("R0");
// %t368 @TEXT("n112", key="name", size=0.75);
// &n112 @WIRE(mode="straight") {#X68:1 %t368:p};
// %t369 = $IO_PORT @ATTACH &n108 => @PLACE(326, -237) => @ORIENT("R0");
// %t369 @TEXT("n108", key="name", size=0.75);
// &n108 @WIRE(mode="straight") {#X68:2 %t369:p};
// %t370 = $IO_PORT @ATTACH &n110 => @PLACE(346, -235) => @ORIENT("MY");
// %t370 @TEXT("n110", key="name", size=0.75);
// &n110 @WIRE(mode="straight") {#X68:3 %t370:p};
// %t371 = $SUPPLY @ATTACH &vdd => @PLACE(336, -224);
// &vdd @WIRE(mode="straight") {#X68:4 %t371:p};
// %t372 = $GROUND @ATTACH &vss => @PLACE(336, -246);
// &vss @WIRE(mode="straight") {#X68:5 %t372:p};
// %t373 = $IO_PORT @ATTACH &n36 => @PLACE(366, -233) => @ORIENT("R0");
// %t373 @TEXT("n36", key="name", size=0.75);
// &n36 @WIRE(mode="straight") {#X69:1 %t373:p};
// %t374 = $IO_PORT @ATTACH &n34 => @PLACE(366, -237) => @ORIENT("R0");
// %t374 @TEXT("n34", key="name", size=0.75);
// &n34 @WIRE(mode="straight") {#X69:2 %t374:p};
// %t375 = $IO_PORT @ATTACH &n112 => @PLACE(386, -235) => @ORIENT("MY");
// %t375 @TEXT("n112", key="name", size=0.75);
// &n112 @WIRE(mode="straight") {#X69:3 %t375:p};
// %t376 = $SUPPLY @ATTACH &vdd => @PLACE(376, -224);
// &vdd @WIRE(mode="straight") {#X69:4 %t376:p};
// %t377 = $GROUND @ATTACH &vss => @PLACE(376, -246);
// &vss @WIRE(mode="straight") {#X69:5 %t377:p};
// %t378 = $IO_PORT @ATTACH &n32 => @PLACE(406, -233) => @ORIENT("R0");
// %t378 @TEXT("n32", key="name", size=0.75);
// &n32 @WIRE(mode="straight") {#X70:1 %t378:p};
// %t379 = $IO_PORT @ATTACH &n30 => @PLACE(406, -237) => @ORIENT("R0");
// %t379 @TEXT("n30", key="name", size=0.75);
// &n30 @WIRE(mode="straight") {#X70:2 %t379:p};
// %t380 = $IO_PORT @ATTACH &n108 => @PLACE(426, -235) => @ORIENT("MY");
// %t380 @TEXT("n108", key="name", size=0.75);
// &n108 @WIRE(mode="straight") {#X70:3 %t380:p};
// %t381 = $SUPPLY @ATTACH &vdd => @PLACE(416, -224);
// &vdd @WIRE(mode="straight") {#X70:4 %t381:p};
// %t382 = $GROUND @ATTACH &vss => @PLACE(416, -246);
// &vss @WIRE(mode="straight") {#X70:5 %t382:p};
// %t383 = $IO_PORT @ATTACH &n16 => @PLACE(446, -233) => @ORIENT("R0");
// %t383 @TEXT("n16", key="name", size=0.75);
// &n16 @WIRE(mode="straight") {#X71:1 %t383:p};
// %t384 = $IO_PORT @ATTACH &n14 => @PLACE(446, -237) => @ORIENT("R0");
// %t384 @TEXT("n14", key="name", size=0.75);
// &n14 @WIRE(mode="straight") {#X71:2 %t384:p};
// %t385 = $IO_PORT @ATTACH &n113 => @PLACE(466, -235) => @ORIENT("MY");
// %t385 @TEXT("n113", key="name", size=0.75);
// &n113 @WIRE(mode="straight") {#X71:3 %t385:p};
// %t386 = $SUPPLY @ATTACH &vdd => @PLACE(456, -224);
// &vdd @WIRE(mode="straight") {#X71:4 %t386:p};
// %t387 = $GROUND @ATTACH &vss => @PLACE(456, -246);
// &vss @WIRE(mode="straight") {#X71:5 %t387:p};
// %t388 = $IO_PORT @ATTACH &n23 => @PLACE(494, -58) => @ORIENT("R0");
// %t388 @TEXT("n23", key="name", size=0.75);
// &n23 @WIRE(mode="straight") {#X72:1 %t388:p};
// %t389 = $IO_PORT @ATTACH &n21 => @PLACE(494, -62) => @ORIENT("R0");
// %t389 @TEXT("n21", key="name", size=0.75);
// &n21 @WIRE(mode="straight") {#X72:2 %t389:p};
// %t390 = $IO_PORT @ATTACH &n114 => @PLACE(514, -60) => @ORIENT("MY");
// %t390 @TEXT("n114", key="name", size=0.75);
// &n114 @WIRE(mode="straight") {#X72:3 %t390:p};
// %t391 = $SUPPLY @ATTACH &vdd => @PLACE(504, -49);
// &vdd @WIRE(mode="straight") {#X72:4 %t391:p};
// %t392 = $GROUND @ATTACH &vss => @PLACE(504, -71);
// &vss @WIRE(mode="straight") {#X72:5 %t392:p};
// %t393 = $IO_PORT @ATTACH &n25 => @PLACE(534, -58) => @ORIENT("R0");
// %t393 @TEXT("n25", key="name", size=0.75);
// &n25 @WIRE(mode="straight") {#X73:1 %t393:p};
// %t394 = $IO_PORT @ATTACH &n115 => @PLACE(534, -62) => @ORIENT("R0");
// %t394 @TEXT("n115", key="name", size=0.75);
// &n115 @WIRE(mode="straight") {#X73:2 %t394:p};
// %t395 = $IO_PORT @ATTACH &n116 => @PLACE(554, -60) => @ORIENT("MY");
// %t395 @TEXT("n116", key="name", size=0.75);
// &n116 @WIRE(mode="straight") {#X73:3 %t395:p};
// %t396 = $SUPPLY @ATTACH &vdd => @PLACE(544, -49);
// &vdd @WIRE(mode="straight") {#X73:4 %t396:p};
// %t397 = $GROUND @ATTACH &vss => @PLACE(544, -71);
// &vss @WIRE(mode="straight") {#X73:5 %t397:p};
// %t398 = $IO_PORT @ATTACH &n27 => @PLACE(574, -58) => @ORIENT("R0");
// %t398 @TEXT("n27", key="name", size=0.75);
// &n27 @WIRE(mode="straight") {#X74:1 %t398:p};
// %t399 = $IO_PORT @ATTACH &n117 => @PLACE(574, -62) => @ORIENT("R0");
// %t399 @TEXT("n117", key="name", size=0.75);
// &n117 @WIRE(mode="straight") {#X74:2 %t399:p};
// %t400 = $IO_PORT @ATTACH &n118 => @PLACE(594, -60) => @ORIENT("MY");
// %t400 @TEXT("n118", key="name", size=0.75);
// &n118 @WIRE(mode="straight") {#X74:3 %t400:p};
// %t401 = $SUPPLY @ATTACH &vdd => @PLACE(584, -49);
// &vdd @WIRE(mode="straight") {#X74:4 %t401:p};
// %t402 = $GROUND @ATTACH &vss => @PLACE(584, -71);
// &vss @WIRE(mode="straight") {#X74:5 %t402:p};
// %t403 = $IO_PORT @ATTACH &n45 => @PLACE(614, -58) => @ORIENT("R0");
// %t403 @TEXT("n45", key="name", size=0.75);
// &n45 @WIRE(mode="straight") {#X75:1 %t403:p};
// %t404 = $IO_PORT @ATTACH &n43 => @PLACE(614, -62) => @ORIENT("R0");
// %t404 @TEXT("n43", key="name", size=0.75);
// &n43 @WIRE(mode="straight") {#X75:2 %t404:p};
// %t405 = $IO_PORT @ATTACH &n119 => @PLACE(635, -60) => @ORIENT("MY");
// %t405 @TEXT("n119", key="name", size=0.75);
// &n119 @WIRE(mode="straight") {#X75:3 %t405:p};
// %t406 = $SUPPLY @ATTACH &vdd => @PLACE(624, -49);
// &vdd @WIRE(mode="straight") {#X75:4 %t406:p};
// %t407 = $GROUND @ATTACH &vss => @PLACE(624, -71);
// &vss @WIRE(mode="straight") {#X75:5 %t407:p};
// %t408 = $IO_PORT @ATTACH &n47 => @PLACE(494, -93) => @ORIENT("R0");
// %t408 @TEXT("n47", key="name", size=0.75);
// &n47 @WIRE(mode="straight") {#X76:1 %t408:p};
// %t409 = $IO_PORT @ATTACH &n99 => @PLACE(494, -97) => @ORIENT("R0");
// %t409 @TEXT("n99", key="name", size=0.75);
// &n99 @WIRE(mode="straight") {#X76:2 %t409:p};
// %t410 = $IO_PORT @ATTACH &n120 => @PLACE(514, -95) => @ORIENT("MY");
// %t410 @TEXT("n120", key="name", size=0.75);
// &n120 @WIRE(mode="straight") {#X76:3 %t410:p};
// %t411 = $SUPPLY @ATTACH &vdd => @PLACE(504, -84);
// &vdd @WIRE(mode="straight") {#X76:4 %t411:p};
// %t412 = $GROUND @ATTACH &vss => @PLACE(504, -106);
// &vss @WIRE(mode="straight") {#X76:5 %t412:p};
// %t413 = $IO_PORT @ATTACH &n49 => @PLACE(534, -93) => @ORIENT("R0");
// %t413 @TEXT("n49", key="name", size=0.75);
// &n49 @WIRE(mode="straight") {#X77:1 %t413:p};
// %t414 = $IO_PORT @ATTACH &n100 => @PLACE(534, -97) => @ORIENT("R0");
// %t414 @TEXT("n100", key="name", size=0.75);
// &n100 @WIRE(mode="straight") {#X77:2 %t414:p};
// %t415 = $IO_PORT @ATTACH &n121 => @PLACE(554, -95) => @ORIENT("MY");
// %t415 @TEXT("n121", key="name", size=0.75);
// &n121 @WIRE(mode="straight") {#X77:3 %t415:p};
// %t416 = $SUPPLY @ATTACH &vdd => @PLACE(544, -84);
// &vdd @WIRE(mode="straight") {#X77:4 %t416:p};
// %t417 = $GROUND @ATTACH &vss => @PLACE(544, -106);
// &vss @WIRE(mode="straight") {#X77:5 %t417:p};
// %t418 = $IO_PORT @ATTACH &n51 => @PLACE(574, -93) => @ORIENT("R0");
// %t418 @TEXT("n51", key="name", size=0.75);
// &n51 @WIRE(mode="straight") {#X78:1 %t418:p};
// %t419 = $IO_PORT @ATTACH &n97 => @PLACE(574, -97) => @ORIENT("R0");
// %t419 @TEXT("n97", key="name", size=0.75);
// &n97 @WIRE(mode="straight") {#X78:2 %t419:p};
// %t420 = $IO_PORT @ATTACH &n122 => @PLACE(594, -95) => @ORIENT("MY");
// %t420 @TEXT("n122", key="name", size=0.75);
// &n122 @WIRE(mode="straight") {#X78:3 %t420:p};
// %t421 = $SUPPLY @ATTACH &vdd => @PLACE(584, -84);
// &vdd @WIRE(mode="straight") {#X78:4 %t421:p};
// %t422 = $GROUND @ATTACH &vss => @PLACE(584, -106);
// &vss @WIRE(mode="straight") {#X78:5 %t422:p};
// %t423 = $IO_PORT @ATTACH &n53 => @PLACE(614, -93) => @ORIENT("R0");
// %t423 @TEXT("n53", key="name", size=0.75);
// &n53 @WIRE(mode="straight") {#X79:1 %t423:p};
// %t424 = $IO_PORT @ATTACH &n98 => @PLACE(614, -97) => @ORIENT("R0");
// %t424 @TEXT("n98", key="name", size=0.75);
// &n98 @WIRE(mode="straight") {#X79:2 %t424:p};
// %t425 = $IO_PORT @ATTACH &n123 => @PLACE(635, -95) => @ORIENT("MY");
// %t425 @TEXT("n123", key="name", size=0.75);
// &n123 @WIRE(mode="straight") {#X79:3 %t425:p};
// %t426 = $SUPPLY @ATTACH &vdd => @PLACE(624, -84);
// &vdd @WIRE(mode="straight") {#X79:4 %t426:p};
// %t427 = $GROUND @ATTACH &vss => @PLACE(624, -106);
// &vss @WIRE(mode="straight") {#X79:5 %t427:p};
// %t428 = $IO_PORT @ATTACH &n55 => @PLACE(494, -128) => @ORIENT("R0");
// %t428 @TEXT("n55", key="name", size=0.75);
// &n55 @WIRE(mode="straight") {#X80:1 %t428:p};
// %t429 = $IO_PORT @ATTACH &n101 => @PLACE(494, -132) => @ORIENT("R0");
// %t429 @TEXT("n101", key="name", size=0.75);
// &n101 @WIRE(mode="straight") {#X80:2 %t429:p};
// %t430 = $IO_PORT @ATTACH &n124 => @PLACE(514, -130) => @ORIENT("MY");
// %t430 @TEXT("n124", key="name", size=0.75);
// &n124 @WIRE(mode="straight") {#X80:3 %t430:p};
// %t431 = $SUPPLY @ATTACH &vdd => @PLACE(504, -119);
// &vdd @WIRE(mode="straight") {#X80:4 %t431:p};
// %t432 = $GROUND @ATTACH &vss => @PLACE(504, -141);
// &vss @WIRE(mode="straight") {#X80:5 %t432:p};
// %t433 = $IO_PORT @ATTACH &n57 => @PLACE(534, -128) => @ORIENT("R0");
// %t433 @TEXT("n57", key="name", size=0.75);
// &n57 @WIRE(mode="straight") {#X81:1 %t433:p};
// %t434 = $IO_PORT @ATTACH &n102 => @PLACE(534, -132) => @ORIENT("R0");
// %t434 @TEXT("n102", key="name", size=0.75);
// &n102 @WIRE(mode="straight") {#X81:2 %t434:p};
// %t435 = $IO_PORT @ATTACH &n125 => @PLACE(554, -130) => @ORIENT("MY");
// %t435 @TEXT("n125", key="name", size=0.75);
// &n125 @WIRE(mode="straight") {#X81:3 %t435:p};
// %t436 = $SUPPLY @ATTACH &vdd => @PLACE(544, -119);
// &vdd @WIRE(mode="straight") {#X81:4 %t436:p};
// %t437 = $GROUND @ATTACH &vss => @PLACE(544, -141);
// &vss @WIRE(mode="straight") {#X81:5 %t437:p};
// %t438 = $IO_PORT @ATTACH &n59 => @PLACE(574, -128) => @ORIENT("R0");
// %t438 @TEXT("n59", key="name", size=0.75);
// &n59 @WIRE(mode="straight") {#X82:1 %t438:p};
// %t439 = $IO_PORT @ATTACH &n105 => @PLACE(574, -132) => @ORIENT("R0");
// %t439 @TEXT("n105", key="name", size=0.75);
// &n105 @WIRE(mode="straight") {#X82:2 %t439:p};
// %t440 = $IO_PORT @ATTACH &n126 => @PLACE(594, -130) => @ORIENT("MY");
// %t440 @TEXT("n126", key="name", size=0.75);
// &n126 @WIRE(mode="straight") {#X82:3 %t440:p};
// %t441 = $SUPPLY @ATTACH &vdd => @PLACE(584, -119);
// &vdd @WIRE(mode="straight") {#X82:4 %t441:p};
// %t442 = $GROUND @ATTACH &vss => @PLACE(584, -141);
// &vss @WIRE(mode="straight") {#X82:5 %t442:p};
// %t443 = $IO_PORT @ATTACH &n32 => @PLACE(614, -128) => @ORIENT("R0");
// %t443 @TEXT("n32", key="name", size=0.75);
// &n32 @WIRE(mode="straight") {#X83:1 %t443:p};
// %t444 = $IO_PORT @ATTACH &n30 => @PLACE(614, -132) => @ORIENT("R0");
// %t444 @TEXT("n30", key="name", size=0.75);
// &n30 @WIRE(mode="straight") {#X83:2 %t444:p};
// %t445 = $IO_PORT @ATTACH &n127 => @PLACE(635, -130) => @ORIENT("MY");
// %t445 @TEXT("n127", key="name", size=0.75);
// &n127 @WIRE(mode="straight") {#X83:3 %t445:p};
// %t446 = $SUPPLY @ATTACH &vdd => @PLACE(624, -119);
// &vdd @WIRE(mode="straight") {#X83:4 %t446:p};
// %t447 = $GROUND @ATTACH &vss => @PLACE(624, -141);
// &vss @WIRE(mode="straight") {#X83:5 %t447:p};
// %t448 = $IO_PORT @ATTACH &n34 => @PLACE(494, -163) => @ORIENT("R0");
// %t448 @TEXT("n34", key="name", size=0.75);
// &n34 @WIRE(mode="straight") {#X84:1 %t448:p};
// %t449 = $IO_PORT @ATTACH &n108 => @PLACE(494, -167) => @ORIENT("R0");
// %t449 @TEXT("n108", key="name", size=0.75);
// &n108 @WIRE(mode="straight") {#X84:2 %t449:p};
// %t450 = $IO_PORT @ATTACH &n128 => @PLACE(514, -165) => @ORIENT("MY");
// %t450 @TEXT("n128", key="name", size=0.75);
// &n128 @WIRE(mode="straight") {#X84:3 %t450:p};
// %t451 = $SUPPLY @ATTACH &vdd => @PLACE(504, -154);
// &vdd @WIRE(mode="straight") {#X84:4 %t451:p};
// %t452 = $GROUND @ATTACH &vss => @PLACE(504, -176);
// &vss @WIRE(mode="straight") {#X84:5 %t452:p};
// %t453 = $IO_PORT @ATTACH &n36 => @PLACE(534, -163) => @ORIENT("R0");
// %t453 @TEXT("n36", key="name", size=0.75);
// &n36 @WIRE(mode="straight") {#X85:1 %t453:p};
// %t454 = $IO_PORT @ATTACH &n109 => @PLACE(534, -167) => @ORIENT("R0");
// %t454 @TEXT("n109", key="name", size=0.75);
// &n109 @WIRE(mode="straight") {#X85:2 %t454:p};
// %t455 = $IO_PORT @ATTACH &n129 => @PLACE(554, -165) => @ORIENT("MY");
// %t455 @TEXT("n129", key="name", size=0.75);
// &n129 @WIRE(mode="straight") {#X85:3 %t455:p};
// %t456 = $SUPPLY @ATTACH &vdd => @PLACE(544, -154);
// &vdd @WIRE(mode="straight") {#X85:4 %t456:p};
// %t457 = $GROUND @ATTACH &vss => @PLACE(544, -176);
// &vss @WIRE(mode="straight") {#X85:5 %t457:p};
// %t458 = $IO_PORT @ATTACH &n38 => @PLACE(574, -163) => @ORIENT("R0");
// %t458 @TEXT("n38", key="name", size=0.75);
// &n38 @WIRE(mode="straight") {#X86:1 %t458:p};
// %t459 = $IO_PORT @ATTACH &n110 => @PLACE(574, -167) => @ORIENT("R0");
// %t459 @TEXT("n110", key="name", size=0.75);
// &n110 @WIRE(mode="straight") {#X86:2 %t459:p};
// %t460 = $IO_PORT @ATTACH &n130 => @PLACE(594, -165) => @ORIENT("MY");
// %t460 @TEXT("n130", key="name", size=0.75);
// &n130 @WIRE(mode="straight") {#X86:3 %t460:p};
// %t461 = $SUPPLY @ATTACH &vdd => @PLACE(584, -154);
// &vdd @WIRE(mode="straight") {#X86:4 %t461:p};
// %t462 = $GROUND @ATTACH &vss => @PLACE(584, -176);
// &vss @WIRE(mode="straight") {#X86:5 %t462:p};
// %t463 = $IO_PORT @ATTACH &n40 => @PLACE(614, -163) => @ORIENT("R0");
// %t463 @TEXT("n40", key="name", size=0.75);
// &n40 @WIRE(mode="straight") {#X87:1 %t463:p};
// %t464 = $IO_PORT @ATTACH &n111 => @PLACE(614, -167) => @ORIENT("R0");
// %t464 @TEXT("n111", key="name", size=0.75);
// &n111 @WIRE(mode="straight") {#X87:2 %t464:p};
// %t465 = $IO_PORT @ATTACH &n131 => @PLACE(635, -165) => @ORIENT("MY");
// %t465 @TEXT("n131", key="name", size=0.75);
// &n131 @WIRE(mode="straight") {#X87:3 %t465:p};
// %t466 = $SUPPLY @ATTACH &vdd => @PLACE(624, -154);
// &vdd @WIRE(mode="straight") {#X87:4 %t466:p};
// %t467 = $GROUND @ATTACH &vss => @PLACE(624, -176);
// &vss @WIRE(mode="straight") {#X87:5 %t467:p};
// %t468 = $IO_PORT @ATTACH &n16 => @PLACE(494, -198) => @ORIENT("R0");
// %t468 @TEXT("n16", key="name", size=0.75);
// &n16 @WIRE(mode="straight") {#X88:1 %t468:p};
// %t469 = $IO_PORT @ATTACH &n14 => @PLACE(494, -202) => @ORIENT("R0");
// %t469 @TEXT("n14", key="name", size=0.75);
// &n14 @WIRE(mode="straight") {#X88:2 %t469:p};
// %t470 = $IO_PORT @ATTACH &n132 => @PLACE(514, -200) => @ORIENT("MY");
// %t470 @TEXT("n132", key="name", size=0.75);
// &n132 @WIRE(mode="straight") {#X88:3 %t470:p};
// %t471 = $SUPPLY @ATTACH &vdd => @PLACE(504, -189);
// &vdd @WIRE(mode="straight") {#X88:4 %t471:p};
// %t472 = $GROUND @ATTACH &vss => @PLACE(504, -211);
// &vss @WIRE(mode="straight") {#X88:5 %t472:p};
// %t473 = $IO_PORT @ATTACH &n18 => @PLACE(534, -198) => @ORIENT("R0");
// %t473 @TEXT("n18", key="name", size=0.75);
// &n18 @WIRE(mode="straight") {#X89:1 %t473:p};
// %t474 = $IO_PORT @ATTACH &n113 => @PLACE(534, -202) => @ORIENT("R0");
// %t474 @TEXT("n113", key="name", size=0.75);
// &n113 @WIRE(mode="straight") {#X89:2 %t474:p};
// %t475 = $IO_PORT @ATTACH &n133 => @PLACE(554, -200) => @ORIENT("MY");
// %t475 @TEXT("n133", key="name", size=0.75);
// &n133 @WIRE(mode="straight") {#X89:3 %t475:p};
// %t476 = $SUPPLY @ATTACH &vdd => @PLACE(544, -189);
// &vdd @WIRE(mode="straight") {#X89:4 %t476:p};
// %t477 = $GROUND @ATTACH &vss => @PLACE(544, -211);
// &vss @WIRE(mode="straight") {#X89:5 %t477:p};
// %t478 = $IO_PORT @ATTACH &n25 => @PLACE(574, -198) => @ORIENT("R0");
// %t478 @TEXT("n25", key="name", size=0.75);
// &n25 @WIRE(mode="straight") {#X90:1 %t478:p};
// %t479 = $IO_PORT @ATTACH &n115 => @PLACE(574, -202) => @ORIENT("R0");
// %t479 @TEXT("n115", key="name", size=0.75);
// &n115 @WIRE(mode="straight") {#X90:2 %t479:p};
// %t480 = $IO_PORT @ATTACH &n117 => @PLACE(594, -200) => @ORIENT("MY");
// %t480 @TEXT("n117", key="name", size=0.75);
// &n117 @WIRE(mode="straight") {#X90:3 %t480:p};
// %t481 = $SUPPLY @ATTACH &vdd => @PLACE(584, -189);
// &vdd @WIRE(mode="straight") {#X90:4 %t481:p};
// %t482 = $GROUND @ATTACH &vss => @PLACE(584, -211);
// &vss @WIRE(mode="straight") {#X90:5 %t482:p};
// %t483 = $IO_PORT @ATTACH &n23 => @PLACE(614, -198) => @ORIENT("R0");
// %t483 @TEXT("n23", key="name", size=0.75);
// &n23 @WIRE(mode="straight") {#X91:1 %t483:p};
// %t484 = $IO_PORT @ATTACH &n21 => @PLACE(614, -202) => @ORIENT("R0");
// %t484 @TEXT("n21", key="name", size=0.75);
// &n21 @WIRE(mode="straight") {#X91:2 %t484:p};
// %t485 = $IO_PORT @ATTACH &n115 => @PLACE(635, -200) => @ORIENT("MY");
// %t485 @TEXT("n115", key="name", size=0.75);
// &n115 @WIRE(mode="straight") {#X91:3 %t485:p};
// %t486 = $SUPPLY @ATTACH &vdd => @PLACE(624, -189);
// &vdd @WIRE(mode="straight") {#X91:4 %t486:p};
// %t487 = $GROUND @ATTACH &vss => @PLACE(624, -211);
// &vss @WIRE(mode="straight") {#X91:5 %t487:p};
// %t488 = $IO_PORT @ATTACH &n134 => @PLACE(494, -233) => @ORIENT("R0");
// %t488 @TEXT("n134", key="name", size=0.75);
// &n134 @WIRE(mode="straight") {#X92:1 %t488:p};
// %t489 = $IO_PORT @ATTACH &n78 => @PLACE(494, -237) => @ORIENT("R0");
// %t489 @TEXT("n78", key="name", size=0.75);
// &n78 @WIRE(mode="straight") {#X92:2 %t489:p};
// %t490 = $IO_PORT @ATTACH &n71 => @PLACE(514, -235) => @ORIENT("MY");
// %t490 @TEXT("n71", key="name", size=0.75);
// &n71 @WIRE(mode="straight") {#X92:3 %t490:p};
// %t491 = $SUPPLY @ATTACH &vdd => @PLACE(504, -224);
// &vdd @WIRE(mode="straight") {#X92:4 %t491:p};
// %t492 = $GROUND @ATTACH &vss => @PLACE(504, -246);
// &vss @WIRE(mode="straight") {#X92:5 %t492:p};
// %t493 = $IO_PORT @ATTACH &range_error => @PLACE(534, -233) => @ORIENT("R0");
// %t493 @TEXT("range_error", key="name", size=0.75);
// &range_error @WIRE(mode="straight") {#X93:1 %t493:p};
// %t494 = $IO_PORT @ATTACH &qualified => @PLACE(534, -237) => @ORIENT("R0");
// %t494 @TEXT("qualified", key="name", size=0.75);
// &qualified @WIRE(mode="straight") {#X93:2 %t494:p};
// %t495 = $IO_PORT @ATTACH &n135 => @PLACE(554, -235) => @ORIENT("MY");
// %t495 @TEXT("n135", key="name", size=0.75);
// &n135 @WIRE(mode="straight") {#X93:3 %t495:p};
// %t496 = $SUPPLY @ATTACH &vdd => @PLACE(544, -224);
// &vdd @WIRE(mode="straight") {#X93:4 %t496:p};
// %t497 = $GROUND @ATTACH &vss => @PLACE(544, -246);
// &vss @WIRE(mode="straight") {#X93:5 %t497:p};
// %t498 = $IO_PORT @ATTACH &n93 => @PLACE(574, -233) => @ORIENT("R0");
// %t498 @TEXT("n93", key="name", size=0.75);
// &n93 @WIRE(mode="straight") {#X94:1 %t498:p};
// %t499 = $IO_PORT @ATTACH &n136 => @PLACE(574, -237) => @ORIENT("R0");
// %t499 @TEXT("n136", key="name", size=0.75);
// &n136 @WIRE(mode="straight") {#X94:2 %t499:p};
// %t500 = $IO_PORT @ATTACH &n137 => @PLACE(594, -235) => @ORIENT("MY");
// %t500 @TEXT("n137", key="name", size=0.75);
// &n137 @WIRE(mode="straight") {#X94:3 %t500:p};
// %t501 = $SUPPLY @ATTACH &vdd => @PLACE(584, -224);
// &vdd @WIRE(mode="straight") {#X94:4 %t501:p};
// %t502 = $GROUND @ATTACH &vss => @PLACE(584, -246);
// &vss @WIRE(mode="straight") {#X94:5 %t502:p};
// %t503 = $IO_PORT @ATTACH &n138 => @PLACE(614, -233) => @ORIENT("R0");
// %t503 @TEXT("n138", key="name", size=0.75);
// &n138 @WIRE(mode="straight") {#X95:1 %t503:p};
// %t504 = $IO_PORT @ATTACH &n135 => @PLACE(614, -237) => @ORIENT("R0");
// %t504 @TEXT("n135", key="name", size=0.75);
// &n135 @WIRE(mode="straight") {#X95:2 %t504:p};
// %t505 = $IO_PORT @ATTACH &n139 => @PLACE(635, -235) => @ORIENT("MY");
// %t505 @TEXT("n139", key="name", size=0.75);
// &n139 @WIRE(mode="straight") {#X95:3 %t505:p};
// %t506 = $SUPPLY @ATTACH &vdd => @PLACE(624, -224);
// &vdd @WIRE(mode="straight") {#X95:4 %t506:p};
// %t507 = $GROUND @ATTACH &vss => @PLACE(624, -246);
// &vss @WIRE(mode="straight") {#X95:5 %t507:p};
// %t508 = $IO_PORT @ATTACH &n139 => @PLACE(-11, -278) => @ORIENT("R0");
// %t508 @TEXT("n139", key="name", size=0.75);
// &n139 @WIRE(mode="straight") {#X96:1 %t508:p};
// %t509 = $IO_PORT @ATTACH &n137 => @PLACE(-11, -282) => @ORIENT("R0");
// %t509 @TEXT("n137", key="name", size=0.75);
// &n137 @WIRE(mode="straight") {#X96:2 %t509:p};
// %t510 = $IO_PORT @ATTACH &n134 => @PLACE(10, -280) => @ORIENT("MY");
// %t510 @TEXT("n134", key="name", size=0.75);
// &n134 @WIRE(mode="straight") {#X96:3 %t510:p};
// %t511 = $SUPPLY @ATTACH &vdd => @PLACE(0, -269);
// &vdd @WIRE(mode="straight") {#X96:4 %t511:p};
// %t512 = $GROUND @ATTACH &vss => @PLACE(0, -291);
// &vss @WIRE(mode="straight") {#X96:5 %t512:p};
// %t513 = $IO_PORT @ATTACH &n90 => @PLACE(30, -278) => @ORIENT("R0");
// %t513 @TEXT("n90", key="name", size=0.75);
// &n90 @WIRE(mode="straight") {#X97:1 %t513:p};
// %t514 = $IO_PORT @ATTACH &n96 => @PLACE(30, -282) => @ORIENT("R0");
// %t514 @TEXT("n96", key="name", size=0.75);
// &n96 @WIRE(mode="straight") {#X97:2 %t514:p};
// %t515 = $IO_PORT @ATTACH &n75 => @PLACE(50, -280) => @ORIENT("MY");
// %t515 @TEXT("n75", key="name", size=0.75);
// &n75 @WIRE(mode="straight") {#X97:3 %t515:p};
// %t516 = $SUPPLY @ATTACH &vdd => @PLACE(40, -269);
// &vdd @WIRE(mode="straight") {#X97:4 %t516:p};
// %t517 = $GROUND @ATTACH &vss => @PLACE(40, -291);
// &vss @WIRE(mode="straight") {#X97:5 %t517:p};
// %t518 = $IO_PORT @ATTACH &n140 => @PLACE(70, -278) => @ORIENT("R0");
// %t518 @TEXT("n140", key="name", size=0.75);
// &n140 @WIRE(mode="straight") {#X98:1 %t518:p};
// %t519 = $IO_PORT @ATTACH &n141 => @PLACE(70, -282) => @ORIENT("R0");
// %t519 @TEXT("n141", key="name", size=0.75);
// &n141 @WIRE(mode="straight") {#X98:2 %t519:p};
// %t520 = $IO_PORT @ATTACH &n142 => @PLACE(90, -280) => @ORIENT("MY");
// %t520 @TEXT("n142", key="name", size=0.75);
// &n142 @WIRE(mode="straight") {#X98:3 %t520:p};
// %t521 = $SUPPLY @ATTACH &vdd => @PLACE(80, -269);
// &vdd @WIRE(mode="straight") {#X98:4 %t521:p};
// %t522 = $GROUND @ATTACH &vss => @PLACE(80, -291);
// &vss @WIRE(mode="straight") {#X98:5 %t522:p};
// %t523 = $IO_PORT @ATTACH &n143 => @PLACE(110, -278) => @ORIENT("R0");
// %t523 @TEXT("n143", key="name", size=0.75);
// &n143 @WIRE(mode="straight") {#X99:1 %t523:p};
// %t524 = $IO_PORT @ATTACH &n75 => @PLACE(110, -282) => @ORIENT("R0");
// %t524 @TEXT("n75", key="name", size=0.75);
// &n75 @WIRE(mode="straight") {#X99:2 %t524:p};
// %t525 = $IO_PORT @ATTACH &n144 => @PLACE(130, -280) => @ORIENT("MY");
// %t525 @TEXT("n144", key="name", size=0.75);
// &n144 @WIRE(mode="straight") {#X99:3 %t525:p};
// %t526 = $SUPPLY @ATTACH &vdd => @PLACE(120, -269);
// &vdd @WIRE(mode="straight") {#X99:4 %t526:p};
// %t527 = $GROUND @ATTACH &vss => @PLACE(120, -291);
// &vss @WIRE(mode="straight") {#X99:5 %t527:p};
// %t528 = $IO_PORT @ATTACH &n142 => @PLACE(-11, -313) => @ORIENT("R0");
// %t528 @TEXT("n142", key="name", size=0.75);
// &n142 @WIRE(mode="straight") {#X100:1 %t528:p};
// %t529 = $IO_PORT @ATTACH &n144 => @PLACE(-11, -317) => @ORIENT("R0");
// %t529 @TEXT("n144", key="name", size=0.75);
// &n144 @WIRE(mode="straight") {#X100:2 %t529:p};
// %t530 = $IO_PORT @ATTACH &n145 => @PLACE(10, -315) => @ORIENT("MY");
// %t530 @TEXT("n145", key="name", size=0.75);
// &n145 @WIRE(mode="straight") {#X100:3 %t530:p};
// %t531 = $SUPPLY @ATTACH &vdd => @PLACE(0, -304);
// &vdd @WIRE(mode="straight") {#X100:4 %t531:p};
// %t532 = $GROUND @ATTACH &vss => @PLACE(0, -326);
// &vss @WIRE(mode="straight") {#X100:5 %t532:p};
// %t533 = $IO_PORT @ATTACH &n145 => @PLACE(30, -313) => @ORIENT("R0");
// %t533 @TEXT("n145", key="name", size=0.75);
// &n145 @WIRE(mode="straight") {#X101:1 %t533:p};
// %t534 = $IO_PORT @ATTACH &n146 => @PLACE(30, -317) => @ORIENT("R0");
// %t534 @TEXT("n146", key="name", size=0.75);
// &n146 @WIRE(mode="straight") {#X101:2 %t534:p};
// %t535 = $IO_PORT @ATTACH &n67 => @PLACE(50, -315) => @ORIENT("MY");
// %t535 @TEXT("n67", key="name", size=0.75);
// &n67 @WIRE(mode="straight") {#X101:3 %t535:p};
// %t536 = $SUPPLY @ATTACH &vdd => @PLACE(40, -304);
// &vdd @WIRE(mode="straight") {#X101:4 %t536:p};
// %t537 = $GROUND @ATTACH &vss => @PLACE(40, -326);
// &vss @WIRE(mode="straight") {#X101:5 %t537:p};
// %t538 = $IO_PORT @ATTACH &n147 => @PLACE(70, -313) => @ORIENT("R0");
// %t538 @TEXT("n147", key="name", size=0.75);
// &n147 @WIRE(mode="straight") {#X102:1 %t538:p};
// %t539 = $IO_PORT @ATTACH &n136 => @PLACE(70, -317) => @ORIENT("R0");
// %t539 @TEXT("n136", key="name", size=0.75);
// &n136 @WIRE(mode="straight") {#X102:2 %t539:p};
// %t540 = $IO_PORT @ATTACH &n148 => @PLACE(90, -315) => @ORIENT("MY");
// %t540 @TEXT("n148", key="name", size=0.75);
// &n148 @WIRE(mode="straight") {#X102:3 %t540:p};
// %t541 = $SUPPLY @ATTACH &vdd => @PLACE(80, -304);
// &vdd @WIRE(mode="straight") {#X102:4 %t541:p};
// %t542 = $GROUND @ATTACH &vss => @PLACE(80, -326);
// &vss @WIRE(mode="straight") {#X102:5 %t542:p};
// %t543 = $IO_PORT @ATTACH &n149 => @PLACE(110, -313) => @ORIENT("R0");
// %t543 @TEXT("n149", key="name", size=0.75);
// &n149 @WIRE(mode="straight") {#X103:1 %t543:p};
// %t544 = $IO_PORT @ATTACH &n148 => @PLACE(110, -317) => @ORIENT("R0");
// %t544 @TEXT("n148", key="name", size=0.75);
// &n148 @WIRE(mode="straight") {#X103:2 %t544:p};
// %t545 = $IO_PORT @ATTACH &n140 => @PLACE(130, -315) => @ORIENT("MY");
// %t545 @TEXT("n140", key="name", size=0.75);
// &n140 @WIRE(mode="straight") {#X103:3 %t545:p};
// %t546 = $SUPPLY @ATTACH &vdd => @PLACE(120, -304);
// &vdd @WIRE(mode="straight") {#X103:4 %t546:p};
// %t547 = $GROUND @ATTACH &vss => @PLACE(120, -326);
// &vss @WIRE(mode="straight") {#X103:5 %t547:p};
// %t548 = $IO_PORT @ATTACH &n90 => @PLACE(-11, -348) => @ORIENT("R0");
// %t548 @TEXT("n90", key="name", size=0.75);
// &n90 @WIRE(mode="straight") {#X104:1 %t548:p};
// %t549 = $IO_PORT @ATTACH &restart => @PLACE(-11, -352) => @ORIENT("R0");
// %t549 @TEXT("restart", key="name", size=0.75);
// &restart @WIRE(mode="straight") {#X104:2 %t549:p};
// %t550 = $IO_PORT @ATTACH &n149 => @PLACE(10, -350) => @ORIENT("MY");
// %t550 @TEXT("n149", key="name", size=0.75);
// &n149 @WIRE(mode="straight") {#X104:3 %t550:p};
// %t551 = $SUPPLY @ATTACH &vdd => @PLACE(0, -339);
// &vdd @WIRE(mode="straight") {#X104:4 %t551:p};
// %t552 = $GROUND @ATTACH &vss => @PLACE(0, -361);
// &vss @WIRE(mode="straight") {#X104:5 %t552:p};
// %t553 = $IO_PORT @ATTACH &n149 => @PLACE(30, -348) => @ORIENT("R0");
// %t553 @TEXT("n149", key="name", size=0.75);
// &n149 @WIRE(mode="straight") {#X105:1 %t553:p};
// %t554 = $IO_PORT @ATTACH &n150 => @PLACE(30, -352) => @ORIENT("R0");
// %t554 @TEXT("n150", key="name", size=0.75);
// &n150 @WIRE(mode="straight") {#X105:2 %t554:p};
// %t555 = $IO_PORT @ATTACH &n141 => @PLACE(50, -350) => @ORIENT("MY");
// %t555 @TEXT("n141", key="name", size=0.75);
// &n141 @WIRE(mode="straight") {#X105:3 %t555:p};
// %t556 = $SUPPLY @ATTACH &vdd => @PLACE(40, -339);
// &vdd @WIRE(mode="straight") {#X105:4 %t556:p};
// %t557 = $GROUND @ATTACH &vss => @PLACE(40, -361);
// &vss @WIRE(mode="straight") {#X105:5 %t557:p};
// %t558 = $IO_PORT @ATTACH &n90 => @PLACE(70, -348) => @ORIENT("R0");
// %t558 @TEXT("n90", key="name", size=0.75);
// &n90 @WIRE(mode="straight") {#X106:1 %t558:p};
// %t559 = $IO_PORT @ATTACH &qualified => @PLACE(70, -352) => @ORIENT("R0");
// %t559 @TEXT("qualified", key="name", size=0.75);
// &qualified @WIRE(mode="straight") {#X106:2 %t559:p};
// %t560 = $IO_PORT @ATTACH &n151 => @PLACE(90, -350) => @ORIENT("MY");
// %t560 @TEXT("n151", key="name", size=0.75);
// &n151 @WIRE(mode="straight") {#X106:3 %t560:p};
// %t561 = $SUPPLY @ATTACH &vdd => @PLACE(80, -339);
// &vdd @WIRE(mode="straight") {#X106:4 %t561:p};
// %t562 = $GROUND @ATTACH &vss => @PLACE(80, -361);
// &vss @WIRE(mode="straight") {#X106:5 %t562:p};
// %t563 = $IO_PORT @ATTACH &restart => @PLACE(110, -348) => @ORIENT("R0");
// %t563 @TEXT("restart", key="name", size=0.75);
// &restart @WIRE(mode="straight") {#X107:1 %t563:p};
// %t564 = $IO_PORT @ATTACH &n136 => @PLACE(110, -352) => @ORIENT("R0");
// %t564 @TEXT("n136", key="name", size=0.75);
// &n136 @WIRE(mode="straight") {#X107:2 %t564:p};
// %t565 = $IO_PORT @ATTACH &n152 => @PLACE(130, -350) => @ORIENT("MY");
// %t565 @TEXT("n152", key="name", size=0.75);
// &n152 @WIRE(mode="straight") {#X107:3 %t565:p};
// %t566 = $SUPPLY @ATTACH &vdd => @PLACE(120, -339);
// &vdd @WIRE(mode="straight") {#X107:4 %t566:p};
// %t567 = $GROUND @ATTACH &vss => @PLACE(120, -361);
// &vss @WIRE(mode="straight") {#X107:5 %t567:p};
// %t568 = $IO_PORT @ATTACH &n151 => @PLACE(-11, -383) => @ORIENT("R0");
// %t568 @TEXT("n151", key="name", size=0.75);
// &n151 @WIRE(mode="straight") {#X108:1 %t568:p};
// %t569 = $IO_PORT @ATTACH &n152 => @PLACE(-11, -387) => @ORIENT("R0");
// %t569 @TEXT("n152", key="name", size=0.75);
// &n152 @WIRE(mode="straight") {#X108:2 %t569:p};
// %t570 = $IO_PORT @ATTACH &n143 => @PLACE(10, -385) => @ORIENT("MY");
// %t570 @TEXT("n143", key="name", size=0.75);
// &n143 @WIRE(mode="straight") {#X108:3 %t570:p};
// %t571 = $SUPPLY @ATTACH &vdd => @PLACE(0, -374);
// &vdd @WIRE(mode="straight") {#X108:4 %t571:p};
// %t572 = $GROUND @ATTACH &vss => @PLACE(0, -396);
// &vss @WIRE(mode="straight") {#X108:5 %t572:p};
// %t573 = $IO_PORT @ATTACH &n90 => @PLACE(30, -383) => @ORIENT("R0");
// %t573 @TEXT("n90", key="name", size=0.75);
// &n90 @WIRE(mode="straight") {#X109:1 %t573:p};
// %t574 = $IO_PORT @ATTACH &fll_enable => @PLACE(30, -387) => @ORIENT("R0");
// %t574 @TEXT("fll_enable", key="name", size=0.75);
// &fll_enable @WIRE(mode="straight") {#X109:2 %t574:p};
// %t575 = $IO_PORT @ATTACH &n153 => @PLACE(50, -385) => @ORIENT("MY");
// %t575 @TEXT("n153", key="name", size=0.75);
// &n153 @WIRE(mode="straight") {#X109:3 %t575:p};
// %t576 = $SUPPLY @ATTACH &vdd => @PLACE(40, -374);
// &vdd @WIRE(mode="straight") {#X109:4 %t576:p};
// %t577 = $GROUND @ATTACH &vss => @PLACE(40, -396);
// &vss @WIRE(mode="straight") {#X109:5 %t577:p};
// %t578 = $IO_PORT @ATTACH &n153 => @PLACE(70, -383) => @ORIENT("R0");
// %t578 @TEXT("n153", key="name", size=0.75);
// &n153 @WIRE(mode="straight") {#X110:1 %t578:p};
// %t579 = $IO_PORT @ATTACH &restart => @PLACE(70, -387) => @ORIENT("R0");
// %t579 @TEXT("restart", key="name", size=0.75);
// &restart @WIRE(mode="straight") {#X110:2 %t579:p};
// %t580 = $IO_PORT @ATTACH &n146 => @PLACE(90, -385) => @ORIENT("MY");
// %t580 @TEXT("n146", key="name", size=0.75);
// &n146 @WIRE(mode="straight") {#X110:3 %t580:p};
// %t581 = $SUPPLY @ATTACH &vdd => @PLACE(80, -374);
// &vdd @WIRE(mode="straight") {#X110:4 %t581:p};
// %t582 = $GROUND @ATTACH &vss => @PLACE(80, -396);
// &vss @WIRE(mode="straight") {#X110:5 %t582:p};
// %t583 = $IO_PORT @ATTACH &n90 => @PLACE(110, -383) => @ORIENT("R0");
// %t583 @TEXT("n90", key="name", size=0.75);
// &n90 @WIRE(mode="straight") {#X111:1 %t583:p};
// %t584 = $IO_PORT @ATTACH &range_error => @PLACE(110, -387) => @ORIENT("R0");
// %t584 @TEXT("range_error", key="name", size=0.75);
// &range_error @WIRE(mode="straight") {#X111:2 %t584:p};
// %t585 = $IO_PORT @ATTACH &n81 => @PLACE(130, -385) => @ORIENT("MY");
// %t585 @TEXT("n81", key="name", size=0.75);
// &n81 @WIRE(mode="straight") {#X111:3 %t585:p};
// %t586 = $SUPPLY @ATTACH &vdd => @PLACE(120, -374);
// &vdd @WIRE(mode="straight") {#X111:4 %t586:p};
// %t587 = $GROUND @ATTACH &vss => @PLACE(120, -396);
// &vss @WIRE(mode="straight") {#X111:5 %t587:p};
// %t588 = $IO_PORT @ATTACH &n81 => @PLACE(-11, -418) => @ORIENT("R0");
// %t588 @TEXT("n81", key="name", size=0.75);
// &n81 @WIRE(mode="straight") {#X112:1 %t588:p};
// %t589 = $IO_PORT @ATTACH &n95 => @PLACE(-11, -422) => @ORIENT("R0");
// %t589 @TEXT("n95", key="name", size=0.75);
// &n95 @WIRE(mode="straight") {#X112:2 %t589:p};
// %t590 = $IO_PORT @ATTACH &n78 => @PLACE(10, -420) => @ORIENT("MY");
// %t590 @TEXT("n78", key="name", size=0.75);
// &n78 @WIRE(mode="straight") {#X112:3 %t590:p};
// %t591 = $SUPPLY @ATTACH &vdd => @PLACE(0, -409);
// &vdd @WIRE(mode="straight") {#X112:4 %t591:p};
// %t592 = $GROUND @ATTACH &vss => @PLACE(0, -431);
// &vss @WIRE(mode="straight") {#X112:5 %t592:p};
// %t593 = $IO_PORT @ATTACH &n78 => @PLACE(30, -418) => @ORIENT("R0");
// %t593 @TEXT("n78", key="name", size=0.75);
// &n78 @WIRE(mode="straight") {#X113:1 %t593:p};
// %t594 = $IO_PORT @ATTACH &n154 => @PLACE(30, -422) => @ORIENT("R0");
// %t594 @TEXT("n154", key="name", size=0.75);
// &n154 @WIRE(mode="straight") {#X113:2 %t594:p};
// %t595 = $IO_PORT @ATTACH &n61 => @PLACE(50, -420) => @ORIENT("MY");
// %t595 @TEXT("n61", key="name", size=0.75);
// &n61 @WIRE(mode="straight") {#X113:3 %t595:p};
// %t596 = $SUPPLY @ATTACH &vdd => @PLACE(40, -409);
// &vdd @WIRE(mode="straight") {#X113:4 %t596:p};
// %t597 = $GROUND @ATTACH &vss => @PLACE(40, -431);
// &vss @WIRE(mode="straight") {#X113:5 %t597:p};
// %t598 = $IO_PORT @ATTACH &n90 => @PLACE(70, -418) => @ORIENT("R0");
// %t598 @TEXT("n90", key="name", size=0.75);
// &n90 @WIRE(mode="straight") {#X114:1 %t598:p};
// %t599 = $IO_PORT @ATTACH &n92 => @PLACE(70, -422) => @ORIENT("R0");
// %t599 @TEXT("n92", key="name", size=0.75);
// &n92 @WIRE(mode="straight") {#X114:2 %t599:p};
// %t600 = $IO_PORT @ATTACH &n138 => @PLACE(90, -420) => @ORIENT("MY");
// %t600 @TEXT("n138", key="name", size=0.75);
// &n138 @WIRE(mode="straight") {#X114:3 %t600:p};
// %t601 = $SUPPLY @ATTACH &vdd => @PLACE(80, -409);
// &vdd @WIRE(mode="straight") {#X114:4 %t601:p};
// %t602 = $GROUND @ATTACH &vss => @PLACE(80, -431);
// &vss @WIRE(mode="straight") {#X114:5 %t602:p};
// %t603 = $IO_PORT @ATTACH &range_error => @PLACE(110, -418) => @ORIENT("R0");
// %t603 @TEXT("range_error", key="name", size=0.75);
// &range_error @WIRE(mode="straight") {#X115:1 %t603:p};
// %t604 = $IO_PORT @ATTACH &n91 => @PLACE(110, -422) => @ORIENT("R0");
// %t604 @TEXT("n91", key="name", size=0.75);
// &n91 @WIRE(mode="straight") {#X115:2 %t604:p};
// %t605 = $IO_PORT @ATTACH &n155 => @PLACE(130, -420) => @ORIENT("MY");
// %t605 @TEXT("n155", key="name", size=0.75);
// &n155 @WIRE(mode="straight") {#X115:3 %t605:p};
// %t606 = $SUPPLY @ATTACH &vdd => @PLACE(120, -409);
// &vdd @WIRE(mode="straight") {#X115:4 %t606:p};
// %t607 = $GROUND @ATTACH &vss => @PLACE(120, -431);
// &vss @WIRE(mode="straight") {#X115:5 %t607:p};
// %t608 = $IO_PORT @ATTACH &n94 => @PLACE(-11, -453) => @ORIENT("R0");
// %t608 @TEXT("n94", key="name", size=0.75);
// &n94 @WIRE(mode="straight") {#X116:1 %t608:p};
// %t609 = $IO_PORT @ATTACH &n136 => @PLACE(-11, -457) => @ORIENT("R0");
// %t609 @TEXT("n136", key="name", size=0.75);
// &n136 @WIRE(mode="straight") {#X116:2 %t609:p};
// %t610 = $IO_PORT @ATTACH &n150 => @PLACE(10, -455) => @ORIENT("MY");
// %t610 @TEXT("n150", key="name", size=0.75);
// &n150 @WIRE(mode="straight") {#X116:3 %t610:p};
// %t611 = $SUPPLY @ATTACH &vdd => @PLACE(0, -444);
// &vdd @WIRE(mode="straight") {#X116:4 %t611:p};
// %t612 = $GROUND @ATTACH &vss => @PLACE(0, -466);
// &vss @WIRE(mode="straight") {#X116:5 %t612:p};
// %t613 = $IO_PORT @ATTACH &n138 => @PLACE(30, -453) => @ORIENT("R0");
// %t613 @TEXT("n138", key="name", size=0.75);
// &n138 @WIRE(mode="straight") {#X117:1 %t613:p};
// %t614 = $IO_PORT @ATTACH &n155 => @PLACE(30, -457) => @ORIENT("R0");
// %t614 @TEXT("n155", key="name", size=0.75);
// &n155 @WIRE(mode="straight") {#X117:2 %t614:p};
// %t615 = $IO_PORT @ATTACH &n156 => @PLACE(50, -455) => @ORIENT("MY");
// %t615 @TEXT("n156", key="name", size=0.75);
// &n156 @WIRE(mode="straight") {#X117:3 %t615:p};
// %t616 = $SUPPLY @ATTACH &vdd => @PLACE(40, -444);
// &vdd @WIRE(mode="straight") {#X117:4 %t616:p};
// %t617 = $GROUND @ATTACH &vss => @PLACE(40, -466);
// &vss @WIRE(mode="straight") {#X117:5 %t617:p};
// %t618 = $IO_PORT @ATTACH &n156 => @PLACE(70, -453) => @ORIENT("R0");
// %t618 @TEXT("n156", key="name", size=0.75);
// &n156 @WIRE(mode="straight") {#X118:1 %t618:p};
// %t619 = $IO_PORT @ATTACH &n150 => @PLACE(70, -457) => @ORIENT("R0");
// %t619 @TEXT("n150", key="name", size=0.75);
// &n150 @WIRE(mode="straight") {#X118:2 %t619:p};
// %t620 = $IO_PORT @ATTACH &n154 => @PLACE(90, -455) => @ORIENT("MY");
// %t620 @TEXT("n154", key="name", size=0.75);
// &n154 @WIRE(mode="straight") {#X118:3 %t620:p};
// %t621 = $SUPPLY @ATTACH &vdd => @PLACE(80, -444);
// &vdd @WIRE(mode="straight") {#X118:4 %t621:p};
// %t622 = $GROUND @ATTACH &vss => @PLACE(80, -466);
// &vss @WIRE(mode="straight") {#X118:5 %t622:p};
// %t623 = $IO_PORT @ATTACH &n89 => @PLACE(110, -453) => @ORIENT("R0");
// %t623 @TEXT("n89", key="name", size=0.75);
// &n89 @WIRE(mode="straight") {#X119:1 %t623:p};
// %t624 = $IO_PORT @ATTACH &n88 => @PLACE(110, -457) => @ORIENT("R0");
// %t624 @TEXT("n88", key="name", size=0.75);
// &n88 @WIRE(mode="straight") {#X119:2 %t624:p};
// %t625 = $IO_PORT @ATTACH &n157 => @PLACE(130, -455) => @ORIENT("MY");
// %t625 @TEXT("n157", key="name", size=0.75);
// &n157 @WIRE(mode="straight") {#X119:3 %t625:p};
// %t626 = $SUPPLY @ATTACH &vdd => @PLACE(120, -444);
// &vdd @WIRE(mode="straight") {#X119:4 %t626:p};
// %t627 = $GROUND @ATTACH &vss => @PLACE(120, -466);
// &vss @WIRE(mode="straight") {#X119:5 %t627:p};
// %t628 = $IO_PORT @ATTACH &n87 => @PLACE(158, -278) => @ORIENT("R0");
// %t628 @TEXT("n87", key="name", size=0.75);
// &n87 @WIRE(mode="straight") {#X120:1 %t628:p};
// %t629 = $IO_PORT @ATTACH &n27 => @PLACE(158, -282) => @ORIENT("R0");
// %t629 @TEXT("n27", key="name", size=0.75);
// &n27 @WIRE(mode="straight") {#X120:2 %t629:p};
// %t630 = $IO_PORT @ATTACH &n158 => @PLACE(178, -280) => @ORIENT("MY");
// %t630 @TEXT("n158", key="name", size=0.75);
// &n158 @WIRE(mode="straight") {#X120:3 %t630:p};
// %t631 = $SUPPLY @ATTACH &vdd => @PLACE(168, -269);
// &vdd @WIRE(mode="straight") {#X120:4 %t631:p};
// %t632 = $GROUND @ATTACH &vss => @PLACE(168, -291);
// &vss @WIRE(mode="straight") {#X120:5 %t632:p};
// %t633 = $IO_PORT @ATTACH &n157 => @PLACE(198, -278) => @ORIENT("R0");
// %t633 @TEXT("n157", key="name", size=0.75);
// &n157 @WIRE(mode="straight") {#X121:1 %t633:p};
// %t634 = $IO_PORT @ATTACH &n158 => @PLACE(198, -282) => @ORIENT("R0");
// %t634 @TEXT("n158", key="name", size=0.75);
// &n158 @WIRE(mode="straight") {#X121:2 %t634:p};
// %t635 = $IO_PORT @ATTACH &n159 => @PLACE(218, -280) => @ORIENT("MY");
// %t635 @TEXT("n159", key="name", size=0.75);
// &n159 @WIRE(mode="straight") {#X121:3 %t635:p};
// %t636 = $SUPPLY @ATTACH &vdd => @PLACE(208, -269);
// &vdd @WIRE(mode="straight") {#X121:4 %t636:p};
// %t637 = $GROUND @ATTACH &vss => @PLACE(208, -291);
// &vss @WIRE(mode="straight") {#X121:5 %t637:p};
// %t638 = $IO_PORT @ATTACH &n82 => @PLACE(238, -278) => @ORIENT("R0");
// %t638 @TEXT("n82", key="name", size=0.75);
// &n82 @WIRE(mode="straight") {#X122:1 %t638:p};
// %t639 = $IO_PORT @ATTACH &n160 => @PLACE(238, -282) => @ORIENT("R0");
// %t639 @TEXT("n160", key="name", size=0.75);
// &n160 @WIRE(mode="straight") {#X122:2 %t639:p};
// %t640 = $IO_PORT @ATTACH &n161 => @PLACE(258, -280) => @ORIENT("MY");
// %t640 @TEXT("n161", key="name", size=0.75);
// &n161 @WIRE(mode="straight") {#X122:3 %t640:p};
// %t641 = $SUPPLY @ATTACH &vdd => @PLACE(248, -269);
// &vdd @WIRE(mode="straight") {#X122:4 %t641:p};
// %t642 = $GROUND @ATTACH &vss => @PLACE(248, -291);
// &vss @WIRE(mode="straight") {#X122:5 %t642:p};
// %t643 = $IO_PORT @ATTACH &n161 => @PLACE(278, -278) => @ORIENT("R0");
// %t643 @TEXT("n161", key="name", size=0.75);
// &n161 @WIRE(mode="straight") {#X123:1 %t643:p};
// %t644 = $IO_PORT @ATTACH &n18 => @PLACE(278, -282) => @ORIENT("R0");
// %t644 @TEXT("n18", key="name", size=0.75);
// &n18 @WIRE(mode="straight") {#X123:2 %t644:p};
// %t645 = $IO_PORT @ATTACH &n162 => @PLACE(298, -280) => @ORIENT("MY");
// %t645 @TEXT("n162", key="name", size=0.75);
// &n162 @WIRE(mode="straight") {#X123:3 %t645:p};
// %t646 = $SUPPLY @ATTACH &vdd => @PLACE(288, -269);
// &vdd @WIRE(mode="straight") {#X123:4 %t646:p};
// %t647 = $GROUND @ATTACH &vss => @PLACE(288, -291);
// &vss @WIRE(mode="straight") {#X123:5 %t647:p};
// %t648 = $IO_PORT @ATTACH &n84 => @PLACE(158, -313) => @ORIENT("R0");
// %t648 @TEXT("n84", key="name", size=0.75);
// &n84 @WIRE(mode="straight") {#X124:1 %t648:p};
// %t649 = $IO_PORT @ATTACH &n163 => @PLACE(158, -317) => @ORIENT("R0");
// %t649 @TEXT("n163", key="name", size=0.75);
// &n163 @WIRE(mode="straight") {#X124:2 %t649:p};
// %t650 = $IO_PORT @ATTACH &n164 => @PLACE(178, -315) => @ORIENT("MY");
// %t650 @TEXT("n164", key="name", size=0.75);
// &n164 @WIRE(mode="straight") {#X124:3 %t650:p};
// %t651 = $SUPPLY @ATTACH &vdd => @PLACE(168, -304);
// &vdd @WIRE(mode="straight") {#X124:4 %t651:p};
// %t652 = $GROUND @ATTACH &vss => @PLACE(168, -326);
// &vss @WIRE(mode="straight") {#X124:5 %t652:p};
// %t653 = $IO_PORT @ATTACH &n165 => @PLACE(198, -313) => @ORIENT("R0");
// %t653 @TEXT("n165", key="name", size=0.75);
// &n165 @WIRE(mode="straight") {#X125:1 %t653:p};
// %t654 = $IO_PORT @ATTACH &n166 => @PLACE(198, -317) => @ORIENT("R0");
// %t654 @TEXT("n166", key="name", size=0.75);
// &n166 @WIRE(mode="straight") {#X125:2 %t654:p};
// %t655 = $IO_PORT @ATTACH &n167 => @PLACE(218, -315) => @ORIENT("MY");
// %t655 @TEXT("n167", key="name", size=0.75);
// &n167 @WIRE(mode="straight") {#X125:3 %t655:p};
// %t656 = $SUPPLY @ATTACH &vdd => @PLACE(208, -304);
// &vdd @WIRE(mode="straight") {#X125:4 %t656:p};
// %t657 = $GROUND @ATTACH &vss => @PLACE(208, -326);
// &vss @WIRE(mode="straight") {#X125:5 %t657:p};
// %t658 = $IO_PORT @ATTACH &n168 => @PLACE(238, -313) => @ORIENT("R0");
// %t658 @TEXT("n168", key="name", size=0.75);
// &n168 @WIRE(mode="straight") {#X126:1 %t658:p};
// %t659 = $IO_PORT @ATTACH &n169 => @PLACE(238, -317) => @ORIENT("R0");
// %t659 @TEXT("n169", key="name", size=0.75);
// &n169 @WIRE(mode="straight") {#X126:2 %t659:p};
// %t660 = $IO_PORT @ATTACH &n170 => @PLACE(258, -315) => @ORIENT("MY");
// %t660 @TEXT("n170", key="name", size=0.75);
// &n170 @WIRE(mode="straight") {#X126:3 %t660:p};
// %t661 = $SUPPLY @ATTACH &vdd => @PLACE(248, -304);
// &vdd @WIRE(mode="straight") {#X126:4 %t661:p};
// %t662 = $GROUND @ATTACH &vss => @PLACE(248, -326);
// &vss @WIRE(mode="straight") {#X126:5 %t662:p};
// %t663 = $IO_PORT @ATTACH &n171 => @PLACE(278, -313) => @ORIENT("R0");
// %t663 @TEXT("n171", key="name", size=0.75);
// &n171 @WIRE(mode="straight") {#X127:1 %t663:p};
// %t664 = $IO_PORT @ATTACH &n172 => @PLACE(278, -317) => @ORIENT("R0");
// %t664 @TEXT("n172", key="name", size=0.75);
// &n172 @WIRE(mode="straight") {#X127:2 %t664:p};
// %t665 = $IO_PORT @ATTACH &n173 => @PLACE(298, -315) => @ORIENT("MY");
// %t665 @TEXT("n173", key="name", size=0.75);
// &n173 @WIRE(mode="straight") {#X127:3 %t665:p};
// %t666 = $SUPPLY @ATTACH &vdd => @PLACE(288, -304);
// &vdd @WIRE(mode="straight") {#X127:4 %t666:p};
// %t667 = $GROUND @ATTACH &vss => @PLACE(288, -326);
// &vss @WIRE(mode="straight") {#X127:5 %t667:p};
// %t668 = $IO_PORT @ATTACH &n164 => @PLACE(158, -348) => @ORIENT("R0");
// %t668 @TEXT("n164", key="name", size=0.75);
// &n164 @WIRE(mode="straight") {#X128:1 %t668:p};
// %t669 = $IO_PORT @ATTACH &n167 => @PLACE(158, -352) => @ORIENT("R0");
// %t669 @TEXT("n167", key="name", size=0.75);
// &n167 @WIRE(mode="straight") {#X128:2 %t669:p};
// %t670 = $IO_PORT @ATTACH &n174 => @PLACE(178, -350) => @ORIENT("MY");
// %t670 @TEXT("n174", key="name", size=0.75);
// &n174 @WIRE(mode="straight") {#X128:3 %t670:p};
// %t671 = $SUPPLY @ATTACH &vdd => @PLACE(168, -339);
// &vdd @WIRE(mode="straight") {#X128:4 %t671:p};
// %t672 = $GROUND @ATTACH &vss => @PLACE(168, -361);
// &vss @WIRE(mode="straight") {#X128:5 %t672:p};
// %t673 = $IO_PORT @ATTACH &n170 => @PLACE(198, -348) => @ORIENT("R0");
// %t673 @TEXT("n170", key="name", size=0.75);
// &n170 @WIRE(mode="straight") {#X129:1 %t673:p};
// %t674 = $IO_PORT @ATTACH &n173 => @PLACE(198, -352) => @ORIENT("R0");
// %t674 @TEXT("n173", key="name", size=0.75);
// &n173 @WIRE(mode="straight") {#X129:2 %t674:p};
// %t675 = $IO_PORT @ATTACH &n175 => @PLACE(218, -350) => @ORIENT("MY");
// %t675 @TEXT("n175", key="name", size=0.75);
// &n175 @WIRE(mode="straight") {#X129:3 %t675:p};
// %t676 = $SUPPLY @ATTACH &vdd => @PLACE(208, -339);
// &vdd @WIRE(mode="straight") {#X129:4 %t676:p};
// %t677 = $GROUND @ATTACH &vss => @PLACE(208, -361);
// &vss @WIRE(mode="straight") {#X129:5 %t677:p};
// %t678 = $IO_PORT @ATTACH &n174 => @PLACE(238, -348) => @ORIENT("R0");
// %t678 @TEXT("n174", key="name", size=0.75);
// &n174 @WIRE(mode="straight") {#X130:1 %t678:p};
// %t679 = $IO_PORT @ATTACH &n175 => @PLACE(238, -352) => @ORIENT("R0");
// %t679 @TEXT("n175", key="name", size=0.75);
// &n175 @WIRE(mode="straight") {#X130:2 %t679:p};
// %t680 = $IO_PORT @ATTACH &n176 => @PLACE(258, -350) => @ORIENT("MY");
// %t680 @TEXT("n176", key="name", size=0.75);
// &n176 @WIRE(mode="straight") {#X130:3 %t680:p};
// %t681 = $SUPPLY @ATTACH &vdd => @PLACE(248, -339);
// &vdd @WIRE(mode="straight") {#X130:4 %t681:p};
// %t682 = $GROUND @ATTACH &vss => @PLACE(248, -361);
// &vss @WIRE(mode="straight") {#X130:5 %t682:p};
// %t683 = $IO_PORT @ATTACH &n176 => @PLACE(278, -348) => @ORIENT("R0");
// %t683 @TEXT("n176", key="name", size=0.75);
// &n176 @WIRE(mode="straight") {#X131:1 %t683:p};
// %t684 = $IO_PORT @ATTACH &n86 => @PLACE(278, -352) => @ORIENT("R0");
// %t684 @TEXT("n86", key="name", size=0.75);
// &n86 @WIRE(mode="straight") {#X131:2 %t684:p};
// %t685 = $IO_PORT @ATTACH &n177 => @PLACE(298, -350) => @ORIENT("MY");
// %t685 @TEXT("n177", key="name", size=0.75);
// &n177 @WIRE(mode="straight") {#X131:3 %t685:p};
// %t686 = $SUPPLY @ATTACH &vdd => @PLACE(288, -339);
// &vdd @WIRE(mode="straight") {#X131:4 %t686:p};
// %t687 = $GROUND @ATTACH &vss => @PLACE(288, -361);
// &vss @WIRE(mode="straight") {#X131:5 %t687:p};
// %t688 = $IO_PORT @ATTACH &n83 => @PLACE(158, -383) => @ORIENT("R0");
// %t688 @TEXT("n83", key="name", size=0.75);
// &n83 @WIRE(mode="straight") {#X132:1 %t688:p};
// %t689 = $IO_PORT @ATTACH &n178 => @PLACE(158, -387) => @ORIENT("R0");
// %t689 @TEXT("n178", key="name", size=0.75);
// &n178 @WIRE(mode="straight") {#X132:2 %t689:p};
// %t690 = $IO_PORT @ATTACH &n179 => @PLACE(178, -385) => @ORIENT("MY");
// %t690 @TEXT("n179", key="name", size=0.75);
// &n179 @WIRE(mode="straight") {#X132:3 %t690:p};
// %t691 = $SUPPLY @ATTACH &vdd => @PLACE(168, -374);
// &vdd @WIRE(mode="straight") {#X132:4 %t691:p};
// %t692 = $GROUND @ATTACH &vss => @PLACE(168, -396);
// &vss @WIRE(mode="straight") {#X132:5 %t692:p};
// %t693 = $IO_PORT @ATTACH &n180 => @PLACE(198, -383) => @ORIENT("R0");
// %t693 @TEXT("n180", key="name", size=0.75);
// &n180 @WIRE(mode="straight") {#X133:1 %t693:p};
// %t694 = $IO_PORT @ATTACH &n85 => @PLACE(198, -387) => @ORIENT("R0");
// %t694 @TEXT("n85", key="name", size=0.75);
// &n85 @WIRE(mode="straight") {#X133:2 %t694:p};
// %t695 = $IO_PORT @ATTACH &n181 => @PLACE(218, -385) => @ORIENT("MY");
// %t695 @TEXT("n181", key="name", size=0.75);
// &n181 @WIRE(mode="straight") {#X133:3 %t695:p};
// %t696 = $SUPPLY @ATTACH &vdd => @PLACE(208, -374);
// &vdd @WIRE(mode="straight") {#X133:4 %t696:p};
// %t697 = $GROUND @ATTACH &vss => @PLACE(208, -396);
// &vss @WIRE(mode="straight") {#X133:5 %t697:p};
// %t698 = $IO_PORT @ATTACH &n182 => @PLACE(238, -383) => @ORIENT("R0");
// %t698 @TEXT("n182", key="name", size=0.75);
// &n182 @WIRE(mode="straight") {#X134:1 %t698:p};
// %t699 = $IO_PORT @ATTACH &n40 => @PLACE(238, -387) => @ORIENT("R0");
// %t699 @TEXT("n40", key="name", size=0.75);
// &n40 @WIRE(mode="straight") {#X134:2 %t699:p};
// %t700 = $IO_PORT @ATTACH &n183 => @PLACE(258, -385) => @ORIENT("MY");
// %t700 @TEXT("n183", key="name", size=0.75);
// &n183 @WIRE(mode="straight") {#X134:3 %t700:p};
// %t701 = $SUPPLY @ATTACH &vdd => @PLACE(248, -374);
// &vdd @WIRE(mode="straight") {#X134:4 %t701:p};
// %t702 = $GROUND @ATTACH &vss => @PLACE(248, -396);
// &vss @WIRE(mode="straight") {#X134:5 %t702:p};
// %t703 = $IO_PORT @ATTACH &n179 => @PLACE(278, -383) => @ORIENT("R0");
// %t703 @TEXT("n179", key="name", size=0.75);
// &n179 @WIRE(mode="straight") {#X135:1 %t703:p};
// %t704 = $IO_PORT @ATTACH &n181 => @PLACE(278, -387) => @ORIENT("R0");
// %t704 @TEXT("n181", key="name", size=0.75);
// &n181 @WIRE(mode="straight") {#X135:2 %t704:p};
// %t705 = $IO_PORT @ATTACH &n184 => @PLACE(298, -385) => @ORIENT("MY");
// %t705 @TEXT("n184", key="name", size=0.75);
// &n184 @WIRE(mode="straight") {#X135:3 %t705:p};
// %t706 = $SUPPLY @ATTACH &vdd => @PLACE(288, -374);
// &vdd @WIRE(mode="straight") {#X135:4 %t706:p};
// %t707 = $GROUND @ATTACH &vss => @PLACE(288, -396);
// &vss @WIRE(mode="straight") {#X135:5 %t707:p};
// %t708 = $IO_PORT @ATTACH &n184 => @PLACE(158, -418) => @ORIENT("R0");
// %t708 @TEXT("n184", key="name", size=0.75);
// &n184 @WIRE(mode="straight") {#X136:1 %t708:p};
// %t709 = $IO_PORT @ATTACH &n183 => @PLACE(158, -422) => @ORIENT("R0");
// %t709 @TEXT("n183", key="name", size=0.75);
// &n183 @WIRE(mode="straight") {#X136:2 %t709:p};
// %t710 = $IO_PORT @ATTACH &n185 => @PLACE(178, -420) => @ORIENT("MY");
// %t710 @TEXT("n185", key="name", size=0.75);
// &n185 @WIRE(mode="straight") {#X136:3 %t710:p};
// %t711 = $SUPPLY @ATTACH &vdd => @PLACE(168, -409);
// &vdd @WIRE(mode="straight") {#X136:4 %t711:p};
// %t712 = $GROUND @ATTACH &vss => @PLACE(168, -431);
// &vss @WIRE(mode="straight") {#X136:5 %t712:p};
// %t713 = $IO_PORT @ATTACH &reset => @PLACE(198, -420) => @ORIENT("R0");
// %t713 @TEXT("reset", key="name", size=0.75);
// &reset @WIRE(mode="straight") {#X137:1 %t713:p};
// %t714 = $IO_PORT @ATTACH &n186 => @PLACE(218, -420) => @ORIENT("MY");
// %t714 @TEXT("n186", key="name", size=0.75);
// &n186 @WIRE(mode="straight") {#X137:2 %t714:p};
// %t715 = $SUPPLY @ATTACH &vdd => @PLACE(208, -411);
// &vdd @WIRE(mode="straight") {#X137:3 %t715:p};
// %t716 = $GROUND @ATTACH &vss => @PLACE(208, -429);
// &vss @WIRE(mode="straight") {#X137:4 %t716:p};
// %t717 = $IO_PORT @ATTACH &n177 => @PLACE(238, -420) => @ORIENT("R0");
// %t717 @TEXT("n177", key="name", size=0.75);
// &n177 @WIRE(mode="straight") {#X138:1 %t717:p};
// %t718 = $IO_PORT @ATTACH &n187 => @PLACE(258, -420) => @ORIENT("MY");
// %t718 @TEXT("n187", key="name", size=0.75);
// &n187 @WIRE(mode="straight") {#X138:2 %t718:p};
// %t719 = $SUPPLY @ATTACH &vdd => @PLACE(248, -411);
// &vdd @WIRE(mode="straight") {#X138:3 %t719:p};
// %t720 = $GROUND @ATTACH &vss => @PLACE(248, -429);
// &vss @WIRE(mode="straight") {#X138:4 %t720:p};
// %t721 = $IO_PORT @ATTACH &n188 => @PLACE(278, -420) => @ORIENT("R0");
// %t721 @TEXT("n188", key="name", size=0.75);
// &n188 @WIRE(mode="straight") {#X139:1 %t721:p};
// %t722 = $IO_PORT @ATTACH &n189 => @PLACE(298, -420) => @ORIENT("MY");
// %t722 @TEXT("n189", key="name", size=0.75);
// &n189 @WIRE(mode="straight") {#X139:2 %t722:p};
// %t723 = $SUPPLY @ATTACH &vdd => @PLACE(288, -411);
// &vdd @WIRE(mode="straight") {#X139:3 %t723:p};
// %t724 = $GROUND @ATTACH &vss => @PLACE(288, -429);
// &vss @WIRE(mode="straight") {#X139:4 %t724:p};
// %t725 = $IO_PORT @ATTACH &phase_good => @PLACE(158, -453) => @ORIENT("R0");
// %t725 @TEXT("phase_good", key="name", size=0.75);
// &phase_good @WIRE(mode="straight") {#X140:1 %t725:p};
// %t726 = $IO_PORT @ATTACH &frequency_good => @PLACE(158, -457) => @ORIENT("R0");
// %t726 @TEXT("frequency_good", key="name", size=0.75);
// &frequency_good @WIRE(mode="straight") {#X140:2 %t726:p};
// %t727 = $IO_PORT @ATTACH &n93 => @PLACE(178, -455) => @ORIENT("MY");
// %t727 @TEXT("n93", key="name", size=0.75);
// &n93 @WIRE(mode="straight") {#X140:3 %t727:p};
// %t728 = $SUPPLY @ATTACH &vdd => @PLACE(168, -444);
// &vdd @WIRE(mode="straight") {#X140:4 %t728:p};
// %t729 = $GROUND @ATTACH &vss => @PLACE(168, -466);
// &vss @WIRE(mode="straight") {#X140:5 %t729:p};
// %t730 = $IO_PORT @ATTACH &cfg_ready => @PLACE(198, -453) => @ORIENT("R0");
// %t730 @TEXT("cfg_ready", key="name", size=0.75);
// &cfg_ready @WIRE(mode="straight") {#X141:1 %t730:p};
// %t731 = $IO_PORT @ATTACH &fll_enable => @PLACE(198, -457) => @ORIENT("R0");
// %t731 @TEXT("fll_enable", key="name", size=0.75);
// &fll_enable @WIRE(mode="straight") {#X141:2 %t731:p};
// %t732 = $IO_PORT @ATTACH &n190 => @PLACE(218, -455) => @ORIENT("MY");
// %t732 @TEXT("n190", key="name", size=0.75);
// &n190 @WIRE(mode="straight") {#X141:3 %t732:p};
// %t733 = $SUPPLY @ATTACH &vdd => @PLACE(208, -444);
// &vdd @WIRE(mode="straight") {#X141:4 %t733:p};
// %t734 = $GROUND @ATTACH &vss => @PLACE(208, -466);
// &vss @WIRE(mode="straight") {#X141:5 %t734:p};
// %t735 = $IO_PORT @ATTACH &n190 => @PLACE(238, -453) => @ORIENT("R0");
// %t735 @TEXT("n190", key="name", size=0.75);
// &n190 @WIRE(mode="straight") {#X142:1 %t735:p};
// %t736 = $IO_PORT @ATTACH &n96 => @PLACE(238, -457) => @ORIENT("R0");
// %t736 @TEXT("n96", key="name", size=0.75);
// &n96 @WIRE(mode="straight") {#X142:2 %t736:p};
// %t737 = $IO_PORT @ATTACH &n191 => @PLACE(258, -455) => @ORIENT("MY");
// %t737 @TEXT("n191", key="name", size=0.75);
// &n191 @WIRE(mode="straight") {#X142:3 %t737:p};
// %t738 = $SUPPLY @ATTACH &vdd => @PLACE(248, -444);
// &vdd @WIRE(mode="straight") {#X142:4 %t738:p};
// %t739 = $GROUND @ATTACH &vss => @PLACE(248, -466);
// &vss @WIRE(mode="straight") {#X142:5 %t739:p};
// %t740 = $IO_PORT @ATTACH &n191 => @PLACE(278, -453) => @ORIENT("R0");
// %t740 @TEXT("n191", key="name", size=0.75);
// &n191 @WIRE(mode="straight") {#X143:1 %t740:p};
// %t741 = $IO_PORT @ATTACH &n95 => @PLACE(278, -457) => @ORIENT("R0");
// %t741 @TEXT("n95", key="name", size=0.75);
// &n95 @WIRE(mode="straight") {#X143:2 %t741:p};
// %t742 = $IO_PORT @ATTACH &n192 => @PLACE(298, -455) => @ORIENT("MY");
// %t742 @TEXT("n192", key="name", size=0.75);
// &n192 @WIRE(mode="straight") {#X143:3 %t742:p};
// %t743 = $SUPPLY @ATTACH &vdd => @PLACE(288, -444);
// &vdd @WIRE(mode="straight") {#X143:4 %t743:p};
// %t744 = $GROUND @ATTACH &vss => @PLACE(288, -466);
// &vss @WIRE(mode="straight") {#X143:5 %t744:p};
// %t745 = $IO_PORT @ATTACH &n192 => @PLACE(326, -278) => @ORIENT("R0");
// %t745 @TEXT("n192", key="name", size=0.75);
// &n192 @WIRE(mode="straight") {#X144:1 %t745:p};
// %t746 = $IO_PORT @ATTACH &n186 => @PLACE(326, -282) => @ORIENT("R0");
// %t746 @TEXT("n186", key="name", size=0.75);
// &n186 @WIRE(mode="straight") {#X144:2 %t746:p};
// %t747 = $IO_PORT @ATTACH &pll_enable => @PLACE(346, -280) => @ORIENT("MY");
// %t747 @TEXT("pll_enable", key="name", size=0.75);
// &pll_enable @WIRE(mode="straight") {#X144:3 %t747:p};
// %t748 = $SUPPLY @ATTACH &vdd => @PLACE(336, -269);
// &vdd @WIRE(mode="straight") {#X144:4 %t748:p};
// %t749 = $GROUND @ATTACH &vss => @PLACE(336, -291);
// &vss @WIRE(mode="straight") {#X144:5 %t749:p};
// %t750 = $IO_PORT @ATTACH &n91 => @PLACE(366, -278) => @ORIENT("R0");
// %t750 @TEXT("n91", key="name", size=0.75);
// &n91 @WIRE(mode="straight") {#X145:1 %t750:p};
// %t751 = $IO_PORT @ATTACH &n187 => @PLACE(366, -282) => @ORIENT("R0");
// %t751 @TEXT("n187", key="name", size=0.75);
// &n187 @WIRE(mode="straight") {#X145:2 %t751:p};
// %t752 = $IO_PORT @ATTACH &n193 => @PLACE(386, -280) => @ORIENT("MY");
// %t752 @TEXT("n193", key="name", size=0.75);
// &n193 @WIRE(mode="straight") {#X145:3 %t752:p};
// %t753 = $SUPPLY @ATTACH &vdd => @PLACE(376, -269);
// &vdd @WIRE(mode="straight") {#X145:4 %t753:p};
// %t754 = $GROUND @ATTACH &vss => @PLACE(376, -291);
// &vss @WIRE(mode="straight") {#X145:5 %t754:p};
// %t755 = $IO_PORT @ATTACH &n93 => @PLACE(406, -278) => @ORIENT("R0");
// %t755 @TEXT("n93", key="name", size=0.75);
// &n93 @WIRE(mode="straight") {#X146:1 %t755:p};
// %t756 = $IO_PORT @ATTACH &n194 => @PLACE(406, -282) => @ORIENT("R0");
// %t756 @TEXT("n194", key="name", size=0.75);
// &n194 @WIRE(mode="straight") {#X146:2 %t756:p};
// %t757 = $IO_PORT @ATTACH &n188 => @PLACE(426, -280) => @ORIENT("MY");
// %t757 @TEXT("n188", key="name", size=0.75);
// &n188 @WIRE(mode="straight") {#X146:3 %t757:p};
// %t758 = $SUPPLY @ATTACH &vdd => @PLACE(416, -269);
// &vdd @WIRE(mode="straight") {#X146:4 %t758:p};
// %t759 = $GROUND @ATTACH &vss => @PLACE(416, -291);
// &vss @WIRE(mode="straight") {#X146:5 %t759:p};
// %t760 = $IO_PORT @ATTACH &n193 => @PLACE(446, -278) => @ORIENT("R0");
// %t760 @TEXT("n193", key="name", size=0.75);
// &n193 @WIRE(mode="straight") {#X147:1 %t760:p};
// %t761 = $IO_PORT @ATTACH &n189 => @PLACE(446, -282) => @ORIENT("R0");
// %t761 @TEXT("n189", key="name", size=0.75);
// &n189 @WIRE(mode="straight") {#X147:2 %t761:p};
// %t762 = $IO_PORT @ATTACH &n136 => @PLACE(466, -280) => @ORIENT("MY");
// %t762 @TEXT("n136", key="name", size=0.75);
// &n136 @WIRE(mode="straight") {#X147:3 %t762:p};
// %t763 = $SUPPLY @ATTACH &vdd => @PLACE(456, -269);
// &vdd @WIRE(mode="straight") {#X147:4 %t763:p};
// %t764 = $GROUND @ATTACH &vss => @PLACE(456, -291);
// &vss @WIRE(mode="straight") {#X147:5 %t764:p};
// %t765 = $IO_PORT @ATTACH &n84 => @PLACE(326, -311) => @ORIENT("R0");
// %t765 @TEXT("n84", key="name", size=0.75);
// &n84 @WIRE(mode="straight") {#X148:1 %t765:p};
// %t766 = $IO_PORT @ATTACH &vss => @PLACE(326, -315) => @ORIENT("R0");
// %t766 @TEXT("vss", key="name", size=0.75);
// &vss @WIRE(mode="straight") {#X148:2 %t766:p};
// %t767 = $IO_PORT @ATTACH &qualified => @PLACE(326, -319) => @ORIENT("R0");
// %t767 @TEXT("qualified", key="name", size=0.75);
// &qualified @WIRE(mode="straight") {#X148:3 %t767:p};
// %t768 = $IO_PORT @ATTACH &n195 => @PLACE(346, -315) => @ORIENT("MY");
// %t768 @TEXT("n195", key="name", size=0.75);
// &n195 @WIRE(mode="straight") {#X148:4 %t768:p};
// %t769 = $SUPPLY @ATTACH &vdd => @PLACE(336, -302);
// &vdd @WIRE(mode="straight") {#X148:5 %t769:p};
// %t770 = $GROUND @ATTACH &vss => @PLACE(336, -328);
// &vss @WIRE(mode="straight") {#X148:6 %t770:p};
// %t771 = $IO_PORT @ATTACH &n119 => @PLACE(366, -311) => @ORIENT("R0");
// %t771 @TEXT("n119", key="name", size=0.75);
// &n119 @WIRE(mode="straight") {#X149:1 %t771:p};
// %t772 = $IO_PORT @ATTACH &vss => @PLACE(366, -315) => @ORIENT("R0");
// %t772 @TEXT("vss", key="name", size=0.75);
// &vss @WIRE(mode="straight") {#X149:2 %t772:p};
// %t773 = $IO_PORT @ATTACH &qualified => @PLACE(366, -319) => @ORIENT("R0");
// %t773 @TEXT("qualified", key="name", size=0.75);
// &qualified @WIRE(mode="straight") {#X149:3 %t773:p};
// %t774 = $IO_PORT @ATTACH &n196 => @PLACE(386, -315) => @ORIENT("MY");
// %t774 @TEXT("n196", key="name", size=0.75);
// &n196 @WIRE(mode="straight") {#X149:4 %t774:p};
// %t775 = $SUPPLY @ATTACH &vdd => @PLACE(376, -302);
// &vdd @WIRE(mode="straight") {#X149:5 %t775:p};
// %t776 = $GROUND @ATTACH &vss => @PLACE(376, -328);
// &vss @WIRE(mode="straight") {#X149:6 %t776:p};
// %t777 = $IO_PORT @ATTACH &n120 => @PLACE(406, -311) => @ORIENT("R0");
// %t777 @TEXT("n120", key="name", size=0.75);
// &n120 @WIRE(mode="straight") {#X150:1 %t777:p};
// %t778 = $IO_PORT @ATTACH &vss => @PLACE(406, -315) => @ORIENT("R0");
// %t778 @TEXT("vss", key="name", size=0.75);
// &vss @WIRE(mode="straight") {#X150:2 %t778:p};
// %t779 = $IO_PORT @ATTACH &qualified => @PLACE(406, -319) => @ORIENT("R0");
// %t779 @TEXT("qualified", key="name", size=0.75);
// &qualified @WIRE(mode="straight") {#X150:3 %t779:p};
// %t780 = $IO_PORT @ATTACH &n197 => @PLACE(426, -315) => @ORIENT("MY");
// %t780 @TEXT("n197", key="name", size=0.75);
// &n197 @WIRE(mode="straight") {#X150:4 %t780:p};
// %t781 = $SUPPLY @ATTACH &vdd => @PLACE(416, -302);
// &vdd @WIRE(mode="straight") {#X150:5 %t781:p};
// %t782 = $GROUND @ATTACH &vss => @PLACE(416, -328);
// &vss @WIRE(mode="straight") {#X150:6 %t782:p};
// %t783 = $IO_PORT @ATTACH &n121 => @PLACE(446, -311) => @ORIENT("R0");
// %t783 @TEXT("n121", key="name", size=0.75);
// &n121 @WIRE(mode="straight") {#X151:1 %t783:p};
// %t784 = $IO_PORT @ATTACH &vss => @PLACE(446, -315) => @ORIENT("R0");
// %t784 @TEXT("vss", key="name", size=0.75);
// &vss @WIRE(mode="straight") {#X151:2 %t784:p};
// %t785 = $IO_PORT @ATTACH &qualified => @PLACE(446, -319) => @ORIENT("R0");
// %t785 @TEXT("qualified", key="name", size=0.75);
// &qualified @WIRE(mode="straight") {#X151:3 %t785:p};
// %t786 = $IO_PORT @ATTACH &n198 => @PLACE(466, -315) => @ORIENT("MY");
// %t786 @TEXT("n198", key="name", size=0.75);
// &n198 @WIRE(mode="straight") {#X151:4 %t786:p};
// %t787 = $SUPPLY @ATTACH &vdd => @PLACE(456, -302);
// &vdd @WIRE(mode="straight") {#X151:5 %t787:p};
// %t788 = $GROUND @ATTACH &vss => @PLACE(456, -328);
// &vss @WIRE(mode="straight") {#X151:6 %t788:p};
// %t789 = $IO_PORT @ATTACH &n122 => @PLACE(326, -346) => @ORIENT("R0");
// %t789 @TEXT("n122", key="name", size=0.75);
// &n122 @WIRE(mode="straight") {#X152:1 %t789:p};
// %t790 = $IO_PORT @ATTACH &vss => @PLACE(326, -350) => @ORIENT("R0");
// %t790 @TEXT("vss", key="name", size=0.75);
// &vss @WIRE(mode="straight") {#X152:2 %t790:p};
// %t791 = $IO_PORT @ATTACH &qualified => @PLACE(326, -354) => @ORIENT("R0");
// %t791 @TEXT("qualified", key="name", size=0.75);
// &qualified @WIRE(mode="straight") {#X152:3 %t791:p};
// %t792 = $IO_PORT @ATTACH &n199 => @PLACE(346, -350) => @ORIENT("MY");
// %t792 @TEXT("n199", key="name", size=0.75);
// &n199 @WIRE(mode="straight") {#X152:4 %t792:p};
// %t793 = $SUPPLY @ATTACH &vdd => @PLACE(336, -337);
// &vdd @WIRE(mode="straight") {#X152:5 %t793:p};
// %t794 = $GROUND @ATTACH &vss => @PLACE(336, -363);
// &vss @WIRE(mode="straight") {#X152:6 %t794:p};
// %t795 = $IO_PORT @ATTACH &n123 => @PLACE(366, -346) => @ORIENT("R0");
// %t795 @TEXT("n123", key="name", size=0.75);
// &n123 @WIRE(mode="straight") {#X153:1 %t795:p};
// %t796 = $IO_PORT @ATTACH &vss => @PLACE(366, -350) => @ORIENT("R0");
// %t796 @TEXT("vss", key="name", size=0.75);
// &vss @WIRE(mode="straight") {#X153:2 %t796:p};
// %t797 = $IO_PORT @ATTACH &qualified => @PLACE(366, -354) => @ORIENT("R0");
// %t797 @TEXT("qualified", key="name", size=0.75);
// &qualified @WIRE(mode="straight") {#X153:3 %t797:p};
// %t798 = $IO_PORT @ATTACH &n200 => @PLACE(386, -350) => @ORIENT("MY");
// %t798 @TEXT("n200", key="name", size=0.75);
// &n200 @WIRE(mode="straight") {#X153:4 %t798:p};
// %t799 = $SUPPLY @ATTACH &vdd => @PLACE(376, -337);
// &vdd @WIRE(mode="straight") {#X153:5 %t799:p};
// %t800 = $GROUND @ATTACH &vss => @PLACE(376, -363);
// &vss @WIRE(mode="straight") {#X153:6 %t800:p};
// %t801 = $IO_PORT @ATTACH &n124 => @PLACE(406, -346) => @ORIENT("R0");
// %t801 @TEXT("n124", key="name", size=0.75);
// &n124 @WIRE(mode="straight") {#X154:1 %t801:p};
// %t802 = $IO_PORT @ATTACH &vss => @PLACE(406, -350) => @ORIENT("R0");
// %t802 @TEXT("vss", key="name", size=0.75);
// &vss @WIRE(mode="straight") {#X154:2 %t802:p};
// %t803 = $IO_PORT @ATTACH &qualified => @PLACE(406, -354) => @ORIENT("R0");
// %t803 @TEXT("qualified", key="name", size=0.75);
// &qualified @WIRE(mode="straight") {#X154:3 %t803:p};
// %t804 = $IO_PORT @ATTACH &n201 => @PLACE(426, -350) => @ORIENT("MY");
// %t804 @TEXT("n201", key="name", size=0.75);
// &n201 @WIRE(mode="straight") {#X154:4 %t804:p};
// %t805 = $SUPPLY @ATTACH &vdd => @PLACE(416, -337);
// &vdd @WIRE(mode="straight") {#X154:5 %t805:p};
// %t806 = $GROUND @ATTACH &vss => @PLACE(416, -363);
// &vss @WIRE(mode="straight") {#X154:6 %t806:p};
// %t807 = $IO_PORT @ATTACH &n125 => @PLACE(446, -346) => @ORIENT("R0");
// %t807 @TEXT("n125", key="name", size=0.75);
// &n125 @WIRE(mode="straight") {#X155:1 %t807:p};
// %t808 = $IO_PORT @ATTACH &vss => @PLACE(446, -350) => @ORIENT("R0");
// %t808 @TEXT("vss", key="name", size=0.75);
// &vss @WIRE(mode="straight") {#X155:2 %t808:p};
// %t809 = $IO_PORT @ATTACH &qualified => @PLACE(446, -354) => @ORIENT("R0");
// %t809 @TEXT("qualified", key="name", size=0.75);
// &qualified @WIRE(mode="straight") {#X155:3 %t809:p};
// %t810 = $IO_PORT @ATTACH &n202 => @PLACE(466, -350) => @ORIENT("MY");
// %t810 @TEXT("n202", key="name", size=0.75);
// &n202 @WIRE(mode="straight") {#X155:4 %t810:p};
// %t811 = $SUPPLY @ATTACH &vdd => @PLACE(456, -337);
// &vdd @WIRE(mode="straight") {#X155:5 %t811:p};
// %t812 = $GROUND @ATTACH &vss => @PLACE(456, -363);
// &vss @WIRE(mode="straight") {#X155:6 %t812:p};
// %t813 = $IO_PORT @ATTACH &n126 => @PLACE(326, -381) => @ORIENT("R0");
// %t813 @TEXT("n126", key="name", size=0.75);
// &n126 @WIRE(mode="straight") {#X156:1 %t813:p};
// %t814 = $IO_PORT @ATTACH &vss => @PLACE(326, -385) => @ORIENT("R0");
// %t814 @TEXT("vss", key="name", size=0.75);
// &vss @WIRE(mode="straight") {#X156:2 %t814:p};
// %t815 = $IO_PORT @ATTACH &qualified => @PLACE(326, -389) => @ORIENT("R0");
// %t815 @TEXT("qualified", key="name", size=0.75);
// &qualified @WIRE(mode="straight") {#X156:3 %t815:p};
// %t816 = $IO_PORT @ATTACH &n203 => @PLACE(346, -385) => @ORIENT("MY");
// %t816 @TEXT("n203", key="name", size=0.75);
// &n203 @WIRE(mode="straight") {#X156:4 %t816:p};
// %t817 = $SUPPLY @ATTACH &vdd => @PLACE(336, -372);
// &vdd @WIRE(mode="straight") {#X156:5 %t817:p};
// %t818 = $GROUND @ATTACH &vss => @PLACE(336, -398);
// &vss @WIRE(mode="straight") {#X156:6 %t818:p};
// %t819 = $IO_PORT @ATTACH &vss => @PLACE(366, -381) => @ORIENT("R0");
// %t819 @TEXT("vss", key="name", size=0.75);
// &vss @WIRE(mode="straight") {#X157:1 %t819:p};
// %t820 = $IO_PORT @ATTACH &n195 => @PLACE(366, -385) => @ORIENT("R0");
// %t820 @TEXT("n195", key="name", size=0.75);
// &n195 @WIRE(mode="straight") {#X157:2 %t820:p};
// %t821 = $IO_PORT @ATTACH &n185 => @PLACE(366, -389) => @ORIENT("R0");
// %t821 @TEXT("n185", key="name", size=0.75);
// &n185 @WIRE(mode="straight") {#X157:3 %t821:p};
// %t822 = $IO_PORT @ATTACH &n204 => @PLACE(386, -385) => @ORIENT("MY");
// %t822 @TEXT("n204", key="name", size=0.75);
// &n204 @WIRE(mode="straight") {#X157:4 %t822:p};
// %t823 = $SUPPLY @ATTACH &vdd => @PLACE(376, -372);
// &vdd @WIRE(mode="straight") {#X157:5 %t823:p};
// %t824 = $GROUND @ATTACH &vss => @PLACE(376, -398);
// &vss @WIRE(mode="straight") {#X157:6 %t824:p};
// %t825 = $IO_PORT @ATTACH &vss => @PLACE(406, -381) => @ORIENT("R0");
// %t825 @TEXT("vss", key="name", size=0.75);
// &vss @WIRE(mode="straight") {#X158:1 %t825:p};
// %t826 = $IO_PORT @ATTACH &n196 => @PLACE(406, -385) => @ORIENT("R0");
// %t826 @TEXT("n196", key="name", size=0.75);
// &n196 @WIRE(mode="straight") {#X158:2 %t826:p};
// %t827 = $IO_PORT @ATTACH &n185 => @PLACE(406, -389) => @ORIENT("R0");
// %t827 @TEXT("n185", key="name", size=0.75);
// &n185 @WIRE(mode="straight") {#X158:3 %t827:p};
// %t828 = $IO_PORT @ATTACH &n205 => @PLACE(426, -385) => @ORIENT("MY");
// %t828 @TEXT("n205", key="name", size=0.75);
// &n205 @WIRE(mode="straight") {#X158:4 %t828:p};
// %t829 = $SUPPLY @ATTACH &vdd => @PLACE(416, -372);
// &vdd @WIRE(mode="straight") {#X158:5 %t829:p};
// %t830 = $GROUND @ATTACH &vss => @PLACE(416, -398);
// &vss @WIRE(mode="straight") {#X158:6 %t830:p};
// %t831 = $IO_PORT @ATTACH &vss => @PLACE(446, -381) => @ORIENT("R0");
// %t831 @TEXT("vss", key="name", size=0.75);
// &vss @WIRE(mode="straight") {#X159:1 %t831:p};
// %t832 = $IO_PORT @ATTACH &n197 => @PLACE(446, -385) => @ORIENT("R0");
// %t832 @TEXT("n197", key="name", size=0.75);
// &n197 @WIRE(mode="straight") {#X159:2 %t832:p};
// %t833 = $IO_PORT @ATTACH &n185 => @PLACE(446, -389) => @ORIENT("R0");
// %t833 @TEXT("n185", key="name", size=0.75);
// &n185 @WIRE(mode="straight") {#X159:3 %t833:p};
// %t834 = $IO_PORT @ATTACH &n206 => @PLACE(466, -385) => @ORIENT("MY");
// %t834 @TEXT("n206", key="name", size=0.75);
// &n206 @WIRE(mode="straight") {#X159:4 %t834:p};
// %t835 = $SUPPLY @ATTACH &vdd => @PLACE(456, -372);
// &vdd @WIRE(mode="straight") {#X159:5 %t835:p};
// %t836 = $GROUND @ATTACH &vss => @PLACE(456, -398);
// &vss @WIRE(mode="straight") {#X159:6 %t836:p};
// %t837 = $IO_PORT @ATTACH &vss => @PLACE(326, -416) => @ORIENT("R0");
// %t837 @TEXT("vss", key="name", size=0.75);
// &vss @WIRE(mode="straight") {#X160:1 %t837:p};
// %t838 = $IO_PORT @ATTACH &n198 => @PLACE(326, -420) => @ORIENT("R0");
// %t838 @TEXT("n198", key="name", size=0.75);
// &n198 @WIRE(mode="straight") {#X160:2 %t838:p};
// %t839 = $IO_PORT @ATTACH &n185 => @PLACE(326, -424) => @ORIENT("R0");
// %t839 @TEXT("n185", key="name", size=0.75);
// &n185 @WIRE(mode="straight") {#X160:3 %t839:p};
// %t840 = $IO_PORT @ATTACH &n207 => @PLACE(346, -420) => @ORIENT("MY");
// %t840 @TEXT("n207", key="name", size=0.75);
// &n207 @WIRE(mode="straight") {#X160:4 %t840:p};
// %t841 = $SUPPLY @ATTACH &vdd => @PLACE(336, -407);
// &vdd @WIRE(mode="straight") {#X160:5 %t841:p};
// %t842 = $GROUND @ATTACH &vss => @PLACE(336, -433);
// &vss @WIRE(mode="straight") {#X160:6 %t842:p};
// %t843 = $IO_PORT @ATTACH &vss => @PLACE(366, -416) => @ORIENT("R0");
// %t843 @TEXT("vss", key="name", size=0.75);
// &vss @WIRE(mode="straight") {#X161:1 %t843:p};
// %t844 = $IO_PORT @ATTACH &n199 => @PLACE(366, -420) => @ORIENT("R0");
// %t844 @TEXT("n199", key="name", size=0.75);
// &n199 @WIRE(mode="straight") {#X161:2 %t844:p};
// %t845 = $IO_PORT @ATTACH &n185 => @PLACE(366, -424) => @ORIENT("R0");
// %t845 @TEXT("n185", key="name", size=0.75);
// &n185 @WIRE(mode="straight") {#X161:3 %t845:p};
// %t846 = $IO_PORT @ATTACH &n208 => @PLACE(386, -420) => @ORIENT("MY");
// %t846 @TEXT("n208", key="name", size=0.75);
// &n208 @WIRE(mode="straight") {#X161:4 %t846:p};
// %t847 = $SUPPLY @ATTACH &vdd => @PLACE(376, -407);
// &vdd @WIRE(mode="straight") {#X161:5 %t847:p};
// %t848 = $GROUND @ATTACH &vss => @PLACE(376, -433);
// &vss @WIRE(mode="straight") {#X161:6 %t848:p};
// %t849 = $IO_PORT @ATTACH &vss => @PLACE(406, -416) => @ORIENT("R0");
// %t849 @TEXT("vss", key="name", size=0.75);
// &vss @WIRE(mode="straight") {#X162:1 %t849:p};
// %t850 = $IO_PORT @ATTACH &n200 => @PLACE(406, -420) => @ORIENT("R0");
// %t850 @TEXT("n200", key="name", size=0.75);
// &n200 @WIRE(mode="straight") {#X162:2 %t850:p};
// %t851 = $IO_PORT @ATTACH &n185 => @PLACE(406, -424) => @ORIENT("R0");
// %t851 @TEXT("n185", key="name", size=0.75);
// &n185 @WIRE(mode="straight") {#X162:3 %t851:p};
// %t852 = $IO_PORT @ATTACH &n209 => @PLACE(426, -420) => @ORIENT("MY");
// %t852 @TEXT("n209", key="name", size=0.75);
// &n209 @WIRE(mode="straight") {#X162:4 %t852:p};
// %t853 = $SUPPLY @ATTACH &vdd => @PLACE(416, -407);
// &vdd @WIRE(mode="straight") {#X162:5 %t853:p};
// %t854 = $GROUND @ATTACH &vss => @PLACE(416, -433);
// &vss @WIRE(mode="straight") {#X162:6 %t854:p};
// %t855 = $IO_PORT @ATTACH &vss => @PLACE(446, -416) => @ORIENT("R0");
// %t855 @TEXT("vss", key="name", size=0.75);
// &vss @WIRE(mode="straight") {#X163:1 %t855:p};
// %t856 = $IO_PORT @ATTACH &n201 => @PLACE(446, -420) => @ORIENT("R0");
// %t856 @TEXT("n201", key="name", size=0.75);
// &n201 @WIRE(mode="straight") {#X163:2 %t856:p};
// %t857 = $IO_PORT @ATTACH &n185 => @PLACE(446, -424) => @ORIENT("R0");
// %t857 @TEXT("n185", key="name", size=0.75);
// &n185 @WIRE(mode="straight") {#X163:3 %t857:p};
// %t858 = $IO_PORT @ATTACH &n210 => @PLACE(466, -420) => @ORIENT("MY");
// %t858 @TEXT("n210", key="name", size=0.75);
// &n210 @WIRE(mode="straight") {#X163:4 %t858:p};
// %t859 = $SUPPLY @ATTACH &vdd => @PLACE(456, -407);
// &vdd @WIRE(mode="straight") {#X163:5 %t859:p};
// %t860 = $GROUND @ATTACH &vss => @PLACE(456, -433);
// &vss @WIRE(mode="straight") {#X163:6 %t860:p};
// %t861 = $IO_PORT @ATTACH &vss => @PLACE(326, -451) => @ORIENT("R0");
// %t861 @TEXT("vss", key="name", size=0.75);
// &vss @WIRE(mode="straight") {#X164:1 %t861:p};
// %t862 = $IO_PORT @ATTACH &n202 => @PLACE(326, -455) => @ORIENT("R0");
// %t862 @TEXT("n202", key="name", size=0.75);
// &n202 @WIRE(mode="straight") {#X164:2 %t862:p};
// %t863 = $IO_PORT @ATTACH &n185 => @PLACE(326, -459) => @ORIENT("R0");
// %t863 @TEXT("n185", key="name", size=0.75);
// &n185 @WIRE(mode="straight") {#X164:3 %t863:p};
// %t864 = $IO_PORT @ATTACH &n211 => @PLACE(346, -455) => @ORIENT("MY");
// %t864 @TEXT("n211", key="name", size=0.75);
// &n211 @WIRE(mode="straight") {#X164:4 %t864:p};
// %t865 = $SUPPLY @ATTACH &vdd => @PLACE(336, -442);
// &vdd @WIRE(mode="straight") {#X164:5 %t865:p};
// %t866 = $GROUND @ATTACH &vss => @PLACE(336, -468);
// &vss @WIRE(mode="straight") {#X164:6 %t866:p};
// %t867 = $IO_PORT @ATTACH &vss => @PLACE(366, -451) => @ORIENT("R0");
// %t867 @TEXT("vss", key="name", size=0.75);
// &vss @WIRE(mode="straight") {#X165:1 %t867:p};
// %t868 = $IO_PORT @ATTACH &n203 => @PLACE(366, -455) => @ORIENT("R0");
// %t868 @TEXT("n203", key="name", size=0.75);
// &n203 @WIRE(mode="straight") {#X165:2 %t868:p};
// %t869 = $IO_PORT @ATTACH &n185 => @PLACE(366, -459) => @ORIENT("R0");
// %t869 @TEXT("n185", key="name", size=0.75);
// &n185 @WIRE(mode="straight") {#X165:3 %t869:p};
// %t870 = $IO_PORT @ATTACH &n212 => @PLACE(386, -455) => @ORIENT("MY");
// %t870 @TEXT("n212", key="name", size=0.75);
// &n212 @WIRE(mode="straight") {#X165:4 %t870:p};
// %t871 = $SUPPLY @ATTACH &vdd => @PLACE(376, -442);
// &vdd @WIRE(mode="straight") {#X165:5 %t871:p};
// %t872 = $GROUND @ATTACH &vss => @PLACE(376, -468);
// &vss @WIRE(mode="straight") {#X165:6 %t872:p};
// %t873 = $IO_PORT @ATTACH &n204 => @PLACE(406, -451) => @ORIENT("R0");
// %t873 @TEXT("n204", key="name", size=0.75);
// &n204 @WIRE(mode="straight") {#X166:1 %t873:p};
// %t874 = $IO_PORT @ATTACH &n195 => @PLACE(406, -455) => @ORIENT("R0");
// %t874 @TEXT("n195", key="name", size=0.75);
// &n195 @WIRE(mode="straight") {#X166:2 %t874:p};
// %t875 = $IO_PORT @ATTACH &qualified => @PLACE(406, -459) => @ORIENT("R0");
// %t875 @TEXT("qualified", key="name", size=0.75);
// &qualified @WIRE(mode="straight") {#X166:3 %t875:p};
// %t876 = $IO_PORT @ATTACH &n213 => @PLACE(426, -455) => @ORIENT("MY");
// %t876 @TEXT("n213", key="name", size=0.75);
// &n213 @WIRE(mode="straight") {#X166:4 %t876:p};
// %t877 = $SUPPLY @ATTACH &vdd => @PLACE(416, -442);
// &vdd @WIRE(mode="straight") {#X166:5 %t877:p};
// %t878 = $GROUND @ATTACH &vss => @PLACE(416, -468);
// &vss @WIRE(mode="straight") {#X166:6 %t878:p};
// %t879 = $IO_PORT @ATTACH &n205 => @PLACE(446, -451) => @ORIENT("R0");
// %t879 @TEXT("n205", key="name", size=0.75);
// &n205 @WIRE(mode="straight") {#X167:1 %t879:p};
// %t880 = $IO_PORT @ATTACH &n196 => @PLACE(446, -455) => @ORIENT("R0");
// %t880 @TEXT("n196", key="name", size=0.75);
// &n196 @WIRE(mode="straight") {#X167:2 %t880:p};
// %t881 = $IO_PORT @ATTACH &qualified => @PLACE(446, -459) => @ORIENT("R0");
// %t881 @TEXT("qualified", key="name", size=0.75);
// &qualified @WIRE(mode="straight") {#X167:3 %t881:p};
// %t882 = $IO_PORT @ATTACH &n214 => @PLACE(466, -455) => @ORIENT("MY");
// %t882 @TEXT("n214", key="name", size=0.75);
// &n214 @WIRE(mode="straight") {#X167:4 %t882:p};
// %t883 = $SUPPLY @ATTACH &vdd => @PLACE(456, -442);
// &vdd @WIRE(mode="straight") {#X167:5 %t883:p};
// %t884 = $GROUND @ATTACH &vss => @PLACE(456, -468);
// &vss @WIRE(mode="straight") {#X167:6 %t884:p};
// %t885 = $IO_PORT @ATTACH &n206 => @PLACE(494, -276) => @ORIENT("R0");
// %t885 @TEXT("n206", key="name", size=0.75);
// &n206 @WIRE(mode="straight") {#X168:1 %t885:p};
// %t886 = $IO_PORT @ATTACH &n197 => @PLACE(494, -280) => @ORIENT("R0");
// %t886 @TEXT("n197", key="name", size=0.75);
// &n197 @WIRE(mode="straight") {#X168:2 %t886:p};
// %t887 = $IO_PORT @ATTACH &qualified => @PLACE(494, -284) => @ORIENT("R0");
// %t887 @TEXT("qualified", key="name", size=0.75);
// &qualified @WIRE(mode="straight") {#X168:3 %t887:p};
// %t888 = $IO_PORT @ATTACH &n215 => @PLACE(514, -280) => @ORIENT("MY");
// %t888 @TEXT("n215", key="name", size=0.75);
// &n215 @WIRE(mode="straight") {#X168:4 %t888:p};
// %t889 = $SUPPLY @ATTACH &vdd => @PLACE(504, -267);
// &vdd @WIRE(mode="straight") {#X168:5 %t889:p};
// %t890 = $GROUND @ATTACH &vss => @PLACE(504, -293);
// &vss @WIRE(mode="straight") {#X168:6 %t890:p};
// %t891 = $IO_PORT @ATTACH &n207 => @PLACE(534, -276) => @ORIENT("R0");
// %t891 @TEXT("n207", key="name", size=0.75);
// &n207 @WIRE(mode="straight") {#X169:1 %t891:p};
// %t892 = $IO_PORT @ATTACH &n198 => @PLACE(534, -280) => @ORIENT("R0");
// %t892 @TEXT("n198", key="name", size=0.75);
// &n198 @WIRE(mode="straight") {#X169:2 %t892:p};
// %t893 = $IO_PORT @ATTACH &qualified => @PLACE(534, -284) => @ORIENT("R0");
// %t893 @TEXT("qualified", key="name", size=0.75);
// &qualified @WIRE(mode="straight") {#X169:3 %t893:p};
// %t894 = $IO_PORT @ATTACH &n216 => @PLACE(554, -280) => @ORIENT("MY");
// %t894 @TEXT("n216", key="name", size=0.75);
// &n216 @WIRE(mode="straight") {#X169:4 %t894:p};
// %t895 = $SUPPLY @ATTACH &vdd => @PLACE(544, -267);
// &vdd @WIRE(mode="straight") {#X169:5 %t895:p};
// %t896 = $GROUND @ATTACH &vss => @PLACE(544, -293);
// &vss @WIRE(mode="straight") {#X169:6 %t896:p};
// %t897 = $IO_PORT @ATTACH &n208 => @PLACE(574, -276) => @ORIENT("R0");
// %t897 @TEXT("n208", key="name", size=0.75);
// &n208 @WIRE(mode="straight") {#X170:1 %t897:p};
// %t898 = $IO_PORT @ATTACH &n199 => @PLACE(574, -280) => @ORIENT("R0");
// %t898 @TEXT("n199", key="name", size=0.75);
// &n199 @WIRE(mode="straight") {#X170:2 %t898:p};
// %t899 = $IO_PORT @ATTACH &qualified => @PLACE(574, -284) => @ORIENT("R0");
// %t899 @TEXT("qualified", key="name", size=0.75);
// &qualified @WIRE(mode="straight") {#X170:3 %t899:p};
// %t900 = $IO_PORT @ATTACH &n217 => @PLACE(594, -280) => @ORIENT("MY");
// %t900 @TEXT("n217", key="name", size=0.75);
// &n217 @WIRE(mode="straight") {#X170:4 %t900:p};
// %t901 = $SUPPLY @ATTACH &vdd => @PLACE(584, -267);
// &vdd @WIRE(mode="straight") {#X170:5 %t901:p};
// %t902 = $GROUND @ATTACH &vss => @PLACE(584, -293);
// &vss @WIRE(mode="straight") {#X170:6 %t902:p};
// %t903 = $IO_PORT @ATTACH &n209 => @PLACE(614, -276) => @ORIENT("R0");
// %t903 @TEXT("n209", key="name", size=0.75);
// &n209 @WIRE(mode="straight") {#X171:1 %t903:p};
// %t904 = $IO_PORT @ATTACH &n200 => @PLACE(614, -280) => @ORIENT("R0");
// %t904 @TEXT("n200", key="name", size=0.75);
// &n200 @WIRE(mode="straight") {#X171:2 %t904:p};
// %t905 = $IO_PORT @ATTACH &qualified => @PLACE(614, -284) => @ORIENT("R0");
// %t905 @TEXT("qualified", key="name", size=0.75);
// &qualified @WIRE(mode="straight") {#X171:3 %t905:p};
// %t906 = $IO_PORT @ATTACH &n218 => @PLACE(635, -280) => @ORIENT("MY");
// %t906 @TEXT("n218", key="name", size=0.75);
// &n218 @WIRE(mode="straight") {#X171:4 %t906:p};
// %t907 = $SUPPLY @ATTACH &vdd => @PLACE(624, -267);
// &vdd @WIRE(mode="straight") {#X171:5 %t907:p};
// %t908 = $GROUND @ATTACH &vss => @PLACE(624, -293);
// &vss @WIRE(mode="straight") {#X171:6 %t908:p};
// %t909 = $IO_PORT @ATTACH &n210 => @PLACE(494, -311) => @ORIENT("R0");
// %t909 @TEXT("n210", key="name", size=0.75);
// &n210 @WIRE(mode="straight") {#X172:1 %t909:p};
// %t910 = $IO_PORT @ATTACH &n201 => @PLACE(494, -315) => @ORIENT("R0");
// %t910 @TEXT("n201", key="name", size=0.75);
// &n201 @WIRE(mode="straight") {#X172:2 %t910:p};
// %t911 = $IO_PORT @ATTACH &qualified => @PLACE(494, -319) => @ORIENT("R0");
// %t911 @TEXT("qualified", key="name", size=0.75);
// &qualified @WIRE(mode="straight") {#X172:3 %t911:p};
// %t912 = $IO_PORT @ATTACH &n219 => @PLACE(514, -315) => @ORIENT("MY");
// %t912 @TEXT("n219", key="name", size=0.75);
// &n219 @WIRE(mode="straight") {#X172:4 %t912:p};
// %t913 = $SUPPLY @ATTACH &vdd => @PLACE(504, -302);
// &vdd @WIRE(mode="straight") {#X172:5 %t913:p};
// %t914 = $GROUND @ATTACH &vss => @PLACE(504, -328);
// &vss @WIRE(mode="straight") {#X172:6 %t914:p};
// %t915 = $IO_PORT @ATTACH &n211 => @PLACE(534, -311) => @ORIENT("R0");
// %t915 @TEXT("n211", key="name", size=0.75);
// &n211 @WIRE(mode="straight") {#X173:1 %t915:p};
// %t916 = $IO_PORT @ATTACH &n202 => @PLACE(534, -315) => @ORIENT("R0");
// %t916 @TEXT("n202", key="name", size=0.75);
// &n202 @WIRE(mode="straight") {#X173:2 %t916:p};
// %t917 = $IO_PORT @ATTACH &qualified => @PLACE(534, -319) => @ORIENT("R0");
// %t917 @TEXT("qualified", key="name", size=0.75);
// &qualified @WIRE(mode="straight") {#X173:3 %t917:p};
// %t918 = $IO_PORT @ATTACH &n220 => @PLACE(554, -315) => @ORIENT("MY");
// %t918 @TEXT("n220", key="name", size=0.75);
// &n220 @WIRE(mode="straight") {#X173:4 %t918:p};
// %t919 = $SUPPLY @ATTACH &vdd => @PLACE(544, -302);
// &vdd @WIRE(mode="straight") {#X173:5 %t919:p};
// %t920 = $GROUND @ATTACH &vss => @PLACE(544, -328);
// &vss @WIRE(mode="straight") {#X173:6 %t920:p};
// %t921 = $IO_PORT @ATTACH &n212 => @PLACE(574, -311) => @ORIENT("R0");
// %t921 @TEXT("n212", key="name", size=0.75);
// &n212 @WIRE(mode="straight") {#X174:1 %t921:p};
// %t922 = $IO_PORT @ATTACH &n203 => @PLACE(574, -315) => @ORIENT("R0");
// %t922 @TEXT("n203", key="name", size=0.75);
// &n203 @WIRE(mode="straight") {#X174:2 %t922:p};
// %t923 = $IO_PORT @ATTACH &qualified => @PLACE(574, -319) => @ORIENT("R0");
// %t923 @TEXT("qualified", key="name", size=0.75);
// &qualified @WIRE(mode="straight") {#X174:3 %t923:p};
// %t924 = $IO_PORT @ATTACH &n221 => @PLACE(594, -315) => @ORIENT("MY");
// %t924 @TEXT("n221", key="name", size=0.75);
// &n221 @WIRE(mode="straight") {#X174:4 %t924:p};
// %t925 = $SUPPLY @ATTACH &vdd => @PLACE(584, -302);
// &vdd @WIRE(mode="straight") {#X174:5 %t925:p};
// %t926 = $GROUND @ATTACH &vss => @PLACE(584, -328);
// &vss @WIRE(mode="straight") {#X174:6 %t926:p};
// %t927 = $IO_PORT @ATTACH &n195 => @PLACE(614, -311) => @ORIENT("R0");
// %t927 @TEXT("n195", key="name", size=0.75);
// &n195 @WIRE(mode="straight") {#X175:1 %t927:p};
// %t928 = $IO_PORT @ATTACH &n213 => @PLACE(614, -315) => @ORIENT("R0");
// %t928 @TEXT("n213", key="name", size=0.75);
// &n213 @WIRE(mode="straight") {#X175:2 %t928:p};
// %t929 = $IO_PORT @ATTACH &n93 => @PLACE(614, -319) => @ORIENT("R0");
// %t929 @TEXT("n93", key="name", size=0.75);
// &n93 @WIRE(mode="straight") {#X175:3 %t929:p};
// %t930 = $IO_PORT @ATTACH &n222 => @PLACE(635, -315) => @ORIENT("MY");
// %t930 @TEXT("n222", key="name", size=0.75);
// &n222 @WIRE(mode="straight") {#X175:4 %t930:p};
// %t931 = $SUPPLY @ATTACH &vdd => @PLACE(624, -302);
// &vdd @WIRE(mode="straight") {#X175:5 %t931:p};
// %t932 = $GROUND @ATTACH &vss => @PLACE(624, -328);
// &vss @WIRE(mode="straight") {#X175:6 %t932:p};
// %t933 = $IO_PORT @ATTACH &n196 => @PLACE(494, -346) => @ORIENT("R0");
// %t933 @TEXT("n196", key="name", size=0.75);
// &n196 @WIRE(mode="straight") {#X176:1 %t933:p};
// %t934 = $IO_PORT @ATTACH &n214 => @PLACE(494, -350) => @ORIENT("R0");
// %t934 @TEXT("n214", key="name", size=0.75);
// &n214 @WIRE(mode="straight") {#X176:2 %t934:p};
// %t935 = $IO_PORT @ATTACH &n93 => @PLACE(494, -354) => @ORIENT("R0");
// %t935 @TEXT("n93", key="name", size=0.75);
// &n93 @WIRE(mode="straight") {#X176:3 %t935:p};
// %t936 = $IO_PORT @ATTACH &n223 => @PLACE(514, -350) => @ORIENT("MY");
// %t936 @TEXT("n223", key="name", size=0.75);
// &n223 @WIRE(mode="straight") {#X176:4 %t936:p};
// %t937 = $SUPPLY @ATTACH &vdd => @PLACE(504, -337);
// &vdd @WIRE(mode="straight") {#X176:5 %t937:p};
// %t938 = $GROUND @ATTACH &vss => @PLACE(504, -363);
// &vss @WIRE(mode="straight") {#X176:6 %t938:p};
// %t939 = $IO_PORT @ATTACH &n197 => @PLACE(534, -346) => @ORIENT("R0");
// %t939 @TEXT("n197", key="name", size=0.75);
// &n197 @WIRE(mode="straight") {#X177:1 %t939:p};
// %t940 = $IO_PORT @ATTACH &n215 => @PLACE(534, -350) => @ORIENT("R0");
// %t940 @TEXT("n215", key="name", size=0.75);
// &n215 @WIRE(mode="straight") {#X177:2 %t940:p};
// %t941 = $IO_PORT @ATTACH &n93 => @PLACE(534, -354) => @ORIENT("R0");
// %t941 @TEXT("n93", key="name", size=0.75);
// &n93 @WIRE(mode="straight") {#X177:3 %t941:p};
// %t942 = $IO_PORT @ATTACH &n224 => @PLACE(554, -350) => @ORIENT("MY");
// %t942 @TEXT("n224", key="name", size=0.75);
// &n224 @WIRE(mode="straight") {#X177:4 %t942:p};
// %t943 = $SUPPLY @ATTACH &vdd => @PLACE(544, -337);
// &vdd @WIRE(mode="straight") {#X177:5 %t943:p};
// %t944 = $GROUND @ATTACH &vss => @PLACE(544, -363);
// &vss @WIRE(mode="straight") {#X177:6 %t944:p};
// %t945 = $IO_PORT @ATTACH &n198 => @PLACE(574, -346) => @ORIENT("R0");
// %t945 @TEXT("n198", key="name", size=0.75);
// &n198 @WIRE(mode="straight") {#X178:1 %t945:p};
// %t946 = $IO_PORT @ATTACH &n216 => @PLACE(574, -350) => @ORIENT("R0");
// %t946 @TEXT("n216", key="name", size=0.75);
// &n216 @WIRE(mode="straight") {#X178:2 %t946:p};
// %t947 = $IO_PORT @ATTACH &n93 => @PLACE(574, -354) => @ORIENT("R0");
// %t947 @TEXT("n93", key="name", size=0.75);
// &n93 @WIRE(mode="straight") {#X178:3 %t947:p};
// %t948 = $IO_PORT @ATTACH &n225 => @PLACE(594, -350) => @ORIENT("MY");
// %t948 @TEXT("n225", key="name", size=0.75);
// &n225 @WIRE(mode="straight") {#X178:4 %t948:p};
// %t949 = $SUPPLY @ATTACH &vdd => @PLACE(584, -337);
// &vdd @WIRE(mode="straight") {#X178:5 %t949:p};
// %t950 = $GROUND @ATTACH &vss => @PLACE(584, -363);
// &vss @WIRE(mode="straight") {#X178:6 %t950:p};
// %t951 = $IO_PORT @ATTACH &n199 => @PLACE(614, -346) => @ORIENT("R0");
// %t951 @TEXT("n199", key="name", size=0.75);
// &n199 @WIRE(mode="straight") {#X179:1 %t951:p};
// %t952 = $IO_PORT @ATTACH &n217 => @PLACE(614, -350) => @ORIENT("R0");
// %t952 @TEXT("n217", key="name", size=0.75);
// &n217 @WIRE(mode="straight") {#X179:2 %t952:p};
// %t953 = $IO_PORT @ATTACH &n93 => @PLACE(614, -354) => @ORIENT("R0");
// %t953 @TEXT("n93", key="name", size=0.75);
// &n93 @WIRE(mode="straight") {#X179:3 %t953:p};
// %t954 = $IO_PORT @ATTACH &n226 => @PLACE(635, -350) => @ORIENT("MY");
// %t954 @TEXT("n226", key="name", size=0.75);
// &n226 @WIRE(mode="straight") {#X179:4 %t954:p};
// %t955 = $SUPPLY @ATTACH &vdd => @PLACE(624, -337);
// &vdd @WIRE(mode="straight") {#X179:5 %t955:p};
// %t956 = $GROUND @ATTACH &vss => @PLACE(624, -363);
// &vss @WIRE(mode="straight") {#X179:6 %t956:p};
// %t957 = $IO_PORT @ATTACH &n200 => @PLACE(494, -381) => @ORIENT("R0");
// %t957 @TEXT("n200", key="name", size=0.75);
// &n200 @WIRE(mode="straight") {#X180:1 %t957:p};
// %t958 = $IO_PORT @ATTACH &n218 => @PLACE(494, -385) => @ORIENT("R0");
// %t958 @TEXT("n218", key="name", size=0.75);
// &n218 @WIRE(mode="straight") {#X180:2 %t958:p};
// %t959 = $IO_PORT @ATTACH &n93 => @PLACE(494, -389) => @ORIENT("R0");
// %t959 @TEXT("n93", key="name", size=0.75);
// &n93 @WIRE(mode="straight") {#X180:3 %t959:p};
// %t960 = $IO_PORT @ATTACH &n227 => @PLACE(514, -385) => @ORIENT("MY");
// %t960 @TEXT("n227", key="name", size=0.75);
// &n227 @WIRE(mode="straight") {#X180:4 %t960:p};
// %t961 = $SUPPLY @ATTACH &vdd => @PLACE(504, -372);
// &vdd @WIRE(mode="straight") {#X180:5 %t961:p};
// %t962 = $GROUND @ATTACH &vss => @PLACE(504, -398);
// &vss @WIRE(mode="straight") {#X180:6 %t962:p};
// %t963 = $IO_PORT @ATTACH &n201 => @PLACE(534, -381) => @ORIENT("R0");
// %t963 @TEXT("n201", key="name", size=0.75);
// &n201 @WIRE(mode="straight") {#X181:1 %t963:p};
// %t964 = $IO_PORT @ATTACH &n219 => @PLACE(534, -385) => @ORIENT("R0");
// %t964 @TEXT("n219", key="name", size=0.75);
// &n219 @WIRE(mode="straight") {#X181:2 %t964:p};
// %t965 = $IO_PORT @ATTACH &n93 => @PLACE(534, -389) => @ORIENT("R0");
// %t965 @TEXT("n93", key="name", size=0.75);
// &n93 @WIRE(mode="straight") {#X181:3 %t965:p};
// %t966 = $IO_PORT @ATTACH &n228 => @PLACE(554, -385) => @ORIENT("MY");
// %t966 @TEXT("n228", key="name", size=0.75);
// &n228 @WIRE(mode="straight") {#X181:4 %t966:p};
// %t967 = $SUPPLY @ATTACH &vdd => @PLACE(544, -372);
// &vdd @WIRE(mode="straight") {#X181:5 %t967:p};
// %t968 = $GROUND @ATTACH &vss => @PLACE(544, -398);
// &vss @WIRE(mode="straight") {#X181:6 %t968:p};
// %t969 = $IO_PORT @ATTACH &n202 => @PLACE(574, -381) => @ORIENT("R0");
// %t969 @TEXT("n202", key="name", size=0.75);
// &n202 @WIRE(mode="straight") {#X182:1 %t969:p};
// %t970 = $IO_PORT @ATTACH &n220 => @PLACE(574, -385) => @ORIENT("R0");
// %t970 @TEXT("n220", key="name", size=0.75);
// &n220 @WIRE(mode="straight") {#X182:2 %t970:p};
// %t971 = $IO_PORT @ATTACH &n93 => @PLACE(574, -389) => @ORIENT("R0");
// %t971 @TEXT("n93", key="name", size=0.75);
// &n93 @WIRE(mode="straight") {#X182:3 %t971:p};
// %t972 = $IO_PORT @ATTACH &n229 => @PLACE(594, -385) => @ORIENT("MY");
// %t972 @TEXT("n229", key="name", size=0.75);
// &n229 @WIRE(mode="straight") {#X182:4 %t972:p};
// %t973 = $SUPPLY @ATTACH &vdd => @PLACE(584, -372);
// &vdd @WIRE(mode="straight") {#X182:5 %t973:p};
// %t974 = $GROUND @ATTACH &vss => @PLACE(584, -398);
// &vss @WIRE(mode="straight") {#X182:6 %t974:p};
// %t975 = $IO_PORT @ATTACH &n203 => @PLACE(614, -381) => @ORIENT("R0");
// %t975 @TEXT("n203", key="name", size=0.75);
// &n203 @WIRE(mode="straight") {#X183:1 %t975:p};
// %t976 = $IO_PORT @ATTACH &n221 => @PLACE(614, -385) => @ORIENT("R0");
// %t976 @TEXT("n221", key="name", size=0.75);
// &n221 @WIRE(mode="straight") {#X183:2 %t976:p};
// %t977 = $IO_PORT @ATTACH &n93 => @PLACE(614, -389) => @ORIENT("R0");
// %t977 @TEXT("n93", key="name", size=0.75);
// &n93 @WIRE(mode="straight") {#X183:3 %t977:p};
// %t978 = $IO_PORT @ATTACH &n230 => @PLACE(635, -385) => @ORIENT("MY");
// %t978 @TEXT("n230", key="name", size=0.75);
// &n230 @WIRE(mode="straight") {#X183:4 %t978:p};
// %t979 = $SUPPLY @ATTACH &vdd => @PLACE(624, -372);
// &vdd @WIRE(mode="straight") {#X183:5 %t979:p};
// %t980 = $GROUND @ATTACH &vss => @PLACE(624, -398);
// &vss @WIRE(mode="straight") {#X183:6 %t980:p};
// %t981 = $IO_PORT @ATTACH &n222 => @PLACE(494, -416) => @ORIENT("R0");
// %t981 @TEXT("n222", key="name", size=0.75);
// &n222 @WIRE(mode="straight") {#X184:1 %t981:p};
// %t982 = $IO_PORT @ATTACH &vss => @PLACE(494, -420) => @ORIENT("R0");
// %t982 @TEXT("vss", key="name", size=0.75);
// &vss @WIRE(mode="straight") {#X184:2 %t982:p};
// %t983 = $IO_PORT @ATTACH &n136 => @PLACE(494, -424) => @ORIENT("R0");
// %t983 @TEXT("n136", key="name", size=0.75);
// &n136 @WIRE(mode="straight") {#X184:3 %t983:p};
// %t984 = $IO_PORT @ATTACH &n231 => @PLACE(514, -420) => @ORIENT("MY");
// %t984 @TEXT("n231", key="name", size=0.75);
// &n231 @WIRE(mode="straight") {#X184:4 %t984:p};
// %t985 = $SUPPLY @ATTACH &vdd => @PLACE(504, -407);
// &vdd @WIRE(mode="straight") {#X184:5 %t985:p};
// %t986 = $GROUND @ATTACH &vss => @PLACE(504, -433);
// &vss @WIRE(mode="straight") {#X184:6 %t986:p};
// %t987 = $IO_PORT @ATTACH &n223 => @PLACE(534, -416) => @ORIENT("R0");
// %t987 @TEXT("n223", key="name", size=0.75);
// &n223 @WIRE(mode="straight") {#X185:1 %t987:p};
// %t988 = $IO_PORT @ATTACH &vss => @PLACE(534, -420) => @ORIENT("R0");
// %t988 @TEXT("vss", key="name", size=0.75);
// &vss @WIRE(mode="straight") {#X185:2 %t988:p};
// %t989 = $IO_PORT @ATTACH &n136 => @PLACE(534, -424) => @ORIENT("R0");
// %t989 @TEXT("n136", key="name", size=0.75);
// &n136 @WIRE(mode="straight") {#X185:3 %t989:p};
// %t990 = $IO_PORT @ATTACH &n232 => @PLACE(554, -420) => @ORIENT("MY");
// %t990 @TEXT("n232", key="name", size=0.75);
// &n232 @WIRE(mode="straight") {#X185:4 %t990:p};
// %t991 = $SUPPLY @ATTACH &vdd => @PLACE(544, -407);
// &vdd @WIRE(mode="straight") {#X185:5 %t991:p};
// %t992 = $GROUND @ATTACH &vss => @PLACE(544, -433);
// &vss @WIRE(mode="straight") {#X185:6 %t992:p};
// %t993 = $IO_PORT @ATTACH &n224 => @PLACE(574, -416) => @ORIENT("R0");
// %t993 @TEXT("n224", key="name", size=0.75);
// &n224 @WIRE(mode="straight") {#X186:1 %t993:p};
// %t994 = $IO_PORT @ATTACH &vss => @PLACE(574, -420) => @ORIENT("R0");
// %t994 @TEXT("vss", key="name", size=0.75);
// &vss @WIRE(mode="straight") {#X186:2 %t994:p};
// %t995 = $IO_PORT @ATTACH &n136 => @PLACE(574, -424) => @ORIENT("R0");
// %t995 @TEXT("n136", key="name", size=0.75);
// &n136 @WIRE(mode="straight") {#X186:3 %t995:p};
// %t996 = $IO_PORT @ATTACH &n233 => @PLACE(594, -420) => @ORIENT("MY");
// %t996 @TEXT("n233", key="name", size=0.75);
// &n233 @WIRE(mode="straight") {#X186:4 %t996:p};
// %t997 = $SUPPLY @ATTACH &vdd => @PLACE(584, -407);
// &vdd @WIRE(mode="straight") {#X186:5 %t997:p};
// %t998 = $GROUND @ATTACH &vss => @PLACE(584, -433);
// &vss @WIRE(mode="straight") {#X186:6 %t998:p};
// %t999 = $IO_PORT @ATTACH &n225 => @PLACE(614, -416) => @ORIENT("R0");
// %t999 @TEXT("n225", key="name", size=0.75);
// &n225 @WIRE(mode="straight") {#X187:1 %t999:p};
// %t1000 = $IO_PORT @ATTACH &vss => @PLACE(614, -420) => @ORIENT("R0");
// %t1000 @TEXT("vss", key="name", size=0.75);
// &vss @WIRE(mode="straight") {#X187:2 %t1000:p};
// %t1001 = $IO_PORT @ATTACH &n136 => @PLACE(614, -424) => @ORIENT("R0");
// %t1001 @TEXT("n136", key="name", size=0.75);
// &n136 @WIRE(mode="straight") {#X187:3 %t1001:p};
// %t1002 = $IO_PORT @ATTACH &n234 => @PLACE(635, -420) => @ORIENT("MY");
// %t1002 @TEXT("n234", key="name", size=0.75);
// &n234 @WIRE(mode="straight") {#X187:4 %t1002:p};
// %t1003 = $SUPPLY @ATTACH &vdd => @PLACE(624, -407);
// &vdd @WIRE(mode="straight") {#X187:5 %t1003:p};
// %t1004 = $GROUND @ATTACH &vss => @PLACE(624, -433);
// &vss @WIRE(mode="straight") {#X187:6 %t1004:p};
// %t1005 = $IO_PORT @ATTACH &n226 => @PLACE(494, -451) => @ORIENT("R0");
// %t1005 @TEXT("n226", key="name", size=0.75);
// &n226 @WIRE(mode="straight") {#X188:1 %t1005:p};
// %t1006 = $IO_PORT @ATTACH &vss => @PLACE(494, -455) => @ORIENT("R0");
// %t1006 @TEXT("vss", key="name", size=0.75);
// &vss @WIRE(mode="straight") {#X188:2 %t1006:p};
// %t1007 = $IO_PORT @ATTACH &n136 => @PLACE(494, -459) => @ORIENT("R0");
// %t1007 @TEXT("n136", key="name", size=0.75);
// &n136 @WIRE(mode="straight") {#X188:3 %t1007:p};
// %t1008 = $IO_PORT @ATTACH &n235 => @PLACE(514, -455) => @ORIENT("MY");
// %t1008 @TEXT("n235", key="name", size=0.75);
// &n235 @WIRE(mode="straight") {#X188:4 %t1008:p};
// %t1009 = $SUPPLY @ATTACH &vdd => @PLACE(504, -442);
// &vdd @WIRE(mode="straight") {#X188:5 %t1009:p};
// %t1010 = $GROUND @ATTACH &vss => @PLACE(504, -468);
// &vss @WIRE(mode="straight") {#X188:6 %t1010:p};
// %t1011 = $IO_PORT @ATTACH &n227 => @PLACE(534, -451) => @ORIENT("R0");
// %t1011 @TEXT("n227", key="name", size=0.75);
// &n227 @WIRE(mode="straight") {#X189:1 %t1011:p};
// %t1012 = $IO_PORT @ATTACH &vss => @PLACE(534, -455) => @ORIENT("R0");
// %t1012 @TEXT("vss", key="name", size=0.75);
// &vss @WIRE(mode="straight") {#X189:2 %t1012:p};
// %t1013 = $IO_PORT @ATTACH &n136 => @PLACE(534, -459) => @ORIENT("R0");
// %t1013 @TEXT("n136", key="name", size=0.75);
// &n136 @WIRE(mode="straight") {#X189:3 %t1013:p};
// %t1014 = $IO_PORT @ATTACH &n236 => @PLACE(554, -455) => @ORIENT("MY");
// %t1014 @TEXT("n236", key="name", size=0.75);
// &n236 @WIRE(mode="straight") {#X189:4 %t1014:p};
// %t1015 = $SUPPLY @ATTACH &vdd => @PLACE(544, -442);
// &vdd @WIRE(mode="straight") {#X189:5 %t1015:p};
// %t1016 = $GROUND @ATTACH &vss => @PLACE(544, -468);
// &vss @WIRE(mode="straight") {#X189:6 %t1016:p};
// %t1017 = $IO_PORT @ATTACH &n228 => @PLACE(574, -451) => @ORIENT("R0");
// %t1017 @TEXT("n228", key="name", size=0.75);
// &n228 @WIRE(mode="straight") {#X190:1 %t1017:p};
// %t1018 = $IO_PORT @ATTACH &vss => @PLACE(574, -455) => @ORIENT("R0");
// %t1018 @TEXT("vss", key="name", size=0.75);
// &vss @WIRE(mode="straight") {#X190:2 %t1018:p};
// %t1019 = $IO_PORT @ATTACH &n136 => @PLACE(574, -459) => @ORIENT("R0");
// %t1019 @TEXT("n136", key="name", size=0.75);
// &n136 @WIRE(mode="straight") {#X190:3 %t1019:p};
// %t1020 = $IO_PORT @ATTACH &n237 => @PLACE(594, -455) => @ORIENT("MY");
// %t1020 @TEXT("n237", key="name", size=0.75);
// &n237 @WIRE(mode="straight") {#X190:4 %t1020:p};
// %t1021 = $SUPPLY @ATTACH &vdd => @PLACE(584, -442);
// &vdd @WIRE(mode="straight") {#X190:5 %t1021:p};
// %t1022 = $GROUND @ATTACH &vss => @PLACE(584, -468);
// &vss @WIRE(mode="straight") {#X190:6 %t1022:p};
// %t1023 = $IO_PORT @ATTACH &n229 => @PLACE(614, -451) => @ORIENT("R0");
// %t1023 @TEXT("n229", key="name", size=0.75);
// &n229 @WIRE(mode="straight") {#X191:1 %t1023:p};
// %t1024 = $IO_PORT @ATTACH &vss => @PLACE(614, -455) => @ORIENT("R0");
// %t1024 @TEXT("vss", key="name", size=0.75);
// &vss @WIRE(mode="straight") {#X191:2 %t1024:p};
// %t1025 = $IO_PORT @ATTACH &n136 => @PLACE(614, -459) => @ORIENT("R0");
// %t1025 @TEXT("n136", key="name", size=0.75);
// &n136 @WIRE(mode="straight") {#X191:3 %t1025:p};
// %t1026 = $IO_PORT @ATTACH &n238 => @PLACE(635, -455) => @ORIENT("MY");
// %t1026 @TEXT("n238", key="name", size=0.75);
// &n238 @WIRE(mode="straight") {#X191:4 %t1026:p};
// %t1027 = $SUPPLY @ATTACH &vdd => @PLACE(624, -442);
// &vdd @WIRE(mode="straight") {#X191:5 %t1027:p};
// %t1028 = $GROUND @ATTACH &vss => @PLACE(624, -468);
// &vss @WIRE(mode="straight") {#X191:6 %t1028:p};
// %t1029 = $IO_PORT @ATTACH &n230 => @PLACE(-11, -496) => @ORIENT("R0");
// %t1029 @TEXT("n230", key="name", size=0.75);
// &n230 @WIRE(mode="straight") {#X192:1 %t1029:p};
// %t1030 = $IO_PORT @ATTACH &vss => @PLACE(-11, -500) => @ORIENT("R0");
// %t1030 @TEXT("vss", key="name", size=0.75);
// &vss @WIRE(mode="straight") {#X192:2 %t1030:p};
// %t1031 = $IO_PORT @ATTACH &n136 => @PLACE(-11, -504) => @ORIENT("R0");
// %t1031 @TEXT("n136", key="name", size=0.75);
// &n136 @WIRE(mode="straight") {#X192:3 %t1031:p};
// %t1032 = $IO_PORT @ATTACH &n239 => @PLACE(10, -500) => @ORIENT("MY");
// %t1032 @TEXT("n239", key="name", size=0.75);
// &n239 @WIRE(mode="straight") {#X192:4 %t1032:p};
// %t1033 = $SUPPLY @ATTACH &vdd => @PLACE(0, -487);
// &vdd @WIRE(mode="straight") {#X192:5 %t1033:p};
// %t1034 = $GROUND @ATTACH &vss => @PLACE(0, -513);
// &vss @WIRE(mode="straight") {#X192:6 %t1034:p};
// %t1035 = $IO_PORT @ATTACH &vss => @PLACE(30, -496) => @ORIENT("R0");
// %t1035 @TEXT("vss", key="name", size=0.75);
// &vss @WIRE(mode="straight") {#X193:1 %t1035:p};
// %t1036 = $IO_PORT @ATTACH &n231 => @PLACE(30, -500) => @ORIENT("R0");
// %t1036 @TEXT("n231", key="name", size=0.75);
// &n231 @WIRE(mode="straight") {#X193:2 %t1036:p};
// %t1037 = $IO_PORT @ATTACH &fll_enable => @PLACE(30, -504) => @ORIENT("R0");
// %t1037 @TEXT("fll_enable", key="name", size=0.75);
// &fll_enable @WIRE(mode="straight") {#X193:3 %t1037:p};
// %t1038 = $IO_PORT @ATTACH &n240 => @PLACE(50, -500) => @ORIENT("MY");
// %t1038 @TEXT("n240", key="name", size=0.75);
// &n240 @WIRE(mode="straight") {#X193:4 %t1038:p};
// %t1039 = $SUPPLY @ATTACH &vdd => @PLACE(40, -487);
// &vdd @WIRE(mode="straight") {#X193:5 %t1039:p};
// %t1040 = $GROUND @ATTACH &vss => @PLACE(40, -513);
// &vss @WIRE(mode="straight") {#X193:6 %t1040:p};
// %t1041 = $IO_PORT @ATTACH &vss => @PLACE(70, -496) => @ORIENT("R0");
// %t1041 @TEXT("vss", key="name", size=0.75);
// &vss @WIRE(mode="straight") {#X194:1 %t1041:p};
// %t1042 = $IO_PORT @ATTACH &n232 => @PLACE(70, -500) => @ORIENT("R0");
// %t1042 @TEXT("n232", key="name", size=0.75);
// &n232 @WIRE(mode="straight") {#X194:2 %t1042:p};
// %t1043 = $IO_PORT @ATTACH &fll_enable => @PLACE(70, -504) => @ORIENT("R0");
// %t1043 @TEXT("fll_enable", key="name", size=0.75);
// &fll_enable @WIRE(mode="straight") {#X194:3 %t1043:p};
// %t1044 = $IO_PORT @ATTACH &n241 => @PLACE(90, -500) => @ORIENT("MY");
// %t1044 @TEXT("n241", key="name", size=0.75);
// &n241 @WIRE(mode="straight") {#X194:4 %t1044:p};
// %t1045 = $SUPPLY @ATTACH &vdd => @PLACE(80, -487);
// &vdd @WIRE(mode="straight") {#X194:5 %t1045:p};
// %t1046 = $GROUND @ATTACH &vss => @PLACE(80, -513);
// &vss @WIRE(mode="straight") {#X194:6 %t1046:p};
// %t1047 = $IO_PORT @ATTACH &vss => @PLACE(110, -496) => @ORIENT("R0");
// %t1047 @TEXT("vss", key="name", size=0.75);
// &vss @WIRE(mode="straight") {#X195:1 %t1047:p};
// %t1048 = $IO_PORT @ATTACH &n233 => @PLACE(110, -500) => @ORIENT("R0");
// %t1048 @TEXT("n233", key="name", size=0.75);
// &n233 @WIRE(mode="straight") {#X195:2 %t1048:p};
// %t1049 = $IO_PORT @ATTACH &fll_enable => @PLACE(110, -504) => @ORIENT("R0");
// %t1049 @TEXT("fll_enable", key="name", size=0.75);
// &fll_enable @WIRE(mode="straight") {#X195:3 %t1049:p};
// %t1050 = $IO_PORT @ATTACH &n242 => @PLACE(130, -500) => @ORIENT("MY");
// %t1050 @TEXT("n242", key="name", size=0.75);
// &n242 @WIRE(mode="straight") {#X195:4 %t1050:p};
// %t1051 = $SUPPLY @ATTACH &vdd => @PLACE(120, -487);
// &vdd @WIRE(mode="straight") {#X195:5 %t1051:p};
// %t1052 = $GROUND @ATTACH &vss => @PLACE(120, -513);
// &vss @WIRE(mode="straight") {#X195:6 %t1052:p};
// %t1053 = $IO_PORT @ATTACH &vss => @PLACE(-11, -531) => @ORIENT("R0");
// %t1053 @TEXT("vss", key="name", size=0.75);
// &vss @WIRE(mode="straight") {#X196:1 %t1053:p};
// %t1054 = $IO_PORT @ATTACH &n234 => @PLACE(-11, -535) => @ORIENT("R0");
// %t1054 @TEXT("n234", key="name", size=0.75);
// &n234 @WIRE(mode="straight") {#X196:2 %t1054:p};
// %t1055 = $IO_PORT @ATTACH &fll_enable => @PLACE(-11, -539) => @ORIENT("R0");
// %t1055 @TEXT("fll_enable", key="name", size=0.75);
// &fll_enable @WIRE(mode="straight") {#X196:3 %t1055:p};
// %t1056 = $IO_PORT @ATTACH &n243 => @PLACE(10, -535) => @ORIENT("MY");
// %t1056 @TEXT("n243", key="name", size=0.75);
// &n243 @WIRE(mode="straight") {#X196:4 %t1056:p};
// %t1057 = $SUPPLY @ATTACH &vdd => @PLACE(0, -522);
// &vdd @WIRE(mode="straight") {#X196:5 %t1057:p};
// %t1058 = $GROUND @ATTACH &vss => @PLACE(0, -548);
// &vss @WIRE(mode="straight") {#X196:6 %t1058:p};
// %t1059 = $IO_PORT @ATTACH &vss => @PLACE(30, -531) => @ORIENT("R0");
// %t1059 @TEXT("vss", key="name", size=0.75);
// &vss @WIRE(mode="straight") {#X197:1 %t1059:p};
// %t1060 = $IO_PORT @ATTACH &n235 => @PLACE(30, -535) => @ORIENT("R0");
// %t1060 @TEXT("n235", key="name", size=0.75);
// &n235 @WIRE(mode="straight") {#X197:2 %t1060:p};
// %t1061 = $IO_PORT @ATTACH &fll_enable => @PLACE(30, -539) => @ORIENT("R0");
// %t1061 @TEXT("fll_enable", key="name", size=0.75);
// &fll_enable @WIRE(mode="straight") {#X197:3 %t1061:p};
// %t1062 = $IO_PORT @ATTACH &n244 => @PLACE(50, -535) => @ORIENT("MY");
// %t1062 @TEXT("n244", key="name", size=0.75);
// &n244 @WIRE(mode="straight") {#X197:4 %t1062:p};
// %t1063 = $SUPPLY @ATTACH &vdd => @PLACE(40, -522);
// &vdd @WIRE(mode="straight") {#X197:5 %t1063:p};
// %t1064 = $GROUND @ATTACH &vss => @PLACE(40, -548);
// &vss @WIRE(mode="straight") {#X197:6 %t1064:p};
// %t1065 = $IO_PORT @ATTACH &vss => @PLACE(70, -531) => @ORIENT("R0");
// %t1065 @TEXT("vss", key="name", size=0.75);
// &vss @WIRE(mode="straight") {#X198:1 %t1065:p};
// %t1066 = $IO_PORT @ATTACH &n236 => @PLACE(70, -535) => @ORIENT("R0");
// %t1066 @TEXT("n236", key="name", size=0.75);
// &n236 @WIRE(mode="straight") {#X198:2 %t1066:p};
// %t1067 = $IO_PORT @ATTACH &fll_enable => @PLACE(70, -539) => @ORIENT("R0");
// %t1067 @TEXT("fll_enable", key="name", size=0.75);
// &fll_enable @WIRE(mode="straight") {#X198:3 %t1067:p};
// %t1068 = $IO_PORT @ATTACH &n245 => @PLACE(90, -535) => @ORIENT("MY");
// %t1068 @TEXT("n245", key="name", size=0.75);
// &n245 @WIRE(mode="straight") {#X198:4 %t1068:p};
// %t1069 = $SUPPLY @ATTACH &vdd => @PLACE(80, -522);
// &vdd @WIRE(mode="straight") {#X198:5 %t1069:p};
// %t1070 = $GROUND @ATTACH &vss => @PLACE(80, -548);
// &vss @WIRE(mode="straight") {#X198:6 %t1070:p};
// %t1071 = $IO_PORT @ATTACH &vss => @PLACE(110, -531) => @ORIENT("R0");
// %t1071 @TEXT("vss", key="name", size=0.75);
// &vss @WIRE(mode="straight") {#X199:1 %t1071:p};
// %t1072 = $IO_PORT @ATTACH &n237 => @PLACE(110, -535) => @ORIENT("R0");
// %t1072 @TEXT("n237", key="name", size=0.75);
// &n237 @WIRE(mode="straight") {#X199:2 %t1072:p};
// %t1073 = $IO_PORT @ATTACH &fll_enable => @PLACE(110, -539) => @ORIENT("R0");
// %t1073 @TEXT("fll_enable", key="name", size=0.75);
// &fll_enable @WIRE(mode="straight") {#X199:3 %t1073:p};
// %t1074 = $IO_PORT @ATTACH &n246 => @PLACE(130, -535) => @ORIENT("MY");
// %t1074 @TEXT("n246", key="name", size=0.75);
// &n246 @WIRE(mode="straight") {#X199:4 %t1074:p};
// %t1075 = $SUPPLY @ATTACH &vdd => @PLACE(120, -522);
// &vdd @WIRE(mode="straight") {#X199:5 %t1075:p};
// %t1076 = $GROUND @ATTACH &vss => @PLACE(120, -548);
// &vss @WIRE(mode="straight") {#X199:6 %t1076:p};
// %t1077 = $IO_PORT @ATTACH &vss => @PLACE(-11, -566) => @ORIENT("R0");
// %t1077 @TEXT("vss", key="name", size=0.75);
// &vss @WIRE(mode="straight") {#X200:1 %t1077:p};
// %t1078 = $IO_PORT @ATTACH &n238 => @PLACE(-11, -570) => @ORIENT("R0");
// %t1078 @TEXT("n238", key="name", size=0.75);
// &n238 @WIRE(mode="straight") {#X200:2 %t1078:p};
// %t1079 = $IO_PORT @ATTACH &fll_enable => @PLACE(-11, -574) => @ORIENT("R0");
// %t1079 @TEXT("fll_enable", key="name", size=0.75);
// &fll_enable @WIRE(mode="straight") {#X200:3 %t1079:p};
// %t1080 = $IO_PORT @ATTACH &n247 => @PLACE(10, -570) => @ORIENT("MY");
// %t1080 @TEXT("n247", key="name", size=0.75);
// &n247 @WIRE(mode="straight") {#X200:4 %t1080:p};
// %t1081 = $SUPPLY @ATTACH &vdd => @PLACE(0, -557);
// &vdd @WIRE(mode="straight") {#X200:5 %t1081:p};
// %t1082 = $GROUND @ATTACH &vss => @PLACE(0, -583);
// &vss @WIRE(mode="straight") {#X200:6 %t1082:p};
// %t1083 = $IO_PORT @ATTACH &vss => @PLACE(30, -566) => @ORIENT("R0");
// %t1083 @TEXT("vss", key="name", size=0.75);
// &vss @WIRE(mode="straight") {#X201:1 %t1083:p};
// %t1084 = $IO_PORT @ATTACH &n239 => @PLACE(30, -570) => @ORIENT("R0");
// %t1084 @TEXT("n239", key="name", size=0.75);
// &n239 @WIRE(mode="straight") {#X201:2 %t1084:p};
// %t1085 = $IO_PORT @ATTACH &fll_enable => @PLACE(30, -574) => @ORIENT("R0");
// %t1085 @TEXT("fll_enable", key="name", size=0.75);
// &fll_enable @WIRE(mode="straight") {#X201:3 %t1085:p};
// %t1086 = $IO_PORT @ATTACH &n248 => @PLACE(50, -570) => @ORIENT("MY");
// %t1086 @TEXT("n248", key="name", size=0.75);
// &n248 @WIRE(mode="straight") {#X201:4 %t1086:p};
// %t1087 = $SUPPLY @ATTACH &vdd => @PLACE(40, -557);
// &vdd @WIRE(mode="straight") {#X201:5 %t1087:p};
// %t1088 = $GROUND @ATTACH &vss => @PLACE(40, -583);
// &vss @WIRE(mode="straight") {#X201:6 %t1088:p};
// %t1089 = $IO_PORT @ATTACH &n240 => @PLACE(70, -566) => @ORIENT("R0");
// %t1089 @TEXT("n240", key="name", size=0.75);
// &n240 @WIRE(mode="straight") {#X202:1 %t1089:p};
// %t1090 = $IO_PORT @ATTACH &vss => @PLACE(70, -570) => @ORIENT("R0");
// %t1090 @TEXT("vss", key="name", size=0.75);
// &vss @WIRE(mode="straight") {#X202:2 %t1090:p};
// %t1091 = $IO_PORT @ATTACH &restart => @PLACE(70, -574) => @ORIENT("R0");
// %t1091 @TEXT("restart", key="name", size=0.75);
// &restart @WIRE(mode="straight") {#X202:3 %t1091:p};
// %t1092 = $IO_PORT @ATTACH &n249 => @PLACE(90, -570) => @ORIENT("MY");
// %t1092 @TEXT("n249", key="name", size=0.75);
// &n249 @WIRE(mode="straight") {#X202:4 %t1092:p};
// %t1093 = $SUPPLY @ATTACH &vdd => @PLACE(80, -557);
// &vdd @WIRE(mode="straight") {#X202:5 %t1093:p};
// %t1094 = $GROUND @ATTACH &vss => @PLACE(80, -583);
// &vss @WIRE(mode="straight") {#X202:6 %t1094:p};
// %t1095 = $IO_PORT @ATTACH &n241 => @PLACE(110, -566) => @ORIENT("R0");
// %t1095 @TEXT("n241", key="name", size=0.75);
// &n241 @WIRE(mode="straight") {#X203:1 %t1095:p};
// %t1096 = $IO_PORT @ATTACH &vss => @PLACE(110, -570) => @ORIENT("R0");
// %t1096 @TEXT("vss", key="name", size=0.75);
// &vss @WIRE(mode="straight") {#X203:2 %t1096:p};
// %t1097 = $IO_PORT @ATTACH &restart => @PLACE(110, -574) => @ORIENT("R0");
// %t1097 @TEXT("restart", key="name", size=0.75);
// &restart @WIRE(mode="straight") {#X203:3 %t1097:p};
// %t1098 = $IO_PORT @ATTACH &n250 => @PLACE(130, -570) => @ORIENT("MY");
// %t1098 @TEXT("n250", key="name", size=0.75);
// &n250 @WIRE(mode="straight") {#X203:4 %t1098:p};
// %t1099 = $SUPPLY @ATTACH &vdd => @PLACE(120, -557);
// &vdd @WIRE(mode="straight") {#X203:5 %t1099:p};
// %t1100 = $GROUND @ATTACH &vss => @PLACE(120, -583);
// &vss @WIRE(mode="straight") {#X203:6 %t1100:p};
// %t1101 = $IO_PORT @ATTACH &n242 => @PLACE(-11, -601) => @ORIENT("R0");
// %t1101 @TEXT("n242", key="name", size=0.75);
// &n242 @WIRE(mode="straight") {#X204:1 %t1101:p};
// %t1102 = $IO_PORT @ATTACH &vss => @PLACE(-11, -605) => @ORIENT("R0");
// %t1102 @TEXT("vss", key="name", size=0.75);
// &vss @WIRE(mode="straight") {#X204:2 %t1102:p};
// %t1103 = $IO_PORT @ATTACH &restart => @PLACE(-11, -609) => @ORIENT("R0");
// %t1103 @TEXT("restart", key="name", size=0.75);
// &restart @WIRE(mode="straight") {#X204:3 %t1103:p};
// %t1104 = $IO_PORT @ATTACH &n251 => @PLACE(10, -605) => @ORIENT("MY");
// %t1104 @TEXT("n251", key="name", size=0.75);
// &n251 @WIRE(mode="straight") {#X204:4 %t1104:p};
// %t1105 = $SUPPLY @ATTACH &vdd => @PLACE(0, -592);
// &vdd @WIRE(mode="straight") {#X204:5 %t1105:p};
// %t1106 = $GROUND @ATTACH &vss => @PLACE(0, -618);
// &vss @WIRE(mode="straight") {#X204:6 %t1106:p};
// %t1107 = $IO_PORT @ATTACH &n243 => @PLACE(30, -601) => @ORIENT("R0");
// %t1107 @TEXT("n243", key="name", size=0.75);
// &n243 @WIRE(mode="straight") {#X205:1 %t1107:p};
// %t1108 = $IO_PORT @ATTACH &vss => @PLACE(30, -605) => @ORIENT("R0");
// %t1108 @TEXT("vss", key="name", size=0.75);
// &vss @WIRE(mode="straight") {#X205:2 %t1108:p};
// %t1109 = $IO_PORT @ATTACH &restart => @PLACE(30, -609) => @ORIENT("R0");
// %t1109 @TEXT("restart", key="name", size=0.75);
// &restart @WIRE(mode="straight") {#X205:3 %t1109:p};
// %t1110 = $IO_PORT @ATTACH &n252 => @PLACE(50, -605) => @ORIENT("MY");
// %t1110 @TEXT("n252", key="name", size=0.75);
// &n252 @WIRE(mode="straight") {#X205:4 %t1110:p};
// %t1111 = $SUPPLY @ATTACH &vdd => @PLACE(40, -592);
// &vdd @WIRE(mode="straight") {#X205:5 %t1111:p};
// %t1112 = $GROUND @ATTACH &vss => @PLACE(40, -618);
// &vss @WIRE(mode="straight") {#X205:6 %t1112:p};
// %t1113 = $IO_PORT @ATTACH &n244 => @PLACE(70, -601) => @ORIENT("R0");
// %t1113 @TEXT("n244", key="name", size=0.75);
// &n244 @WIRE(mode="straight") {#X206:1 %t1113:p};
// %t1114 = $IO_PORT @ATTACH &vss => @PLACE(70, -605) => @ORIENT("R0");
// %t1114 @TEXT("vss", key="name", size=0.75);
// &vss @WIRE(mode="straight") {#X206:2 %t1114:p};
// %t1115 = $IO_PORT @ATTACH &restart => @PLACE(70, -609) => @ORIENT("R0");
// %t1115 @TEXT("restart", key="name", size=0.75);
// &restart @WIRE(mode="straight") {#X206:3 %t1115:p};
// %t1116 = $IO_PORT @ATTACH &n253 => @PLACE(90, -605) => @ORIENT("MY");
// %t1116 @TEXT("n253", key="name", size=0.75);
// &n253 @WIRE(mode="straight") {#X206:4 %t1116:p};
// %t1117 = $SUPPLY @ATTACH &vdd => @PLACE(80, -592);
// &vdd @WIRE(mode="straight") {#X206:5 %t1117:p};
// %t1118 = $GROUND @ATTACH &vss => @PLACE(80, -618);
// &vss @WIRE(mode="straight") {#X206:6 %t1118:p};
// %t1119 = $IO_PORT @ATTACH &n245 => @PLACE(110, -601) => @ORIENT("R0");
// %t1119 @TEXT("n245", key="name", size=0.75);
// &n245 @WIRE(mode="straight") {#X207:1 %t1119:p};
// %t1120 = $IO_PORT @ATTACH &vss => @PLACE(110, -605) => @ORIENT("R0");
// %t1120 @TEXT("vss", key="name", size=0.75);
// &vss @WIRE(mode="straight") {#X207:2 %t1120:p};
// %t1121 = $IO_PORT @ATTACH &restart => @PLACE(110, -609) => @ORIENT("R0");
// %t1121 @TEXT("restart", key="name", size=0.75);
// &restart @WIRE(mode="straight") {#X207:3 %t1121:p};
// %t1122 = $IO_PORT @ATTACH &n254 => @PLACE(130, -605) => @ORIENT("MY");
// %t1122 @TEXT("n254", key="name", size=0.75);
// &n254 @WIRE(mode="straight") {#X207:4 %t1122:p};
// %t1123 = $SUPPLY @ATTACH &vdd => @PLACE(120, -592);
// &vdd @WIRE(mode="straight") {#X207:5 %t1123:p};
// %t1124 = $GROUND @ATTACH &vss => @PLACE(120, -618);
// &vss @WIRE(mode="straight") {#X207:6 %t1124:p};
// %t1125 = $IO_PORT @ATTACH &n246 => @PLACE(-11, -636) => @ORIENT("R0");
// %t1125 @TEXT("n246", key="name", size=0.75);
// &n246 @WIRE(mode="straight") {#X208:1 %t1125:p};
// %t1126 = $IO_PORT @ATTACH &vss => @PLACE(-11, -640) => @ORIENT("R0");
// %t1126 @TEXT("vss", key="name", size=0.75);
// &vss @WIRE(mode="straight") {#X208:2 %t1126:p};
// %t1127 = $IO_PORT @ATTACH &restart => @PLACE(-11, -644) => @ORIENT("R0");
// %t1127 @TEXT("restart", key="name", size=0.75);
// &restart @WIRE(mode="straight") {#X208:3 %t1127:p};
// %t1128 = $IO_PORT @ATTACH &n255 => @PLACE(10, -640) => @ORIENT("MY");
// %t1128 @TEXT("n255", key="name", size=0.75);
// &n255 @WIRE(mode="straight") {#X208:4 %t1128:p};
// %t1129 = $SUPPLY @ATTACH &vdd => @PLACE(0, -627);
// &vdd @WIRE(mode="straight") {#X208:5 %t1129:p};
// %t1130 = $GROUND @ATTACH &vss => @PLACE(0, -653);
// &vss @WIRE(mode="straight") {#X208:6 %t1130:p};
// %t1131 = $IO_PORT @ATTACH &n247 => @PLACE(30, -636) => @ORIENT("R0");
// %t1131 @TEXT("n247", key="name", size=0.75);
// &n247 @WIRE(mode="straight") {#X209:1 %t1131:p};
// %t1132 = $IO_PORT @ATTACH &vss => @PLACE(30, -640) => @ORIENT("R0");
// %t1132 @TEXT("vss", key="name", size=0.75);
// &vss @WIRE(mode="straight") {#X209:2 %t1132:p};
// %t1133 = $IO_PORT @ATTACH &restart => @PLACE(30, -644) => @ORIENT("R0");
// %t1133 @TEXT("restart", key="name", size=0.75);
// &restart @WIRE(mode="straight") {#X209:3 %t1133:p};
// %t1134 = $IO_PORT @ATTACH &n256 => @PLACE(50, -640) => @ORIENT("MY");
// %t1134 @TEXT("n256", key="name", size=0.75);
// &n256 @WIRE(mode="straight") {#X209:4 %t1134:p};
// %t1135 = $SUPPLY @ATTACH &vdd => @PLACE(40, -627);
// &vdd @WIRE(mode="straight") {#X209:5 %t1135:p};
// %t1136 = $GROUND @ATTACH &vss => @PLACE(40, -653);
// &vss @WIRE(mode="straight") {#X209:6 %t1136:p};
// %t1137 = $IO_PORT @ATTACH &n248 => @PLACE(70, -636) => @ORIENT("R0");
// %t1137 @TEXT("n248", key="name", size=0.75);
// &n248 @WIRE(mode="straight") {#X210:1 %t1137:p};
// %t1138 = $IO_PORT @ATTACH &vss => @PLACE(70, -640) => @ORIENT("R0");
// %t1138 @TEXT("vss", key="name", size=0.75);
// &vss @WIRE(mode="straight") {#X210:2 %t1138:p};
// %t1139 = $IO_PORT @ATTACH &restart => @PLACE(70, -644) => @ORIENT("R0");
// %t1139 @TEXT("restart", key="name", size=0.75);
// &restart @WIRE(mode="straight") {#X210:3 %t1139:p};
// %t1140 = $IO_PORT @ATTACH &n257 => @PLACE(90, -640) => @ORIENT("MY");
// %t1140 @TEXT("n257", key="name", size=0.75);
// &n257 @WIRE(mode="straight") {#X210:4 %t1140:p};
// %t1141 = $SUPPLY @ATTACH &vdd => @PLACE(80, -627);
// &vdd @WIRE(mode="straight") {#X210:5 %t1141:p};
// %t1142 = $GROUND @ATTACH &vss => @PLACE(80, -653);
// &vss @WIRE(mode="straight") {#X210:6 %t1142:p};
// %t1143 = $IO_PORT @ATTACH &n249 => @PLACE(110, -636) => @ORIENT("R0");
// %t1143 @TEXT("n249", key="name", size=0.75);
// &n249 @WIRE(mode="straight") {#X211:1 %t1143:p};
// %t1144 = $IO_PORT @ATTACH &vss => @PLACE(110, -640) => @ORIENT("R0");
// %t1144 @TEXT("vss", key="name", size=0.75);
// &vss @WIRE(mode="straight") {#X211:2 %t1144:p};
// %t1145 = $IO_PORT @ATTACH &range_error => @PLACE(110, -644) => @ORIENT("R0");
// %t1145 @TEXT("range_error", key="name", size=0.75);
// &range_error @WIRE(mode="straight") {#X211:3 %t1145:p};
// %t1146 = $IO_PORT @ATTACH &n258 => @PLACE(130, -640) => @ORIENT("MY");
// %t1146 @TEXT("n258", key="name", size=0.75);
// &n258 @WIRE(mode="straight") {#X211:4 %t1146:p};
// %t1147 = $SUPPLY @ATTACH &vdd => @PLACE(120, -627);
// &vdd @WIRE(mode="straight") {#X211:5 %t1147:p};
// %t1148 = $GROUND @ATTACH &vss => @PLACE(120, -653);
// &vss @WIRE(mode="straight") {#X211:6 %t1148:p};
// %t1149 = $IO_PORT @ATTACH &n250 => @PLACE(-11, -671) => @ORIENT("R0");
// %t1149 @TEXT("n250", key="name", size=0.75);
// &n250 @WIRE(mode="straight") {#X212:1 %t1149:p};
// %t1150 = $IO_PORT @ATTACH &vss => @PLACE(-11, -675) => @ORIENT("R0");
// %t1150 @TEXT("vss", key="name", size=0.75);
// &vss @WIRE(mode="straight") {#X212:2 %t1150:p};
// %t1151 = $IO_PORT @ATTACH &range_error => @PLACE(-11, -679) => @ORIENT("R0");
// %t1151 @TEXT("range_error", key="name", size=0.75);
// &range_error @WIRE(mode="straight") {#X212:3 %t1151:p};
// %t1152 = $IO_PORT @ATTACH &n259 => @PLACE(10, -675) => @ORIENT("MY");
// %t1152 @TEXT("n259", key="name", size=0.75);
// &n259 @WIRE(mode="straight") {#X212:4 %t1152:p};
// %t1153 = $SUPPLY @ATTACH &vdd => @PLACE(0, -662);
// &vdd @WIRE(mode="straight") {#X212:5 %t1153:p};
// %t1154 = $GROUND @ATTACH &vss => @PLACE(0, -688);
// &vss @WIRE(mode="straight") {#X212:6 %t1154:p};
// %t1155 = $IO_PORT @ATTACH &n251 => @PLACE(30, -671) => @ORIENT("R0");
// %t1155 @TEXT("n251", key="name", size=0.75);
// &n251 @WIRE(mode="straight") {#X213:1 %t1155:p};
// %t1156 = $IO_PORT @ATTACH &vss => @PLACE(30, -675) => @ORIENT("R0");
// %t1156 @TEXT("vss", key="name", size=0.75);
// &vss @WIRE(mode="straight") {#X213:2 %t1156:p};
// %t1157 = $IO_PORT @ATTACH &range_error => @PLACE(30, -679) => @ORIENT("R0");
// %t1157 @TEXT("range_error", key="name", size=0.75);
// &range_error @WIRE(mode="straight") {#X213:3 %t1157:p};
// %t1158 = $IO_PORT @ATTACH &n260 => @PLACE(50, -675) => @ORIENT("MY");
// %t1158 @TEXT("n260", key="name", size=0.75);
// &n260 @WIRE(mode="straight") {#X213:4 %t1158:p};
// %t1159 = $SUPPLY @ATTACH &vdd => @PLACE(40, -662);
// &vdd @WIRE(mode="straight") {#X213:5 %t1159:p};
// %t1160 = $GROUND @ATTACH &vss => @PLACE(40, -688);
// &vss @WIRE(mode="straight") {#X213:6 %t1160:p};
// %t1161 = $IO_PORT @ATTACH &n252 => @PLACE(70, -671) => @ORIENT("R0");
// %t1161 @TEXT("n252", key="name", size=0.75);
// &n252 @WIRE(mode="straight") {#X214:1 %t1161:p};
// %t1162 = $IO_PORT @ATTACH &vss => @PLACE(70, -675) => @ORIENT("R0");
// %t1162 @TEXT("vss", key="name", size=0.75);
// &vss @WIRE(mode="straight") {#X214:2 %t1162:p};
// %t1163 = $IO_PORT @ATTACH &range_error => @PLACE(70, -679) => @ORIENT("R0");
// %t1163 @TEXT("range_error", key="name", size=0.75);
// &range_error @WIRE(mode="straight") {#X214:3 %t1163:p};
// %t1164 = $IO_PORT @ATTACH &n261 => @PLACE(90, -675) => @ORIENT("MY");
// %t1164 @TEXT("n261", key="name", size=0.75);
// &n261 @WIRE(mode="straight") {#X214:4 %t1164:p};
// %t1165 = $SUPPLY @ATTACH &vdd => @PLACE(80, -662);
// &vdd @WIRE(mode="straight") {#X214:5 %t1165:p};
// %t1166 = $GROUND @ATTACH &vss => @PLACE(80, -688);
// &vss @WIRE(mode="straight") {#X214:6 %t1166:p};
// %t1167 = $IO_PORT @ATTACH &n253 => @PLACE(110, -671) => @ORIENT("R0");
// %t1167 @TEXT("n253", key="name", size=0.75);
// &n253 @WIRE(mode="straight") {#X215:1 %t1167:p};
// %t1168 = $IO_PORT @ATTACH &vss => @PLACE(110, -675) => @ORIENT("R0");
// %t1168 @TEXT("vss", key="name", size=0.75);
// &vss @WIRE(mode="straight") {#X215:2 %t1168:p};
// %t1169 = $IO_PORT @ATTACH &range_error => @PLACE(110, -679) => @ORIENT("R0");
// %t1169 @TEXT("range_error", key="name", size=0.75);
// &range_error @WIRE(mode="straight") {#X215:3 %t1169:p};
// %t1170 = $IO_PORT @ATTACH &n262 => @PLACE(130, -675) => @ORIENT("MY");
// %t1170 @TEXT("n262", key="name", size=0.75);
// &n262 @WIRE(mode="straight") {#X215:4 %t1170:p};
// %t1171 = $SUPPLY @ATTACH &vdd => @PLACE(120, -662);
// &vdd @WIRE(mode="straight") {#X215:5 %t1171:p};
// %t1172 = $GROUND @ATTACH &vss => @PLACE(120, -688);
// &vss @WIRE(mode="straight") {#X215:6 %t1172:p};
// %t1173 = $IO_PORT @ATTACH &n254 => @PLACE(158, -496) => @ORIENT("R0");
// %t1173 @TEXT("n254", key="name", size=0.75);
// &n254 @WIRE(mode="straight") {#X216:1 %t1173:p};
// %t1174 = $IO_PORT @ATTACH &vss => @PLACE(158, -500) => @ORIENT("R0");
// %t1174 @TEXT("vss", key="name", size=0.75);
// &vss @WIRE(mode="straight") {#X216:2 %t1174:p};
// %t1175 = $IO_PORT @ATTACH &range_error => @PLACE(158, -504) => @ORIENT("R0");
// %t1175 @TEXT("range_error", key="name", size=0.75);
// &range_error @WIRE(mode="straight") {#X216:3 %t1175:p};
// %t1176 = $IO_PORT @ATTACH &n263 => @PLACE(178, -500) => @ORIENT("MY");
// %t1176 @TEXT("n263", key="name", size=0.75);
// &n263 @WIRE(mode="straight") {#X216:4 %t1176:p};
// %t1177 = $SUPPLY @ATTACH &vdd => @PLACE(168, -487);
// &vdd @WIRE(mode="straight") {#X216:5 %t1177:p};
// %t1178 = $GROUND @ATTACH &vss => @PLACE(168, -513);
// &vss @WIRE(mode="straight") {#X216:6 %t1178:p};
// %t1179 = $IO_PORT @ATTACH &n255 => @PLACE(198, -496) => @ORIENT("R0");
// %t1179 @TEXT("n255", key="name", size=0.75);
// &n255 @WIRE(mode="straight") {#X217:1 %t1179:p};
// %t1180 = $IO_PORT @ATTACH &vss => @PLACE(198, -500) => @ORIENT("R0");
// %t1180 @TEXT("vss", key="name", size=0.75);
// &vss @WIRE(mode="straight") {#X217:2 %t1180:p};
// %t1181 = $IO_PORT @ATTACH &range_error => @PLACE(198, -504) => @ORIENT("R0");
// %t1181 @TEXT("range_error", key="name", size=0.75);
// &range_error @WIRE(mode="straight") {#X217:3 %t1181:p};
// %t1182 = $IO_PORT @ATTACH &n264 => @PLACE(218, -500) => @ORIENT("MY");
// %t1182 @TEXT("n264", key="name", size=0.75);
// &n264 @WIRE(mode="straight") {#X217:4 %t1182:p};
// %t1183 = $SUPPLY @ATTACH &vdd => @PLACE(208, -487);
// &vdd @WIRE(mode="straight") {#X217:5 %t1183:p};
// %t1184 = $GROUND @ATTACH &vss => @PLACE(208, -513);
// &vss @WIRE(mode="straight") {#X217:6 %t1184:p};
// %t1185 = $IO_PORT @ATTACH &n256 => @PLACE(238, -496) => @ORIENT("R0");
// %t1185 @TEXT("n256", key="name", size=0.75);
// &n256 @WIRE(mode="straight") {#X218:1 %t1185:p};
// %t1186 = $IO_PORT @ATTACH &vss => @PLACE(238, -500) => @ORIENT("R0");
// %t1186 @TEXT("vss", key="name", size=0.75);
// &vss @WIRE(mode="straight") {#X218:2 %t1186:p};
// %t1187 = $IO_PORT @ATTACH &range_error => @PLACE(238, -504) => @ORIENT("R0");
// %t1187 @TEXT("range_error", key="name", size=0.75);
// &range_error @WIRE(mode="straight") {#X218:3 %t1187:p};
// %t1188 = $IO_PORT @ATTACH &n265 => @PLACE(258, -500) => @ORIENT("MY");
// %t1188 @TEXT("n265", key="name", size=0.75);
// &n265 @WIRE(mode="straight") {#X218:4 %t1188:p};
// %t1189 = $SUPPLY @ATTACH &vdd => @PLACE(248, -487);
// &vdd @WIRE(mode="straight") {#X218:5 %t1189:p};
// %t1190 = $GROUND @ATTACH &vss => @PLACE(248, -513);
// &vss @WIRE(mode="straight") {#X218:6 %t1190:p};
// %t1191 = $IO_PORT @ATTACH &n257 => @PLACE(278, -496) => @ORIENT("R0");
// %t1191 @TEXT("n257", key="name", size=0.75);
// &n257 @WIRE(mode="straight") {#X219:1 %t1191:p};
// %t1192 = $IO_PORT @ATTACH &vss => @PLACE(278, -500) => @ORIENT("R0");
// %t1192 @TEXT("vss", key="name", size=0.75);
// &vss @WIRE(mode="straight") {#X219:2 %t1192:p};
// %t1193 = $IO_PORT @ATTACH &range_error => @PLACE(278, -504) => @ORIENT("R0");
// %t1193 @TEXT("range_error", key="name", size=0.75);
// &range_error @WIRE(mode="straight") {#X219:3 %t1193:p};
// %t1194 = $IO_PORT @ATTACH &n266 => @PLACE(298, -500) => @ORIENT("MY");
// %t1194 @TEXT("n266", key="name", size=0.75);
// &n266 @WIRE(mode="straight") {#X219:4 %t1194:p};
// %t1195 = $SUPPLY @ATTACH &vdd => @PLACE(288, -487);
// &vdd @WIRE(mode="straight") {#X219:5 %t1195:p};
// %t1196 = $GROUND @ATTACH &vss => @PLACE(288, -513);
// &vss @WIRE(mode="straight") {#X219:6 %t1196:p};
// %t1197 = $IO_PORT @ATTACH &vss => @PLACE(158, -531) => @ORIENT("R0");
// %t1197 @TEXT("vss", key="name", size=0.75);
// &vss @WIRE(mode="straight") {#X220:1 %t1197:p};
// %t1198 = $IO_PORT @ATTACH &n258 => @PLACE(158, -535) => @ORIENT("R0");
// %t1198 @TEXT("n258", key="name", size=0.75);
// &n258 @WIRE(mode="straight") {#X220:2 %t1198:p};
// %t1199 = $IO_PORT @ATTACH &cfg_ready => @PLACE(158, -539) => @ORIENT("R0");
// %t1199 @TEXT("cfg_ready", key="name", size=0.75);
// &cfg_ready @WIRE(mode="straight") {#X220:3 %t1199:p};
// %t1200 = $IO_PORT @ATTACH &n42 => @PLACE(178, -535) => @ORIENT("MY");
// %t1200 @TEXT("n42", key="name", size=0.75);
// &n42 @WIRE(mode="straight") {#X220:4 %t1200:p};
// %t1201 = $SUPPLY @ATTACH &vdd => @PLACE(168, -522);
// &vdd @WIRE(mode="straight") {#X220:5 %t1201:p};
// %t1202 = $GROUND @ATTACH &vss => @PLACE(168, -548);
// &vss @WIRE(mode="straight") {#X220:6 %t1202:p};
// %t1203 = $IO_PORT @ATTACH &vss => @PLACE(198, -531) => @ORIENT("R0");
// %t1203 @TEXT("vss", key="name", size=0.75);
// &vss @WIRE(mode="straight") {#X221:1 %t1203:p};
// %t1204 = $IO_PORT @ATTACH &n259 => @PLACE(198, -535) => @ORIENT("R0");
// %t1204 @TEXT("n259", key="name", size=0.75);
// &n259 @WIRE(mode="straight") {#X221:2 %t1204:p};
// %t1205 = $IO_PORT @ATTACH &cfg_ready => @PLACE(198, -539) => @ORIENT("R0");
// %t1205 @TEXT("cfg_ready", key="name", size=0.75);
// &cfg_ready @WIRE(mode="straight") {#X221:3 %t1205:p};
// %t1206 = $IO_PORT @ATTACH &n44 => @PLACE(218, -535) => @ORIENT("MY");
// %t1206 @TEXT("n44", key="name", size=0.75);
// &n44 @WIRE(mode="straight") {#X221:4 %t1206:p};
// %t1207 = $SUPPLY @ATTACH &vdd => @PLACE(208, -522);
// &vdd @WIRE(mode="straight") {#X221:5 %t1207:p};
// %t1208 = $GROUND @ATTACH &vss => @PLACE(208, -548);
// &vss @WIRE(mode="straight") {#X221:6 %t1208:p};
// %t1209 = $IO_PORT @ATTACH &vss => @PLACE(238, -531) => @ORIENT("R0");
// %t1209 @TEXT("vss", key="name", size=0.75);
// &vss @WIRE(mode="straight") {#X222:1 %t1209:p};
// %t1210 = $IO_PORT @ATTACH &n260 => @PLACE(238, -535) => @ORIENT("R0");
// %t1210 @TEXT("n260", key="name", size=0.75);
// &n260 @WIRE(mode="straight") {#X222:2 %t1210:p};
// %t1211 = $IO_PORT @ATTACH &cfg_ready => @PLACE(238, -539) => @ORIENT("R0");
// %t1211 @TEXT("cfg_ready", key="name", size=0.75);
// &cfg_ready @WIRE(mode="straight") {#X222:3 %t1211:p};
// %t1212 = $IO_PORT @ATTACH &n46 => @PLACE(258, -535) => @ORIENT("MY");
// %t1212 @TEXT("n46", key="name", size=0.75);
// &n46 @WIRE(mode="straight") {#X222:4 %t1212:p};
// %t1213 = $SUPPLY @ATTACH &vdd => @PLACE(248, -522);
// &vdd @WIRE(mode="straight") {#X222:5 %t1213:p};
// %t1214 = $GROUND @ATTACH &vss => @PLACE(248, -548);
// &vss @WIRE(mode="straight") {#X222:6 %t1214:p};
// %t1215 = $IO_PORT @ATTACH &vss => @PLACE(278, -531) => @ORIENT("R0");
// %t1215 @TEXT("vss", key="name", size=0.75);
// &vss @WIRE(mode="straight") {#X223:1 %t1215:p};
// %t1216 = $IO_PORT @ATTACH &n261 => @PLACE(278, -535) => @ORIENT("R0");
// %t1216 @TEXT("n261", key="name", size=0.75);
// &n261 @WIRE(mode="straight") {#X223:2 %t1216:p};
// %t1217 = $IO_PORT @ATTACH &cfg_ready => @PLACE(278, -539) => @ORIENT("R0");
// %t1217 @TEXT("cfg_ready", key="name", size=0.75);
// &cfg_ready @WIRE(mode="straight") {#X223:3 %t1217:p};
// %t1218 = $IO_PORT @ATTACH &n48 => @PLACE(298, -535) => @ORIENT("MY");
// %t1218 @TEXT("n48", key="name", size=0.75);
// &n48 @WIRE(mode="straight") {#X223:4 %t1218:p};
// %t1219 = $SUPPLY @ATTACH &vdd => @PLACE(288, -522);
// &vdd @WIRE(mode="straight") {#X223:5 %t1219:p};
// %t1220 = $GROUND @ATTACH &vss => @PLACE(288, -548);
// &vss @WIRE(mode="straight") {#X223:6 %t1220:p};
// %t1221 = $IO_PORT @ATTACH &vss => @PLACE(158, -566) => @ORIENT("R0");
// %t1221 @TEXT("vss", key="name", size=0.75);
// &vss @WIRE(mode="straight") {#X224:1 %t1221:p};
// %t1222 = $IO_PORT @ATTACH &n262 => @PLACE(158, -570) => @ORIENT("R0");
// %t1222 @TEXT("n262", key="name", size=0.75);
// &n262 @WIRE(mode="straight") {#X224:2 %t1222:p};
// %t1223 = $IO_PORT @ATTACH &cfg_ready => @PLACE(158, -574) => @ORIENT("R0");
// %t1223 @TEXT("cfg_ready", key="name", size=0.75);
// &cfg_ready @WIRE(mode="straight") {#X224:3 %t1223:p};
// %t1224 = $IO_PORT @ATTACH &n50 => @PLACE(178, -570) => @ORIENT("MY");
// %t1224 @TEXT("n50", key="name", size=0.75);
// &n50 @WIRE(mode="straight") {#X224:4 %t1224:p};
// %t1225 = $SUPPLY @ATTACH &vdd => @PLACE(168, -557);
// &vdd @WIRE(mode="straight") {#X224:5 %t1225:p};
// %t1226 = $GROUND @ATTACH &vss => @PLACE(168, -583);
// &vss @WIRE(mode="straight") {#X224:6 %t1226:p};
// %t1227 = $IO_PORT @ATTACH &vss => @PLACE(198, -566) => @ORIENT("R0");
// %t1227 @TEXT("vss", key="name", size=0.75);
// &vss @WIRE(mode="straight") {#X225:1 %t1227:p};
// %t1228 = $IO_PORT @ATTACH &n263 => @PLACE(198, -570) => @ORIENT("R0");
// %t1228 @TEXT("n263", key="name", size=0.75);
// &n263 @WIRE(mode="straight") {#X225:2 %t1228:p};
// %t1229 = $IO_PORT @ATTACH &cfg_ready => @PLACE(198, -574) => @ORIENT("R0");
// %t1229 @TEXT("cfg_ready", key="name", size=0.75);
// &cfg_ready @WIRE(mode="straight") {#X225:3 %t1229:p};
// %t1230 = $IO_PORT @ATTACH &n52 => @PLACE(218, -570) => @ORIENT("MY");
// %t1230 @TEXT("n52", key="name", size=0.75);
// &n52 @WIRE(mode="straight") {#X225:4 %t1230:p};
// %t1231 = $SUPPLY @ATTACH &vdd => @PLACE(208, -557);
// &vdd @WIRE(mode="straight") {#X225:5 %t1231:p};
// %t1232 = $GROUND @ATTACH &vss => @PLACE(208, -583);
// &vss @WIRE(mode="straight") {#X225:6 %t1232:p};
// %t1233 = $IO_PORT @ATTACH &vss => @PLACE(238, -566) => @ORIENT("R0");
// %t1233 @TEXT("vss", key="name", size=0.75);
// &vss @WIRE(mode="straight") {#X226:1 %t1233:p};
// %t1234 = $IO_PORT @ATTACH &n264 => @PLACE(238, -570) => @ORIENT("R0");
// %t1234 @TEXT("n264", key="name", size=0.75);
// &n264 @WIRE(mode="straight") {#X226:2 %t1234:p};
// %t1235 = $IO_PORT @ATTACH &cfg_ready => @PLACE(238, -574) => @ORIENT("R0");
// %t1235 @TEXT("cfg_ready", key="name", size=0.75);
// &cfg_ready @WIRE(mode="straight") {#X226:3 %t1235:p};
// %t1236 = $IO_PORT @ATTACH &n54 => @PLACE(258, -570) => @ORIENT("MY");
// %t1236 @TEXT("n54", key="name", size=0.75);
// &n54 @WIRE(mode="straight") {#X226:4 %t1236:p};
// %t1237 = $SUPPLY @ATTACH &vdd => @PLACE(248, -557);
// &vdd @WIRE(mode="straight") {#X226:5 %t1237:p};
// %t1238 = $GROUND @ATTACH &vss => @PLACE(248, -583);
// &vss @WIRE(mode="straight") {#X226:6 %t1238:p};
// %t1239 = $IO_PORT @ATTACH &vss => @PLACE(278, -566) => @ORIENT("R0");
// %t1239 @TEXT("vss", key="name", size=0.75);
// &vss @WIRE(mode="straight") {#X227:1 %t1239:p};
// %t1240 = $IO_PORT @ATTACH &n265 => @PLACE(278, -570) => @ORIENT("R0");
// %t1240 @TEXT("n265", key="name", size=0.75);
// &n265 @WIRE(mode="straight") {#X227:2 %t1240:p};
// %t1241 = $IO_PORT @ATTACH &cfg_ready => @PLACE(278, -574) => @ORIENT("R0");
// %t1241 @TEXT("cfg_ready", key="name", size=0.75);
// &cfg_ready @WIRE(mode="straight") {#X227:3 %t1241:p};
// %t1242 = $IO_PORT @ATTACH &n56 => @PLACE(298, -570) => @ORIENT("MY");
// %t1242 @TEXT("n56", key="name", size=0.75);
// &n56 @WIRE(mode="straight") {#X227:4 %t1242:p};
// %t1243 = $SUPPLY @ATTACH &vdd => @PLACE(288, -557);
// &vdd @WIRE(mode="straight") {#X227:5 %t1243:p};
// %t1244 = $GROUND @ATTACH &vss => @PLACE(288, -583);
// &vss @WIRE(mode="straight") {#X227:6 %t1244:p};
// %t1245 = $IO_PORT @ATTACH &vss => @PLACE(158, -601) => @ORIENT("R0");
// %t1245 @TEXT("vss", key="name", size=0.75);
// &vss @WIRE(mode="straight") {#X228:1 %t1245:p};
// %t1246 = $IO_PORT @ATTACH &n266 => @PLACE(158, -605) => @ORIENT("R0");
// %t1246 @TEXT("n266", key="name", size=0.75);
// &n266 @WIRE(mode="straight") {#X228:2 %t1246:p};
// %t1247 = $IO_PORT @ATTACH &cfg_ready => @PLACE(158, -609) => @ORIENT("R0");
// %t1247 @TEXT("cfg_ready", key="name", size=0.75);
// &cfg_ready @WIRE(mode="straight") {#X228:3 %t1247:p};
// %t1248 = $IO_PORT @ATTACH &n58 => @PLACE(178, -605) => @ORIENT("MY");
// %t1248 @TEXT("n58", key="name", size=0.75);
// &n58 @WIRE(mode="straight") {#X228:4 %t1248:p};
// %t1249 = $SUPPLY @ATTACH &vdd => @PLACE(168, -592);
// &vdd @WIRE(mode="straight") {#X228:5 %t1249:p};
// %t1250 = $GROUND @ATTACH &vss => @PLACE(168, -618);
// &vss @WIRE(mode="straight") {#X228:6 %t1250:p};
// %t1251 = $IO_PORT @ATTACH &vss => @PLACE(198, -601) => @ORIENT("R0");
// %t1251 @TEXT("vss", key="name", size=0.75);
// &vss @WIRE(mode="straight") {#X229:1 %t1251:p};
// %t1252 = $IO_PORT @ATTACH &vss => @PLACE(198, -605) => @ORIENT("R0");
// %t1252 @TEXT("vss", key="name", size=0.75);
// &vss @WIRE(mode="straight") {#X229:2 %t1252:p};
// %t1253 = $IO_PORT @ATTACH &n162 => @PLACE(198, -609) => @ORIENT("R0");
// %t1253 @TEXT("n162", key="name", size=0.75);
// &n162 @WIRE(mode="straight") {#X229:3 %t1253:p};
// %t1254 = $IO_PORT @ATTACH &n267 => @PLACE(218, -605) => @ORIENT("MY");
// %t1254 @TEXT("n267", key="name", size=0.75);
// &n267 @WIRE(mode="straight") {#X229:4 %t1254:p};
// %t1255 = $SUPPLY @ATTACH &vdd => @PLACE(208, -592);
// &vdd @WIRE(mode="straight") {#X229:5 %t1255:p};
// %t1256 = $GROUND @ATTACH &vss => @PLACE(208, -618);
// &vss @WIRE(mode="straight") {#X229:6 %t1256:p};
// %t1257 = $IO_PORT @ATTACH &vss => @PLACE(238, -601) => @ORIENT("R0");
// %t1257 @TEXT("vss", key="name", size=0.75);
// &vss @WIRE(mode="straight") {#X230:1 %t1257:p};
// %t1258 = $IO_PORT @ATTACH &n267 => @PLACE(238, -605) => @ORIENT("R0");
// %t1258 @TEXT("n267", key="name", size=0.75);
// &n267 @WIRE(mode="straight") {#X230:2 %t1258:p};
// %t1259 = $IO_PORT @ATTACH &qualified => @PLACE(238, -609) => @ORIENT("R0");
// %t1259 @TEXT("qualified", key="name", size=0.75);
// &qualified @WIRE(mode="straight") {#X230:3 %t1259:p};
// %t1260 = $IO_PORT @ATTACH &n268 => @PLACE(258, -605) => @ORIENT("MY");
// %t1260 @TEXT("n268", key="name", size=0.75);
// &n268 @WIRE(mode="straight") {#X230:4 %t1260:p};
// %t1261 = $SUPPLY @ATTACH &vdd => @PLACE(248, -592);
// &vdd @WIRE(mode="straight") {#X230:5 %t1261:p};
// %t1262 = $GROUND @ATTACH &vss => @PLACE(248, -618);
// &vss @WIRE(mode="straight") {#X230:6 %t1262:p};
// %t1263 = $IO_PORT @ATTACH &n268 => @PLACE(278, -601) => @ORIENT("R0");
// %t1263 @TEXT("n268", key="name", size=0.75);
// &n268 @WIRE(mode="straight") {#X231:1 %t1263:p};
// %t1264 = $IO_PORT @ATTACH &vss => @PLACE(278, -605) => @ORIENT("R0");
// %t1264 @TEXT("vss", key="name", size=0.75);
// &vss @WIRE(mode="straight") {#X231:2 %t1264:p};
// %t1265 = $IO_PORT @ATTACH &n93 => @PLACE(278, -609) => @ORIENT("R0");
// %t1265 @TEXT("n93", key="name", size=0.75);
// &n93 @WIRE(mode="straight") {#X231:3 %t1265:p};
// %t1266 = $IO_PORT @ATTACH &n269 => @PLACE(298, -605) => @ORIENT("MY");
// %t1266 @TEXT("n269", key="name", size=0.75);
// &n269 @WIRE(mode="straight") {#X231:4 %t1266:p};
// %t1267 = $SUPPLY @ATTACH &vdd => @PLACE(288, -592);
// &vdd @WIRE(mode="straight") {#X231:5 %t1267:p};
// %t1268 = $GROUND @ATTACH &vss => @PLACE(288, -618);
// &vss @WIRE(mode="straight") {#X231:6 %t1268:p};
// %t1269 = $IO_PORT @ATTACH &n269 => @PLACE(158, -636) => @ORIENT("R0");
// %t1269 @TEXT("n269", key="name", size=0.75);
// &n269 @WIRE(mode="straight") {#X232:1 %t1269:p};
// %t1270 = $IO_PORT @ATTACH &vss => @PLACE(158, -640) => @ORIENT("R0");
// %t1270 @TEXT("vss", key="name", size=0.75);
// &vss @WIRE(mode="straight") {#X232:2 %t1270:p};
// %t1271 = $IO_PORT @ATTACH &n136 => @PLACE(158, -644) => @ORIENT("R0");
// %t1271 @TEXT("n136", key="name", size=0.75);
// &n136 @WIRE(mode="straight") {#X232:3 %t1271:p};
// %t1272 = $IO_PORT @ATTACH &n270 => @PLACE(178, -640) => @ORIENT("MY");
// %t1272 @TEXT("n270", key="name", size=0.75);
// &n270 @WIRE(mode="straight") {#X232:4 %t1272:p};
// %t1273 = $SUPPLY @ATTACH &vdd => @PLACE(168, -627);
// &vdd @WIRE(mode="straight") {#X232:5 %t1273:p};
// %t1274 = $GROUND @ATTACH &vss => @PLACE(168, -653);
// &vss @WIRE(mode="straight") {#X232:6 %t1274:p};
// %t1275 = $IO_PORT @ATTACH &vss => @PLACE(198, -636) => @ORIENT("R0");
// %t1275 @TEXT("vss", key="name", size=0.75);
// &vss @WIRE(mode="straight") {#X233:1 %t1275:p};
// %t1276 = $IO_PORT @ATTACH &n270 => @PLACE(198, -640) => @ORIENT("R0");
// %t1276 @TEXT("n270", key="name", size=0.75);
// &n270 @WIRE(mode="straight") {#X233:2 %t1276:p};
// %t1277 = $IO_PORT @ATTACH &fll_enable => @PLACE(198, -644) => @ORIENT("R0");
// %t1277 @TEXT("fll_enable", key="name", size=0.75);
// &fll_enable @WIRE(mode="straight") {#X233:3 %t1277:p};
// %t1278 = $IO_PORT @ATTACH &n271 => @PLACE(218, -640) => @ORIENT("MY");
// %t1278 @TEXT("n271", key="name", size=0.75);
// &n271 @WIRE(mode="straight") {#X233:4 %t1278:p};
// %t1279 = $SUPPLY @ATTACH &vdd => @PLACE(208, -627);
// &vdd @WIRE(mode="straight") {#X233:5 %t1279:p};
// %t1280 = $GROUND @ATTACH &vss => @PLACE(208, -653);
// &vss @WIRE(mode="straight") {#X233:6 %t1280:p};
// %t1281 = $IO_PORT @ATTACH &vss => @PLACE(238, -636) => @ORIENT("R0");
// %t1281 @TEXT("vss", key="name", size=0.75);
// &vss @WIRE(mode="straight") {#X234:1 %t1281:p};
// %t1282 = $IO_PORT @ATTACH &n89 => @PLACE(238, -640) => @ORIENT("R0");
// %t1282 @TEXT("n89", key="name", size=0.75);
// &n89 @WIRE(mode="straight") {#X234:2 %t1282:p};
// %t1283 = $IO_PORT @ATTACH &n159 => @PLACE(238, -644) => @ORIENT("R0");
// %t1283 @TEXT("n159", key="name", size=0.75);
// &n159 @WIRE(mode="straight") {#X234:3 %t1283:p};
// %t1284 = $IO_PORT @ATTACH &n272 => @PLACE(258, -640) => @ORIENT("MY");
// %t1284 @TEXT("n272", key="name", size=0.75);
// &n272 @WIRE(mode="straight") {#X234:4 %t1284:p};
// %t1285 = $SUPPLY @ATTACH &vdd => @PLACE(248, -627);
// &vdd @WIRE(mode="straight") {#X234:5 %t1285:p};
// %t1286 = $GROUND @ATTACH &vss => @PLACE(248, -653);
// &vss @WIRE(mode="straight") {#X234:6 %t1286:p};
// %t1287 = $IO_PORT @ATTACH &vss => @PLACE(278, -636) => @ORIENT("R0");
// %t1287 @TEXT("vss", key="name", size=0.75);
// &vss @WIRE(mode="straight") {#X235:1 %t1287:p};
// %t1288 = $IO_PORT @ATTACH &n114 => @PLACE(278, -640) => @ORIENT("R0");
// %t1288 @TEXT("n114", key="name", size=0.75);
// &n114 @WIRE(mode="straight") {#X235:2 %t1288:p};
// %t1289 = $IO_PORT @ATTACH &n159 => @PLACE(278, -644) => @ORIENT("R0");
// %t1289 @TEXT("n159", key="name", size=0.75);
// &n159 @WIRE(mode="straight") {#X235:3 %t1289:p};
// %t1290 = $IO_PORT @ATTACH &n273 => @PLACE(298, -640) => @ORIENT("MY");
// %t1290 @TEXT("n273", key="name", size=0.75);
// &n273 @WIRE(mode="straight") {#X235:4 %t1290:p};
// %t1291 = $SUPPLY @ATTACH &vdd => @PLACE(288, -627);
// &vdd @WIRE(mode="straight") {#X235:5 %t1291:p};
// %t1292 = $GROUND @ATTACH &vss => @PLACE(288, -653);
// &vss @WIRE(mode="straight") {#X235:6 %t1292:p};
// %t1293 = $IO_PORT @ATTACH &vss => @PLACE(158, -671) => @ORIENT("R0");
// %t1293 @TEXT("vss", key="name", size=0.75);
// &vss @WIRE(mode="straight") {#X236:1 %t1293:p};
// %t1294 = $IO_PORT @ATTACH &n116 => @PLACE(158, -675) => @ORIENT("R0");
// %t1294 @TEXT("n116", key="name", size=0.75);
// &n116 @WIRE(mode="straight") {#X236:2 %t1294:p};
// %t1295 = $IO_PORT @ATTACH &n159 => @PLACE(158, -679) => @ORIENT("R0");
// %t1295 @TEXT("n159", key="name", size=0.75);
// &n159 @WIRE(mode="straight") {#X236:3 %t1295:p};
// %t1296 = $IO_PORT @ATTACH &n274 => @PLACE(178, -675) => @ORIENT("MY");
// %t1296 @TEXT("n274", key="name", size=0.75);
// &n274 @WIRE(mode="straight") {#X236:4 %t1296:p};
// %t1297 = $SUPPLY @ATTACH &vdd => @PLACE(168, -662);
// &vdd @WIRE(mode="straight") {#X236:5 %t1297:p};
// %t1298 = $GROUND @ATTACH &vss => @PLACE(168, -688);
// &vss @WIRE(mode="straight") {#X236:6 %t1298:p};
// %t1299 = $IO_PORT @ATTACH &vss => @PLACE(198, -671) => @ORIENT("R0");
// %t1299 @TEXT("vss", key="name", size=0.75);
// &vss @WIRE(mode="straight") {#X237:1 %t1299:p};
// %t1300 = $IO_PORT @ATTACH &n118 => @PLACE(198, -675) => @ORIENT("R0");
// %t1300 @TEXT("n118", key="name", size=0.75);
// &n118 @WIRE(mode="straight") {#X237:2 %t1300:p};
// %t1301 = $IO_PORT @ATTACH &n159 => @PLACE(198, -679) => @ORIENT("R0");
// %t1301 @TEXT("n159", key="name", size=0.75);
// &n159 @WIRE(mode="straight") {#X237:3 %t1301:p};
// %t1302 = $IO_PORT @ATTACH &n275 => @PLACE(218, -675) => @ORIENT("MY");
// %t1302 @TEXT("n275", key="name", size=0.75);
// &n275 @WIRE(mode="straight") {#X237:4 %t1302:p};
// %t1303 = $SUPPLY @ATTACH &vdd => @PLACE(208, -662);
// &vdd @WIRE(mode="straight") {#X237:5 %t1303:p};
// %t1304 = $GROUND @ATTACH &vss => @PLACE(208, -688);
// &vss @WIRE(mode="straight") {#X237:6 %t1304:p};
// %t1305 = $IO_PORT @ATTACH &n271 => @PLACE(238, -671) => @ORIENT("R0");
// %t1305 @TEXT("n271", key="name", size=0.75);
// &n271 @WIRE(mode="straight") {#X238:1 %t1305:p};
// %t1306 = $IO_PORT @ATTACH &n272 => @PLACE(238, -675) => @ORIENT("R0");
// %t1306 @TEXT("n272", key="name", size=0.75);
// &n272 @WIRE(mode="straight") {#X238:2 %t1306:p};
// %t1307 = $IO_PORT @ATTACH &restart => @PLACE(238, -679) => @ORIENT("R0");
// %t1307 @TEXT("restart", key="name", size=0.75);
// &restart @WIRE(mode="straight") {#X238:3 %t1307:p};
// %t1308 = $IO_PORT @ATTACH &n276 => @PLACE(258, -675) => @ORIENT("MY");
// %t1308 @TEXT("n276", key="name", size=0.75);
// &n276 @WIRE(mode="straight") {#X238:4 %t1308:p};
// %t1309 = $SUPPLY @ATTACH &vdd => @PLACE(248, -662);
// &vdd @WIRE(mode="straight") {#X238:5 %t1309:p};
// %t1310 = $GROUND @ATTACH &vss => @PLACE(248, -688);
// &vss @WIRE(mode="straight") {#X238:6 %t1310:p};
// %t1311 = $IO_PORT @ATTACH &n271 => @PLACE(278, -671) => @ORIENT("R0");
// %t1311 @TEXT("n271", key="name", size=0.75);
// &n271 @WIRE(mode="straight") {#X239:1 %t1311:p};
// %t1312 = $IO_PORT @ATTACH &n273 => @PLACE(278, -675) => @ORIENT("R0");
// %t1312 @TEXT("n273", key="name", size=0.75);
// &n273 @WIRE(mode="straight") {#X239:2 %t1312:p};
// %t1313 = $IO_PORT @ATTACH &restart => @PLACE(278, -679) => @ORIENT("R0");
// %t1313 @TEXT("restart", key="name", size=0.75);
// &restart @WIRE(mode="straight") {#X239:3 %t1313:p};
// %t1314 = $IO_PORT @ATTACH &n277 => @PLACE(298, -675) => @ORIENT("MY");
// %t1314 @TEXT("n277", key="name", size=0.75);
// &n277 @WIRE(mode="straight") {#X239:4 %t1314:p};
// %t1315 = $SUPPLY @ATTACH &vdd => @PLACE(288, -662);
// &vdd @WIRE(mode="straight") {#X239:5 %t1315:p};
// %t1316 = $GROUND @ATTACH &vss => @PLACE(288, -688);
// &vss @WIRE(mode="straight") {#X239:6 %t1316:p};
// %t1317 = $IO_PORT @ATTACH &n271 => @PLACE(326, -496) => @ORIENT("R0");
// %t1317 @TEXT("n271", key="name", size=0.75);
// &n271 @WIRE(mode="straight") {#X240:1 %t1317:p};
// %t1318 = $IO_PORT @ATTACH &n274 => @PLACE(326, -500) => @ORIENT("R0");
// %t1318 @TEXT("n274", key="name", size=0.75);
// &n274 @WIRE(mode="straight") {#X240:2 %t1318:p};
// %t1319 = $IO_PORT @ATTACH &restart => @PLACE(326, -504) => @ORIENT("R0");
// %t1319 @TEXT("restart", key="name", size=0.75);
// &restart @WIRE(mode="straight") {#X240:3 %t1319:p};
// %t1320 = $IO_PORT @ATTACH &n278 => @PLACE(346, -500) => @ORIENT("MY");
// %t1320 @TEXT("n278", key="name", size=0.75);
// &n278 @WIRE(mode="straight") {#X240:4 %t1320:p};
// %t1321 = $SUPPLY @ATTACH &vdd => @PLACE(336, -487);
// &vdd @WIRE(mode="straight") {#X240:5 %t1321:p};
// %t1322 = $GROUND @ATTACH &vss => @PLACE(336, -513);
// &vss @WIRE(mode="straight") {#X240:6 %t1322:p};
// %t1323 = $IO_PORT @ATTACH &n271 => @PLACE(366, -496) => @ORIENT("R0");
// %t1323 @TEXT("n271", key="name", size=0.75);
// &n271 @WIRE(mode="straight") {#X241:1 %t1323:p};
// %t1324 = $IO_PORT @ATTACH &n275 => @PLACE(366, -500) => @ORIENT("R0");
// %t1324 @TEXT("n275", key="name", size=0.75);
// &n275 @WIRE(mode="straight") {#X241:2 %t1324:p};
// %t1325 = $IO_PORT @ATTACH &restart => @PLACE(366, -504) => @ORIENT("R0");
// %t1325 @TEXT("restart", key="name", size=0.75);
// &restart @WIRE(mode="straight") {#X241:3 %t1325:p};
// %t1326 = $IO_PORT @ATTACH &n279 => @PLACE(386, -500) => @ORIENT("MY");
// %t1326 @TEXT("n279", key="name", size=0.75);
// &n279 @WIRE(mode="straight") {#X241:4 %t1326:p};
// %t1327 = $SUPPLY @ATTACH &vdd => @PLACE(376, -487);
// &vdd @WIRE(mode="straight") {#X241:5 %t1327:p};
// %t1328 = $GROUND @ATTACH &vss => @PLACE(376, -513);
// &vss @WIRE(mode="straight") {#X241:6 %t1328:p};
// %t1329 = $IO_PORT @ATTACH &n276 => @PLACE(406, -496) => @ORIENT("R0");
// %t1329 @TEXT("n276", key="name", size=0.75);
// &n276 @WIRE(mode="straight") {#X242:1 %t1329:p};
// %t1330 = $IO_PORT @ATTACH &vss => @PLACE(406, -500) => @ORIENT("R0");
// %t1330 @TEXT("vss", key="name", size=0.75);
// &vss @WIRE(mode="straight") {#X242:2 %t1330:p};
// %t1331 = $IO_PORT @ATTACH &range_error => @PLACE(406, -504) => @ORIENT("R0");
// %t1331 @TEXT("range_error", key="name", size=0.75);
// &range_error @WIRE(mode="straight") {#X242:3 %t1331:p};
// %t1332 = $IO_PORT @ATTACH &n280 => @PLACE(426, -500) => @ORIENT("MY");
// %t1332 @TEXT("n280", key="name", size=0.75);
// &n280 @WIRE(mode="straight") {#X242:4 %t1332:p};
// %t1333 = $SUPPLY @ATTACH &vdd => @PLACE(416, -487);
// &vdd @WIRE(mode="straight") {#X242:5 %t1333:p};
// %t1334 = $GROUND @ATTACH &vss => @PLACE(416, -513);
// &vss @WIRE(mode="straight") {#X242:6 %t1334:p};
// %t1335 = $IO_PORT @ATTACH &n277 => @PLACE(446, -496) => @ORIENT("R0");
// %t1335 @TEXT("n277", key="name", size=0.75);
// &n277 @WIRE(mode="straight") {#X243:1 %t1335:p};
// %t1336 = $IO_PORT @ATTACH &vss => @PLACE(446, -500) => @ORIENT("R0");
// %t1336 @TEXT("vss", key="name", size=0.75);
// &vss @WIRE(mode="straight") {#X243:2 %t1336:p};
// %t1337 = $IO_PORT @ATTACH &range_error => @PLACE(446, -504) => @ORIENT("R0");
// %t1337 @TEXT("range_error", key="name", size=0.75);
// &range_error @WIRE(mode="straight") {#X243:3 %t1337:p};
// %t1338 = $IO_PORT @ATTACH &n281 => @PLACE(466, -500) => @ORIENT("MY");
// %t1338 @TEXT("n281", key="name", size=0.75);
// &n281 @WIRE(mode="straight") {#X243:4 %t1338:p};
// %t1339 = $SUPPLY @ATTACH &vdd => @PLACE(456, -487);
// &vdd @WIRE(mode="straight") {#X243:5 %t1339:p};
// %t1340 = $GROUND @ATTACH &vss => @PLACE(456, -513);
// &vss @WIRE(mode="straight") {#X243:6 %t1340:p};
// %t1341 = $IO_PORT @ATTACH &n278 => @PLACE(326, -531) => @ORIENT("R0");
// %t1341 @TEXT("n278", key="name", size=0.75);
// &n278 @WIRE(mode="straight") {#X244:1 %t1341:p};
// %t1342 = $IO_PORT @ATTACH &vss => @PLACE(326, -535) => @ORIENT("R0");
// %t1342 @TEXT("vss", key="name", size=0.75);
// &vss @WIRE(mode="straight") {#X244:2 %t1342:p};
// %t1343 = $IO_PORT @ATTACH &range_error => @PLACE(326, -539) => @ORIENT("R0");
// %t1343 @TEXT("range_error", key="name", size=0.75);
// &range_error @WIRE(mode="straight") {#X244:3 %t1343:p};
// %t1344 = $IO_PORT @ATTACH &n282 => @PLACE(346, -535) => @ORIENT("MY");
// %t1344 @TEXT("n282", key="name", size=0.75);
// &n282 @WIRE(mode="straight") {#X244:4 %t1344:p};
// %t1345 = $SUPPLY @ATTACH &vdd => @PLACE(336, -522);
// &vdd @WIRE(mode="straight") {#X244:5 %t1345:p};
// %t1346 = $GROUND @ATTACH &vss => @PLACE(336, -548);
// &vss @WIRE(mode="straight") {#X244:6 %t1346:p};
// %t1347 = $IO_PORT @ATTACH &n279 => @PLACE(366, -531) => @ORIENT("R0");
// %t1347 @TEXT("n279", key="name", size=0.75);
// &n279 @WIRE(mode="straight") {#X245:1 %t1347:p};
// %t1348 = $IO_PORT @ATTACH &vss => @PLACE(366, -535) => @ORIENT("R0");
// %t1348 @TEXT("vss", key="name", size=0.75);
// &vss @WIRE(mode="straight") {#X245:2 %t1348:p};
// %t1349 = $IO_PORT @ATTACH &range_error => @PLACE(366, -539) => @ORIENT("R0");
// %t1349 @TEXT("range_error", key="name", size=0.75);
// &range_error @WIRE(mode="straight") {#X245:3 %t1349:p};
// %t1350 = $IO_PORT @ATTACH &n283 => @PLACE(386, -535) => @ORIENT("MY");
// %t1350 @TEXT("n283", key="name", size=0.75);
// &n283 @WIRE(mode="straight") {#X245:4 %t1350:p};
// %t1351 = $SUPPLY @ATTACH &vdd => @PLACE(376, -522);
// &vdd @WIRE(mode="straight") {#X245:5 %t1351:p};
// %t1352 = $GROUND @ATTACH &vss => @PLACE(376, -548);
// &vss @WIRE(mode="straight") {#X245:6 %t1352:p};
// %t1353 = $IO_PORT @ATTACH &vss => @PLACE(406, -531) => @ORIENT("R0");
// %t1353 @TEXT("vss", key="name", size=0.75);
// &vss @WIRE(mode="straight") {#X246:1 %t1353:p};
// %t1354 = $IO_PORT @ATTACH &n280 => @PLACE(406, -535) => @ORIENT("R0");
// %t1354 @TEXT("n280", key="name", size=0.75);
// &n280 @WIRE(mode="straight") {#X246:2 %t1354:p};
// %t1355 = $IO_PORT @ATTACH &cfg_ready => @PLACE(406, -539) => @ORIENT("R0");
// %t1355 @TEXT("cfg_ready", key="name", size=0.75);
// &cfg_ready @WIRE(mode="straight") {#X246:3 %t1355:p};
// %t1356 = $IO_PORT @ATTACH &n69 => @PLACE(426, -535) => @ORIENT("MY");
// %t1356 @TEXT("n69", key="name", size=0.75);
// &n69 @WIRE(mode="straight") {#X246:4 %t1356:p};
// %t1357 = $SUPPLY @ATTACH &vdd => @PLACE(416, -522);
// &vdd @WIRE(mode="straight") {#X246:5 %t1357:p};
// %t1358 = $GROUND @ATTACH &vss => @PLACE(416, -548);
// &vss @WIRE(mode="straight") {#X246:6 %t1358:p};
// %t1359 = $IO_PORT @ATTACH &vss => @PLACE(446, -531) => @ORIENT("R0");
// %t1359 @TEXT("vss", key="name", size=0.75);
// &vss @WIRE(mode="straight") {#X247:1 %t1359:p};
// %t1360 = $IO_PORT @ATTACH &n281 => @PLACE(446, -535) => @ORIENT("R0");
// %t1360 @TEXT("n281", key="name", size=0.75);
// &n281 @WIRE(mode="straight") {#X247:2 %t1360:p};
// %t1361 = $IO_PORT @ATTACH &cfg_ready => @PLACE(446, -539) => @ORIENT("R0");
// %t1361 @TEXT("cfg_ready", key="name", size=0.75);
// &cfg_ready @WIRE(mode="straight") {#X247:3 %t1361:p};
// %t1362 = $IO_PORT @ATTACH &n68 => @PLACE(466, -535) => @ORIENT("MY");
// %t1362 @TEXT("n68", key="name", size=0.75);
// &n68 @WIRE(mode="straight") {#X247:4 %t1362:p};
// %t1363 = $SUPPLY @ATTACH &vdd => @PLACE(456, -522);
// &vdd @WIRE(mode="straight") {#X247:5 %t1363:p};
// %t1364 = $GROUND @ATTACH &vss => @PLACE(456, -548);
// &vss @WIRE(mode="straight") {#X247:6 %t1364:p};
// %t1365 = $IO_PORT @ATTACH &vss => @PLACE(326, -566) => @ORIENT("R0");
// %t1365 @TEXT("vss", key="name", size=0.75);
// &vss @WIRE(mode="straight") {#X248:1 %t1365:p};
// %t1366 = $IO_PORT @ATTACH &n282 => @PLACE(326, -570) => @ORIENT("R0");
// %t1366 @TEXT("n282", key="name", size=0.75);
// &n282 @WIRE(mode="straight") {#X248:2 %t1366:p};
// %t1367 = $IO_PORT @ATTACH &cfg_ready => @PLACE(326, -574) => @ORIENT("R0");
// %t1367 @TEXT("cfg_ready", key="name", size=0.75);
// &cfg_ready @WIRE(mode="straight") {#X248:3 %t1367:p};
// %t1368 = $IO_PORT @ATTACH &n66 => @PLACE(346, -570) => @ORIENT("MY");
// %t1368 @TEXT("n66", key="name", size=0.75);
// &n66 @WIRE(mode="straight") {#X248:4 %t1368:p};
// %t1369 = $SUPPLY @ATTACH &vdd => @PLACE(336, -557);
// &vdd @WIRE(mode="straight") {#X248:5 %t1369:p};
// %t1370 = $GROUND @ATTACH &vss => @PLACE(336, -583);
// &vss @WIRE(mode="straight") {#X248:6 %t1370:p};
// %t1371 = $IO_PORT @ATTACH &vss => @PLACE(366, -566) => @ORIENT("R0");
// %t1371 @TEXT("vss", key="name", size=0.75);
// &vss @WIRE(mode="straight") {#X249:1 %t1371:p};
// %t1372 = $IO_PORT @ATTACH &n283 => @PLACE(366, -570) => @ORIENT("R0");
// %t1372 @TEXT("n283", key="name", size=0.75);
// &n283 @WIRE(mode="straight") {#X249:2 %t1372:p};
// %t1373 = $IO_PORT @ATTACH &cfg_ready => @PLACE(366, -574) => @ORIENT("R0");
// %t1373 @TEXT("cfg_ready", key="name", size=0.75);
// &cfg_ready @WIRE(mode="straight") {#X249:3 %t1373:p};
// %t1374 = $IO_PORT @ATTACH &n76 => @PLACE(386, -570) => @ORIENT("MY");
// %t1374 @TEXT("n76", key="name", size=0.75);
// &n76 @WIRE(mode="straight") {#X249:4 %t1374:p};
// %t1375 = $SUPPLY @ATTACH &vdd => @PLACE(376, -557);
// &vdd @WIRE(mode="straight") {#X249:5 %t1375:p};
// %t1376 = $GROUND @ATTACH &vss => @PLACE(376, -583);
// &vss @WIRE(mode="straight") {#X249:6 %t1376:p};
// %t1377 = $IO_PORT @ATTACH &vss => @PLACE(406, -566) => @ORIENT("R0");
// %t1377 @TEXT("vss", key="name", size=0.75);
// &vss @WIRE(mode="straight") {#X250:1 %t1377:p};
// %t1378 = $IO_PORT @ATTACH &n82 => @PLACE(406, -570) => @ORIENT("R0");
// %t1378 @TEXT("n82", key="name", size=0.75);
// &n82 @WIRE(mode="straight") {#X250:2 %t1378:p};
// %t1379 = $IO_PORT @ATTACH &n162 => @PLACE(406, -574) => @ORIENT("R0");
// %t1379 @TEXT("n162", key="name", size=0.75);
// &n162 @WIRE(mode="straight") {#X250:3 %t1379:p};
// %t1380 = $IO_PORT @ATTACH &n284 => @PLACE(426, -570) => @ORIENT("MY");
// %t1380 @TEXT("n284", key="name", size=0.75);
// &n284 @WIRE(mode="straight") {#X250:4 %t1380:p};
// %t1381 = $SUPPLY @ATTACH &vdd => @PLACE(416, -557);
// &vdd @WIRE(mode="straight") {#X250:5 %t1381:p};
// %t1382 = $GROUND @ATTACH &vss => @PLACE(416, -583);
// &vss @WIRE(mode="straight") {#X250:6 %t1382:p};
// %t1383 = $IO_PORT @ATTACH &vss => @PLACE(446, -566) => @ORIENT("R0");
// %t1383 @TEXT("vss", key="name", size=0.75);
// &vss @WIRE(mode="straight") {#X251:1 %t1383:p};
// %t1384 = $IO_PORT @ATTACH &n132 => @PLACE(446, -570) => @ORIENT("R0");
// %t1384 @TEXT("n132", key="name", size=0.75);
// &n132 @WIRE(mode="straight") {#X251:2 %t1384:p};
// %t1385 = $IO_PORT @ATTACH &n162 => @PLACE(446, -574) => @ORIENT("R0");
// %t1385 @TEXT("n162", key="name", size=0.75);
// &n162 @WIRE(mode="straight") {#X251:3 %t1385:p};
// %t1386 = $IO_PORT @ATTACH &n285 => @PLACE(466, -570) => @ORIENT("MY");
// %t1386 @TEXT("n285", key="name", size=0.75);
// &n285 @WIRE(mode="straight") {#X251:4 %t1386:p};
// %t1387 = $SUPPLY @ATTACH &vdd => @PLACE(456, -557);
// &vdd @WIRE(mode="straight") {#X251:5 %t1387:p};
// %t1388 = $GROUND @ATTACH &vss => @PLACE(456, -583);
// &vss @WIRE(mode="straight") {#X251:6 %t1388:p};
// %t1389 = $IO_PORT @ATTACH &vss => @PLACE(326, -601) => @ORIENT("R0");
// %t1389 @TEXT("vss", key="name", size=0.75);
// &vss @WIRE(mode="straight") {#X252:1 %t1389:p};
// %t1390 = $IO_PORT @ATTACH &n133 => @PLACE(326, -605) => @ORIENT("R0");
// %t1390 @TEXT("n133", key="name", size=0.75);
// &n133 @WIRE(mode="straight") {#X252:2 %t1390:p};
// %t1391 = $IO_PORT @ATTACH &n162 => @PLACE(326, -609) => @ORIENT("R0");
// %t1391 @TEXT("n162", key="name", size=0.75);
// &n162 @WIRE(mode="straight") {#X252:3 %t1391:p};
// %t1392 = $IO_PORT @ATTACH &n286 => @PLACE(346, -605) => @ORIENT("MY");
// %t1392 @TEXT("n286", key="name", size=0.75);
// &n286 @WIRE(mode="straight") {#X252:4 %t1392:p};
// %t1393 = $SUPPLY @ATTACH &vdd => @PLACE(336, -592);
// &vdd @WIRE(mode="straight") {#X252:5 %t1393:p};
// %t1394 = $GROUND @ATTACH &vss => @PLACE(336, -618);
// &vss @WIRE(mode="straight") {#X252:6 %t1394:p};
// %t1395 = $IO_PORT @ATTACH &vss => @PLACE(366, -601) => @ORIENT("R0");
// %t1395 @TEXT("vss", key="name", size=0.75);
// &vss @WIRE(mode="straight") {#X253:1 %t1395:p};
// %t1396 = $IO_PORT @ATTACH &n284 => @PLACE(366, -605) => @ORIENT("R0");
// %t1396 @TEXT("n284", key="name", size=0.75);
// &n284 @WIRE(mode="straight") {#X253:2 %t1396:p};
// %t1397 = $IO_PORT @ATTACH &qualified => @PLACE(366, -609) => @ORIENT("R0");
// %t1397 @TEXT("qualified", key="name", size=0.75);
// &qualified @WIRE(mode="straight") {#X253:3 %t1397:p};
// %t1398 = $IO_PORT @ATTACH &n287 => @PLACE(386, -605) => @ORIENT("MY");
// %t1398 @TEXT("n287", key="name", size=0.75);
// &n287 @WIRE(mode="straight") {#X253:4 %t1398:p};
// %t1399 = $SUPPLY @ATTACH &vdd => @PLACE(376, -592);
// &vdd @WIRE(mode="straight") {#X253:5 %t1399:p};
// %t1400 = $GROUND @ATTACH &vss => @PLACE(376, -618);
// &vss @WIRE(mode="straight") {#X253:6 %t1400:p};
// %t1401 = $IO_PORT @ATTACH &vss => @PLACE(406, -601) => @ORIENT("R0");
// %t1401 @TEXT("vss", key="name", size=0.75);
// &vss @WIRE(mode="straight") {#X254:1 %t1401:p};
// %t1402 = $IO_PORT @ATTACH &n285 => @PLACE(406, -605) => @ORIENT("R0");
// %t1402 @TEXT("n285", key="name", size=0.75);
// &n285 @WIRE(mode="straight") {#X254:2 %t1402:p};
// %t1403 = $IO_PORT @ATTACH &qualified => @PLACE(406, -609) => @ORIENT("R0");
// %t1403 @TEXT("qualified", key="name", size=0.75);
// &qualified @WIRE(mode="straight") {#X254:3 %t1403:p};
// %t1404 = $IO_PORT @ATTACH &n288 => @PLACE(426, -605) => @ORIENT("MY");
// %t1404 @TEXT("n288", key="name", size=0.75);
// &n288 @WIRE(mode="straight") {#X254:4 %t1404:p};
// %t1405 = $SUPPLY @ATTACH &vdd => @PLACE(416, -592);
// &vdd @WIRE(mode="straight") {#X254:5 %t1405:p};
// %t1406 = $GROUND @ATTACH &vss => @PLACE(416, -618);
// &vss @WIRE(mode="straight") {#X254:6 %t1406:p};
// %t1407 = $IO_PORT @ATTACH &vss => @PLACE(446, -601) => @ORIENT("R0");
// %t1407 @TEXT("vss", key="name", size=0.75);
// &vss @WIRE(mode="straight") {#X255:1 %t1407:p};
// %t1408 = $IO_PORT @ATTACH &n286 => @PLACE(446, -605) => @ORIENT("R0");
// %t1408 @TEXT("n286", key="name", size=0.75);
// &n286 @WIRE(mode="straight") {#X255:2 %t1408:p};
// %t1409 = $IO_PORT @ATTACH &qualified => @PLACE(446, -609) => @ORIENT("R0");
// %t1409 @TEXT("qualified", key="name", size=0.75);
// &qualified @WIRE(mode="straight") {#X255:3 %t1409:p};
// %t1410 = $IO_PORT @ATTACH &n289 => @PLACE(466, -605) => @ORIENT("MY");
// %t1410 @TEXT("n289", key="name", size=0.75);
// &n289 @WIRE(mode="straight") {#X255:4 %t1410:p};
// %t1411 = $SUPPLY @ATTACH &vdd => @PLACE(456, -592);
// &vdd @WIRE(mode="straight") {#X255:5 %t1411:p};
// %t1412 = $GROUND @ATTACH &vss => @PLACE(456, -618);
// &vss @WIRE(mode="straight") {#X255:6 %t1412:p};
// %t1413 = $IO_PORT @ATTACH &n287 => @PLACE(326, -636) => @ORIENT("R0");
// %t1413 @TEXT("n287", key="name", size=0.75);
// &n287 @WIRE(mode="straight") {#X256:1 %t1413:p};
// %t1414 = $IO_PORT @ATTACH &vss => @PLACE(326, -640) => @ORIENT("R0");
// %t1414 @TEXT("vss", key="name", size=0.75);
// &vss @WIRE(mode="straight") {#X256:2 %t1414:p};
// %t1415 = $IO_PORT @ATTACH &n93 => @PLACE(326, -644) => @ORIENT("R0");
// %t1415 @TEXT("n93", key="name", size=0.75);
// &n93 @WIRE(mode="straight") {#X256:3 %t1415:p};
// %t1416 = $IO_PORT @ATTACH &n290 => @PLACE(346, -640) => @ORIENT("MY");
// %t1416 @TEXT("n290", key="name", size=0.75);
// &n290 @WIRE(mode="straight") {#X256:4 %t1416:p};
// %t1417 = $SUPPLY @ATTACH &vdd => @PLACE(336, -627);
// &vdd @WIRE(mode="straight") {#X256:5 %t1417:p};
// %t1418 = $GROUND @ATTACH &vss => @PLACE(336, -653);
// &vss @WIRE(mode="straight") {#X256:6 %t1418:p};
// %t1419 = $IO_PORT @ATTACH &n288 => @PLACE(366, -636) => @ORIENT("R0");
// %t1419 @TEXT("n288", key="name", size=0.75);
// &n288 @WIRE(mode="straight") {#X257:1 %t1419:p};
// %t1420 = $IO_PORT @ATTACH &vss => @PLACE(366, -640) => @ORIENT("R0");
// %t1420 @TEXT("vss", key="name", size=0.75);
// &vss @WIRE(mode="straight") {#X257:2 %t1420:p};
// %t1421 = $IO_PORT @ATTACH &n93 => @PLACE(366, -644) => @ORIENT("R0");
// %t1421 @TEXT("n93", key="name", size=0.75);
// &n93 @WIRE(mode="straight") {#X257:3 %t1421:p};
// %t1422 = $IO_PORT @ATTACH &n291 => @PLACE(386, -640) => @ORIENT("MY");
// %t1422 @TEXT("n291", key="name", size=0.75);
// &n291 @WIRE(mode="straight") {#X257:4 %t1422:p};
// %t1423 = $SUPPLY @ATTACH &vdd => @PLACE(376, -627);
// &vdd @WIRE(mode="straight") {#X257:5 %t1423:p};
// %t1424 = $GROUND @ATTACH &vss => @PLACE(376, -653);
// &vss @WIRE(mode="straight") {#X257:6 %t1424:p};
// %t1425 = $IO_PORT @ATTACH &n289 => @PLACE(406, -636) => @ORIENT("R0");
// %t1425 @TEXT("n289", key="name", size=0.75);
// &n289 @WIRE(mode="straight") {#X258:1 %t1425:p};
// %t1426 = $IO_PORT @ATTACH &vss => @PLACE(406, -640) => @ORIENT("R0");
// %t1426 @TEXT("vss", key="name", size=0.75);
// &vss @WIRE(mode="straight") {#X258:2 %t1426:p};
// %t1427 = $IO_PORT @ATTACH &n93 => @PLACE(406, -644) => @ORIENT("R0");
// %t1427 @TEXT("n93", key="name", size=0.75);
// &n93 @WIRE(mode="straight") {#X258:3 %t1427:p};
// %t1428 = $IO_PORT @ATTACH &n292 => @PLACE(426, -640) => @ORIENT("MY");
// %t1428 @TEXT("n292", key="name", size=0.75);
// &n292 @WIRE(mode="straight") {#X258:4 %t1428:p};
// %t1429 = $SUPPLY @ATTACH &vdd => @PLACE(416, -627);
// &vdd @WIRE(mode="straight") {#X258:5 %t1429:p};
// %t1430 = $GROUND @ATTACH &vss => @PLACE(416, -653);
// &vss @WIRE(mode="straight") {#X258:6 %t1430:p};
// %t1431 = $IO_PORT @ATTACH &n290 => @PLACE(446, -636) => @ORIENT("R0");
// %t1431 @TEXT("n290", key="name", size=0.75);
// &n290 @WIRE(mode="straight") {#X259:1 %t1431:p};
// %t1432 = $IO_PORT @ATTACH &vss => @PLACE(446, -640) => @ORIENT("R0");
// %t1432 @TEXT("vss", key="name", size=0.75);
// &vss @WIRE(mode="straight") {#X259:2 %t1432:p};
// %t1433 = $IO_PORT @ATTACH &n136 => @PLACE(446, -644) => @ORIENT("R0");
// %t1433 @TEXT("n136", key="name", size=0.75);
// &n136 @WIRE(mode="straight") {#X259:3 %t1433:p};
// %t1434 = $IO_PORT @ATTACH &n293 => @PLACE(466, -640) => @ORIENT("MY");
// %t1434 @TEXT("n293", key="name", size=0.75);
// &n293 @WIRE(mode="straight") {#X259:4 %t1434:p};
// %t1435 = $SUPPLY @ATTACH &vdd => @PLACE(456, -627);
// &vdd @WIRE(mode="straight") {#X259:5 %t1435:p};
// %t1436 = $GROUND @ATTACH &vss => @PLACE(456, -653);
// &vss @WIRE(mode="straight") {#X259:6 %t1436:p};
// %t1437 = $IO_PORT @ATTACH &n291 => @PLACE(326, -671) => @ORIENT("R0");
// %t1437 @TEXT("n291", key="name", size=0.75);
// &n291 @WIRE(mode="straight") {#X260:1 %t1437:p};
// %t1438 = $IO_PORT @ATTACH &vss => @PLACE(326, -675) => @ORIENT("R0");
// %t1438 @TEXT("vss", key="name", size=0.75);
// &vss @WIRE(mode="straight") {#X260:2 %t1438:p};
// %t1439 = $IO_PORT @ATTACH &n136 => @PLACE(326, -679) => @ORIENT("R0");
// %t1439 @TEXT("n136", key="name", size=0.75);
// &n136 @WIRE(mode="straight") {#X260:3 %t1439:p};
// %t1440 = $IO_PORT @ATTACH &n294 => @PLACE(346, -675) => @ORIENT("MY");
// %t1440 @TEXT("n294", key="name", size=0.75);
// &n294 @WIRE(mode="straight") {#X260:4 %t1440:p};
// %t1441 = $SUPPLY @ATTACH &vdd => @PLACE(336, -662);
// &vdd @WIRE(mode="straight") {#X260:5 %t1441:p};
// %t1442 = $GROUND @ATTACH &vss => @PLACE(336, -688);
// &vss @WIRE(mode="straight") {#X260:6 %t1442:p};
// %t1443 = $IO_PORT @ATTACH &n292 => @PLACE(366, -671) => @ORIENT("R0");
// %t1443 @TEXT("n292", key="name", size=0.75);
// &n292 @WIRE(mode="straight") {#X261:1 %t1443:p};
// %t1444 = $IO_PORT @ATTACH &vss => @PLACE(366, -675) => @ORIENT("R0");
// %t1444 @TEXT("vss", key="name", size=0.75);
// &vss @WIRE(mode="straight") {#X261:2 %t1444:p};
// %t1445 = $IO_PORT @ATTACH &n136 => @PLACE(366, -679) => @ORIENT("R0");
// %t1445 @TEXT("n136", key="name", size=0.75);
// &n136 @WIRE(mode="straight") {#X261:3 %t1445:p};
// %t1446 = $IO_PORT @ATTACH &n295 => @PLACE(386, -675) => @ORIENT("MY");
// %t1446 @TEXT("n295", key="name", size=0.75);
// &n295 @WIRE(mode="straight") {#X261:4 %t1446:p};
// %t1447 = $SUPPLY @ATTACH &vdd => @PLACE(376, -662);
// &vdd @WIRE(mode="straight") {#X261:5 %t1447:p};
// %t1448 = $GROUND @ATTACH &vss => @PLACE(376, -688);
// &vss @WIRE(mode="straight") {#X261:6 %t1448:p};
// %t1449 = $IO_PORT @ATTACH &vss => @PLACE(406, -671) => @ORIENT("R0");
// %t1449 @TEXT("vss", key="name", size=0.75);
// &vss @WIRE(mode="straight") {#X262:1 %t1449:p};
// %t1450 = $IO_PORT @ATTACH &n293 => @PLACE(406, -675) => @ORIENT("R0");
// %t1450 @TEXT("n293", key="name", size=0.75);
// &n293 @WIRE(mode="straight") {#X262:2 %t1450:p};
// %t1451 = $IO_PORT @ATTACH &fll_enable => @PLACE(406, -679) => @ORIENT("R0");
// %t1451 @TEXT("fll_enable", key="name", size=0.75);
// &fll_enable @WIRE(mode="straight") {#X262:3 %t1451:p};
// %t1452 = $IO_PORT @ATTACH &n296 => @PLACE(426, -675) => @ORIENT("MY");
// %t1452 @TEXT("n296", key="name", size=0.75);
// &n296 @WIRE(mode="straight") {#X262:4 %t1452:p};
// %t1453 = $SUPPLY @ATTACH &vdd => @PLACE(416, -662);
// &vdd @WIRE(mode="straight") {#X262:5 %t1453:p};
// %t1454 = $GROUND @ATTACH &vss => @PLACE(416, -688);
// &vss @WIRE(mode="straight") {#X262:6 %t1454:p};
// %t1455 = $IO_PORT @ATTACH &vss => @PLACE(446, -671) => @ORIENT("R0");
// %t1455 @TEXT("vss", key="name", size=0.75);
// &vss @WIRE(mode="straight") {#X263:1 %t1455:p};
// %t1456 = $IO_PORT @ATTACH &n294 => @PLACE(446, -675) => @ORIENT("R0");
// %t1456 @TEXT("n294", key="name", size=0.75);
// &n294 @WIRE(mode="straight") {#X263:2 %t1456:p};
// %t1457 = $IO_PORT @ATTACH &fll_enable => @PLACE(446, -679) => @ORIENT("R0");
// %t1457 @TEXT("fll_enable", key="name", size=0.75);
// &fll_enable @WIRE(mode="straight") {#X263:3 %t1457:p};
// %t1458 = $IO_PORT @ATTACH &n297 => @PLACE(466, -675) => @ORIENT("MY");
// %t1458 @TEXT("n297", key="name", size=0.75);
// &n297 @WIRE(mode="straight") {#X263:4 %t1458:p};
// %t1459 = $SUPPLY @ATTACH &vdd => @PLACE(456, -662);
// &vdd @WIRE(mode="straight") {#X263:5 %t1459:p};
// %t1460 = $GROUND @ATTACH &vss => @PLACE(456, -688);
// &vss @WIRE(mode="straight") {#X263:6 %t1460:p};
// %t1461 = $IO_PORT @ATTACH &vss => @PLACE(494, -496) => @ORIENT("R0");
// %t1461 @TEXT("vss", key="name", size=0.75);
// &vss @WIRE(mode="straight") {#X264:1 %t1461:p};
// %t1462 = $IO_PORT @ATTACH &n295 => @PLACE(494, -500) => @ORIENT("R0");
// %t1462 @TEXT("n295", key="name", size=0.75);
// &n295 @WIRE(mode="straight") {#X264:2 %t1462:p};
// %t1463 = $IO_PORT @ATTACH &fll_enable => @PLACE(494, -504) => @ORIENT("R0");
// %t1463 @TEXT("fll_enable", key="name", size=0.75);
// &fll_enable @WIRE(mode="straight") {#X264:3 %t1463:p};
// %t1464 = $IO_PORT @ATTACH &n298 => @PLACE(514, -500) => @ORIENT("MY");
// %t1464 @TEXT("n298", key="name", size=0.75);
// &n298 @WIRE(mode="straight") {#X264:4 %t1464:p};
// %t1465 = $SUPPLY @ATTACH &vdd => @PLACE(504, -487);
// &vdd @WIRE(mode="straight") {#X264:5 %t1465:p};
// %t1466 = $GROUND @ATTACH &vss => @PLACE(504, -513);
// &vss @WIRE(mode="straight") {#X264:6 %t1466:p};
// %t1467 = $IO_PORT @ATTACH &n296 => @PLACE(534, -496) => @ORIENT("R0");
// %t1467 @TEXT("n296", key="name", size=0.75);
// &n296 @WIRE(mode="straight") {#X265:1 %t1467:p};
// %t1468 = $IO_PORT @ATTACH &vss => @PLACE(534, -500) => @ORIENT("R0");
// %t1468 @TEXT("vss", key="name", size=0.75);
// &vss @WIRE(mode="straight") {#X265:2 %t1468:p};
// %t1469 = $IO_PORT @ATTACH &restart => @PLACE(534, -504) => @ORIENT("R0");
// %t1469 @TEXT("restart", key="name", size=0.75);
// &restart @WIRE(mode="straight") {#X265:3 %t1469:p};
// %t1470 = $IO_PORT @ATTACH &n299 => @PLACE(554, -500) => @ORIENT("MY");
// %t1470 @TEXT("n299", key="name", size=0.75);
// &n299 @WIRE(mode="straight") {#X265:4 %t1470:p};
// %t1471 = $SUPPLY @ATTACH &vdd => @PLACE(544, -487);
// &vdd @WIRE(mode="straight") {#X265:5 %t1471:p};
// %t1472 = $GROUND @ATTACH &vss => @PLACE(544, -513);
// &vss @WIRE(mode="straight") {#X265:6 %t1472:p};
// %t1473 = $IO_PORT @ATTACH &n297 => @PLACE(574, -496) => @ORIENT("R0");
// %t1473 @TEXT("n297", key="name", size=0.75);
// &n297 @WIRE(mode="straight") {#X266:1 %t1473:p};
// %t1474 = $IO_PORT @ATTACH &vss => @PLACE(574, -500) => @ORIENT("R0");
// %t1474 @TEXT("vss", key="name", size=0.75);
// &vss @WIRE(mode="straight") {#X266:2 %t1474:p};
// %t1475 = $IO_PORT @ATTACH &restart => @PLACE(574, -504) => @ORIENT("R0");
// %t1475 @TEXT("restart", key="name", size=0.75);
// &restart @WIRE(mode="straight") {#X266:3 %t1475:p};
// %t1476 = $IO_PORT @ATTACH &n300 => @PLACE(594, -500) => @ORIENT("MY");
// %t1476 @TEXT("n300", key="name", size=0.75);
// &n300 @WIRE(mode="straight") {#X266:4 %t1476:p};
// %t1477 = $SUPPLY @ATTACH &vdd => @PLACE(584, -487);
// &vdd @WIRE(mode="straight") {#X266:5 %t1477:p};
// %t1478 = $GROUND @ATTACH &vss => @PLACE(584, -513);
// &vss @WIRE(mode="straight") {#X266:6 %t1478:p};
// %t1479 = $IO_PORT @ATTACH &n298 => @PLACE(614, -496) => @ORIENT("R0");
// %t1479 @TEXT("n298", key="name", size=0.75);
// &n298 @WIRE(mode="straight") {#X267:1 %t1479:p};
// %t1480 = $IO_PORT @ATTACH &vss => @PLACE(614, -500) => @ORIENT("R0");
// %t1480 @TEXT("vss", key="name", size=0.75);
// &vss @WIRE(mode="straight") {#X267:2 %t1480:p};
// %t1481 = $IO_PORT @ATTACH &restart => @PLACE(614, -504) => @ORIENT("R0");
// %t1481 @TEXT("restart", key="name", size=0.75);
// &restart @WIRE(mode="straight") {#X267:3 %t1481:p};
// %t1482 = $IO_PORT @ATTACH &n301 => @PLACE(635, -500) => @ORIENT("MY");
// %t1482 @TEXT("n301", key="name", size=0.75);
// &n301 @WIRE(mode="straight") {#X267:4 %t1482:p};
// %t1483 = $SUPPLY @ATTACH &vdd => @PLACE(624, -487);
// &vdd @WIRE(mode="straight") {#X267:5 %t1483:p};
// %t1484 = $GROUND @ATTACH &vss => @PLACE(624, -513);
// &vss @WIRE(mode="straight") {#X267:6 %t1484:p};
// %t1485 = $IO_PORT @ATTACH &n299 => @PLACE(494, -531) => @ORIENT("R0");
// %t1485 @TEXT("n299", key="name", size=0.75);
// &n299 @WIRE(mode="straight") {#X268:1 %t1485:p};
// %t1486 = $IO_PORT @ATTACH &vss => @PLACE(494, -535) => @ORIENT("R0");
// %t1486 @TEXT("vss", key="name", size=0.75);
// &vss @WIRE(mode="straight") {#X268:2 %t1486:p};
// %t1487 = $IO_PORT @ATTACH &range_error => @PLACE(494, -539) => @ORIENT("R0");
// %t1487 @TEXT("range_error", key="name", size=0.75);
// &range_error @WIRE(mode="straight") {#X268:3 %t1487:p};
// %t1488 = $IO_PORT @ATTACH &n302 => @PLACE(514, -535) => @ORIENT("MY");
// %t1488 @TEXT("n302", key="name", size=0.75);
// &n302 @WIRE(mode="straight") {#X268:4 %t1488:p};
// %t1489 = $SUPPLY @ATTACH &vdd => @PLACE(504, -522);
// &vdd @WIRE(mode="straight") {#X268:5 %t1489:p};
// %t1490 = $GROUND @ATTACH &vss => @PLACE(504, -548);
// &vss @WIRE(mode="straight") {#X268:6 %t1490:p};
// %t1491 = $IO_PORT @ATTACH &n300 => @PLACE(534, -531) => @ORIENT("R0");
// %t1491 @TEXT("n300", key="name", size=0.75);
// &n300 @WIRE(mode="straight") {#X269:1 %t1491:p};
// %t1492 = $IO_PORT @ATTACH &vss => @PLACE(534, -535) => @ORIENT("R0");
// %t1492 @TEXT("vss", key="name", size=0.75);
// &vss @WIRE(mode="straight") {#X269:2 %t1492:p};
// %t1493 = $IO_PORT @ATTACH &range_error => @PLACE(534, -539) => @ORIENT("R0");
// %t1493 @TEXT("range_error", key="name", size=0.75);
// &range_error @WIRE(mode="straight") {#X269:3 %t1493:p};
// %t1494 = $IO_PORT @ATTACH &n303 => @PLACE(554, -535) => @ORIENT("MY");
// %t1494 @TEXT("n303", key="name", size=0.75);
// &n303 @WIRE(mode="straight") {#X269:4 %t1494:p};
// %t1495 = $SUPPLY @ATTACH &vdd => @PLACE(544, -522);
// &vdd @WIRE(mode="straight") {#X269:5 %t1495:p};
// %t1496 = $GROUND @ATTACH &vss => @PLACE(544, -548);
// &vss @WIRE(mode="straight") {#X269:6 %t1496:p};
// %t1497 = $IO_PORT @ATTACH &n301 => @PLACE(574, -531) => @ORIENT("R0");
// %t1497 @TEXT("n301", key="name", size=0.75);
// &n301 @WIRE(mode="straight") {#X270:1 %t1497:p};
// %t1498 = $IO_PORT @ATTACH &vss => @PLACE(574, -535) => @ORIENT("R0");
// %t1498 @TEXT("vss", key="name", size=0.75);
// &vss @WIRE(mode="straight") {#X270:2 %t1498:p};
// %t1499 = $IO_PORT @ATTACH &range_error => @PLACE(574, -539) => @ORIENT("R0");
// %t1499 @TEXT("range_error", key="name", size=0.75);
// &range_error @WIRE(mode="straight") {#X270:3 %t1499:p};
// %t1500 = $IO_PORT @ATTACH &n304 => @PLACE(594, -535) => @ORIENT("MY");
// %t1500 @TEXT("n304", key="name", size=0.75);
// &n304 @WIRE(mode="straight") {#X270:4 %t1500:p};
// %t1501 = $SUPPLY @ATTACH &vdd => @PLACE(584, -522);
// &vdd @WIRE(mode="straight") {#X270:5 %t1501:p};
// %t1502 = $GROUND @ATTACH &vss => @PLACE(584, -548);
// &vss @WIRE(mode="straight") {#X270:6 %t1502:p};
// %t1503 = $IO_PORT @ATTACH &vss => @PLACE(614, -531) => @ORIENT("R0");
// %t1503 @TEXT("vss", key="name", size=0.75);
// &vss @WIRE(mode="straight") {#X271:1 %t1503:p};
// %t1504 = $IO_PORT @ATTACH &n302 => @PLACE(614, -535) => @ORIENT("R0");
// %t1504 @TEXT("n302", key="name", size=0.75);
// &n302 @WIRE(mode="straight") {#X271:2 %t1504:p};
// %t1505 = $IO_PORT @ATTACH &cfg_ready => @PLACE(614, -539) => @ORIENT("R0");
// %t1505 @TEXT("cfg_ready", key="name", size=0.75);
// &cfg_ready @WIRE(mode="straight") {#X271:3 %t1505:p};
// %t1506 = $IO_PORT @ATTACH &n72 => @PLACE(635, -535) => @ORIENT("MY");
// %t1506 @TEXT("n72", key="name", size=0.75);
// &n72 @WIRE(mode="straight") {#X271:4 %t1506:p};
// %t1507 = $SUPPLY @ATTACH &vdd => @PLACE(624, -522);
// &vdd @WIRE(mode="straight") {#X271:5 %t1507:p};
// %t1508 = $GROUND @ATTACH &vss => @PLACE(624, -548);
// &vss @WIRE(mode="straight") {#X271:6 %t1508:p};
// %t1509 = $IO_PORT @ATTACH &vss => @PLACE(494, -566) => @ORIENT("R0");
// %t1509 @TEXT("vss", key="name", size=0.75);
// &vss @WIRE(mode="straight") {#X272:1 %t1509:p};
// %t1510 = $IO_PORT @ATTACH &n303 => @PLACE(494, -570) => @ORIENT("R0");
// %t1510 @TEXT("n303", key="name", size=0.75);
// &n303 @WIRE(mode="straight") {#X272:2 %t1510:p};
// %t1511 = $IO_PORT @ATTACH &cfg_ready => @PLACE(494, -574) => @ORIENT("R0");
// %t1511 @TEXT("cfg_ready", key="name", size=0.75);
// &cfg_ready @WIRE(mode="straight") {#X272:3 %t1511:p};
// %t1512 = $IO_PORT @ATTACH &n70 => @PLACE(514, -570) => @ORIENT("MY");
// %t1512 @TEXT("n70", key="name", size=0.75);
// &n70 @WIRE(mode="straight") {#X272:4 %t1512:p};
// %t1513 = $SUPPLY @ATTACH &vdd => @PLACE(504, -557);
// &vdd @WIRE(mode="straight") {#X272:5 %t1513:p};
// %t1514 = $GROUND @ATTACH &vss => @PLACE(504, -583);
// &vss @WIRE(mode="straight") {#X272:6 %t1514:p};
// %t1515 = $IO_PORT @ATTACH &vss => @PLACE(534, -566) => @ORIENT("R0");
// %t1515 @TEXT("vss", key="name", size=0.75);
// &vss @WIRE(mode="straight") {#X273:1 %t1515:p};
// %t1516 = $IO_PORT @ATTACH &n304 => @PLACE(534, -570) => @ORIENT("R0");
// %t1516 @TEXT("n304", key="name", size=0.75);
// &n304 @WIRE(mode="straight") {#X273:2 %t1516:p};
// %t1517 = $IO_PORT @ATTACH &cfg_ready => @PLACE(534, -574) => @ORIENT("R0");
// %t1517 @TEXT("cfg_ready", key="name", size=0.75);
// &cfg_ready @WIRE(mode="straight") {#X273:3 %t1517:p};
// %t1518 = $IO_PORT @ATTACH &n73 => @PLACE(554, -570) => @ORIENT("MY");
// %t1518 @TEXT("n73", key="name", size=0.75);
// &n73 @WIRE(mode="straight") {#X273:4 %t1518:p};
// %t1519 = $SUPPLY @ATTACH &vdd => @PLACE(544, -557);
// &vdd @WIRE(mode="straight") {#X273:5 %t1519:p};
// %t1520 = $GROUND @ATTACH &vss => @PLACE(544, -583);
// &vss @WIRE(mode="straight") {#X273:6 %t1520:p};
// %t1521 = $IO_PORT @ATTACH &vss => @PLACE(574, -566) => @ORIENT("R0");
// %t1521 @TEXT("vss", key="name", size=0.75);
// &vss @WIRE(mode="straight") {#X274:1 %t1521:p};
// %t1522 = $IO_PORT @ATTACH &n83 => @PLACE(574, -570) => @ORIENT("R0");
// %t1522 @TEXT("n83", key="name", size=0.75);
// &n83 @WIRE(mode="straight") {#X274:2 %t1522:p};
// %t1523 = $IO_PORT @ATTACH &n185 => @PLACE(574, -574) => @ORIENT("R0");
// %t1523 @TEXT("n185", key="name", size=0.75);
// &n185 @WIRE(mode="straight") {#X274:3 %t1523:p};
// %t1524 = $IO_PORT @ATTACH &n305 => @PLACE(594, -570) => @ORIENT("MY");
// %t1524 @TEXT("n305", key="name", size=0.75);
// &n305 @WIRE(mode="straight") {#X274:4 %t1524:p};
// %t1525 = $SUPPLY @ATTACH &vdd => @PLACE(584, -557);
// &vdd @WIRE(mode="straight") {#X274:5 %t1525:p};
// %t1526 = $GROUND @ATTACH &vss => @PLACE(584, -583);
// &vss @WIRE(mode="straight") {#X274:6 %t1526:p};
// %t1527 = $IO_PORT @ATTACH &vss => @PLACE(614, -566) => @ORIENT("R0");
// %t1527 @TEXT("vss", key="name", size=0.75);
// &vss @WIRE(mode="straight") {#X275:1 %t1527:p};
// %t1528 = $IO_PORT @ATTACH &n127 => @PLACE(614, -570) => @ORIENT("R0");
// %t1528 @TEXT("n127", key="name", size=0.75);
// &n127 @WIRE(mode="straight") {#X275:2 %t1528:p};
// %t1529 = $IO_PORT @ATTACH &n185 => @PLACE(614, -574) => @ORIENT("R0");
// %t1529 @TEXT("n185", key="name", size=0.75);
// &n185 @WIRE(mode="straight") {#X275:3 %t1529:p};
// %t1530 = $IO_PORT @ATTACH &n306 => @PLACE(635, -570) => @ORIENT("MY");
// %t1530 @TEXT("n306", key="name", size=0.75);
// &n306 @WIRE(mode="straight") {#X275:4 %t1530:p};
// %t1531 = $SUPPLY @ATTACH &vdd => @PLACE(624, -557);
// &vdd @WIRE(mode="straight") {#X275:5 %t1531:p};
// %t1532 = $GROUND @ATTACH &vss => @PLACE(624, -583);
// &vss @WIRE(mode="straight") {#X275:6 %t1532:p};
// %t1533 = $IO_PORT @ATTACH &vss => @PLACE(494, -601) => @ORIENT("R0");
// %t1533 @TEXT("vss", key="name", size=0.75);
// &vss @WIRE(mode="straight") {#X276:1 %t1533:p};
// %t1534 = $IO_PORT @ATTACH &n128 => @PLACE(494, -605) => @ORIENT("R0");
// %t1534 @TEXT("n128", key="name", size=0.75);
// &n128 @WIRE(mode="straight") {#X276:2 %t1534:p};
// %t1535 = $IO_PORT @ATTACH &n185 => @PLACE(494, -609) => @ORIENT("R0");
// %t1535 @TEXT("n185", key="name", size=0.75);
// &n185 @WIRE(mode="straight") {#X276:3 %t1535:p};
// %t1536 = $IO_PORT @ATTACH &n307 => @PLACE(514, -605) => @ORIENT("MY");
// %t1536 @TEXT("n307", key="name", size=0.75);
// &n307 @WIRE(mode="straight") {#X276:4 %t1536:p};
// %t1537 = $SUPPLY @ATTACH &vdd => @PLACE(504, -592);
// &vdd @WIRE(mode="straight") {#X276:5 %t1537:p};
// %t1538 = $GROUND @ATTACH &vss => @PLACE(504, -618);
// &vss @WIRE(mode="straight") {#X276:6 %t1538:p};
// %t1539 = $IO_PORT @ATTACH &vss => @PLACE(534, -601) => @ORIENT("R0");
// %t1539 @TEXT("vss", key="name", size=0.75);
// &vss @WIRE(mode="straight") {#X277:1 %t1539:p};
// %t1540 = $IO_PORT @ATTACH &n129 => @PLACE(534, -605) => @ORIENT("R0");
// %t1540 @TEXT("n129", key="name", size=0.75);
// &n129 @WIRE(mode="straight") {#X277:2 %t1540:p};
// %t1541 = $IO_PORT @ATTACH &n185 => @PLACE(534, -609) => @ORIENT("R0");
// %t1541 @TEXT("n185", key="name", size=0.75);
// &n185 @WIRE(mode="straight") {#X277:3 %t1541:p};
// %t1542 = $IO_PORT @ATTACH &n308 => @PLACE(554, -605) => @ORIENT("MY");
// %t1542 @TEXT("n308", key="name", size=0.75);
// &n308 @WIRE(mode="straight") {#X277:4 %t1542:p};
// %t1543 = $SUPPLY @ATTACH &vdd => @PLACE(544, -592);
// &vdd @WIRE(mode="straight") {#X277:5 %t1543:p};
// %t1544 = $GROUND @ATTACH &vss => @PLACE(544, -618);
// &vss @WIRE(mode="straight") {#X277:6 %t1544:p};
// %t1545 = $IO_PORT @ATTACH &vss => @PLACE(574, -601) => @ORIENT("R0");
// %t1545 @TEXT("vss", key="name", size=0.75);
// &vss @WIRE(mode="straight") {#X278:1 %t1545:p};
// %t1546 = $IO_PORT @ATTACH &n130 => @PLACE(574, -605) => @ORIENT("R0");
// %t1546 @TEXT("n130", key="name", size=0.75);
// &n130 @WIRE(mode="straight") {#X278:2 %t1546:p};
// %t1547 = $IO_PORT @ATTACH &n185 => @PLACE(574, -609) => @ORIENT("R0");
// %t1547 @TEXT("n185", key="name", size=0.75);
// &n185 @WIRE(mode="straight") {#X278:3 %t1547:p};
// %t1548 = $IO_PORT @ATTACH &n309 => @PLACE(594, -605) => @ORIENT("MY");
// %t1548 @TEXT("n309", key="name", size=0.75);
// &n309 @WIRE(mode="straight") {#X278:4 %t1548:p};
// %t1549 = $SUPPLY @ATTACH &vdd => @PLACE(584, -592);
// &vdd @WIRE(mode="straight") {#X278:5 %t1549:p};
// %t1550 = $GROUND @ATTACH &vss => @PLACE(584, -618);
// &vss @WIRE(mode="straight") {#X278:6 %t1550:p};
// %t1551 = $IO_PORT @ATTACH &vss => @PLACE(614, -601) => @ORIENT("R0");
// %t1551 @TEXT("vss", key="name", size=0.75);
// &vss @WIRE(mode="straight") {#X279:1 %t1551:p};
// %t1552 = $IO_PORT @ATTACH &n131 => @PLACE(614, -605) => @ORIENT("R0");
// %t1552 @TEXT("n131", key="name", size=0.75);
// &n131 @WIRE(mode="straight") {#X279:2 %t1552:p};
// %t1553 = $IO_PORT @ATTACH &n185 => @PLACE(614, -609) => @ORIENT("R0");
// %t1553 @TEXT("n185", key="name", size=0.75);
// &n185 @WIRE(mode="straight") {#X279:3 %t1553:p};
// %t1554 = $IO_PORT @ATTACH &n310 => @PLACE(635, -605) => @ORIENT("MY");
// %t1554 @TEXT("n310", key="name", size=0.75);
// &n310 @WIRE(mode="straight") {#X279:4 %t1554:p};
// %t1555 = $SUPPLY @ATTACH &vdd => @PLACE(624, -592);
// &vdd @WIRE(mode="straight") {#X279:5 %t1555:p};
// %t1556 = $GROUND @ATTACH &vss => @PLACE(624, -618);
// &vss @WIRE(mode="straight") {#X279:6 %t1556:p};
// %t1557 = $IO_PORT @ATTACH &n305 => @PLACE(494, -636) => @ORIENT("R0");
// %t1557 @TEXT("n305", key="name", size=0.75);
// &n305 @WIRE(mode="straight") {#X280:1 %t1557:p};
// %t1558 = $IO_PORT @ATTACH &vss => @PLACE(494, -640) => @ORIENT("R0");
// %t1558 @TEXT("vss", key="name", size=0.75);
// &vss @WIRE(mode="straight") {#X280:2 %t1558:p};
// %t1559 = $IO_PORT @ATTACH &qualified => @PLACE(494, -644) => @ORIENT("R0");
// %t1559 @TEXT("qualified", key="name", size=0.75);
// &qualified @WIRE(mode="straight") {#X280:3 %t1559:p};
// %t1560 = $IO_PORT @ATTACH &n311 => @PLACE(514, -640) => @ORIENT("MY");
// %t1560 @TEXT("n311", key="name", size=0.75);
// &n311 @WIRE(mode="straight") {#X280:4 %t1560:p};
// %t1561 = $SUPPLY @ATTACH &vdd => @PLACE(504, -627);
// &vdd @WIRE(mode="straight") {#X280:5 %t1561:p};
// %t1562 = $GROUND @ATTACH &vss => @PLACE(504, -653);
// &vss @WIRE(mode="straight") {#X280:6 %t1562:p};
// %t1563 = $IO_PORT @ATTACH &n306 => @PLACE(534, -636) => @ORIENT("R0");
// %t1563 @TEXT("n306", key="name", size=0.75);
// &n306 @WIRE(mode="straight") {#X281:1 %t1563:p};
// %t1564 = $IO_PORT @ATTACH &vss => @PLACE(534, -640) => @ORIENT("R0");
// %t1564 @TEXT("vss", key="name", size=0.75);
// &vss @WIRE(mode="straight") {#X281:2 %t1564:p};
// %t1565 = $IO_PORT @ATTACH &qualified => @PLACE(534, -644) => @ORIENT("R0");
// %t1565 @TEXT("qualified", key="name", size=0.75);
// &qualified @WIRE(mode="straight") {#X281:3 %t1565:p};
// %t1566 = $IO_PORT @ATTACH &n312 => @PLACE(554, -640) => @ORIENT("MY");
// %t1566 @TEXT("n312", key="name", size=0.75);
// &n312 @WIRE(mode="straight") {#X281:4 %t1566:p};
// %t1567 = $SUPPLY @ATTACH &vdd => @PLACE(544, -627);
// &vdd @WIRE(mode="straight") {#X281:5 %t1567:p};
// %t1568 = $GROUND @ATTACH &vss => @PLACE(544, -653);
// &vss @WIRE(mode="straight") {#X281:6 %t1568:p};
// %t1569 = $IO_PORT @ATTACH &n307 => @PLACE(574, -636) => @ORIENT("R0");
// %t1569 @TEXT("n307", key="name", size=0.75);
// &n307 @WIRE(mode="straight") {#X282:1 %t1569:p};
// %t1570 = $IO_PORT @ATTACH &vss => @PLACE(574, -640) => @ORIENT("R0");
// %t1570 @TEXT("vss", key="name", size=0.75);
// &vss @WIRE(mode="straight") {#X282:2 %t1570:p};
// %t1571 = $IO_PORT @ATTACH &qualified => @PLACE(574, -644) => @ORIENT("R0");
// %t1571 @TEXT("qualified", key="name", size=0.75);
// &qualified @WIRE(mode="straight") {#X282:3 %t1571:p};
// %t1572 = $IO_PORT @ATTACH &n313 => @PLACE(594, -640) => @ORIENT("MY");
// %t1572 @TEXT("n313", key="name", size=0.75);
// &n313 @WIRE(mode="straight") {#X282:4 %t1572:p};
// %t1573 = $SUPPLY @ATTACH &vdd => @PLACE(584, -627);
// &vdd @WIRE(mode="straight") {#X282:5 %t1573:p};
// %t1574 = $GROUND @ATTACH &vss => @PLACE(584, -653);
// &vss @WIRE(mode="straight") {#X282:6 %t1574:p};
// %t1575 = $IO_PORT @ATTACH &n308 => @PLACE(614, -636) => @ORIENT("R0");
// %t1575 @TEXT("n308", key="name", size=0.75);
// &n308 @WIRE(mode="straight") {#X283:1 %t1575:p};
// %t1576 = $IO_PORT @ATTACH &vss => @PLACE(614, -640) => @ORIENT("R0");
// %t1576 @TEXT("vss", key="name", size=0.75);
// &vss @WIRE(mode="straight") {#X283:2 %t1576:p};
// %t1577 = $IO_PORT @ATTACH &qualified => @PLACE(614, -644) => @ORIENT("R0");
// %t1577 @TEXT("qualified", key="name", size=0.75);
// &qualified @WIRE(mode="straight") {#X283:3 %t1577:p};
// %t1578 = $IO_PORT @ATTACH &n314 => @PLACE(635, -640) => @ORIENT("MY");
// %t1578 @TEXT("n314", key="name", size=0.75);
// &n314 @WIRE(mode="straight") {#X283:4 %t1578:p};
// %t1579 = $SUPPLY @ATTACH &vdd => @PLACE(624, -627);
// &vdd @WIRE(mode="straight") {#X283:5 %t1579:p};
// %t1580 = $GROUND @ATTACH &vss => @PLACE(624, -653);
// &vss @WIRE(mode="straight") {#X283:6 %t1580:p};
// %t1581 = $IO_PORT @ATTACH &n309 => @PLACE(494, -671) => @ORIENT("R0");
// %t1581 @TEXT("n309", key="name", size=0.75);
// &n309 @WIRE(mode="straight") {#X284:1 %t1581:p};
// %t1582 = $IO_PORT @ATTACH &vss => @PLACE(494, -675) => @ORIENT("R0");
// %t1582 @TEXT("vss", key="name", size=0.75);
// &vss @WIRE(mode="straight") {#X284:2 %t1582:p};
// %t1583 = $IO_PORT @ATTACH &qualified => @PLACE(494, -679) => @ORIENT("R0");
// %t1583 @TEXT("qualified", key="name", size=0.75);
// &qualified @WIRE(mode="straight") {#X284:3 %t1583:p};
// %t1584 = $IO_PORT @ATTACH &n315 => @PLACE(514, -675) => @ORIENT("MY");
// %t1584 @TEXT("n315", key="name", size=0.75);
// &n315 @WIRE(mode="straight") {#X284:4 %t1584:p};
// %t1585 = $SUPPLY @ATTACH &vdd => @PLACE(504, -662);
// &vdd @WIRE(mode="straight") {#X284:5 %t1585:p};
// %t1586 = $GROUND @ATTACH &vss => @PLACE(504, -688);
// &vss @WIRE(mode="straight") {#X284:6 %t1586:p};
// %t1587 = $IO_PORT @ATTACH &n310 => @PLACE(534, -671) => @ORIENT("R0");
// %t1587 @TEXT("n310", key="name", size=0.75);
// &n310 @WIRE(mode="straight") {#X285:1 %t1587:p};
// %t1588 = $IO_PORT @ATTACH &vss => @PLACE(534, -675) => @ORIENT("R0");
// %t1588 @TEXT("vss", key="name", size=0.75);
// &vss @WIRE(mode="straight") {#X285:2 %t1588:p};
// %t1589 = $IO_PORT @ATTACH &qualified => @PLACE(534, -679) => @ORIENT("R0");
// %t1589 @TEXT("qualified", key="name", size=0.75);
// &qualified @WIRE(mode="straight") {#X285:3 %t1589:p};
// %t1590 = $IO_PORT @ATTACH &n316 => @PLACE(554, -675) => @ORIENT("MY");
// %t1590 @TEXT("n316", key="name", size=0.75);
// &n316 @WIRE(mode="straight") {#X285:4 %t1590:p};
// %t1591 = $SUPPLY @ATTACH &vdd => @PLACE(544, -662);
// &vdd @WIRE(mode="straight") {#X285:5 %t1591:p};
// %t1592 = $GROUND @ATTACH &vss => @PLACE(544, -688);
// &vss @WIRE(mode="straight") {#X285:6 %t1592:p};
// %t1593 = $IO_PORT @ATTACH &vss => @PLACE(574, -671) => @ORIENT("R0");
// %t1593 @TEXT("vss", key="name", size=0.75);
// &vss @WIRE(mode="straight") {#X286:1 %t1593:p};
// %t1594 = $IO_PORT @ATTACH &n311 => @PLACE(574, -675) => @ORIENT("R0");
// %t1594 @TEXT("n311", key="name", size=0.75);
// &n311 @WIRE(mode="straight") {#X286:2 %t1594:p};
// %t1595 = $IO_PORT @ATTACH &n93 => @PLACE(574, -679) => @ORIENT("R0");
// %t1595 @TEXT("n93", key="name", size=0.75);
// &n93 @WIRE(mode="straight") {#X286:3 %t1595:p};
// %t1596 = $IO_PORT @ATTACH &n317 => @PLACE(594, -675) => @ORIENT("MY");
// %t1596 @TEXT("n317", key="name", size=0.75);
// &n317 @WIRE(mode="straight") {#X286:4 %t1596:p};
// %t1597 = $SUPPLY @ATTACH &vdd => @PLACE(584, -662);
// &vdd @WIRE(mode="straight") {#X286:5 %t1597:p};
// %t1598 = $GROUND @ATTACH &vss => @PLACE(584, -688);
// &vss @WIRE(mode="straight") {#X286:6 %t1598:p};
// %t1599 = $IO_PORT @ATTACH &vss => @PLACE(614, -671) => @ORIENT("R0");
// %t1599 @TEXT("vss", key="name", size=0.75);
// &vss @WIRE(mode="straight") {#X287:1 %t1599:p};
// %t1600 = $IO_PORT @ATTACH &n312 => @PLACE(614, -675) => @ORIENT("R0");
// %t1600 @TEXT("n312", key="name", size=0.75);
// &n312 @WIRE(mode="straight") {#X287:2 %t1600:p};
// %t1601 = $IO_PORT @ATTACH &n93 => @PLACE(614, -679) => @ORIENT("R0");
// %t1601 @TEXT("n93", key="name", size=0.75);
// &n93 @WIRE(mode="straight") {#X287:3 %t1601:p};
// %t1602 = $IO_PORT @ATTACH &n318 => @PLACE(635, -675) => @ORIENT("MY");
// %t1602 @TEXT("n318", key="name", size=0.75);
// &n318 @WIRE(mode="straight") {#X287:4 %t1602:p};
// %t1603 = $SUPPLY @ATTACH &vdd => @PLACE(624, -662);
// &vdd @WIRE(mode="straight") {#X287:5 %t1603:p};
// %t1604 = $GROUND @ATTACH &vss => @PLACE(624, -688);
// &vss @WIRE(mode="straight") {#X287:6 %t1604:p};
// %t1605 = $IO_PORT @ATTACH &vss => @PLACE(-11, -716) => @ORIENT("R0");
// %t1605 @TEXT("vss", key="name", size=0.75);
// &vss @WIRE(mode="straight") {#X288:1 %t1605:p};
// %t1606 = $IO_PORT @ATTACH &n313 => @PLACE(-11, -720) => @ORIENT("R0");
// %t1606 @TEXT("n313", key="name", size=0.75);
// &n313 @WIRE(mode="straight") {#X288:2 %t1606:p};
// %t1607 = $IO_PORT @ATTACH &n93 => @PLACE(-11, -724) => @ORIENT("R0");
// %t1607 @TEXT("n93", key="name", size=0.75);
// &n93 @WIRE(mode="straight") {#X288:3 %t1607:p};
// %t1608 = $IO_PORT @ATTACH &n319 => @PLACE(10, -720) => @ORIENT("MY");
// %t1608 @TEXT("n319", key="name", size=0.75);
// &n319 @WIRE(mode="straight") {#X288:4 %t1608:p};
// %t1609 = $SUPPLY @ATTACH &vdd => @PLACE(0, -707);
// &vdd @WIRE(mode="straight") {#X288:5 %t1609:p};
// %t1610 = $GROUND @ATTACH &vss => @PLACE(0, -733);
// &vss @WIRE(mode="straight") {#X288:6 %t1610:p};
// %t1611 = $IO_PORT @ATTACH &vss => @PLACE(30, -716) => @ORIENT("R0");
// %t1611 @TEXT("vss", key="name", size=0.75);
// &vss @WIRE(mode="straight") {#X289:1 %t1611:p};
// %t1612 = $IO_PORT @ATTACH &n314 => @PLACE(30, -720) => @ORIENT("R0");
// %t1612 @TEXT("n314", key="name", size=0.75);
// &n314 @WIRE(mode="straight") {#X289:2 %t1612:p};
// %t1613 = $IO_PORT @ATTACH &n93 => @PLACE(30, -724) => @ORIENT("R0");
// %t1613 @TEXT("n93", key="name", size=0.75);
// &n93 @WIRE(mode="straight") {#X289:3 %t1613:p};
// %t1614 = $IO_PORT @ATTACH &n320 => @PLACE(50, -720) => @ORIENT("MY");
// %t1614 @TEXT("n320", key="name", size=0.75);
// &n320 @WIRE(mode="straight") {#X289:4 %t1614:p};
// %t1615 = $SUPPLY @ATTACH &vdd => @PLACE(40, -707);
// &vdd @WIRE(mode="straight") {#X289:5 %t1615:p};
// %t1616 = $GROUND @ATTACH &vss => @PLACE(40, -733);
// &vss @WIRE(mode="straight") {#X289:6 %t1616:p};
// %t1617 = $IO_PORT @ATTACH &vss => @PLACE(70, -716) => @ORIENT("R0");
// %t1617 @TEXT("vss", key="name", size=0.75);
// &vss @WIRE(mode="straight") {#X290:1 %t1617:p};
// %t1618 = $IO_PORT @ATTACH &n315 => @PLACE(70, -720) => @ORIENT("R0");
// %t1618 @TEXT("n315", key="name", size=0.75);
// &n315 @WIRE(mode="straight") {#X290:2 %t1618:p};
// %t1619 = $IO_PORT @ATTACH &n93 => @PLACE(70, -724) => @ORIENT("R0");
// %t1619 @TEXT("n93", key="name", size=0.75);
// &n93 @WIRE(mode="straight") {#X290:3 %t1619:p};
// %t1620 = $IO_PORT @ATTACH &n321 => @PLACE(90, -720) => @ORIENT("MY");
// %t1620 @TEXT("n321", key="name", size=0.75);
// &n321 @WIRE(mode="straight") {#X290:4 %t1620:p};
// %t1621 = $SUPPLY @ATTACH &vdd => @PLACE(80, -707);
// &vdd @WIRE(mode="straight") {#X290:5 %t1621:p};
// %t1622 = $GROUND @ATTACH &vss => @PLACE(80, -733);
// &vss @WIRE(mode="straight") {#X290:6 %t1622:p};
// %t1623 = $IO_PORT @ATTACH &vss => @PLACE(110, -716) => @ORIENT("R0");
// %t1623 @TEXT("vss", key="name", size=0.75);
// &vss @WIRE(mode="straight") {#X291:1 %t1623:p};
// %t1624 = $IO_PORT @ATTACH &n316 => @PLACE(110, -720) => @ORIENT("R0");
// %t1624 @TEXT("n316", key="name", size=0.75);
// &n316 @WIRE(mode="straight") {#X291:2 %t1624:p};
// %t1625 = $IO_PORT @ATTACH &n93 => @PLACE(110, -724) => @ORIENT("R0");
// %t1625 @TEXT("n93", key="name", size=0.75);
// &n93 @WIRE(mode="straight") {#X291:3 %t1625:p};
// %t1626 = $IO_PORT @ATTACH &n322 => @PLACE(130, -720) => @ORIENT("MY");
// %t1626 @TEXT("n322", key="name", size=0.75);
// &n322 @WIRE(mode="straight") {#X291:4 %t1626:p};
// %t1627 = $SUPPLY @ATTACH &vdd => @PLACE(120, -707);
// &vdd @WIRE(mode="straight") {#X291:5 %t1627:p};
// %t1628 = $GROUND @ATTACH &vss => @PLACE(120, -733);
// &vss @WIRE(mode="straight") {#X291:6 %t1628:p};
// %t1629 = $IO_PORT @ATTACH &n317 => @PLACE(-11, -751) => @ORIENT("R0");
// %t1629 @TEXT("n317", key="name", size=0.75);
// &n317 @WIRE(mode="straight") {#X292:1 %t1629:p};
// %t1630 = $IO_PORT @ATTACH &vss => @PLACE(-11, -755) => @ORIENT("R0");
// %t1630 @TEXT("vss", key="name", size=0.75);
// &vss @WIRE(mode="straight") {#X292:2 %t1630:p};
// %t1631 = $IO_PORT @ATTACH &n136 => @PLACE(-11, -759) => @ORIENT("R0");
// %t1631 @TEXT("n136", key="name", size=0.75);
// &n136 @WIRE(mode="straight") {#X292:3 %t1631:p};
// %t1632 = $IO_PORT @ATTACH &n323 => @PLACE(10, -755) => @ORIENT("MY");
// %t1632 @TEXT("n323", key="name", size=0.75);
// &n323 @WIRE(mode="straight") {#X292:4 %t1632:p};
// %t1633 = $SUPPLY @ATTACH &vdd => @PLACE(0, -742);
// &vdd @WIRE(mode="straight") {#X292:5 %t1633:p};
// %t1634 = $GROUND @ATTACH &vss => @PLACE(0, -768);
// &vss @WIRE(mode="straight") {#X292:6 %t1634:p};
// %t1635 = $IO_PORT @ATTACH &n318 => @PLACE(30, -751) => @ORIENT("R0");
// %t1635 @TEXT("n318", key="name", size=0.75);
// &n318 @WIRE(mode="straight") {#X293:1 %t1635:p};
// %t1636 = $IO_PORT @ATTACH &vss => @PLACE(30, -755) => @ORIENT("R0");
// %t1636 @TEXT("vss", key="name", size=0.75);
// &vss @WIRE(mode="straight") {#X293:2 %t1636:p};
// %t1637 = $IO_PORT @ATTACH &n136 => @PLACE(30, -759) => @ORIENT("R0");
// %t1637 @TEXT("n136", key="name", size=0.75);
// &n136 @WIRE(mode="straight") {#X293:3 %t1637:p};
// %t1638 = $IO_PORT @ATTACH &n324 => @PLACE(50, -755) => @ORIENT("MY");
// %t1638 @TEXT("n324", key="name", size=0.75);
// &n324 @WIRE(mode="straight") {#X293:4 %t1638:p};
// %t1639 = $SUPPLY @ATTACH &vdd => @PLACE(40, -742);
// &vdd @WIRE(mode="straight") {#X293:5 %t1639:p};
// %t1640 = $GROUND @ATTACH &vss => @PLACE(40, -768);
// &vss @WIRE(mode="straight") {#X293:6 %t1640:p};
// %t1641 = $IO_PORT @ATTACH &n319 => @PLACE(70, -751) => @ORIENT("R0");
// %t1641 @TEXT("n319", key="name", size=0.75);
// &n319 @WIRE(mode="straight") {#X294:1 %t1641:p};
// %t1642 = $IO_PORT @ATTACH &vss => @PLACE(70, -755) => @ORIENT("R0");
// %t1642 @TEXT("vss", key="name", size=0.75);
// &vss @WIRE(mode="straight") {#X294:2 %t1642:p};
// %t1643 = $IO_PORT @ATTACH &n136 => @PLACE(70, -759) => @ORIENT("R0");
// %t1643 @TEXT("n136", key="name", size=0.75);
// &n136 @WIRE(mode="straight") {#X294:3 %t1643:p};
// %t1644 = $IO_PORT @ATTACH &n325 => @PLACE(90, -755) => @ORIENT("MY");
// %t1644 @TEXT("n325", key="name", size=0.75);
// &n325 @WIRE(mode="straight") {#X294:4 %t1644:p};
// %t1645 = $SUPPLY @ATTACH &vdd => @PLACE(80, -742);
// &vdd @WIRE(mode="straight") {#X294:5 %t1645:p};
// %t1646 = $GROUND @ATTACH &vss => @PLACE(80, -768);
// &vss @WIRE(mode="straight") {#X294:6 %t1646:p};
// %t1647 = $IO_PORT @ATTACH &n320 => @PLACE(110, -751) => @ORIENT("R0");
// %t1647 @TEXT("n320", key="name", size=0.75);
// &n320 @WIRE(mode="straight") {#X295:1 %t1647:p};
// %t1648 = $IO_PORT @ATTACH &vss => @PLACE(110, -755) => @ORIENT("R0");
// %t1648 @TEXT("vss", key="name", size=0.75);
// &vss @WIRE(mode="straight") {#X295:2 %t1648:p};
// %t1649 = $IO_PORT @ATTACH &n136 => @PLACE(110, -759) => @ORIENT("R0");
// %t1649 @TEXT("n136", key="name", size=0.75);
// &n136 @WIRE(mode="straight") {#X295:3 %t1649:p};
// %t1650 = $IO_PORT @ATTACH &n326 => @PLACE(130, -755) => @ORIENT("MY");
// %t1650 @TEXT("n326", key="name", size=0.75);
// &n326 @WIRE(mode="straight") {#X295:4 %t1650:p};
// %t1651 = $SUPPLY @ATTACH &vdd => @PLACE(120, -742);
// &vdd @WIRE(mode="straight") {#X295:5 %t1651:p};
// %t1652 = $GROUND @ATTACH &vss => @PLACE(120, -768);
// &vss @WIRE(mode="straight") {#X295:6 %t1652:p};
// %t1653 = $IO_PORT @ATTACH &n321 => @PLACE(-11, -786) => @ORIENT("R0");
// %t1653 @TEXT("n321", key="name", size=0.75);
// &n321 @WIRE(mode="straight") {#X296:1 %t1653:p};
// %t1654 = $IO_PORT @ATTACH &vss => @PLACE(-11, -790) => @ORIENT("R0");
// %t1654 @TEXT("vss", key="name", size=0.75);
// &vss @WIRE(mode="straight") {#X296:2 %t1654:p};
// %t1655 = $IO_PORT @ATTACH &n136 => @PLACE(-11, -794) => @ORIENT("R0");
// %t1655 @TEXT("n136", key="name", size=0.75);
// &n136 @WIRE(mode="straight") {#X296:3 %t1655:p};
// %t1656 = $IO_PORT @ATTACH &n327 => @PLACE(10, -790) => @ORIENT("MY");
// %t1656 @TEXT("n327", key="name", size=0.75);
// &n327 @WIRE(mode="straight") {#X296:4 %t1656:p};
// %t1657 = $SUPPLY @ATTACH &vdd => @PLACE(0, -777);
// &vdd @WIRE(mode="straight") {#X296:5 %t1657:p};
// %t1658 = $GROUND @ATTACH &vss => @PLACE(0, -803);
// &vss @WIRE(mode="straight") {#X296:6 %t1658:p};
// %t1659 = $IO_PORT @ATTACH &n322 => @PLACE(30, -786) => @ORIENT("R0");
// %t1659 @TEXT("n322", key="name", size=0.75);
// &n322 @WIRE(mode="straight") {#X297:1 %t1659:p};
// %t1660 = $IO_PORT @ATTACH &vss => @PLACE(30, -790) => @ORIENT("R0");
// %t1660 @TEXT("vss", key="name", size=0.75);
// &vss @WIRE(mode="straight") {#X297:2 %t1660:p};
// %t1661 = $IO_PORT @ATTACH &n136 => @PLACE(30, -794) => @ORIENT("R0");
// %t1661 @TEXT("n136", key="name", size=0.75);
// &n136 @WIRE(mode="straight") {#X297:3 %t1661:p};
// %t1662 = $IO_PORT @ATTACH &n328 => @PLACE(50, -790) => @ORIENT("MY");
// %t1662 @TEXT("n328", key="name", size=0.75);
// &n328 @WIRE(mode="straight") {#X297:4 %t1662:p};
// %t1663 = $SUPPLY @ATTACH &vdd => @PLACE(40, -777);
// &vdd @WIRE(mode="straight") {#X297:5 %t1663:p};
// %t1664 = $GROUND @ATTACH &vss => @PLACE(40, -803);
// &vss @WIRE(mode="straight") {#X297:6 %t1664:p};
// %t1665 = $IO_PORT @ATTACH &vss => @PLACE(70, -786) => @ORIENT("R0");
// %t1665 @TEXT("vss", key="name", size=0.75);
// &vss @WIRE(mode="straight") {#X298:1 %t1665:p};
// %t1666 = $IO_PORT @ATTACH &n323 => @PLACE(70, -790) => @ORIENT("R0");
// %t1666 @TEXT("n323", key="name", size=0.75);
// &n323 @WIRE(mode="straight") {#X298:2 %t1666:p};
// %t1667 = $IO_PORT @ATTACH &fll_enable => @PLACE(70, -794) => @ORIENT("R0");
// %t1667 @TEXT("fll_enable", key="name", size=0.75);
// &fll_enable @WIRE(mode="straight") {#X298:3 %t1667:p};
// %t1668 = $IO_PORT @ATTACH &n329 => @PLACE(90, -790) => @ORIENT("MY");
// %t1668 @TEXT("n329", key="name", size=0.75);
// &n329 @WIRE(mode="straight") {#X298:4 %t1668:p};
// %t1669 = $SUPPLY @ATTACH &vdd => @PLACE(80, -777);
// &vdd @WIRE(mode="straight") {#X298:5 %t1669:p};
// %t1670 = $GROUND @ATTACH &vss => @PLACE(80, -803);
// &vss @WIRE(mode="straight") {#X298:6 %t1670:p};
// %t1671 = $IO_PORT @ATTACH &vss => @PLACE(110, -786) => @ORIENT("R0");
// %t1671 @TEXT("vss", key="name", size=0.75);
// &vss @WIRE(mode="straight") {#X299:1 %t1671:p};
// %t1672 = $IO_PORT @ATTACH &n324 => @PLACE(110, -790) => @ORIENT("R0");
// %t1672 @TEXT("n324", key="name", size=0.75);
// &n324 @WIRE(mode="straight") {#X299:2 %t1672:p};
// %t1673 = $IO_PORT @ATTACH &fll_enable => @PLACE(110, -794) => @ORIENT("R0");
// %t1673 @TEXT("fll_enable", key="name", size=0.75);
// &fll_enable @WIRE(mode="straight") {#X299:3 %t1673:p};
// %t1674 = $IO_PORT @ATTACH &n330 => @PLACE(130, -790) => @ORIENT("MY");
// %t1674 @TEXT("n330", key="name", size=0.75);
// &n330 @WIRE(mode="straight") {#X299:4 %t1674:p};
// %t1675 = $SUPPLY @ATTACH &vdd => @PLACE(120, -777);
// &vdd @WIRE(mode="straight") {#X299:5 %t1675:p};
// %t1676 = $GROUND @ATTACH &vss => @PLACE(120, -803);
// &vss @WIRE(mode="straight") {#X299:6 %t1676:p};
// %t1677 = $IO_PORT @ATTACH &vss => @PLACE(-11, -821) => @ORIENT("R0");
// %t1677 @TEXT("vss", key="name", size=0.75);
// &vss @WIRE(mode="straight") {#X300:1 %t1677:p};
// %t1678 = $IO_PORT @ATTACH &n325 => @PLACE(-11, -825) => @ORIENT("R0");
// %t1678 @TEXT("n325", key="name", size=0.75);
// &n325 @WIRE(mode="straight") {#X300:2 %t1678:p};
// %t1679 = $IO_PORT @ATTACH &fll_enable => @PLACE(-11, -829) => @ORIENT("R0");
// %t1679 @TEXT("fll_enable", key="name", size=0.75);
// &fll_enable @WIRE(mode="straight") {#X300:3 %t1679:p};
// %t1680 = $IO_PORT @ATTACH &n331 => @PLACE(10, -825) => @ORIENT("MY");
// %t1680 @TEXT("n331", key="name", size=0.75);
// &n331 @WIRE(mode="straight") {#X300:4 %t1680:p};
// %t1681 = $SUPPLY @ATTACH &vdd => @PLACE(0, -812);
// &vdd @WIRE(mode="straight") {#X300:5 %t1681:p};
// %t1682 = $GROUND @ATTACH &vss => @PLACE(0, -838);
// &vss @WIRE(mode="straight") {#X300:6 %t1682:p};
// %t1683 = $IO_PORT @ATTACH &vss => @PLACE(30, -821) => @ORIENT("R0");
// %t1683 @TEXT("vss", key="name", size=0.75);
// &vss @WIRE(mode="straight") {#X301:1 %t1683:p};
// %t1684 = $IO_PORT @ATTACH &n326 => @PLACE(30, -825) => @ORIENT("R0");
// %t1684 @TEXT("n326", key="name", size=0.75);
// &n326 @WIRE(mode="straight") {#X301:2 %t1684:p};
// %t1685 = $IO_PORT @ATTACH &fll_enable => @PLACE(30, -829) => @ORIENT("R0");
// %t1685 @TEXT("fll_enable", key="name", size=0.75);
// &fll_enable @WIRE(mode="straight") {#X301:3 %t1685:p};
// %t1686 = $IO_PORT @ATTACH &n332 => @PLACE(50, -825) => @ORIENT("MY");
// %t1686 @TEXT("n332", key="name", size=0.75);
// &n332 @WIRE(mode="straight") {#X301:4 %t1686:p};
// %t1687 = $SUPPLY @ATTACH &vdd => @PLACE(40, -812);
// &vdd @WIRE(mode="straight") {#X301:5 %t1687:p};
// %t1688 = $GROUND @ATTACH &vss => @PLACE(40, -838);
// &vss @WIRE(mode="straight") {#X301:6 %t1688:p};
// %t1689 = $IO_PORT @ATTACH &vss => @PLACE(70, -821) => @ORIENT("R0");
// %t1689 @TEXT("vss", key="name", size=0.75);
// &vss @WIRE(mode="straight") {#X302:1 %t1689:p};
// %t1690 = $IO_PORT @ATTACH &n327 => @PLACE(70, -825) => @ORIENT("R0");
// %t1690 @TEXT("n327", key="name", size=0.75);
// &n327 @WIRE(mode="straight") {#X302:2 %t1690:p};
// %t1691 = $IO_PORT @ATTACH &fll_enable => @PLACE(70, -829) => @ORIENT("R0");
// %t1691 @TEXT("fll_enable", key="name", size=0.75);
// &fll_enable @WIRE(mode="straight") {#X302:3 %t1691:p};
// %t1692 = $IO_PORT @ATTACH &n333 => @PLACE(90, -825) => @ORIENT("MY");
// %t1692 @TEXT("n333", key="name", size=0.75);
// &n333 @WIRE(mode="straight") {#X302:4 %t1692:p};
// %t1693 = $SUPPLY @ATTACH &vdd => @PLACE(80, -812);
// &vdd @WIRE(mode="straight") {#X302:5 %t1693:p};
// %t1694 = $GROUND @ATTACH &vss => @PLACE(80, -838);
// &vss @WIRE(mode="straight") {#X302:6 %t1694:p};
// %t1695 = $IO_PORT @ATTACH &vss => @PLACE(110, -821) => @ORIENT("R0");
// %t1695 @TEXT("vss", key="name", size=0.75);
// &vss @WIRE(mode="straight") {#X303:1 %t1695:p};
// %t1696 = $IO_PORT @ATTACH &n328 => @PLACE(110, -825) => @ORIENT("R0");
// %t1696 @TEXT("n328", key="name", size=0.75);
// &n328 @WIRE(mode="straight") {#X303:2 %t1696:p};
// %t1697 = $IO_PORT @ATTACH &fll_enable => @PLACE(110, -829) => @ORIENT("R0");
// %t1697 @TEXT("fll_enable", key="name", size=0.75);
// &fll_enable @WIRE(mode="straight") {#X303:3 %t1697:p};
// %t1698 = $IO_PORT @ATTACH &n334 => @PLACE(130, -825) => @ORIENT("MY");
// %t1698 @TEXT("n334", key="name", size=0.75);
// &n334 @WIRE(mode="straight") {#X303:4 %t1698:p};
// %t1699 = $SUPPLY @ATTACH &vdd => @PLACE(120, -812);
// &vdd @WIRE(mode="straight") {#X303:5 %t1699:p};
// %t1700 = $GROUND @ATTACH &vss => @PLACE(120, -838);
// &vss @WIRE(mode="straight") {#X303:6 %t1700:p};
// %t1701 = $IO_PORT @ATTACH &n329 => @PLACE(-11, -856) => @ORIENT("R0");
// %t1701 @TEXT("n329", key="name", size=0.75);
// &n329 @WIRE(mode="straight") {#X304:1 %t1701:p};
// %t1702 = $IO_PORT @ATTACH &vss => @PLACE(-11, -860) => @ORIENT("R0");
// %t1702 @TEXT("vss", key="name", size=0.75);
// &vss @WIRE(mode="straight") {#X304:2 %t1702:p};
// %t1703 = $IO_PORT @ATTACH &restart => @PLACE(-11, -864) => @ORIENT("R0");
// %t1703 @TEXT("restart", key="name", size=0.75);
// &restart @WIRE(mode="straight") {#X304:3 %t1703:p};
// %t1704 = $IO_PORT @ATTACH &n335 => @PLACE(10, -860) => @ORIENT("MY");
// %t1704 @TEXT("n335", key="name", size=0.75);
// &n335 @WIRE(mode="straight") {#X304:4 %t1704:p};
// %t1705 = $SUPPLY @ATTACH &vdd => @PLACE(0, -847);
// &vdd @WIRE(mode="straight") {#X304:5 %t1705:p};
// %t1706 = $GROUND @ATTACH &vss => @PLACE(0, -873);
// &vss @WIRE(mode="straight") {#X304:6 %t1706:p};
// %t1707 = $IO_PORT @ATTACH &n330 => @PLACE(30, -856) => @ORIENT("R0");
// %t1707 @TEXT("n330", key="name", size=0.75);
// &n330 @WIRE(mode="straight") {#X305:1 %t1707:p};
// %t1708 = $IO_PORT @ATTACH &vss => @PLACE(30, -860) => @ORIENT("R0");
// %t1708 @TEXT("vss", key="name", size=0.75);
// &vss @WIRE(mode="straight") {#X305:2 %t1708:p};
// %t1709 = $IO_PORT @ATTACH &restart => @PLACE(30, -864) => @ORIENT("R0");
// %t1709 @TEXT("restart", key="name", size=0.75);
// &restart @WIRE(mode="straight") {#X305:3 %t1709:p};
// %t1710 = $IO_PORT @ATTACH &n336 => @PLACE(50, -860) => @ORIENT("MY");
// %t1710 @TEXT("n336", key="name", size=0.75);
// &n336 @WIRE(mode="straight") {#X305:4 %t1710:p};
// %t1711 = $SUPPLY @ATTACH &vdd => @PLACE(40, -847);
// &vdd @WIRE(mode="straight") {#X305:5 %t1711:p};
// %t1712 = $GROUND @ATTACH &vss => @PLACE(40, -873);
// &vss @WIRE(mode="straight") {#X305:6 %t1712:p};
// %t1713 = $IO_PORT @ATTACH &n331 => @PLACE(70, -856) => @ORIENT("R0");
// %t1713 @TEXT("n331", key="name", size=0.75);
// &n331 @WIRE(mode="straight") {#X306:1 %t1713:p};
// %t1714 = $IO_PORT @ATTACH &vss => @PLACE(70, -860) => @ORIENT("R0");
// %t1714 @TEXT("vss", key="name", size=0.75);
// &vss @WIRE(mode="straight") {#X306:2 %t1714:p};
// %t1715 = $IO_PORT @ATTACH &restart => @PLACE(70, -864) => @ORIENT("R0");
// %t1715 @TEXT("restart", key="name", size=0.75);
// &restart @WIRE(mode="straight") {#X306:3 %t1715:p};
// %t1716 = $IO_PORT @ATTACH &n337 => @PLACE(90, -860) => @ORIENT("MY");
// %t1716 @TEXT("n337", key="name", size=0.75);
// &n337 @WIRE(mode="straight") {#X306:4 %t1716:p};
// %t1717 = $SUPPLY @ATTACH &vdd => @PLACE(80, -847);
// &vdd @WIRE(mode="straight") {#X306:5 %t1717:p};
// %t1718 = $GROUND @ATTACH &vss => @PLACE(80, -873);
// &vss @WIRE(mode="straight") {#X306:6 %t1718:p};
// %t1719 = $IO_PORT @ATTACH &n332 => @PLACE(110, -856) => @ORIENT("R0");
// %t1719 @TEXT("n332", key="name", size=0.75);
// &n332 @WIRE(mode="straight") {#X307:1 %t1719:p};
// %t1720 = $IO_PORT @ATTACH &vss => @PLACE(110, -860) => @ORIENT("R0");
// %t1720 @TEXT("vss", key="name", size=0.75);
// &vss @WIRE(mode="straight") {#X307:2 %t1720:p};
// %t1721 = $IO_PORT @ATTACH &restart => @PLACE(110, -864) => @ORIENT("R0");
// %t1721 @TEXT("restart", key="name", size=0.75);
// &restart @WIRE(mode="straight") {#X307:3 %t1721:p};
// %t1722 = $IO_PORT @ATTACH &n338 => @PLACE(130, -860) => @ORIENT("MY");
// %t1722 @TEXT("n338", key="name", size=0.75);
// &n338 @WIRE(mode="straight") {#X307:4 %t1722:p};
// %t1723 = $SUPPLY @ATTACH &vdd => @PLACE(120, -847);
// &vdd @WIRE(mode="straight") {#X307:5 %t1723:p};
// %t1724 = $GROUND @ATTACH &vss => @PLACE(120, -873);
// &vss @WIRE(mode="straight") {#X307:6 %t1724:p};
// %t1725 = $IO_PORT @ATTACH &n333 => @PLACE(-11, -891) => @ORIENT("R0");
// %t1725 @TEXT("n333", key="name", size=0.75);
// &n333 @WIRE(mode="straight") {#X308:1 %t1725:p};
// %t1726 = $IO_PORT @ATTACH &vss => @PLACE(-11, -895) => @ORIENT("R0");
// %t1726 @TEXT("vss", key="name", size=0.75);
// &vss @WIRE(mode="straight") {#X308:2 %t1726:p};
// %t1727 = $IO_PORT @ATTACH &restart => @PLACE(-11, -899) => @ORIENT("R0");
// %t1727 @TEXT("restart", key="name", size=0.75);
// &restart @WIRE(mode="straight") {#X308:3 %t1727:p};
// %t1728 = $IO_PORT @ATTACH &n339 => @PLACE(10, -895) => @ORIENT("MY");
// %t1728 @TEXT("n339", key="name", size=0.75);
// &n339 @WIRE(mode="straight") {#X308:4 %t1728:p};
// %t1729 = $SUPPLY @ATTACH &vdd => @PLACE(0, -882);
// &vdd @WIRE(mode="straight") {#X308:5 %t1729:p};
// %t1730 = $GROUND @ATTACH &vss => @PLACE(0, -908);
// &vss @WIRE(mode="straight") {#X308:6 %t1730:p};
// %t1731 = $IO_PORT @ATTACH &n334 => @PLACE(30, -891) => @ORIENT("R0");
// %t1731 @TEXT("n334", key="name", size=0.75);
// &n334 @WIRE(mode="straight") {#X309:1 %t1731:p};
// %t1732 = $IO_PORT @ATTACH &vss => @PLACE(30, -895) => @ORIENT("R0");
// %t1732 @TEXT("vss", key="name", size=0.75);
// &vss @WIRE(mode="straight") {#X309:2 %t1732:p};
// %t1733 = $IO_PORT @ATTACH &restart => @PLACE(30, -899) => @ORIENT("R0");
// %t1733 @TEXT("restart", key="name", size=0.75);
// &restart @WIRE(mode="straight") {#X309:3 %t1733:p};
// %t1734 = $IO_PORT @ATTACH &n340 => @PLACE(50, -895) => @ORIENT("MY");
// %t1734 @TEXT("n340", key="name", size=0.75);
// &n340 @WIRE(mode="straight") {#X309:4 %t1734:p};
// %t1735 = $SUPPLY @ATTACH &vdd => @PLACE(40, -882);
// &vdd @WIRE(mode="straight") {#X309:5 %t1735:p};
// %t1736 = $GROUND @ATTACH &vss => @PLACE(40, -908);
// &vss @WIRE(mode="straight") {#X309:6 %t1736:p};
// %t1737 = $IO_PORT @ATTACH &n335 => @PLACE(70, -891) => @ORIENT("R0");
// %t1737 @TEXT("n335", key="name", size=0.75);
// &n335 @WIRE(mode="straight") {#X310:1 %t1737:p};
// %t1738 = $IO_PORT @ATTACH &vss => @PLACE(70, -895) => @ORIENT("R0");
// %t1738 @TEXT("vss", key="name", size=0.75);
// &vss @WIRE(mode="straight") {#X310:2 %t1738:p};
// %t1739 = $IO_PORT @ATTACH &range_error => @PLACE(70, -899) => @ORIENT("R0");
// %t1739 @TEXT("range_error", key="name", size=0.75);
// &range_error @WIRE(mode="straight") {#X310:3 %t1739:p};
// %t1740 = $IO_PORT @ATTACH &n341 => @PLACE(90, -895) => @ORIENT("MY");
// %t1740 @TEXT("n341", key="name", size=0.75);
// &n341 @WIRE(mode="straight") {#X310:4 %t1740:p};
// %t1741 = $SUPPLY @ATTACH &vdd => @PLACE(80, -882);
// &vdd @WIRE(mode="straight") {#X310:5 %t1741:p};
// %t1742 = $GROUND @ATTACH &vss => @PLACE(80, -908);
// &vss @WIRE(mode="straight") {#X310:6 %t1742:p};
// %t1743 = $IO_PORT @ATTACH &n336 => @PLACE(110, -891) => @ORIENT("R0");
// %t1743 @TEXT("n336", key="name", size=0.75);
// &n336 @WIRE(mode="straight") {#X311:1 %t1743:p};
// %t1744 = $IO_PORT @ATTACH &vss => @PLACE(110, -895) => @ORIENT("R0");
// %t1744 @TEXT("vss", key="name", size=0.75);
// &vss @WIRE(mode="straight") {#X311:2 %t1744:p};
// %t1745 = $IO_PORT @ATTACH &range_error => @PLACE(110, -899) => @ORIENT("R0");
// %t1745 @TEXT("range_error", key="name", size=0.75);
// &range_error @WIRE(mode="straight") {#X311:3 %t1745:p};
// %t1746 = $IO_PORT @ATTACH &n342 => @PLACE(130, -895) => @ORIENT("MY");
// %t1746 @TEXT("n342", key="name", size=0.75);
// &n342 @WIRE(mode="straight") {#X311:4 %t1746:p};
// %t1747 = $SUPPLY @ATTACH &vdd => @PLACE(120, -882);
// &vdd @WIRE(mode="straight") {#X311:5 %t1747:p};
// %t1748 = $GROUND @ATTACH &vss => @PLACE(120, -908);
// &vss @WIRE(mode="straight") {#X311:6 %t1748:p};
// %t1749 = $IO_PORT @ATTACH &n337 => @PLACE(158, -716) => @ORIENT("R0");
// %t1749 @TEXT("n337", key="name", size=0.75);
// &n337 @WIRE(mode="straight") {#X312:1 %t1749:p};
// %t1750 = $IO_PORT @ATTACH &vss => @PLACE(158, -720) => @ORIENT("R0");
// %t1750 @TEXT("vss", key="name", size=0.75);
// &vss @WIRE(mode="straight") {#X312:2 %t1750:p};
// %t1751 = $IO_PORT @ATTACH &range_error => @PLACE(158, -724) => @ORIENT("R0");
// %t1751 @TEXT("range_error", key="name", size=0.75);
// &range_error @WIRE(mode="straight") {#X312:3 %t1751:p};
// %t1752 = $IO_PORT @ATTACH &n343 => @PLACE(178, -720) => @ORIENT("MY");
// %t1752 @TEXT("n343", key="name", size=0.75);
// &n343 @WIRE(mode="straight") {#X312:4 %t1752:p};
// %t1753 = $SUPPLY @ATTACH &vdd => @PLACE(168, -707);
// &vdd @WIRE(mode="straight") {#X312:5 %t1753:p};
// %t1754 = $GROUND @ATTACH &vss => @PLACE(168, -733);
// &vss @WIRE(mode="straight") {#X312:6 %t1754:p};
// %t1755 = $IO_PORT @ATTACH &n338 => @PLACE(198, -716) => @ORIENT("R0");
// %t1755 @TEXT("n338", key="name", size=0.75);
// &n338 @WIRE(mode="straight") {#X313:1 %t1755:p};
// %t1756 = $IO_PORT @ATTACH &vss => @PLACE(198, -720) => @ORIENT("R0");
// %t1756 @TEXT("vss", key="name", size=0.75);
// &vss @WIRE(mode="straight") {#X313:2 %t1756:p};
// %t1757 = $IO_PORT @ATTACH &range_error => @PLACE(198, -724) => @ORIENT("R0");
// %t1757 @TEXT("range_error", key="name", size=0.75);
// &range_error @WIRE(mode="straight") {#X313:3 %t1757:p};
// %t1758 = $IO_PORT @ATTACH &n344 => @PLACE(218, -720) => @ORIENT("MY");
// %t1758 @TEXT("n344", key="name", size=0.75);
// &n344 @WIRE(mode="straight") {#X313:4 %t1758:p};
// %t1759 = $SUPPLY @ATTACH &vdd => @PLACE(208, -707);
// &vdd @WIRE(mode="straight") {#X313:5 %t1759:p};
// %t1760 = $GROUND @ATTACH &vss => @PLACE(208, -733);
// &vss @WIRE(mode="straight") {#X313:6 %t1760:p};
// %t1761 = $IO_PORT @ATTACH &n339 => @PLACE(238, -716) => @ORIENT("R0");
// %t1761 @TEXT("n339", key="name", size=0.75);
// &n339 @WIRE(mode="straight") {#X314:1 %t1761:p};
// %t1762 = $IO_PORT @ATTACH &vss => @PLACE(238, -720) => @ORIENT("R0");
// %t1762 @TEXT("vss", key="name", size=0.75);
// &vss @WIRE(mode="straight") {#X314:2 %t1762:p};
// %t1763 = $IO_PORT @ATTACH &range_error => @PLACE(238, -724) => @ORIENT("R0");
// %t1763 @TEXT("range_error", key="name", size=0.75);
// &range_error @WIRE(mode="straight") {#X314:3 %t1763:p};
// %t1764 = $IO_PORT @ATTACH &n345 => @PLACE(258, -720) => @ORIENT("MY");
// %t1764 @TEXT("n345", key="name", size=0.75);
// &n345 @WIRE(mode="straight") {#X314:4 %t1764:p};
// %t1765 = $SUPPLY @ATTACH &vdd => @PLACE(248, -707);
// &vdd @WIRE(mode="straight") {#X314:5 %t1765:p};
// %t1766 = $GROUND @ATTACH &vss => @PLACE(248, -733);
// &vss @WIRE(mode="straight") {#X314:6 %t1766:p};
// %t1767 = $IO_PORT @ATTACH &n340 => @PLACE(278, -716) => @ORIENT("R0");
// %t1767 @TEXT("n340", key="name", size=0.75);
// &n340 @WIRE(mode="straight") {#X315:1 %t1767:p};
// %t1768 = $IO_PORT @ATTACH &vss => @PLACE(278, -720) => @ORIENT("R0");
// %t1768 @TEXT("vss", key="name", size=0.75);
// &vss @WIRE(mode="straight") {#X315:2 %t1768:p};
// %t1769 = $IO_PORT @ATTACH &range_error => @PLACE(278, -724) => @ORIENT("R0");
// %t1769 @TEXT("range_error", key="name", size=0.75);
// &range_error @WIRE(mode="straight") {#X315:3 %t1769:p};
// %t1770 = $IO_PORT @ATTACH &n346 => @PLACE(298, -720) => @ORIENT("MY");
// %t1770 @TEXT("n346", key="name", size=0.75);
// &n346 @WIRE(mode="straight") {#X315:4 %t1770:p};
// %t1771 = $SUPPLY @ATTACH &vdd => @PLACE(288, -707);
// &vdd @WIRE(mode="straight") {#X315:5 %t1771:p};
// %t1772 = $GROUND @ATTACH &vss => @PLACE(288, -733);
// &vss @WIRE(mode="straight") {#X315:6 %t1772:p};
// %t1773 = $IO_PORT @ATTACH &vss => @PLACE(158, -751) => @ORIENT("R0");
// %t1773 @TEXT("vss", key="name", size=0.75);
// &vss @WIRE(mode="straight") {#X316:1 %t1773:p};
// %t1774 = $IO_PORT @ATTACH &n341 => @PLACE(158, -755) => @ORIENT("R0");
// %t1774 @TEXT("n341", key="name", size=0.75);
// &n341 @WIRE(mode="straight") {#X316:2 %t1774:p};
// %t1775 = $IO_PORT @ATTACH &cfg_ready => @PLACE(158, -759) => @ORIENT("R0");
// %t1775 @TEXT("cfg_ready", key="name", size=0.75);
// &cfg_ready @WIRE(mode="straight") {#X316:3 %t1775:p};
// %t1776 = $IO_PORT @ATTACH &n65 => @PLACE(178, -755) => @ORIENT("MY");
// %t1776 @TEXT("n65", key="name", size=0.75);
// &n65 @WIRE(mode="straight") {#X316:4 %t1776:p};
// %t1777 = $SUPPLY @ATTACH &vdd => @PLACE(168, -742);
// &vdd @WIRE(mode="straight") {#X316:5 %t1777:p};
// %t1778 = $GROUND @ATTACH &vss => @PLACE(168, -768);
// &vss @WIRE(mode="straight") {#X316:6 %t1778:p};
// %t1779 = $IO_PORT @ATTACH &vss => @PLACE(198, -751) => @ORIENT("R0");
// %t1779 @TEXT("vss", key="name", size=0.75);
// &vss @WIRE(mode="straight") {#X317:1 %t1779:p};
// %t1780 = $IO_PORT @ATTACH &n342 => @PLACE(198, -755) => @ORIENT("R0");
// %t1780 @TEXT("n342", key="name", size=0.75);
// &n342 @WIRE(mode="straight") {#X317:2 %t1780:p};
// %t1781 = $IO_PORT @ATTACH &cfg_ready => @PLACE(198, -759) => @ORIENT("R0");
// %t1781 @TEXT("cfg_ready", key="name", size=0.75);
// &cfg_ready @WIRE(mode="straight") {#X317:3 %t1781:p};
// %t1782 = $IO_PORT @ATTACH &n64 => @PLACE(218, -755) => @ORIENT("MY");
// %t1782 @TEXT("n64", key="name", size=0.75);
// &n64 @WIRE(mode="straight") {#X317:4 %t1782:p};
// %t1783 = $SUPPLY @ATTACH &vdd => @PLACE(208, -742);
// &vdd @WIRE(mode="straight") {#X317:5 %t1783:p};
// %t1784 = $GROUND @ATTACH &vss => @PLACE(208, -768);
// &vss @WIRE(mode="straight") {#X317:6 %t1784:p};
// %t1785 = $IO_PORT @ATTACH &vss => @PLACE(238, -751) => @ORIENT("R0");
// %t1785 @TEXT("vss", key="name", size=0.75);
// &vss @WIRE(mode="straight") {#X318:1 %t1785:p};
// %t1786 = $IO_PORT @ATTACH &n343 => @PLACE(238, -755) => @ORIENT("R0");
// %t1786 @TEXT("n343", key="name", size=0.75);
// &n343 @WIRE(mode="straight") {#X318:2 %t1786:p};
// %t1787 = $IO_PORT @ATTACH &cfg_ready => @PLACE(238, -759) => @ORIENT("R0");
// %t1787 @TEXT("cfg_ready", key="name", size=0.75);
// &cfg_ready @WIRE(mode="straight") {#X318:3 %t1787:p};
// %t1788 = $IO_PORT @ATTACH &n63 => @PLACE(258, -755) => @ORIENT("MY");
// %t1788 @TEXT("n63", key="name", size=0.75);
// &n63 @WIRE(mode="straight") {#X318:4 %t1788:p};
// %t1789 = $SUPPLY @ATTACH &vdd => @PLACE(248, -742);
// &vdd @WIRE(mode="straight") {#X318:5 %t1789:p};
// %t1790 = $GROUND @ATTACH &vss => @PLACE(248, -768);
// &vss @WIRE(mode="straight") {#X318:6 %t1790:p};
// %t1791 = $IO_PORT @ATTACH &vss => @PLACE(278, -751) => @ORIENT("R0");
// %t1791 @TEXT("vss", key="name", size=0.75);
// &vss @WIRE(mode="straight") {#X319:1 %t1791:p};
// %t1792 = $IO_PORT @ATTACH &n344 => @PLACE(278, -755) => @ORIENT("R0");
// %t1792 @TEXT("n344", key="name", size=0.75);
// &n344 @WIRE(mode="straight") {#X319:2 %t1792:p};
// %t1793 = $IO_PORT @ATTACH &cfg_ready => @PLACE(278, -759) => @ORIENT("R0");
// %t1793 @TEXT("cfg_ready", key="name", size=0.75);
// &cfg_ready @WIRE(mode="straight") {#X319:3 %t1793:p};
// %t1794 = $IO_PORT @ATTACH &n62 => @PLACE(298, -755) => @ORIENT("MY");
// %t1794 @TEXT("n62", key="name", size=0.75);
// &n62 @WIRE(mode="straight") {#X319:4 %t1794:p};
// %t1795 = $SUPPLY @ATTACH &vdd => @PLACE(288, -742);
// &vdd @WIRE(mode="straight") {#X319:5 %t1795:p};
// %t1796 = $GROUND @ATTACH &vss => @PLACE(288, -768);
// &vss @WIRE(mode="straight") {#X319:6 %t1796:p};
// %t1797 = $IO_PORT @ATTACH &vss => @PLACE(158, -786) => @ORIENT("R0");
// %t1797 @TEXT("vss", key="name", size=0.75);
// &vss @WIRE(mode="straight") {#X320:1 %t1797:p};
// %t1798 = $IO_PORT @ATTACH &n345 => @PLACE(158, -790) => @ORIENT("R0");
// %t1798 @TEXT("n345", key="name", size=0.75);
// &n345 @WIRE(mode="straight") {#X320:2 %t1798:p};
// %t1799 = $IO_PORT @ATTACH &cfg_ready => @PLACE(158, -794) => @ORIENT("R0");
// %t1799 @TEXT("cfg_ready", key="name", size=0.75);
// &cfg_ready @WIRE(mode="straight") {#X320:3 %t1799:p};
// %t1800 = $IO_PORT @ATTACH &n60 => @PLACE(178, -790) => @ORIENT("MY");
// %t1800 @TEXT("n60", key="name", size=0.75);
// &n60 @WIRE(mode="straight") {#X320:4 %t1800:p};
// %t1801 = $SUPPLY @ATTACH &vdd => @PLACE(168, -777);
// &vdd @WIRE(mode="straight") {#X320:5 %t1801:p};
// %t1802 = $GROUND @ATTACH &vss => @PLACE(168, -803);
// &vss @WIRE(mode="straight") {#X320:6 %t1802:p};
// %t1803 = $IO_PORT @ATTACH &vss => @PLACE(198, -786) => @ORIENT("R0");
// %t1803 @TEXT("vss", key="name", size=0.75);
// &vss @WIRE(mode="straight") {#X321:1 %t1803:p};
// %t1804 = $IO_PORT @ATTACH &n346 => @PLACE(198, -790) => @ORIENT("R0");
// %t1804 @TEXT("n346", key="name", size=0.75);
// &n346 @WIRE(mode="straight") {#X321:2 %t1804:p};
// %t1805 = $IO_PORT @ATTACH &cfg_ready => @PLACE(198, -794) => @ORIENT("R0");
// %t1805 @TEXT("cfg_ready", key="name", size=0.75);
// &cfg_ready @WIRE(mode="straight") {#X321:3 %t1805:p};
// %t1806 = $IO_PORT @ATTACH &n79 => @PLACE(218, -790) => @ORIENT("MY");
// %t1806 @TEXT("n79", key="name", size=0.75);
// &n79 @WIRE(mode="straight") {#X321:4 %t1806:p};
// %t1807 = $SUPPLY @ATTACH &vdd => @PLACE(208, -777);
// &vdd @WIRE(mode="straight") {#X321:5 %t1807:p};
// %t1808 = $GROUND @ATTACH &vss => @PLACE(208, -803);
// &vss @WIRE(mode="straight") {#X321:6 %t1808:p};
// %t1809 = $IO_PORT @ATTACH &vss => @PLACE(238, -786) => @ORIENT("R0");
// %t1809 @TEXT("vss", key="name", size=0.75);
// &vss @WIRE(mode="straight") {#X322:1 %t1809:p};
// %t1810 = $IO_PORT @ATTACH &vdd => @PLACE(238, -790) => @ORIENT("R0");
// %t1810 @TEXT("vdd", key="name", size=0.75);
// &vdd @WIRE(mode="straight") {#X322:2 %t1810:p};
// %t1811 = $IO_PORT @ATTACH &range_error => @PLACE(238, -794) => @ORIENT("R0");
// %t1811 @TEXT("range_error", key="name", size=0.75);
// &range_error @WIRE(mode="straight") {#X322:3 %t1811:p};
// %t1812 = $IO_PORT @ATTACH &n347 => @PLACE(258, -790) => @ORIENT("MY");
// %t1812 @TEXT("n347", key="name", size=0.75);
// &n347 @WIRE(mode="straight") {#X322:4 %t1812:p};
// %t1813 = $SUPPLY @ATTACH &vdd => @PLACE(248, -777);
// &vdd @WIRE(mode="straight") {#X322:5 %t1813:p};
// %t1814 = $GROUND @ATTACH &vss => @PLACE(248, -803);
// &vss @WIRE(mode="straight") {#X322:6 %t1814:p};
// %t1815 = $IO_PORT @ATTACH &vss => @PLACE(278, -786) => @ORIENT("R0");
// %t1815 @TEXT("vss", key="name", size=0.75);
// &vss @WIRE(mode="straight") {#X323:1 %t1815:p};
// %t1816 = $IO_PORT @ATTACH &n347 => @PLACE(278, -790) => @ORIENT("R0");
// %t1816 @TEXT("n347", key="name", size=0.75);
// &n347 @WIRE(mode="straight") {#X323:2 %t1816:p};
// %t1817 = $IO_PORT @ATTACH &cfg_ready => @PLACE(278, -794) => @ORIENT("R0");
// %t1817 @TEXT("cfg_ready", key="name", size=0.75);
// &cfg_ready @WIRE(mode="straight") {#X323:3 %t1817:p};
// %t1818 = $IO_PORT @ATTACH &n80 => @PLACE(298, -790) => @ORIENT("MY");
// %t1818 @TEXT("n80", key="name", size=0.75);
// &n80 @WIRE(mode="straight") {#X323:4 %t1818:p};
// %t1819 = $SUPPLY @ATTACH &vdd => @PLACE(288, -777);
// &vdd @WIRE(mode="straight") {#X323:5 %t1819:p};
// %t1820 = $GROUND @ATTACH &vss => @PLACE(288, -803);
// &vss @WIRE(mode="straight") {#X323:6 %t1820:p};
// %t1821 = $IO_PORT @ATTACH &n162 => @PLACE(158, -825) => @ORIENT("R0");
// %t1821 @TEXT("n162", key="name", size=0.75);
// &n162 @WIRE(mode="straight") {#X324:1 %t1821:p};
// %t1822 = $IO_PORT @ATTACH &n147 => @PLACE(178, -825) => @ORIENT("MY");
// %t1822 @TEXT("n147", key="name", size=0.75);
// &n147 @WIRE(mode="straight") {#X324:2 %t1822:p};
// %t1823 = $SUPPLY @ATTACH &vdd => @PLACE(168, -816);
// &vdd @WIRE(mode="straight") {#X324:3 %t1823:p};
// %t1824 = $GROUND @ATTACH &vss => @PLACE(168, -834);
// &vss @WIRE(mode="straight") {#X324:4 %t1824:p};
// %t1825 = $IO_PORT @ATTACH &vss => @PLACE(198, -821) => @ORIENT("R0");
// %t1825 @TEXT("vss", key="name", size=0.75);
// &vss @WIRE(mode="straight") {#X325:1 %t1825:p};
// %t1826 = $IO_PORT @ATTACH &n147 => @PLACE(198, -825) => @ORIENT("R0");
// %t1826 @TEXT("n147", key="name", size=0.75);
// &n147 @WIRE(mode="straight") {#X325:2 %t1826:p};
// %t1827 = $IO_PORT @ATTACH &qualified => @PLACE(198, -829) => @ORIENT("R0");
// %t1827 @TEXT("qualified", key="name", size=0.75);
// &qualified @WIRE(mode="straight") {#X325:3 %t1827:p};
// %t1828 = $IO_PORT @ATTACH &n348 => @PLACE(218, -825) => @ORIENT("MY");
// %t1828 @TEXT("n348", key="name", size=0.75);
// &n348 @WIRE(mode="straight") {#X325:4 %t1828:p};
// %t1829 = $SUPPLY @ATTACH &vdd => @PLACE(208, -812);
// &vdd @WIRE(mode="straight") {#X325:5 %t1829:p};
// %t1830 = $GROUND @ATTACH &vss => @PLACE(208, -838);
// &vss @WIRE(mode="straight") {#X325:6 %t1830:p};
// %t1831 = $IO_PORT @ATTACH &n348 => @PLACE(238, -821) => @ORIENT("R0");
// %t1831 @TEXT("n348", key="name", size=0.75);
// &n348 @WIRE(mode="straight") {#X326:1 %t1831:p};
// %t1832 = $IO_PORT @ATTACH &vss => @PLACE(238, -825) => @ORIENT("R0");
// %t1832 @TEXT("vss", key="name", size=0.75);
// &vss @WIRE(mode="straight") {#X326:2 %t1832:p};
// %t1833 = $IO_PORT @ATTACH &n93 => @PLACE(238, -829) => @ORIENT("R0");
// %t1833 @TEXT("n93", key="name", size=0.75);
// &n93 @WIRE(mode="straight") {#X326:3 %t1833:p};
// %t1834 = $IO_PORT @ATTACH &n349 => @PLACE(258, -825) => @ORIENT("MY");
// %t1834 @TEXT("n349", key="name", size=0.75);
// &n349 @WIRE(mode="straight") {#X326:4 %t1834:p};
// %t1835 = $SUPPLY @ATTACH &vdd => @PLACE(248, -812);
// &vdd @WIRE(mode="straight") {#X326:5 %t1835:p};
// %t1836 = $GROUND @ATTACH &vss => @PLACE(248, -838);
// &vss @WIRE(mode="straight") {#X326:6 %t1836:p};
// %t1837 = $IO_PORT @ATTACH &n349 => @PLACE(278, -821) => @ORIENT("R0");
// %t1837 @TEXT("n349", key="name", size=0.75);
// &n349 @WIRE(mode="straight") {#X327:1 %t1837:p};
// %t1838 = $IO_PORT @ATTACH &vdd => @PLACE(278, -825) => @ORIENT("R0");
// %t1838 @TEXT("vdd", key="name", size=0.75);
// &vdd @WIRE(mode="straight") {#X327:2 %t1838:p};
// %t1839 = $IO_PORT @ATTACH &n136 => @PLACE(278, -829) => @ORIENT("R0");
// %t1839 @TEXT("n136", key="name", size=0.75);
// &n136 @WIRE(mode="straight") {#X327:3 %t1839:p};
// %t1840 = $IO_PORT @ATTACH &n350 => @PLACE(298, -825) => @ORIENT("MY");
// %t1840 @TEXT("n350", key="name", size=0.75);
// &n350 @WIRE(mode="straight") {#X327:4 %t1840:p};
// %t1841 = $SUPPLY @ATTACH &vdd => @PLACE(288, -812);
// &vdd @WIRE(mode="straight") {#X327:5 %t1841:p};
// %t1842 = $GROUND @ATTACH &vss => @PLACE(288, -838);
// &vss @WIRE(mode="straight") {#X327:6 %t1842:p};
// %t1843 = $IO_PORT @ATTACH &vss => @PLACE(158, -856) => @ORIENT("R0");
// %t1843 @TEXT("vss", key="name", size=0.75);
// &vss @WIRE(mode="straight") {#X328:1 %t1843:p};
// %t1844 = $IO_PORT @ATTACH &n350 => @PLACE(158, -860) => @ORIENT("R0");
// %t1844 @TEXT("n350", key="name", size=0.75);
// &n350 @WIRE(mode="straight") {#X328:2 %t1844:p};
// %t1845 = $IO_PORT @ATTACH &fll_enable => @PLACE(158, -864) => @ORIENT("R0");
// %t1845 @TEXT("fll_enable", key="name", size=0.75);
// &fll_enable @WIRE(mode="straight") {#X328:3 %t1845:p};
// %t1846 = $IO_PORT @ATTACH &n351 => @PLACE(178, -860) => @ORIENT("MY");
// %t1846 @TEXT("n351", key="name", size=0.75);
// &n351 @WIRE(mode="straight") {#X328:4 %t1846:p};
// %t1847 = $SUPPLY @ATTACH &vdd => @PLACE(168, -847);
// &vdd @WIRE(mode="straight") {#X328:5 %t1847:p};
// %t1848 = $GROUND @ATTACH &vss => @PLACE(168, -873);
// &vss @WIRE(mode="straight") {#X328:6 %t1848:p};
// %t1849 = $IO_PORT @ATTACH &n351 => @PLACE(198, -856) => @ORIENT("R0");
// %t1849 @TEXT("n351", key="name", size=0.75);
// &n351 @WIRE(mode="straight") {#X329:1 %t1849:p};
// %t1850 = $IO_PORT @ATTACH &n159 => @PLACE(198, -860) => @ORIENT("R0");
// %t1850 @TEXT("n159", key="name", size=0.75);
// &n159 @WIRE(mode="straight") {#X329:2 %t1850:p};
// %t1851 = $IO_PORT @ATTACH &restart => @PLACE(198, -864) => @ORIENT("R0");
// %t1851 @TEXT("restart", key="name", size=0.75);
// &restart @WIRE(mode="straight") {#X329:3 %t1851:p};
// %t1852 = $IO_PORT @ATTACH &n352 => @PLACE(218, -860) => @ORIENT("MY");
// %t1852 @TEXT("n352", key="name", size=0.75);
// &n352 @WIRE(mode="straight") {#X329:4 %t1852:p};
// %t1853 = $SUPPLY @ATTACH &vdd => @PLACE(208, -847);
// &vdd @WIRE(mode="straight") {#X329:5 %t1853:p};
// %t1854 = $GROUND @ATTACH &vss => @PLACE(208, -873);
// &vss @WIRE(mode="straight") {#X329:6 %t1854:p};
// %t1855 = $IO_PORT @ATTACH &n352 => @PLACE(238, -856) => @ORIENT("R0");
// %t1855 @TEXT("n352", key="name", size=0.75);
// &n352 @WIRE(mode="straight") {#X330:1 %t1855:p};
// %t1856 = $IO_PORT @ATTACH &vss => @PLACE(238, -860) => @ORIENT("R0");
// %t1856 @TEXT("vss", key="name", size=0.75);
// &vss @WIRE(mode="straight") {#X330:2 %t1856:p};
// %t1857 = $IO_PORT @ATTACH &range_error => @PLACE(238, -864) => @ORIENT("R0");
// %t1857 @TEXT("range_error", key="name", size=0.75);
// &range_error @WIRE(mode="straight") {#X330:3 %t1857:p};
// %t1858 = $IO_PORT @ATTACH &n353 => @PLACE(258, -860) => @ORIENT("MY");
// %t1858 @TEXT("n353", key="name", size=0.75);
// &n353 @WIRE(mode="straight") {#X330:4 %t1858:p};
// %t1859 = $SUPPLY @ATTACH &vdd => @PLACE(248, -847);
// &vdd @WIRE(mode="straight") {#X330:5 %t1859:p};
// %t1860 = $GROUND @ATTACH &vss => @PLACE(248, -873);
// &vss @WIRE(mode="straight") {#X330:6 %t1860:p};
// %t1861 = $IO_PORT @ATTACH &vss => @PLACE(278, -856) => @ORIENT("R0");
// %t1861 @TEXT("vss", key="name", size=0.75);
// &vss @WIRE(mode="straight") {#X331:1 %t1861:p};
// %t1862 = $IO_PORT @ATTACH &n353 => @PLACE(278, -860) => @ORIENT("R0");
// %t1862 @TEXT("n353", key="name", size=0.75);
// &n353 @WIRE(mode="straight") {#X331:2 %t1862:p};
// %t1863 = $IO_PORT @ATTACH &cfg_ready => @PLACE(278, -864) => @ORIENT("R0");
// %t1863 @TEXT("cfg_ready", key="name", size=0.75);
// &cfg_ready @WIRE(mode="straight") {#X331:3 %t1863:p};
// %t1864 = $IO_PORT @ATTACH &n74 => @PLACE(298, -860) => @ORIENT("MY");
// %t1864 @TEXT("n74", key="name", size=0.75);
// &n74 @WIRE(mode="straight") {#X331:4 %t1864:p};
// %t1865 = $SUPPLY @ATTACH &vdd => @PLACE(288, -847);
// &vdd @WIRE(mode="straight") {#X331:5 %t1865:p};
// %t1866 = $GROUND @ATTACH &vss => @PLACE(288, -873);
// &vss @WIRE(mode="straight") {#X331:6 %t1866:p};
// %t1867 = $IO_PORT @ATTACH &vss => @PLACE(158, -891) => @ORIENT("R0");
// %t1867 @TEXT("vss", key="name", size=0.75);
// &vss @WIRE(mode="straight") {#X332:1 %t1867:p};
// %t1868 = $IO_PORT @ATTACH &n162 => @PLACE(158, -895) => @ORIENT("R0");
// %t1868 @TEXT("n162", key="name", size=0.75);
// &n162 @WIRE(mode="straight") {#X332:2 %t1868:p};
// %t1869 = $IO_PORT @ATTACH &qualified => @PLACE(158, -899) => @ORIENT("R0");
// %t1869 @TEXT("qualified", key="name", size=0.75);
// &qualified @WIRE(mode="straight") {#X332:3 %t1869:p};
// %t1870 = $IO_PORT @ATTACH &n354 => @PLACE(178, -895) => @ORIENT("MY");
// %t1870 @TEXT("n354", key="name", size=0.75);
// &n354 @WIRE(mode="straight") {#X332:4 %t1870:p};
// %t1871 = $SUPPLY @ATTACH &vdd => @PLACE(168, -882);
// &vdd @WIRE(mode="straight") {#X332:5 %t1871:p};
// %t1872 = $GROUND @ATTACH &vss => @PLACE(168, -908);
// &vss @WIRE(mode="straight") {#X332:6 %t1872:p};
// %t1873 = $IO_PORT @ATTACH &n185 => @PLACE(198, -895) => @ORIENT("R0");
// %t1873 @TEXT("n185", key="name", size=0.75);
// &n185 @WIRE(mode="straight") {#X333:1 %t1873:p};
// %t1874 = $IO_PORT @ATTACH &n194 => @PLACE(218, -895) => @ORIENT("MY");
// %t1874 @TEXT("n194", key="name", size=0.75);
// &n194 @WIRE(mode="straight") {#X333:2 %t1874:p};
// %t1875 = $SUPPLY @ATTACH &vdd => @PLACE(208, -886);
// &vdd @WIRE(mode="straight") {#X333:3 %t1875:p};
// %t1876 = $GROUND @ATTACH &vss => @PLACE(208, -904);
// &vss @WIRE(mode="straight") {#X333:4 %t1876:p};
// %t1877 = $IO_PORT @ATTACH &n194 => @PLACE(238, -891) => @ORIENT("R0");
// %t1877 @TEXT("n194", key="name", size=0.75);
// &n194 @WIRE(mode="straight") {#X334:1 %t1877:p};
// %t1878 = $IO_PORT @ATTACH &vdd => @PLACE(238, -895) => @ORIENT("R0");
// %t1878 @TEXT("vdd", key="name", size=0.75);
// &vdd @WIRE(mode="straight") {#X334:2 %t1878:p};
// %t1879 = $IO_PORT @ATTACH &qualified => @PLACE(238, -899) => @ORIENT("R0");
// %t1879 @TEXT("qualified", key="name", size=0.75);
// &qualified @WIRE(mode="straight") {#X334:3 %t1879:p};
// %t1880 = $IO_PORT @ATTACH &n355 => @PLACE(258, -895) => @ORIENT("MY");
// %t1880 @TEXT("n355", key="name", size=0.75);
// &n355 @WIRE(mode="straight") {#X334:4 %t1880:p};
// %t1881 = $SUPPLY @ATTACH &vdd => @PLACE(248, -882);
// &vdd @WIRE(mode="straight") {#X334:5 %t1881:p};
// %t1882 = $GROUND @ATTACH &vss => @PLACE(248, -908);
// &vss @WIRE(mode="straight") {#X334:6 %t1882:p};
// %t1883 = $IO_PORT @ATTACH &n354 => @PLACE(278, -891) => @ORIENT("R0");
// %t1883 @TEXT("n354", key="name", size=0.75);
// &n354 @WIRE(mode="straight") {#X335:1 %t1883:p};
// %t1884 = $IO_PORT @ATTACH &n355 => @PLACE(278, -895) => @ORIENT("R0");
// %t1884 @TEXT("n355", key="name", size=0.75);
// &n355 @WIRE(mode="straight") {#X335:2 %t1884:p};
// %t1885 = $IO_PORT @ATTACH &n93 => @PLACE(278, -899) => @ORIENT("R0");
// %t1885 @TEXT("n93", key="name", size=0.75);
// &n93 @WIRE(mode="straight") {#X335:3 %t1885:p};
// %t1886 = $IO_PORT @ATTACH &n356 => @PLACE(298, -895) => @ORIENT("MY");
// %t1886 @TEXT("n356", key="name", size=0.75);
// &n356 @WIRE(mode="straight") {#X335:4 %t1886:p};
// %t1887 = $SUPPLY @ATTACH &vdd => @PLACE(288, -882);
// &vdd @WIRE(mode="straight") {#X335:5 %t1887:p};
// %t1888 = $GROUND @ATTACH &vss => @PLACE(288, -908);
// &vss @WIRE(mode="straight") {#X335:6 %t1888:p};
// %t1889 = $IO_PORT @ATTACH &n356 => @PLACE(326, -716) => @ORIENT("R0");
// %t1889 @TEXT("n356", key="name", size=0.75);
// &n356 @WIRE(mode="straight") {#X336:1 %t1889:p};
// %t1890 = $IO_PORT @ATTACH &vss => @PLACE(326, -720) => @ORIENT("R0");
// %t1890 @TEXT("vss", key="name", size=0.75);
// &vss @WIRE(mode="straight") {#X336:2 %t1890:p};
// %t1891 = $IO_PORT @ATTACH &n136 => @PLACE(326, -724) => @ORIENT("R0");
// %t1891 @TEXT("n136", key="name", size=0.75);
// &n136 @WIRE(mode="straight") {#X336:3 %t1891:p};
// %t1892 = $IO_PORT @ATTACH &n357 => @PLACE(346, -720) => @ORIENT("MY");
// %t1892 @TEXT("n357", key="name", size=0.75);
// &n357 @WIRE(mode="straight") {#X336:4 %t1892:p};
// %t1893 = $SUPPLY @ATTACH &vdd => @PLACE(336, -707);
// &vdd @WIRE(mode="straight") {#X336:5 %t1893:p};
// %t1894 = $GROUND @ATTACH &vss => @PLACE(336, -733);
// &vss @WIRE(mode="straight") {#X336:6 %t1894:p};
// %t1895 = $IO_PORT @ATTACH &vss => @PLACE(366, -716) => @ORIENT("R0");
// %t1895 @TEXT("vss", key="name", size=0.75);
// &vss @WIRE(mode="straight") {#X337:1 %t1895:p};
// %t1896 = $IO_PORT @ATTACH &n357 => @PLACE(366, -720) => @ORIENT("R0");
// %t1896 @TEXT("n357", key="name", size=0.75);
// &n357 @WIRE(mode="straight") {#X337:2 %t1896:p};
// %t1897 = $IO_PORT @ATTACH &fll_enable => @PLACE(366, -724) => @ORIENT("R0");
// %t1897 @TEXT("fll_enable", key="name", size=0.75);
// &fll_enable @WIRE(mode="straight") {#X337:3 %t1897:p};
// %t1898 = $IO_PORT @ATTACH &n358 => @PLACE(386, -720) => @ORIENT("MY");
// %t1898 @TEXT("n358", key="name", size=0.75);
// &n358 @WIRE(mode="straight") {#X337:4 %t1898:p};
// %t1899 = $SUPPLY @ATTACH &vdd => @PLACE(376, -707);
// &vdd @WIRE(mode="straight") {#X337:5 %t1899:p};
// %t1900 = $GROUND @ATTACH &vss => @PLACE(376, -733);
// &vss @WIRE(mode="straight") {#X337:6 %t1900:p};
// %t1901 = $IO_PORT @ATTACH &n358 => @PLACE(406, -716) => @ORIENT("R0");
// %t1901 @TEXT("n358", key="name", size=0.75);
// &n358 @WIRE(mode="straight") {#X338:1 %t1901:p};
// %t1902 = $IO_PORT @ATTACH &vss => @PLACE(406, -720) => @ORIENT("R0");
// %t1902 @TEXT("vss", key="name", size=0.75);
// &vss @WIRE(mode="straight") {#X338:2 %t1902:p};
// %t1903 = $IO_PORT @ATTACH &restart => @PLACE(406, -724) => @ORIENT("R0");
// %t1903 @TEXT("restart", key="name", size=0.75);
// &restart @WIRE(mode="straight") {#X338:3 %t1903:p};
// %t1904 = $IO_PORT @ATTACH &n359 => @PLACE(426, -720) => @ORIENT("MY");
// %t1904 @TEXT("n359", key="name", size=0.75);
// &n359 @WIRE(mode="straight") {#X338:4 %t1904:p};
// %t1905 = $SUPPLY @ATTACH &vdd => @PLACE(416, -707);
// &vdd @WIRE(mode="straight") {#X338:5 %t1905:p};
// %t1906 = $GROUND @ATTACH &vss => @PLACE(416, -733);
// &vss @WIRE(mode="straight") {#X338:6 %t1906:p};
// %t1907 = $IO_PORT @ATTACH &n359 => @PLACE(446, -716) => @ORIENT("R0");
// %t1907 @TEXT("n359", key="name", size=0.75);
// &n359 @WIRE(mode="straight") {#X339:1 %t1907:p};
// %t1908 = $IO_PORT @ATTACH &vss => @PLACE(446, -720) => @ORIENT("R0");
// %t1908 @TEXT("vss", key="name", size=0.75);
// &vss @WIRE(mode="straight") {#X339:2 %t1908:p};
// %t1909 = $IO_PORT @ATTACH &range_error => @PLACE(446, -724) => @ORIENT("R0");
// %t1909 @TEXT("range_error", key="name", size=0.75);
// &range_error @WIRE(mode="straight") {#X339:3 %t1909:p};
// %t1910 = $IO_PORT @ATTACH &n360 => @PLACE(466, -720) => @ORIENT("MY");
// %t1910 @TEXT("n360", key="name", size=0.75);
// &n360 @WIRE(mode="straight") {#X339:4 %t1910:p};
// %t1911 = $SUPPLY @ATTACH &vdd => @PLACE(456, -707);
// &vdd @WIRE(mode="straight") {#X339:5 %t1911:p};
// %t1912 = $GROUND @ATTACH &vss => @PLACE(456, -733);
// &vss @WIRE(mode="straight") {#X339:6 %t1912:p};
// %t1913 = $IO_PORT @ATTACH &vss => @PLACE(326, -751) => @ORIENT("R0");
// %t1913 @TEXT("vss", key="name", size=0.75);
// &vss @WIRE(mode="straight") {#X340:1 %t1913:p};
// %t1914 = $IO_PORT @ATTACH &n360 => @PLACE(326, -755) => @ORIENT("R0");
// %t1914 @TEXT("n360", key="name", size=0.75);
// &n360 @WIRE(mode="straight") {#X340:2 %t1914:p};
// %t1915 = $IO_PORT @ATTACH &cfg_ready => @PLACE(326, -759) => @ORIENT("R0");
// %t1915 @TEXT("cfg_ready", key="name", size=0.75);
// &cfg_ready @WIRE(mode="straight") {#X340:3 %t1915:p};
// %t1916 = $IO_PORT @ATTACH &n77 => @PLACE(346, -755) => @ORIENT("MY");
// %t1916 @TEXT("n77", key="name", size=0.75);
// &n77 @WIRE(mode="straight") {#X340:4 %t1916:p};
// %t1917 = $SUPPLY @ATTACH &vdd => @PLACE(336, -742);
// &vdd @WIRE(mode="straight") {#X340:5 %t1917:p};
// %t1918 = $GROUND @ATTACH &vss => @PLACE(336, -768);
// &vss @WIRE(mode="straight") {#X340:6 %t1918:p};
// %t1919 = $IO_PORT @ATTACH &n45 => @PLACE(366, -755) => @ORIENT("R0");
// %t1919 @TEXT("n45", key="name", size=0.75);
// &n45 @WIRE(mode="straight") {#X341:1 %t1919:p};
// %t1920 = $IO_PORT @ATTACH &n163 => @PLACE(386, -755) => @ORIENT("MY");
// %t1920 @TEXT("n163", key="name", size=0.75);
// &n163 @WIRE(mode="straight") {#X341:2 %t1920:p};
// %t1921 = $SUPPLY @ATTACH &vdd => @PLACE(376, -746);
// &vdd @WIRE(mode="straight") {#X341:3 %t1921:p};
// %t1922 = $GROUND @ATTACH &vss => @PLACE(376, -764);
// &vss @WIRE(mode="straight") {#X341:4 %t1922:p};
// %t1923 = $IO_PORT @ATTACH &n47 => @PLACE(406, -755) => @ORIENT("R0");
// %t1923 @TEXT("n47", key="name", size=0.75);
// &n47 @WIRE(mode="straight") {#X342:1 %t1923:p};
// %t1924 = $IO_PORT @ATTACH &n165 => @PLACE(426, -755) => @ORIENT("MY");
// %t1924 @TEXT("n165", key="name", size=0.75);
// &n165 @WIRE(mode="straight") {#X342:2 %t1924:p};
// %t1925 = $SUPPLY @ATTACH &vdd => @PLACE(416, -746);
// &vdd @WIRE(mode="straight") {#X342:3 %t1925:p};
// %t1926 = $GROUND @ATTACH &vss => @PLACE(416, -764);
// &vss @WIRE(mode="straight") {#X342:4 %t1926:p};
// %t1927 = $IO_PORT @ATTACH &n49 => @PLACE(446, -755) => @ORIENT("R0");
// %t1927 @TEXT("n49", key="name", size=0.75);
// &n49 @WIRE(mode="straight") {#X343:1 %t1927:p};
// %t1928 = $IO_PORT @ATTACH &n166 => @PLACE(466, -755) => @ORIENT("MY");
// %t1928 @TEXT("n166", key="name", size=0.75);
// &n166 @WIRE(mode="straight") {#X343:2 %t1928:p};
// %t1929 = $SUPPLY @ATTACH &vdd => @PLACE(456, -746);
// &vdd @WIRE(mode="straight") {#X343:3 %t1929:p};
// %t1930 = $GROUND @ATTACH &vss => @PLACE(456, -764);
// &vss @WIRE(mode="straight") {#X343:4 %t1930:p};
// %t1931 = $IO_PORT @ATTACH &n51 => @PLACE(326, -790) => @ORIENT("R0");
// %t1931 @TEXT("n51", key="name", size=0.75);
// &n51 @WIRE(mode="straight") {#X344:1 %t1931:p};
// %t1932 = $IO_PORT @ATTACH &n168 => @PLACE(346, -790) => @ORIENT("MY");
// %t1932 @TEXT("n168", key="name", size=0.75);
// &n168 @WIRE(mode="straight") {#X344:2 %t1932:p};
// %t1933 = $SUPPLY @ATTACH &vdd => @PLACE(336, -781);
// &vdd @WIRE(mode="straight") {#X344:3 %t1933:p};
// %t1934 = $GROUND @ATTACH &vss => @PLACE(336, -799);
// &vss @WIRE(mode="straight") {#X344:4 %t1934:p};
// %t1935 = $IO_PORT @ATTACH &n53 => @PLACE(366, -790) => @ORIENT("R0");
// %t1935 @TEXT("n53", key="name", size=0.75);
// &n53 @WIRE(mode="straight") {#X345:1 %t1935:p};
// %t1936 = $IO_PORT @ATTACH &n169 => @PLACE(386, -790) => @ORIENT("MY");
// %t1936 @TEXT("n169", key="name", size=0.75);
// &n169 @WIRE(mode="straight") {#X345:2 %t1936:p};
// %t1937 = $SUPPLY @ATTACH &vdd => @PLACE(376, -781);
// &vdd @WIRE(mode="straight") {#X345:3 %t1937:p};
// %t1938 = $GROUND @ATTACH &vss => @PLACE(376, -799);
// &vss @WIRE(mode="straight") {#X345:4 %t1938:p};
// %t1939 = $IO_PORT @ATTACH &n55 => @PLACE(406, -790) => @ORIENT("R0");
// %t1939 @TEXT("n55", key="name", size=0.75);
// &n55 @WIRE(mode="straight") {#X346:1 %t1939:p};
// %t1940 = $IO_PORT @ATTACH &n171 => @PLACE(426, -790) => @ORIENT("MY");
// %t1940 @TEXT("n171", key="name", size=0.75);
// &n171 @WIRE(mode="straight") {#X346:2 %t1940:p};
// %t1941 = $SUPPLY @ATTACH &vdd => @PLACE(416, -781);
// &vdd @WIRE(mode="straight") {#X346:3 %t1941:p};
// %t1942 = $GROUND @ATTACH &vss => @PLACE(416, -799);
// &vss @WIRE(mode="straight") {#X346:4 %t1942:p};
// %t1943 = $IO_PORT @ATTACH &n57 => @PLACE(446, -790) => @ORIENT("R0");
// %t1943 @TEXT("n57", key="name", size=0.75);
// &n57 @WIRE(mode="straight") {#X347:1 %t1943:p};
// %t1944 = $IO_PORT @ATTACH &n172 => @PLACE(466, -790) => @ORIENT("MY");
// %t1944 @TEXT("n172", key="name", size=0.75);
// &n172 @WIRE(mode="straight") {#X347:2 %t1944:p};
// %t1945 = $SUPPLY @ATTACH &vdd => @PLACE(456, -781);
// &vdd @WIRE(mode="straight") {#X347:3 %t1945:p};
// %t1946 = $GROUND @ATTACH &vss => @PLACE(456, -799);
// &vss @WIRE(mode="straight") {#X347:4 %t1946:p};
// %t1947 = $IO_PORT @ATTACH &n32 => @PLACE(326, -825) => @ORIENT("R0");
// %t1947 @TEXT("n32", key="name", size=0.75);
// &n32 @WIRE(mode="straight") {#X348:1 %t1947:p};
// %t1948 = $IO_PORT @ATTACH &n178 => @PLACE(346, -825) => @ORIENT("MY");
// %t1948 @TEXT("n178", key="name", size=0.75);
// &n178 @WIRE(mode="straight") {#X348:2 %t1948:p};
// %t1949 = $SUPPLY @ATTACH &vdd => @PLACE(336, -816);
// &vdd @WIRE(mode="straight") {#X348:3 %t1949:p};
// %t1950 = $GROUND @ATTACH &vss => @PLACE(336, -834);
// &vss @WIRE(mode="straight") {#X348:4 %t1950:p};
// %t1951 = $IO_PORT @ATTACH &n34 => @PLACE(366, -825) => @ORIENT("R0");
// %t1951 @TEXT("n34", key="name", size=0.75);
// &n34 @WIRE(mode="straight") {#X349:1 %t1951:p};
// %t1952 = $IO_PORT @ATTACH &n180 => @PLACE(386, -825) => @ORIENT("MY");
// %t1952 @TEXT("n180", key="name", size=0.75);
// &n180 @WIRE(mode="straight") {#X349:2 %t1952:p};
// %t1953 = $SUPPLY @ATTACH &vdd => @PLACE(376, -816);
// &vdd @WIRE(mode="straight") {#X349:3 %t1953:p};
// %t1954 = $GROUND @ATTACH &vss => @PLACE(376, -834);
// &vss @WIRE(mode="straight") {#X349:4 %t1954:p};
// %t1955 = $IO_PORT @ATTACH &n38 => @PLACE(406, -825) => @ORIENT("R0");
// %t1955 @TEXT("n38", key="name", size=0.75);
// &n38 @WIRE(mode="straight") {#X350:1 %t1955:p};
// %t1956 = $IO_PORT @ATTACH &n182 => @PLACE(426, -825) => @ORIENT("MY");
// %t1956 @TEXT("n182", key="name", size=0.75);
// &n182 @WIRE(mode="straight") {#X350:2 %t1956:p};
// %t1957 = $SUPPLY @ATTACH &vdd => @PLACE(416, -816);
// &vdd @WIRE(mode="straight") {#X350:3 %t1957:p};
// %t1958 = $GROUND @ATTACH &vss => @PLACE(416, -834);
// &vss @WIRE(mode="straight") {#X350:4 %t1958:p};
// %t1959 = $IO_PORT @ATTACH &n16 => @PLACE(446, -825) => @ORIENT("R0");
// %t1959 @TEXT("n16", key="name", size=0.75);
// &n16 @WIRE(mode="straight") {#X351:1 %t1959:p};
// %t1960 = $IO_PORT @ATTACH &n160 => @PLACE(466, -825) => @ORIENT("MY");
// %t1960 @TEXT("n160", key="name", size=0.75);
// &n160 @WIRE(mode="straight") {#X351:2 %t1960:p};
// %t1961 = $SUPPLY @ATTACH &vdd => @PLACE(456, -816);
// &vdd @WIRE(mode="straight") {#X351:3 %t1961:p};
// %t1962 = $GROUND @ATTACH &vss => @PLACE(456, -834);
// &vss @WIRE(mode="straight") {#X351:4 %t1962:p};
// (-16, -28) @TEXT("77  Supervisor | 352 instances", size=1.2, halign="start");
// (-16, -32) @TEXT("Same-name tags connect locally. Open blocks for transistor details.", size=0.8, halign="start");
// }
ends tx_pll_supervisor_capture_v14_pdk110_77
