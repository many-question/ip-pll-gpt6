// Fast NOR | frozen callback110 / recenter109 | RNL 0.3
// @RNL(type="header") { @VERSION("0.3"); @USE-PACKAGE(name="rnl-std-fill") {} }
simulator lang=spectre
subckt nor_fast_v14_pdk110_32 (a b out vdd vss)
MP0 (p a vdd vdd) pch w=8e-06 l=1.8e-07 ad=3.84e-12 as=3.84e-12 pd=1.696e-05 ps=1.696e-05 nrd=0.03375 nrs=0.03375 sa=4.8e-07 sb=4.8e-07 sd=5.4e-07 sca=0 scb=0 scc=0
MP1 (out b p vdd) pch w=8e-06 l=1.8e-07 ad=3.84e-12 as=3.84e-12 pd=1.696e-05 ps=1.696e-05 nrd=0.03375 nrs=0.03375 sa=4.8e-07 sb=4.8e-07 sd=5.4e-07 sca=0 scb=0 scc=0
MN0 (out a vss vss) nch w=2e-06 l=1.8e-07 ad=9.599999999999999e-13 as=9.599999999999999e-13 pd=4.96e-06 ps=4.96e-06 nrd=0.135 nrs=0.135 sa=4.8e-07 sb=4.8e-07 sd=5.4e-07 sca=0 scb=0 scc=0
MN1 (out b vss vss) nch w=2e-06 l=1.8e-07 ad=9.599999999999999e-13 as=9.599999999999999e-13 pd=4.96e-06 ps=4.96e-06 nrd=0.135 nrs=0.135 sa=4.8e-07 sb=4.8e-07 sd=5.4e-07 sca=0 scb=0 scc=0
// @RNL(author="functional-compact127") {
// $CELL = @DEFINE-SYMBOL {
// @LINE {(-5, 4) (-2.5, 4) (-0.4, 3.5) (1.5, 2.5) (4, 0) (1.5, -2.5) (-0.4, -3.5) (-2.5, -4) (-5, -4) (-3.8, -2) (-3.4, 0) (-3.8, 2) (-5, 4)};
// @LINE {(6, 0) (5.96593, 0.258819) (5.86603, 0.5) (5.70711, 0.707107) (5.5, 0.866025) (5.25882, 0.965926) (5, 1) (4.74118, 0.965926) (4.5, 0.866025) (4.29289, 0.707107) (4.13397, 0.5) (4.03407, 0.258819) (4, 1.22465e-16) (4.03407, -0.258819) (4.13397, -0.5) (4.29289, -0.707107) (4.5, -0.866025) (4.74118, -0.965926) (5, -1) (5.25882, -0.965926) (5.5, -0.866025) (5.70711, -0.707107) (5.86603, -0.5) (5.96593, -0.258819) (6, -2.44929e-16)};
// (-8, 4) @PIN(terminal="a", direction="left");
// @LINE {(-8, 4) (-4, 4)};
// (-8, 0) @PIN(terminal="b", direction="left");
// @LINE {(-8, 0) (-4, 0)};
// (-8, -4) @PIN(terminal="out", direction="left");
// @LINE {(-8, -4) (-4, -4)};
// (0, 10) @PIN(terminal="vdd", direction="up");
// @LINE {(0, 10) (0, 3.4)};
// (0, -10) @PIN(terminal="vss", direction="down");
// @LINE {(0, -10) (0, -3.4)};
// ? @TEXT("${name}", key="name", size=1, halign="middle") => @PLACE(8, 11.5);
// };
// # @SET-SYMBOL $CELL;
// #MP0 @PLACE(0, 25) => @ORIENT("R0");
// #MP0 @SET-SYMBOL $PMOS_4TERM;
// #MP0 @TEXT("MP0", key="name", dx=5, dy=1.5, size=0.9, halign="start");
// #MP0 @TEXT("8u / 180n", key="model", dx=5, dy=-1.5, size=0.75, halign="start");
// #MP1 @PLACE(0, 11) => @ORIENT("R0");
// #MP1 @SET-SYMBOL $PMOS_4TERM;
// #MP1 @TEXT("MP1", key="name", dx=5, dy=1.5, size=0.9, halign="start");
// #MP1 @TEXT("8u / 180n", key="model", dx=5, dy=-1.5, size=0.75, halign="start");
// #MN0 @PLACE(-14, -4) => @ORIENT("R0");
// #MN0 @SET-SYMBOL $NMOS_4TERM;
// #MN0 @TEXT("MN0", key="name", dx=5, dy=1.5, size=0.9, halign="start");
// #MN0 @TEXT("2u / 180n", key="model", dx=5, dy=-1.5, size=0.75, halign="start");
// #MN1 @PLACE(14, -4) => @ORIENT("R0");
// #MN1 @SET-SYMBOL $NMOS_4TERM;
// #MN1 @TEXT("MN1", key="name", dx=5, dy=1.5, size=0.9, halign="start");
// #MN1 @TEXT("2u / 180n", key="model", dx=5, dy=-1.5, size=0.75, halign="start");
// &p @WIRE(mode="straight") {#MP0:1 #MP1:3};
// %o = (0, 4);
// &out @WIRE(mode="straight") {#MP1:1 %o (-14, 4) #MN0:1};
// &out @WIRE(mode="straight") {%o (14, 4) #MN1:1};
// $JUNCTION @ATTACH %o;
// %t1 = $IO_PORT @ATTACH &a => @PLACE(-6, 25) => @ORIENT("R0");
// %t1 @TEXT("a", key="name", size=0.75);
// &a @WIRE(mode="straight") {#MP0:2 %t1:p};
// %t2 = $SUPPLY @ATTACH &vdd => @PLACE(0, 30);
// &vdd @WIRE(mode="straight") {#MP0:3 %t2:p};
// %t3 = $IO_PORT @ATTACH &vdd => @PLACE(4, 25) => @ORIENT("MY");
// %t3 @TEXT("vdd", key="name", size=0.75);
// &vdd @WIRE(mode="straight") {#MP0:4 %t3:p};
// %t4 = $IO_PORT @ATTACH &b => @PLACE(-6, 11) => @ORIENT("R0");
// %t4 @TEXT("b", key="name", size=0.75);
// &b @WIRE(mode="straight") {#MP1:2 %t4:p};
// %t5 = $IO_PORT @ATTACH &vdd => @PLACE(4, 11) => @ORIENT("MY");
// %t5 @TEXT("vdd", key="name", size=0.75);
// &vdd @WIRE(mode="straight") {#MP1:4 %t5:p};
// %t6 = $IO_PORT @ATTACH &a => @PLACE(-20, -4) => @ORIENT("R0");
// %t6 @TEXT("a", key="name", size=0.75);
// &a @WIRE(mode="straight") {#MN0:2 %t6:p};
// %t7 = $GROUND @ATTACH &vss => @PLACE(-14, -9);
// &vss @WIRE(mode="straight") {#MN0:3 %t7:p};
// %t8 = $IO_PORT @ATTACH &vss => @PLACE(-10, -4) => @ORIENT("MY");
// %t8 @TEXT("vss", key="name", size=0.75);
// &vss @WIRE(mode="straight") {#MN0:4 %t8:p};
// %t9 = $IO_PORT @ATTACH &b => @PLACE(8, -4) => @ORIENT("R0");
// %t9 @TEXT("b", key="name", size=0.75);
// &b @WIRE(mode="straight") {#MN1:2 %t9:p};
// %t10 = $GROUND @ATTACH &vss => @PLACE(14, -9);
// &vss @WIRE(mode="straight") {#MN1:3 %t10:p};
// %t11 = $IO_PORT @ATTACH &vss => @PLACE(18, -4) => @ORIENT("MY");
// %t11 @TEXT("vss", key="name", size=0.75);
// &vss @WIRE(mode="straight") {#MN1:4 %t11:p};
// %t12 = $IO_PORT @ATTACH &out => @PLACE(-4, 6) => @ORIENT("R0");
// %t12 @TEXT("out", key="name", size=0.75);
// &out @WIRE(mode="straight") {#MP1:1 (0, 6) %t12:p};
// (-25, 49) @TEXT("32  Fast NOR | 4 instances", size=1.2, halign="start");
// }
ends nor_fast_v14_pdk110_32
