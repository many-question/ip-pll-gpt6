// Toggle FF | frozen callback110 / recenter109 | RNL 0.3
// @RNL(type="header") { @VERSION("0.3"); @USE-PACKAGE(name="rnl-std-fill") {} }
simulator lang=spectre
subckt tx_tff_pdk110_73 (clk reset q qb vdd vss)
XF (qb clk reset q vdd vss) tx_dff_r0_pdk110_58
XI (q qb vdd vss) pll_inv_pdk110_7
// @RNL(author="manual-schematic126") {
// $CELL = @DEFINE-SYMBOL {
// @LINE {(-6, 6) (6, 6) (6, -6) (-6, -6) (-6, 6)};
// (-8, 2) @PIN(terminal="clk", direction="left");
// @LINE {(-8, 2) (-6, 2)};
// (-5.4, 2) @TEXT("clk", size=0.7, halign="start");
// (-8, -2) @PIN(terminal="reset", direction="left");
// @LINE {(-8, -2) (-6, -2)};
// (-5.4, -2) @TEXT("reset", size=0.7, halign="start");
// (8, 2) @PIN(terminal="q", direction="right");
// @LINE {(8, 2) (6, 2)};
// (5.4, 2) @TEXT("q", size=0.7, halign="end");
// (8, -2) @PIN(terminal="qb", direction="right");
// @LINE {(8, -2) (6, -2)};
// (5.4, -2) @TEXT("qb", size=0.7, halign="end");
// (0, 8) @PIN(terminal="vdd", direction="up");
// @LINE {(0, 8) (0, 6)};
// (0, -8) @PIN(terminal="vss", direction="down");
// @LINE {(0, -8) (0, -6)};
// ? @TEXT("${name}", key="name", size=1, halign="middle") => @PLACE(8, 9.5);
// (0, 5.1) @TEXT("Toggle FF", size=0.85, halign="middle");
// };
// # @SET-SYMBOL $CELL;
// #XF @PLACE(0, 0) => @ORIENT("R0");
// #XI @PLACE(45, 0) => @ORIENT("R0");
// &q @WIRE(mode="straight") {#XF:4 (25, 0) (25, 0) #XI:1};
// &qb @WIRE(mode="straight") {#XI:2 (53, -20) (-8, -20) #XF:1};
// %t1 = $IO_PORT @ATTACH &clk => @PLACE(-11, 0) => @ORIENT("R0");
// %t1 @TEXT("clk", key="name", size=0.75);
// &clk @WIRE(mode="straight") {#XF:2 %t1:p};
// %t2 = $IO_PORT @ATTACH &reset => @PLACE(-11, -4) => @ORIENT("R0");
// %t2 @TEXT("reset", key="name", size=0.75);
// &reset @WIRE(mode="straight") {#XF:3 %t2:p};
// %t3 = $SUPPLY @ATTACH &vdd => @PLACE(0, 13);
// &vdd @WIRE(mode="straight") {#XF:5 %t3:p};
// %t4 = $GROUND @ATTACH &vss => @PLACE(0, -13);
// &vss @WIRE(mode="straight") {#XF:6 %t4:p};
// %t5 = $SUPPLY @ATTACH &vdd => @PLACE(45, 9);
// &vdd @WIRE(mode="straight") {#XI:3 %t5:p};
// %t6 = $GROUND @ATTACH &vss => @PLACE(45, -9);
// &vss @WIRE(mode="straight") {#XI:4 %t6:p};
// %t7 = $IO_PORT @ATTACH &q => @PLACE(11, 0) => @ORIENT("MY");
// %t7 @TEXT("q", key="name", size=0.75);
// &q @WIRE(mode="straight") {#XF:4 %t7:p};
// %t8 = $IO_PORT @ATTACH &qb => @PLACE(-11, 4) => @ORIENT("R0");
// %t8 @TEXT("qb", key="name", size=0.75);
// &qb @WIRE(mode="straight") {#XF:1 %t8:p};
// (-16, 32) @TEXT("73  Toggle FF | 2 instances", size=1.2, halign="start");
// }
ends tx_tff_pdk110_73
