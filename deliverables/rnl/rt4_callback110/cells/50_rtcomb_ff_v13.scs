// Retiming FF | frozen callback110 / recenter109 | RNL 0.3
// @RNL(type="header") { @VERSION("0.3"); @USE-PACKAGE(name="rnl-std-fill") {} }
simulator lang=spectre
subckt rtcomb_ff_v13_pdk110_50 (d ck qb vdd vss)
MP0 (p0 d vdd vdd) pch w=9.6e-06 l=1.8e-07 ad=4.608e-12 as=4.608e-12 pd=2.016e-05 ps=2.016e-05 nrd=0.028125 nrs=0.028125 sa=4.8e-07 sb=4.8e-07 sd=5.4e-07 sca=0 scb=0 scc=0
MPC0 (b ck p0 vdd) pch w=9.6e-06 l=1.8e-07 ad=4.608e-12 as=4.608e-12 pd=2.016e-05 ps=2.016e-05 nrd=0.028125 nrs=0.028125 sa=4.8e-07 sb=4.8e-07 sd=5.4e-07 sca=0 scb=0 scc=0
MN0 (b d vss vss) nch w=3.840000000000001e-06 l=1.8e-07 ad=1.8432e-12 as=1.8432e-12 pd=8.64e-06 ps=8.64e-06 nrd=0.0703125 nrs=0.0703125 sa=4.8e-07 sb=4.8e-07 sd=5.4e-07 sca=0 scb=0 scc=0
MP1 (a ck vdd vdd) pch w=9.6e-06 l=1.8e-07 ad=4.608e-12 as=4.608e-12 pd=2.016e-05 ps=2.016e-05 nrd=0.028125 nrs=0.028125 sa=4.8e-07 sb=4.8e-07 sd=5.4e-07 sca=0 scb=0 scc=0
MN1 (a b n1 vss) nch w=1.152e-05 l=1.8e-07 ad=5.5296e-12 as=5.5296e-12 pd=2.4e-05 ps=2.4e-05 nrd=0.0234375 nrs=0.0234375 sa=4.8e-07 sb=4.8e-07 sd=5.4e-07 sca=0 scb=0 scc=0
MNC1 (n1 ck vss vss) nch w=1.152e-05 l=1.8e-07 ad=5.5296e-12 as=5.5296e-12 pd=2.4e-05 ps=2.4e-05 nrd=0.0234375 nrs=0.0234375 sa=4.8e-07 sb=4.8e-07 sd=5.4e-07 sca=0 scb=0 scc=0
MP2 (qb a vdd vdd) pch w=1.44e-05 l=1.8e-07 ad=6.912e-12 as=6.912e-12 pd=2.976e-05 ps=2.976e-05 nrd=0.01875 nrs=0.01875 sa=4.8e-07 sb=4.8e-07 sd=5.4e-07 sca=0 scb=0 scc=0
MNC2 (qb ck n2 vss) nch w=7.679999999999999e-06 l=1.8e-07 ad=3.6864e-12 as=3.6864e-12 pd=1.632e-05 ps=1.632e-05 nrd=0.0351562 nrs=0.0351562 sa=4.8e-07 sb=4.8e-07 sd=5.4e-07 sca=0 scb=0 scc=0
MN2 (n2 a vss vss) nch w=7.679999999999999e-06 l=1.8e-07 ad=3.6864e-12 as=3.6864e-12 pd=1.632e-05 ps=1.632e-05 nrd=0.0351562 nrs=0.0351562 sa=4.8e-07 sb=4.8e-07 sd=5.4e-07 sca=0 scb=0 scc=0
// @RNL(author="functional-compact127") {
// $CELL = @DEFINE-SYMBOL {
// @LINE {(-6, -6) (6, -6) (6, 6) (-6, 6) (-6, -6)};
// (-2, 1) @TEXT("D", size=1.15, halign="middle");
// (2, 1) @TEXT("Q", size=1.15, halign="middle");
// @LINE {(-2, -1) (2, -1)};
// @LINE {(0.946901, -0.424689) (2, -1) (0.946901, -1.57531)};
// (0, -3) @TEXT("FF", size=0.8, halign="middle");
// @LINE {(-6, -1) (-4.5, -2) (-6, -3)};
// (-8, 2) @PIN(terminal="d", direction="left");
// @LINE {(-8, 2) (-6, 2)};
// (-5.4, 2) @TEXT("d", size=0.7, halign="start");
// (-8, -2) @PIN(terminal="ck", direction="left");
// @LINE {(-8, -2) (-6, -2)};
// (-5.4, -2) @TEXT("ck", size=0.7, halign="start");
// (8, 0) @PIN(terminal="qb", direction="right");
// @LINE {(8, 0) (6, 0)};
// (5.4, 0) @TEXT("qb", size=0.7, halign="end");
// (0, 8) @PIN(terminal="vdd", direction="up");
// @LINE {(0, 8) (0, 6)};
// (0, -8) @PIN(terminal="vss", direction="down");
// @LINE {(0, -8) (0, -6)};
// ? @TEXT("${name}", key="name", size=1, halign="middle") => @PLACE(8, 9.5);
// (0, 5.1) @TEXT("Retiming FF", size=0.85, halign="middle");
// };
// # @SET-SYMBOL $CELL;
// #MP0 @PLACE(0, 30) => @ORIENT("R0");
// #MP0 @SET-SYMBOL $PMOS_4TERM;
// #MP0 @TEXT("MP0", key="name", dx=5, dy=1.5, size=0.9, halign="start");
// #MP0 @TEXT("9.6u / 180n", key="model", dx=5, dy=-1.5, size=0.75, halign="start");
// #MPC0 @PLACE(0, 15) => @ORIENT("R0");
// #MPC0 @SET-SYMBOL $PMOS_4TERM;
// #MPC0 @TEXT("MPC0", key="name", dx=5, dy=1.5, size=0.9, halign="start");
// #MPC0 @TEXT("9.6u / 180n", key="model", dx=5, dy=-1.5, size=0.75, halign="start");
// #MN0 @PLACE(0, -8) => @ORIENT("R0");
// #MN0 @SET-SYMBOL $NMOS_4TERM;
// #MN0 @TEXT("MN0", key="name", dx=5, dy=1.5, size=0.9, halign="start");
// #MN0 @TEXT("3.84u / 180n", key="model", dx=5, dy=-1.5, size=0.75, halign="start");
// #MP1 @PLACE(25, 30) => @ORIENT("R0");
// #MP1 @SET-SYMBOL $PMOS_4TERM;
// #MP1 @TEXT("MP1", key="name", dx=5, dy=1.5, size=0.9, halign="start");
// #MP1 @TEXT("9.6u / 180n", key="model", dx=5, dy=-1.5, size=0.75, halign="start");
// #MN1 @PLACE(25, 0) => @ORIENT("R0");
// #MN1 @SET-SYMBOL $NMOS_4TERM;
// #MN1 @TEXT("MN1", key="name", dx=5, dy=1.5, size=0.9, halign="start");
// #MN1 @TEXT("11.52u / 180n", key="model", dx=5, dy=-1.5, size=0.75, halign="start");
// #MNC1 @PLACE(25, -16) => @ORIENT("R0");
// #MNC1 @SET-SYMBOL $NMOS_4TERM;
// #MNC1 @TEXT("MNC1", key="name", dx=5, dy=1.5, size=0.9, halign="start");
// #MNC1 @TEXT("11.52u / 180n", key="model", dx=5, dy=-1.5, size=0.75, halign="start");
// #MP2 @PLACE(50, 30) => @ORIENT("R0");
// #MP2 @SET-SYMBOL $PMOS_4TERM;
// #MP2 @TEXT("MP2", key="name", dx=5, dy=1.5, size=0.9, halign="start");
// #MP2 @TEXT("14.4u / 180n", key="model", dx=5, dy=-1.5, size=0.75, halign="start");
// #MNC2 @PLACE(50, 0) => @ORIENT("R0");
// #MNC2 @SET-SYMBOL $NMOS_4TERM;
// #MNC2 @TEXT("MNC2", key="name", dx=5, dy=1.5, size=0.9, halign="start");
// #MNC2 @TEXT("7.68u / 180n", key="model", dx=5, dy=-1.5, size=0.75, halign="start");
// #MN2 @PLACE(50, -16) => @ORIENT("R0");
// #MN2 @SET-SYMBOL $NMOS_4TERM;
// #MN2 @TEXT("MN2", key="name", dx=5, dy=1.5, size=0.9, halign="start");
// #MN2 @TEXT("7.68u / 180n", key="model", dx=5, dy=-1.5, size=0.75, halign="start");
// &p0 @WIRE(mode="straight") {#MP0:1 #MPC0:3};
// &b @WIRE(mode="straight") {#MPC0:1 #MN0:1};
// &a @WIRE(mode="straight") {#MP1:1 #MN1:1};
// &n1 @WIRE(mode="straight") {#MN1:3 #MNC1:1};
// &qb @WIRE(mode="straight") {#MP2:1 #MNC2:1};
// &n2 @WIRE(mode="straight") {#MNC2:3 #MN2:1};
// &b @WIRE(mode="straight") {#MPC0:1 (0, 6) (15, 6) (15, 0) #MN1:2};
// &a @WIRE(mode="straight") {#MP1:1 (25, 9) (40, 9) (40, 30) #MP2:2};
// &a @WIRE(mode="straight") {#MN1:1 (25, 9) (40, 9) (40, -16) #MN2:2};
// %t1 = $IO_PORT @ATTACH &d => @PLACE(-6, 30) => @ORIENT("R0");
// %t1 @TEXT("d", key="name", size=0.75);
// &d @WIRE(mode="straight") {#MP0:2 %t1:p};
// %t2 = $SUPPLY @ATTACH &vdd => @PLACE(0, 35);
// &vdd @WIRE(mode="straight") {#MP0:3 %t2:p};
// %t3 = $IO_PORT @ATTACH &vdd => @PLACE(4, 30) => @ORIENT("MY");
// %t3 @TEXT("vdd", key="name", size=0.75);
// &vdd @WIRE(mode="straight") {#MP0:4 %t3:p};
// %t4 = $IO_PORT @ATTACH &ck => @PLACE(-6, 15) => @ORIENT("R0");
// %t4 @TEXT("ck", key="name", size=0.75);
// &ck @WIRE(mode="straight") {#MPC0:2 %t4:p};
// %t5 = $IO_PORT @ATTACH &vdd => @PLACE(4, 15) => @ORIENT("MY");
// %t5 @TEXT("vdd", key="name", size=0.75);
// &vdd @WIRE(mode="straight") {#MPC0:4 %t5:p};
// %t6 = $IO_PORT @ATTACH &d => @PLACE(-6, -8) => @ORIENT("R0");
// %t6 @TEXT("d", key="name", size=0.75);
// &d @WIRE(mode="straight") {#MN0:2 %t6:p};
// %t7 = $GROUND @ATTACH &vss => @PLACE(0, -13);
// &vss @WIRE(mode="straight") {#MN0:3 %t7:p};
// %t8 = $IO_PORT @ATTACH &vss => @PLACE(4, -8) => @ORIENT("MY");
// %t8 @TEXT("vss", key="name", size=0.75);
// &vss @WIRE(mode="straight") {#MN0:4 %t8:p};
// %t9 = $IO_PORT @ATTACH &ck => @PLACE(19, 30) => @ORIENT("R0");
// %t9 @TEXT("ck", key="name", size=0.75);
// &ck @WIRE(mode="straight") {#MP1:2 %t9:p};
// %t10 = $SUPPLY @ATTACH &vdd => @PLACE(25, 35);
// &vdd @WIRE(mode="straight") {#MP1:3 %t10:p};
// %t11 = $IO_PORT @ATTACH &vdd => @PLACE(29, 30) => @ORIENT("MY");
// %t11 @TEXT("vdd", key="name", size=0.75);
// &vdd @WIRE(mode="straight") {#MP1:4 %t11:p};
// %t12 = $IO_PORT @ATTACH &vss => @PLACE(29, 0) => @ORIENT("MY");
// %t12 @TEXT("vss", key="name", size=0.75);
// &vss @WIRE(mode="straight") {#MN1:4 %t12:p};
// %t13 = $IO_PORT @ATTACH &ck => @PLACE(19, -16) => @ORIENT("R0");
// %t13 @TEXT("ck", key="name", size=0.75);
// &ck @WIRE(mode="straight") {#MNC1:2 %t13:p};
// %t14 = $GROUND @ATTACH &vss => @PLACE(25, -21);
// &vss @WIRE(mode="straight") {#MNC1:3 %t14:p};
// %t15 = $IO_PORT @ATTACH &vss => @PLACE(29, -16) => @ORIENT("MY");
// %t15 @TEXT("vss", key="name", size=0.75);
// &vss @WIRE(mode="straight") {#MNC1:4 %t15:p};
// %t16 = $SUPPLY @ATTACH &vdd => @PLACE(50, 35);
// &vdd @WIRE(mode="straight") {#MP2:3 %t16:p};
// %t17 = $IO_PORT @ATTACH &vdd => @PLACE(54, 30) => @ORIENT("MY");
// %t17 @TEXT("vdd", key="name", size=0.75);
// &vdd @WIRE(mode="straight") {#MP2:4 %t17:p};
// %t18 = $IO_PORT @ATTACH &ck => @PLACE(44, 0) => @ORIENT("R0");
// %t18 @TEXT("ck", key="name", size=0.75);
// &ck @WIRE(mode="straight") {#MNC2:2 %t18:p};
// %t19 = $IO_PORT @ATTACH &vss => @PLACE(54, 0) => @ORIENT("MY");
// %t19 @TEXT("vss", key="name", size=0.75);
// &vss @WIRE(mode="straight") {#MNC2:4 %t19:p};
// %t20 = $GROUND @ATTACH &vss => @PLACE(50, -21);
// &vss @WIRE(mode="straight") {#MN2:3 %t20:p};
// %t21 = $IO_PORT @ATTACH &vss => @PLACE(54, -16) => @ORIENT("MY");
// %t21 @TEXT("vss", key="name", size=0.75);
// &vss @WIRE(mode="straight") {#MN2:4 %t21:p};
// %t22 = $IO_PORT @ATTACH &qb => @PLACE(46, 25) => @ORIENT("R0");
// %t22 @TEXT("qb", key="name", size=0.75);
// &qb @WIRE(mode="straight") {#MP2:1 (50, 25) %t22:p};
// (-11, 54) @TEXT("50  Retiming FF | 9 instances", size=1.2, halign="start");
// }
ends rtcomb_ff_v13_pdk110_50
