// Configuration | frozen callback110 / recenter109 | RNL 0.3
// @RNL(type="header") { @VERSION("0.3"); @USE-PACKAGE(name="rnl-std-fill") {} }
simulator lang=spectre
subckt tx_pll_config_pdk110_57 (refclk reset apply cfg_k0 cfg_k1 cfg_k2 cfg_k3 cfg_k4 cfg_k5 active_k0 active_k1 active_k2 active_k3 active_k4 active_k5 select_m0 select_m1 select_m2 select_m3 select_m4 select_m5 ready invalid divider_reset vdd vss)
X0 (n26 refclk reset invalid vdd vss) tx_dff_r0_pdk110_58
X1 (n27 refclk reset ready vdd vss) tx_dff_r0_pdk110_58
X2 (n28 refclk reset n29 vdd vss) tx_dff_r0_pdk110_58
X3 (n30 refclk reset n31 vdd vss) tx_dff_r0_pdk110_58
X4 (n32 refclk reset n33 vdd vss) tx_dff_r0_pdk110_58
X5 (n34 refclk reset n35 vdd vss) tx_dff_r0_pdk110_58
X6 (n36 refclk reset n37 vdd vss) tx_dff_r0_pdk110_58
X7 (n38 refclk reset n39 vdd vss) tx_dff_r0_pdk110_58
X8 (n40 refclk reset active_k0 vdd vss) tx_dff_r0_pdk110_58
X9 (n41 refclk reset active_k1 vdd vss) tx_dff_r0_pdk110_58
X10 (n42 refclk reset active_k2 vdd vss) tx_dff_r0_pdk110_58
X11 (n43 refclk reset active_k3 vdd vss) tx_dff_r0_pdk110_58
X12 (n44 refclk reset active_k4 vdd vss) tx_dff_r0_pdk110_58
X13 (n45 refclk reset active_k5 vdd vss) tx_dff_r0_pdk110_58
X14 (n46 refclk reset n47 vdd vss) tx_dff_r0_pdk110_58
X15 (n48 refclk reset n49 vdd vss) tx_dff_r0_pdk110_58
X16 (n50 refclk reset n51 vdd vss) tx_dff_r0_pdk110_58
X17 (n52 refclk reset n53 vdd vss) tx_dff_r0_pdk110_58
X18 (apply refclk reset n54 vdd vss) tx_dff_r0_pdk110_58
X19 (n54 refclk reset n55 vdd vss) tx_dff_r0_pdk110_58
X20 (n55 refclk reset n56 vdd vss) tx_dff_r0_pdk110_58
X21 (n57 refclk reset n58 vdd vss) tx_dff_r0_pdk110_58
X22 (n51 n59 n60 n50 vdd vss) tx_mux_pdk110_64
X23 (n49 n61 n60 n48 vdd vss) tx_mux_pdk110_64
X24 (n47 n62 n60 n46 vdd vss) tx_mux_pdk110_64
X25 (active_k4 n37 n63 n44 vdd vss) tx_mux_pdk110_64
X26 (active_k3 n35 n63 n43 vdd vss) tx_mux_pdk110_64
X27 (active_k2 n33 n63 n42 vdd vss) tx_mux_pdk110_64
X28 (active_k1 n31 n63 n41 vdd vss) tx_mux_pdk110_64
X29 (active_k0 n29 n63 n40 vdd vss) tx_mux_pdk110_64
X30 (n37 cfg_k4 n64 n36 vdd vss) tx_mux_pdk110_64
X31 (n35 cfg_k3 n64 n34 vdd vss) tx_mux_pdk110_64
X32 (n33 cfg_k2 n64 n32 vdd vss) tx_mux_pdk110_64
X33 (n31 cfg_k1 n64 n30 vdd vss) tx_mux_pdk110_64
X34 (n29 cfg_k0 n64 n28 vdd vss) tx_mux_pdk110_64
X35 (invalid n65 n66 n26 vdd vss) tx_mux_pdk110_64
X36 (ready n67 n66 n27 vdd vss) tx_mux_pdk110_64
X37 (n39 cfg_k5 n64 n38 vdd vss) tx_mux_pdk110_64
X38 (active_k5 n39 n63 n45 vdd vss) tx_mux_pdk110_64
X39 (n53 n68 n60 n52 vdd vss) tx_mux_pdk110_64
X40 (n47 n69 vdd vss) pll_inv_pdk110_7
X41 (n31 n70 vdd vss) pll_inv_pdk110_7
X42 (n33 n71 vdd vss) pll_inv_pdk110_7
X43 (n39 n72 vdd vss) pll_inv_pdk110_7
X44 (n37 n73 vdd vss) pll_inv_pdk110_7
X45 (active_k1 n74 vdd vss) pll_inv_pdk110_7
X46 (active_k0 n75 vdd vss) pll_inv_pdk110_7
X47 (active_k5 n76 vdd vss) pll_inv_pdk110_7
X48 (active_k3 n77 vdd vss) pll_inv_pdk110_7
X49 (active_k2 n78 vdd vss) pll_inv_pdk110_7
X50 (active_k4 n79 vdd vss) pll_inv_pdk110_7
X51 (n51 n80 vdd vss) pll_inv_pdk110_7
X52 (n81 n82 vdd vss) pll_inv_pdk110_7
X53 (n83 n84 vdd vss) pll_inv_pdk110_7
X54 (n85 n86 vdd vss) pll_inv_pdk110_7
X55 (n87 n88 vdd vss) pll_inv_pdk110_7
X56 (n89 n90 vdd vss) pll_inv_pdk110_7
X57 (n91 n92 vdd vss) pll_inv_pdk110_7
X58 (n93 n94 vdd vss) pll_inv_pdk110_7
X59 (n95 n96 vdd vss) pll_inv_pdk110_7
X60 (n97 n98 vdd vss) pll_inv_pdk110_7
X61 (n99 n100 vdd vss) pll_inv_pdk110_7
X62 (n101 n102 vdd vss) pll_inv_pdk110_7
X63 (n103 n104 vdd vss) pll_inv_pdk110_7
X64 (n105 n106 vdd vss) pll_inv_pdk110_7
X65 (n49 n47 n107 vdd vss) tx_xor_pdk110_66
X66 (n51 n108 n109 vdd vss) tx_xor_pdk110_66
X67 (n53 n110 n111 vdd vss) tx_xor_pdk110_66
X68 (n112 n113 n105 vdd vss) tx_or_pdk110_67
X69 (n114 n115 n113 vdd vss) tx_and_pdk110_47
X70 (active_k5 n116 n112 vdd vss) tx_or_pdk110_67
X71 (active_k3 active_k2 n117 vdd vss) tx_and_pdk110_47
X72 (n118 n119 n103 vdd vss) tx_or_pdk110_67
X73 (n120 n115 n119 vdd vss) tx_and_pdk110_47
X74 (n117 n121 n115 vdd vss) tx_or_pdk110_67
X75 (n122 n123 n121 vdd vss) tx_and_pdk110_47
X76 (active_k5 n79 n120 vdd vss) tx_and_pdk110_47
X77 (active_k5 active_k4 n118 vdd vss) tx_and_pdk110_47
X78 (active_k5 n124 n101 vdd vss) tx_or_pdk110_67
X79 (n116 n117 n124 vdd vss) tx_and_pdk110_47
X80 (n116 n125 n126 vdd vss) tx_and_pdk110_47
X81 (active_k5 n126 n99 vdd vss) tx_or_pdk110_67
X82 (n127 n128 n125 vdd vss) tx_or_pdk110_67
X83 (n129 n130 n128 vdd vss) tx_and_pdk110_47
X84 (n76 active_k4 n116 vdd vss) tx_and_pdk110_47
X85 (n77 n78 n129 vdd vss) tx_and_pdk110_47
X86 (active_k3 n131 n127 vdd vss) tx_or_pdk110_67
X87 (active_k5 n132 n97 vdd vss) tx_or_pdk110_67
X88 (n116 n133 n132 vdd vss) tx_and_pdk110_47
X89 (n106 n134 n135 vdd vss) tx_or_pdk110_67
X90 (n117 n136 n133 vdd vss) tx_or_pdk110_67
X91 (n114 n137 n138 vdd vss) tx_and_pdk110_47
X92 (n112 n138 n95 vdd vss) tx_or_pdk110_67
X93 (n117 active_k1 n137 vdd vss) tx_and_pdk110_47
X94 (n76 n79 n114 vdd vss) tx_and_pdk110_47
X95 (active_k5 n139 n93 vdd vss) tx_or_pdk110_67
X96 (n116 n140 n139 vdd vss) tx_and_pdk110_47
X97 (n127 n141 n140 vdd vss) tx_or_pdk110_67
X98 (n129 active_k1 n141 vdd vss) tx_and_pdk110_47
X99 (n77 active_k2 n131 vdd vss) tx_and_pdk110_47
X100 (n102 n142 n143 vdd vss) tx_or_pdk110_67
X101 (n114 n117 n144 vdd vss) tx_and_pdk110_47
X102 (n112 n144 n91 vdd vss) tx_or_pdk110_67
X103 (n112 n145 n89 vdd vss) tx_or_pdk110_67
X104 (n114 n146 n145 vdd vss) tx_and_pdk110_47
X105 (n117 n123 n146 vdd vss) tx_and_pdk110_47
X106 (n100 n147 n148 vdd vss) tx_or_pdk110_67
X107 (active_k1 n149 n123 vdd vss) tx_or_pdk110_67
X108 (n74 active_k0 n149 vdd vss) tx_and_pdk110_47
X109 (n112 n150 n87 vdd vss) tx_or_pdk110_67
X110 (n114 n151 n150 vdd vss) tx_and_pdk110_47
X111 (n117 n152 n151 vdd vss) tx_or_pdk110_67
X112 (n122 active_k1 n152 vdd vss) tx_and_pdk110_47
X113 (active_k3 n78 n122 vdd vss) tx_and_pdk110_47
X114 (n112 n153 n85 vdd vss) tx_or_pdk110_67
X115 (n114 n133 n153 vdd vss) tx_and_pdk110_47
X116 (active_k1 active_k0 n130 vdd vss) tx_and_pdk110_47
X117 (n96 n154 n155 vdd vss) tx_or_pdk110_67
X118 (n156 n157 n83 vdd vss) tx_or_pdk110_67
X119 (n158 n159 n157 vdd vss) tx_and_pdk110_47
X120 (n160 n161 n159 vdd vss) tx_or_pdk110_67
X121 (n39 n162 n156 vdd vss) tx_or_pdk110_67
X122 (n72 n37 n162 vdd vss) tx_and_pdk110_47
X123 (n31 n163 n164 vdd vss) tx_or_pdk110_67
X124 (n165 n159 n166 vdd vss) tx_and_pdk110_47
X125 (n167 n166 n81 vdd vss) tx_or_pdk110_67
X126 (n168 n164 n161 vdd vss) tx_and_pdk110_47
X127 (n39 n37 n167 vdd vss) tx_and_pdk110_47
X128 (n35 n33 n160 vdd vss) tx_and_pdk110_47
X129 (n70 n29 n163 vdd vss) tx_and_pdk110_47
X130 (n51 n108 n110 vdd vss) tx_and_pdk110_47
X131 (n49 n47 n108 vdd vss) tx_and_pdk110_47
X132 (n92 n169 n170 vdd vss) tx_or_pdk110_67
X133 (n88 n171 n172 vdd vss) tx_or_pdk110_67
X134 (n84 n173 n174 vdd vss) tx_or_pdk110_67
X135 (n175 n176 n66 vdd vss) tx_and_pdk110_47
X136 (n64 n177 n175 vdd vss) tx_or_pdk110_67
X137 (n58 n64 n176 vdd vss) tx_or_pdk110_67
X138 (n178 n58 n179 vdd vss) tx_and_pdk110_47
X139 (n179 n180 n63 vdd vss) tx_and_pdk110_47
X140 (n181 n176 n60 vdd vss) tx_and_pdk110_47
X141 (n64 n182 n181 vdd vss) tx_or_pdk110_67
X142 (n75 active_k1 n183 vdd vss) tx_or_pdk110_67
X143 (active_k2 n77 n184 vdd vss) tx_or_pdk110_67
X144 (active_k4 active_k5 n185 vdd vss) tx_or_pdk110_67
X145 (n183 n184 n186 vdd vss) tx_or_pdk110_67
X146 (n186 n185 n187 vdd vss) tx_or_pdk110_67
X147 (n69 n49 n188 vdd vss) tx_or_pdk110_67
X148 (n51 n53 n189 vdd vss) tx_or_pdk110_67
X149 (n188 n189 n190 vdd vss) tx_or_pdk110_67
X150 (n69 n191 n192 vdd vss) tx_or_pdk110_67
X151 (n80 n53 n193 vdd vss) tx_or_pdk110_67
X152 (n192 n193 n182 vdd vss) tx_or_pdk110_67
X153 (n194 n114 n134 vdd vss) tx_and_pdk110_47
X154 (n195 n134 n196 vdd vss) tx_or_pdk110_67
X155 (n149 n122 n194 vdd vss) tx_and_pdk110_47
X156 (n194 n120 n197 vdd vss) tx_and_pdk110_47
X157 (n104 n197 n198 vdd vss) tx_or_pdk110_67
X158 (n75 n74 n199 vdd vss) tx_and_pdk110_47
X159 (n199 n117 n200 vdd vss) tx_and_pdk110_47
X160 (n200 n116 n142 vdd vss) tx_and_pdk110_47
X161 (n201 n142 n202 vdd vss) tx_or_pdk110_67
X162 (n128 n116 n147 vdd vss) tx_and_pdk110_47
X163 (n203 n147 n204 vdd vss) tx_or_pdk110_67
X164 (n130 n122 n136 vdd vss) tx_and_pdk110_47
X165 (n136 n116 n205 vdd vss) tx_and_pdk110_47
X166 (n98 n205 n206 vdd vss) tx_or_pdk110_67
X167 (n207 n117 n208 vdd vss) tx_and_pdk110_47
X168 (n208 n114 n154 vdd vss) tx_and_pdk110_47
X169 (n209 n154 n210 vdd vss) tx_or_pdk110_67
X170 (n75 active_k1 n207 vdd vss) tx_and_pdk110_47
X171 (n207 n129 n211 vdd vss) tx_and_pdk110_47
X172 (n211 n116 n212 vdd vss) tx_and_pdk110_47
X173 (n94 n212 n213 vdd vss) tx_or_pdk110_67
X174 (n200 n114 n169 vdd vss) tx_and_pdk110_47
X175 (n214 n169 n215 vdd vss) tx_or_pdk110_67
X176 (n149 n117 n216 vdd vss) tx_and_pdk110_47
X177 (n216 n114 n217 vdd vss) tx_and_pdk110_47
X178 (n90 n217 n218 vdd vss) tx_or_pdk110_67
X179 (n207 n122 n219 vdd vss) tx_and_pdk110_47
X180 (n219 n114 n171 vdd vss) tx_and_pdk110_47
X181 (n220 n171 n221 vdd vss) tx_or_pdk110_67
X182 (n136 n114 n222 vdd vss) tx_and_pdk110_47
X183 (n86 n222 n223 vdd vss) tx_or_pdk110_67
X184 (n71 n35 n168 vdd vss) tx_and_pdk110_47
X185 (n73 n72 n158 vdd vss) tx_and_pdk110_47
X186 (n163 n168 n224 vdd vss) tx_and_pdk110_47
X187 (n224 n158 n173 vdd vss) tx_and_pdk110_47
X188 (n225 n173 n226 vdd vss) tx_or_pdk110_67
X189 (n73 n39 n165 vdd vss) tx_and_pdk110_47
X190 (n224 n165 n227 vdd vss) tx_and_pdk110_47
X191 (n82 n227 n228 vdd vss) tx_or_pdk110_67
X192 (n187 n229 vdd vss) pll_inv_pdk110_7
X193 (ready n230 vdd vss) pll_inv_pdk110_7
X194 (n56 n231 vdd vss) pll_inv_pdk110_7
X195 (n190 n180 vdd vss) pll_inv_pdk110_7
X196 (n182 n177 vdd vss) pll_inv_pdk110_7
X197 (n232 n233 vdd vss) pll_inv_pdk110_7
X198 (n196 n198 n234 vdd vss) tx_and_pdk110_47
X199 (n234 n202 select_m0 vdd vss) tx_and_pdk110_47
X200 (n234 n204 n235 vdd vss) tx_and_pdk110_47
X201 (n235 n206 select_m1 vdd vss) tx_and_pdk110_47
X202 (n234 n210 n236 vdd vss) tx_and_pdk110_47
X203 (n236 n213 select_m2 vdd vss) tx_and_pdk110_47
X204 (n234 n215 n237 vdd vss) tx_and_pdk110_47
X205 (n237 n218 select_m3 vdd vss) tx_and_pdk110_47
X206 (n234 n221 n238 vdd vss) tx_and_pdk110_47
X207 (n238 n223 select_m4 vdd vss) tx_and_pdk110_47
X208 (n234 n229 select_m5 vdd vss) tx_and_pdk110_47
X209 (reset n230 divider_reset vdd vss) tx_or_pdk110_67
X210 (n55 n231 n64 vdd vss) tx_and_pdk110_47
X211 (n226 n228 n232 vdd vss) tx_and_pdk110_47
X212 (vss n182 n58 n239 vdd vss) tx_mux_pdk110_64
X213 (n239 vdd n64 n57 vdd vss) tx_mux_pdk110_64
X214 (nx n69 n182 n240 vdd vss) tx_mux_pdk110_64
X215 (nx n107 n182 n241 vdd vss) tx_mux_pdk110_64
X216 (nx n109 n182 n242 vdd vss) tx_mux_pdk110_64
X217 (nx n111 n182 n243 vdd vss) tx_mux_pdk110_64
X218 (nx n240 n58 n244 vdd vss) tx_mux_pdk110_64
X219 (nx n241 n58 n245 vdd vss) tx_mux_pdk110_64
X220 (nx n242 n58 n246 vdd vss) tx_mux_pdk110_64
X221 (nx n243 n58 n247 vdd vss) tx_mux_pdk110_64
X222 (n244 vss n64 n62 vdd vss) tx_mux_pdk110_64
X223 (n245 vss n64 n61 vdd vss) tx_mux_pdk110_64
X224 (n246 vss n64 n59 vdd vss) tx_mux_pdk110_64
X225 (n247 vss n64 n68 vdd vss) tx_mux_pdk110_64
X226 (n233 nx n182 n248 vdd vss) tx_mux_pdk110_64
X227 (nx n248 n58 n249 vdd vss) tx_mux_pdk110_64
X228 (n249 vss n64 n65 vdd vss) tx_mux_pdk110_64
X229 (n232 nx n182 n250 vdd vss) tx_mux_pdk110_64
X230 (nx n250 n58 n251 vdd vss) tx_mux_pdk110_64
X231 (n251 vss n64 n67 vdd vss) tx_mux_pdk110_64
X232 (n49 n191 vdd vss) pll_inv_pdk110_7
X233 (n64 n178 vdd vss) pll_inv_pdk110_7
X234 (n135 n195 vdd vss) pll_inv_pdk110_7
X235 (n143 n201 vdd vss) pll_inv_pdk110_7
X236 (n148 n203 vdd vss) pll_inv_pdk110_7
X237 (n155 n209 vdd vss) pll_inv_pdk110_7
X238 (n170 n214 vdd vss) pll_inv_pdk110_7
X239 (n172 n220 vdd vss) pll_inv_pdk110_7
X240 (n174 n225 vdd vss) pll_inv_pdk110_7
// @RNL(author="manual-schematic126") {
// $CELL = @DEFINE-SYMBOL {
// @LINE {(-18, 32) (18, 32) (18, -32) (-18, -32) (-18, 32)};
// (-20, 16) @PIN(terminal="refclk", direction="left");
// @LINE {(-20, 16) (-18, 16)};
// (-17.4, 16) @TEXT("refclk", size=0.7, halign="start");
// (-20, 12) @PIN(terminal="reset", direction="left");
// @LINE {(-20, 12) (-18, 12)};
// (-17.4, 12) @TEXT("reset", size=0.7, halign="start");
// (-20, 8) @PIN(terminal="apply", direction="left");
// @LINE {(-20, 8) (-18, 8)};
// (-17.4, 8) @TEXT("apply", size=0.7, halign="start");
// (-20, 4) @PIN(terminal="cfg_k0", direction="left");
// @LINE {(-20, 4) (-18, 4)};
// (-17.4, 4) @TEXT("cfg_k0", size=0.7, halign="start");
// (-20, 0) @PIN(terminal="cfg_k1", direction="left");
// @LINE {(-20, 0) (-18, 0)};
// (-17.4, 0) @TEXT("cfg_k1", size=0.7, halign="start");
// (-20, -4) @PIN(terminal="cfg_k2", direction="left");
// @LINE {(-20, -4) (-18, -4)};
// (-17.4, -4) @TEXT("cfg_k2", size=0.7, halign="start");
// (-20, -8) @PIN(terminal="cfg_k3", direction="left");
// @LINE {(-20, -8) (-18, -8)};
// (-17.4, -8) @TEXT("cfg_k3", size=0.7, halign="start");
// (-20, -12) @PIN(terminal="cfg_k4", direction="left");
// @LINE {(-20, -12) (-18, -12)};
// (-17.4, -12) @TEXT("cfg_k4", size=0.7, halign="start");
// (-20, -16) @PIN(terminal="cfg_k5", direction="left");
// @LINE {(-20, -16) (-18, -16)};
// (-17.4, -16) @TEXT("cfg_k5", size=0.7, halign="start");
// (20, 28) @PIN(terminal="active_k0", direction="right");
// @LINE {(20, 28) (18, 28)};
// (17.4, 28) @TEXT("active_k0", size=0.7, halign="end");
// (20, 24) @PIN(terminal="active_k1", direction="right");
// @LINE {(20, 24) (18, 24)};
// (17.4, 24) @TEXT("active_k1", size=0.7, halign="end");
// (20, 20) @PIN(terminal="active_k2", direction="right");
// @LINE {(20, 20) (18, 20)};
// (17.4, 20) @TEXT("active_k2", size=0.7, halign="end");
// (20, 16) @PIN(terminal="active_k3", direction="right");
// @LINE {(20, 16) (18, 16)};
// (17.4, 16) @TEXT("active_k3", size=0.7, halign="end");
// (20, 12) @PIN(terminal="active_k4", direction="right");
// @LINE {(20, 12) (18, 12)};
// (17.4, 12) @TEXT("active_k4", size=0.7, halign="end");
// (20, 8) @PIN(terminal="active_k5", direction="right");
// @LINE {(20, 8) (18, 8)};
// (17.4, 8) @TEXT("active_k5", size=0.7, halign="end");
// (20, 4) @PIN(terminal="select_m0", direction="right");
// @LINE {(20, 4) (18, 4)};
// (17.4, 4) @TEXT("select_m0", size=0.7, halign="end");
// (20, 0) @PIN(terminal="select_m1", direction="right");
// @LINE {(20, 0) (18, 0)};
// (17.4, 0) @TEXT("select_m1", size=0.7, halign="end");
// (20, -4) @PIN(terminal="select_m2", direction="right");
// @LINE {(20, -4) (18, -4)};
// (17.4, -4) @TEXT("select_m2", size=0.7, halign="end");
// (20, -8) @PIN(terminal="select_m3", direction="right");
// @LINE {(20, -8) (18, -8)};
// (17.4, -8) @TEXT("select_m3", size=0.7, halign="end");
// (20, -12) @PIN(terminal="select_m4", direction="right");
// @LINE {(20, -12) (18, -12)};
// (17.4, -12) @TEXT("select_m4", size=0.7, halign="end");
// (20, -16) @PIN(terminal="select_m5", direction="right");
// @LINE {(20, -16) (18, -16)};
// (17.4, -16) @TEXT("select_m5", size=0.7, halign="end");
// (20, -20) @PIN(terminal="ready", direction="right");
// @LINE {(20, -20) (18, -20)};
// (17.4, -20) @TEXT("ready", size=0.7, halign="end");
// (20, -24) @PIN(terminal="invalid", direction="right");
// @LINE {(20, -24) (18, -24)};
// (17.4, -24) @TEXT("invalid", size=0.7, halign="end");
// (20, -28) @PIN(terminal="divider_reset", direction="right");
// @LINE {(20, -28) (18, -28)};
// (17.4, -28) @TEXT("divider_reset", size=0.7, halign="end");
// (0, 34) @PIN(terminal="vdd", direction="up");
// @LINE {(0, 34) (0, 32)};
// (0, -34) @PIN(terminal="vss", direction="down");
// @LINE {(0, -34) (0, -32)};
// ? @TEXT("${name}", key="name", size=1, halign="middle") => @PLACE(20, 35.5);
// (0, 31.1) @TEXT("Configuration", size=0.85, halign="middle");
// };
// # @SET-SYMBOL $CELL;
// #X0 @PLACE(0, 0) => @ORIENT("R0");
// (-25, 14) @TEXT("Panel 01 | X0 - X23", size=1.1, halign="start");
// #X1 @PLACE(70, 0) => @ORIENT("R0");
// #X2 @PLACE(140, 0) => @ORIENT("R0");
// #X3 @PLACE(210, 0) => @ORIENT("R0");
// #X4 @PLACE(0, -35) => @ORIENT("R0");
// #X5 @PLACE(70, -35) => @ORIENT("R0");
// #X6 @PLACE(140, -35) => @ORIENT("R0");
// #X7 @PLACE(210, -35) => @ORIENT("R0");
// #X8 @PLACE(0, -70) => @ORIENT("R0");
// #X9 @PLACE(70, -70) => @ORIENT("R0");
// #X10 @PLACE(140, -70) => @ORIENT("R0");
// #X11 @PLACE(210, -70) => @ORIENT("R0");
// #X12 @PLACE(0, -105) => @ORIENT("R0");
// #X13 @PLACE(70, -105) => @ORIENT("R0");
// #X14 @PLACE(140, -105) => @ORIENT("R0");
// #X15 @PLACE(210, -105) => @ORIENT("R0");
// #X16 @PLACE(0, -140) => @ORIENT("R0");
// #X17 @PLACE(70, -140) => @ORIENT("R0");
// #X18 @PLACE(140, -140) => @ORIENT("R0");
// #X19 @PLACE(210, -140) => @ORIENT("R0");
// #X20 @PLACE(0, -175) => @ORIENT("R0");
// #X21 @PLACE(70, -175) => @ORIENT("R0");
// #X22 @PLACE(140, -175) => @ORIENT("R0");
// #X23 @PLACE(210, -175) => @ORIENT("R0");
// #X24 @PLACE(300, 0) => @ORIENT("R0");
// (275, 14) @TEXT("Panel 02 | X24 - X47", size=1.1, halign="start");
// #X25 @PLACE(370, 0) => @ORIENT("R0");
// #X26 @PLACE(440, 0) => @ORIENT("R0");
// #X27 @PLACE(510, 0) => @ORIENT("R0");
// #X28 @PLACE(300, -35) => @ORIENT("R0");
// #X29 @PLACE(370, -35) => @ORIENT("R0");
// #X30 @PLACE(440, -35) => @ORIENT("R0");
// #X31 @PLACE(510, -35) => @ORIENT("R0");
// #X32 @PLACE(300, -70) => @ORIENT("R0");
// #X33 @PLACE(370, -70) => @ORIENT("R0");
// #X34 @PLACE(440, -70) => @ORIENT("R0");
// #X35 @PLACE(510, -70) => @ORIENT("R0");
// #X36 @PLACE(300, -105) => @ORIENT("R0");
// #X37 @PLACE(370, -105) => @ORIENT("R0");
// #X38 @PLACE(440, -105) => @ORIENT("R0");
// #X39 @PLACE(510, -105) => @ORIENT("R0");
// #X40 @PLACE(300, -140) => @ORIENT("R0");
// #X41 @PLACE(370, -140) => @ORIENT("R0");
// #X42 @PLACE(440, -140) => @ORIENT("R0");
// #X43 @PLACE(510, -140) => @ORIENT("R0");
// #X44 @PLACE(300, -175) => @ORIENT("R0");
// #X45 @PLACE(370, -175) => @ORIENT("R0");
// #X46 @PLACE(440, -175) => @ORIENT("R0");
// #X47 @PLACE(510, -175) => @ORIENT("R0");
// #X48 @PLACE(600, 0) => @ORIENT("R0");
// (575, 14) @TEXT("Panel 03 | X48 - X71", size=1.1, halign="start");
// #X49 @PLACE(670, 0) => @ORIENT("R0");
// #X50 @PLACE(740, 0) => @ORIENT("R0");
// #X51 @PLACE(810, 0) => @ORIENT("R0");
// #X52 @PLACE(600, -35) => @ORIENT("R0");
// #X53 @PLACE(670, -35) => @ORIENT("R0");
// #X54 @PLACE(740, -35) => @ORIENT("R0");
// #X55 @PLACE(810, -35) => @ORIENT("R0");
// #X56 @PLACE(600, -70) => @ORIENT("R0");
// #X57 @PLACE(670, -70) => @ORIENT("R0");
// #X58 @PLACE(740, -70) => @ORIENT("R0");
// #X59 @PLACE(810, -70) => @ORIENT("R0");
// #X60 @PLACE(600, -105) => @ORIENT("R0");
// #X61 @PLACE(670, -105) => @ORIENT("R0");
// #X62 @PLACE(740, -105) => @ORIENT("R0");
// #X63 @PLACE(810, -105) => @ORIENT("R0");
// #X64 @PLACE(600, -140) => @ORIENT("R0");
// #X65 @PLACE(670, -140) => @ORIENT("R0");
// #X66 @PLACE(740, -140) => @ORIENT("R0");
// #X67 @PLACE(810, -140) => @ORIENT("R0");
// #X68 @PLACE(600, -175) => @ORIENT("R0");
// #X69 @PLACE(670, -175) => @ORIENT("R0");
// #X70 @PLACE(740, -175) => @ORIENT("R0");
// #X71 @PLACE(810, -175) => @ORIENT("R0");
// #X72 @PLACE(900, 0) => @ORIENT("R0");
// (875, 14) @TEXT("Panel 04 | X72 - X95", size=1.1, halign="start");
// #X73 @PLACE(970, 0) => @ORIENT("R0");
// #X74 @PLACE(1040, 0) => @ORIENT("R0");
// #X75 @PLACE(1110, 0) => @ORIENT("R0");
// #X76 @PLACE(900, -35) => @ORIENT("R0");
// #X77 @PLACE(970, -35) => @ORIENT("R0");
// #X78 @PLACE(1040, -35) => @ORIENT("R0");
// #X79 @PLACE(1110, -35) => @ORIENT("R0");
// #X80 @PLACE(900, -70) => @ORIENT("R0");
// #X81 @PLACE(970, -70) => @ORIENT("R0");
// #X82 @PLACE(1040, -70) => @ORIENT("R0");
// #X83 @PLACE(1110, -70) => @ORIENT("R0");
// #X84 @PLACE(900, -105) => @ORIENT("R0");
// #X85 @PLACE(970, -105) => @ORIENT("R0");
// #X86 @PLACE(1040, -105) => @ORIENT("R0");
// #X87 @PLACE(1110, -105) => @ORIENT("R0");
// #X88 @PLACE(900, -140) => @ORIENT("R0");
// #X89 @PLACE(970, -140) => @ORIENT("R0");
// #X90 @PLACE(1040, -140) => @ORIENT("R0");
// #X91 @PLACE(1110, -140) => @ORIENT("R0");
// #X92 @PLACE(900, -175) => @ORIENT("R0");
// #X93 @PLACE(970, -175) => @ORIENT("R0");
// #X94 @PLACE(1040, -175) => @ORIENT("R0");
// #X95 @PLACE(1110, -175) => @ORIENT("R0");
// #X96 @PLACE(0, -240) => @ORIENT("R0");
// (-25, -226) @TEXT("Panel 05 | X96 - X119", size=1.1, halign="start");
// #X97 @PLACE(70, -240) => @ORIENT("R0");
// #X98 @PLACE(140, -240) => @ORIENT("R0");
// #X99 @PLACE(210, -240) => @ORIENT("R0");
// #X100 @PLACE(0, -275) => @ORIENT("R0");
// #X101 @PLACE(70, -275) => @ORIENT("R0");
// #X102 @PLACE(140, -275) => @ORIENT("R0");
// #X103 @PLACE(210, -275) => @ORIENT("R0");
// #X104 @PLACE(0, -310) => @ORIENT("R0");
// #X105 @PLACE(70, -310) => @ORIENT("R0");
// #X106 @PLACE(140, -310) => @ORIENT("R0");
// #X107 @PLACE(210, -310) => @ORIENT("R0");
// #X108 @PLACE(0, -345) => @ORIENT("R0");
// #X109 @PLACE(70, -345) => @ORIENT("R0");
// #X110 @PLACE(140, -345) => @ORIENT("R0");
// #X111 @PLACE(210, -345) => @ORIENT("R0");
// #X112 @PLACE(0, -380) => @ORIENT("R0");
// #X113 @PLACE(70, -380) => @ORIENT("R0");
// #X114 @PLACE(140, -380) => @ORIENT("R0");
// #X115 @PLACE(210, -380) => @ORIENT("R0");
// #X116 @PLACE(0, -415) => @ORIENT("R0");
// #X117 @PLACE(70, -415) => @ORIENT("R0");
// #X118 @PLACE(140, -415) => @ORIENT("R0");
// #X119 @PLACE(210, -415) => @ORIENT("R0");
// #X120 @PLACE(300, -240) => @ORIENT("R0");
// (275, -226) @TEXT("Panel 06 | X120 - X143", size=1.1, halign="start");
// #X121 @PLACE(370, -240) => @ORIENT("R0");
// #X122 @PLACE(440, -240) => @ORIENT("R0");
// #X123 @PLACE(510, -240) => @ORIENT("R0");
// #X124 @PLACE(300, -275) => @ORIENT("R0");
// #X125 @PLACE(370, -275) => @ORIENT("R0");
// #X126 @PLACE(440, -275) => @ORIENT("R0");
// #X127 @PLACE(510, -275) => @ORIENT("R0");
// #X128 @PLACE(300, -310) => @ORIENT("R0");
// #X129 @PLACE(370, -310) => @ORIENT("R0");
// #X130 @PLACE(440, -310) => @ORIENT("R0");
// #X131 @PLACE(510, -310) => @ORIENT("R0");
// #X132 @PLACE(300, -345) => @ORIENT("R0");
// #X133 @PLACE(370, -345) => @ORIENT("R0");
// #X134 @PLACE(440, -345) => @ORIENT("R0");
// #X135 @PLACE(510, -345) => @ORIENT("R0");
// #X136 @PLACE(300, -380) => @ORIENT("R0");
// #X137 @PLACE(370, -380) => @ORIENT("R0");
// #X138 @PLACE(440, -380) => @ORIENT("R0");
// #X139 @PLACE(510, -380) => @ORIENT("R0");
// #X140 @PLACE(300, -415) => @ORIENT("R0");
// #X141 @PLACE(370, -415) => @ORIENT("R0");
// #X142 @PLACE(440, -415) => @ORIENT("R0");
// #X143 @PLACE(510, -415) => @ORIENT("R0");
// #X144 @PLACE(600, -240) => @ORIENT("R0");
// (575, -226) @TEXT("Panel 07 | X144 - X167", size=1.1, halign="start");
// #X145 @PLACE(670, -240) => @ORIENT("R0");
// #X146 @PLACE(740, -240) => @ORIENT("R0");
// #X147 @PLACE(810, -240) => @ORIENT("R0");
// #X148 @PLACE(600, -275) => @ORIENT("R0");
// #X149 @PLACE(670, -275) => @ORIENT("R0");
// #X150 @PLACE(740, -275) => @ORIENT("R0");
// #X151 @PLACE(810, -275) => @ORIENT("R0");
// #X152 @PLACE(600, -310) => @ORIENT("R0");
// #X153 @PLACE(670, -310) => @ORIENT("R0");
// #X154 @PLACE(740, -310) => @ORIENT("R0");
// #X155 @PLACE(810, -310) => @ORIENT("R0");
// #X156 @PLACE(600, -345) => @ORIENT("R0");
// #X157 @PLACE(670, -345) => @ORIENT("R0");
// #X158 @PLACE(740, -345) => @ORIENT("R0");
// #X159 @PLACE(810, -345) => @ORIENT("R0");
// #X160 @PLACE(600, -380) => @ORIENT("R0");
// #X161 @PLACE(670, -380) => @ORIENT("R0");
// #X162 @PLACE(740, -380) => @ORIENT("R0");
// #X163 @PLACE(810, -380) => @ORIENT("R0");
// #X164 @PLACE(600, -415) => @ORIENT("R0");
// #X165 @PLACE(670, -415) => @ORIENT("R0");
// #X166 @PLACE(740, -415) => @ORIENT("R0");
// #X167 @PLACE(810, -415) => @ORIENT("R0");
// #X168 @PLACE(900, -240) => @ORIENT("R0");
// (875, -226) @TEXT("Panel 08 | X168 - X191", size=1.1, halign="start");
// #X169 @PLACE(970, -240) => @ORIENT("R0");
// #X170 @PLACE(1040, -240) => @ORIENT("R0");
// #X171 @PLACE(1110, -240) => @ORIENT("R0");
// #X172 @PLACE(900, -275) => @ORIENT("R0");
// #X173 @PLACE(970, -275) => @ORIENT("R0");
// #X174 @PLACE(1040, -275) => @ORIENT("R0");
// #X175 @PLACE(1110, -275) => @ORIENT("R0");
// #X176 @PLACE(900, -310) => @ORIENT("R0");
// #X177 @PLACE(970, -310) => @ORIENT("R0");
// #X178 @PLACE(1040, -310) => @ORIENT("R0");
// #X179 @PLACE(1110, -310) => @ORIENT("R0");
// #X180 @PLACE(900, -345) => @ORIENT("R0");
// #X181 @PLACE(970, -345) => @ORIENT("R0");
// #X182 @PLACE(1040, -345) => @ORIENT("R0");
// #X183 @PLACE(1110, -345) => @ORIENT("R0");
// #X184 @PLACE(900, -380) => @ORIENT("R0");
// #X185 @PLACE(970, -380) => @ORIENT("R0");
// #X186 @PLACE(1040, -380) => @ORIENT("R0");
// #X187 @PLACE(1110, -380) => @ORIENT("R0");
// #X188 @PLACE(900, -415) => @ORIENT("R0");
// #X189 @PLACE(970, -415) => @ORIENT("R0");
// #X190 @PLACE(1040, -415) => @ORIENT("R0");
// #X191 @PLACE(1110, -415) => @ORIENT("R0");
// #X192 @PLACE(0, -480) => @ORIENT("R0");
// (-25, -466) @TEXT("Panel 09 | X192 - X215", size=1.1, halign="start");
// #X193 @PLACE(70, -480) => @ORIENT("R0");
// #X194 @PLACE(140, -480) => @ORIENT("R0");
// #X195 @PLACE(210, -480) => @ORIENT("R0");
// #X196 @PLACE(0, -515) => @ORIENT("R0");
// #X197 @PLACE(70, -515) => @ORIENT("R0");
// #X198 @PLACE(140, -515) => @ORIENT("R0");
// #X199 @PLACE(210, -515) => @ORIENT("R0");
// #X200 @PLACE(0, -550) => @ORIENT("R0");
// #X201 @PLACE(70, -550) => @ORIENT("R0");
// #X202 @PLACE(140, -550) => @ORIENT("R0");
// #X203 @PLACE(210, -550) => @ORIENT("R0");
// #X204 @PLACE(0, -585) => @ORIENT("R0");
// #X205 @PLACE(70, -585) => @ORIENT("R0");
// #X206 @PLACE(140, -585) => @ORIENT("R0");
// #X207 @PLACE(210, -585) => @ORIENT("R0");
// #X208 @PLACE(0, -620) => @ORIENT("R0");
// #X209 @PLACE(70, -620) => @ORIENT("R0");
// #X210 @PLACE(140, -620) => @ORIENT("R0");
// #X211 @PLACE(210, -620) => @ORIENT("R0");
// #X212 @PLACE(0, -655) => @ORIENT("R0");
// #X213 @PLACE(70, -655) => @ORIENT("R0");
// #X214 @PLACE(140, -655) => @ORIENT("R0");
// #X215 @PLACE(210, -655) => @ORIENT("R0");
// #X216 @PLACE(300, -480) => @ORIENT("R0");
// (275, -466) @TEXT("Panel 10 | X216 - X239", size=1.1, halign="start");
// #X217 @PLACE(370, -480) => @ORIENT("R0");
// #X218 @PLACE(440, -480) => @ORIENT("R0");
// #X219 @PLACE(510, -480) => @ORIENT("R0");
// #X220 @PLACE(300, -515) => @ORIENT("R0");
// #X221 @PLACE(370, -515) => @ORIENT("R0");
// #X222 @PLACE(440, -515) => @ORIENT("R0");
// #X223 @PLACE(510, -515) => @ORIENT("R0");
// #X224 @PLACE(300, -550) => @ORIENT("R0");
// #X225 @PLACE(370, -550) => @ORIENT("R0");
// #X226 @PLACE(440, -550) => @ORIENT("R0");
// #X227 @PLACE(510, -550) => @ORIENT("R0");
// #X228 @PLACE(300, -585) => @ORIENT("R0");
// #X229 @PLACE(370, -585) => @ORIENT("R0");
// #X230 @PLACE(440, -585) => @ORIENT("R0");
// #X231 @PLACE(510, -585) => @ORIENT("R0");
// #X232 @PLACE(300, -620) => @ORIENT("R0");
// #X233 @PLACE(370, -620) => @ORIENT("R0");
// #X234 @PLACE(440, -620) => @ORIENT("R0");
// #X235 @PLACE(510, -620) => @ORIENT("R0");
// #X236 @PLACE(300, -655) => @ORIENT("R0");
// #X237 @PLACE(370, -655) => @ORIENT("R0");
// #X238 @PLACE(440, -655) => @ORIENT("R0");
// #X239 @PLACE(510, -655) => @ORIENT("R0");
// #X240 @PLACE(600, -480) => @ORIENT("R0");
// (575, -466) @TEXT("Panel 11 | X240 - X240", size=1.1, halign="start");
// %t1 = $IO_PORT @ATTACH &n26 => @PLACE(-11, 4) => @ORIENT("R0");
// %t1 @TEXT("n26", key="name", size=0.75);
// &n26 @WIRE(mode="straight") {#X0:1 %t1:p};
// %t2 = $IO_PORT @ATTACH &refclk => @PLACE(-11, 0) => @ORIENT("R0");
// %t2 @TEXT("refclk", key="name", size=0.75);
// &refclk @WIRE(mode="straight") {#X0:2 %t2:p};
// %t3 = $IO_PORT @ATTACH &reset => @PLACE(-11, -4) => @ORIENT("R0");
// %t3 @TEXT("reset", key="name", size=0.75);
// &reset @WIRE(mode="straight") {#X0:3 %t3:p};
// %t4 = $IO_PORT @ATTACH &invalid => @PLACE(11, 0) => @ORIENT("MY");
// %t4 @TEXT("invalid", key="name", size=0.75);
// &invalid @WIRE(mode="straight") {#X0:4 %t4:p};
// %t5 = $SUPPLY @ATTACH &vdd => @PLACE(0, 13);
// &vdd @WIRE(mode="straight") {#X0:5 %t5:p};
// %t6 = $GROUND @ATTACH &vss => @PLACE(0, -13);
// &vss @WIRE(mode="straight") {#X0:6 %t6:p};
// %t7 = $IO_PORT @ATTACH &n27 => @PLACE(59, 4) => @ORIENT("R0");
// %t7 @TEXT("n27", key="name", size=0.75);
// &n27 @WIRE(mode="straight") {#X1:1 %t7:p};
// %t8 = $IO_PORT @ATTACH &refclk => @PLACE(59, 0) => @ORIENT("R0");
// %t8 @TEXT("refclk", key="name", size=0.75);
// &refclk @WIRE(mode="straight") {#X1:2 %t8:p};
// %t9 = $IO_PORT @ATTACH &reset => @PLACE(59, -4) => @ORIENT("R0");
// %t9 @TEXT("reset", key="name", size=0.75);
// &reset @WIRE(mode="straight") {#X1:3 %t9:p};
// %t10 = $IO_PORT @ATTACH &ready => @PLACE(81, 0) => @ORIENT("MY");
// %t10 @TEXT("ready", key="name", size=0.75);
// &ready @WIRE(mode="straight") {#X1:4 %t10:p};
// %t11 = $SUPPLY @ATTACH &vdd => @PLACE(70, 13);
// &vdd @WIRE(mode="straight") {#X1:5 %t11:p};
// %t12 = $GROUND @ATTACH &vss => @PLACE(70, -13);
// &vss @WIRE(mode="straight") {#X1:6 %t12:p};
// %t13 = $IO_PORT @ATTACH &n28 => @PLACE(129, 4) => @ORIENT("R0");
// %t13 @TEXT("n28", key="name", size=0.75);
// &n28 @WIRE(mode="straight") {#X2:1 %t13:p};
// %t14 = $IO_PORT @ATTACH &refclk => @PLACE(129, 0) => @ORIENT("R0");
// %t14 @TEXT("refclk", key="name", size=0.75);
// &refclk @WIRE(mode="straight") {#X2:2 %t14:p};
// %t15 = $IO_PORT @ATTACH &reset => @PLACE(129, -4) => @ORIENT("R0");
// %t15 @TEXT("reset", key="name", size=0.75);
// &reset @WIRE(mode="straight") {#X2:3 %t15:p};
// %t16 = $IO_PORT @ATTACH &n29 => @PLACE(151, 0) => @ORIENT("MY");
// %t16 @TEXT("n29", key="name", size=0.75);
// &n29 @WIRE(mode="straight") {#X2:4 %t16:p};
// %t17 = $SUPPLY @ATTACH &vdd => @PLACE(140, 13);
// &vdd @WIRE(mode="straight") {#X2:5 %t17:p};
// %t18 = $GROUND @ATTACH &vss => @PLACE(140, -13);
// &vss @WIRE(mode="straight") {#X2:6 %t18:p};
// %t19 = $IO_PORT @ATTACH &n30 => @PLACE(199, 4) => @ORIENT("R0");
// %t19 @TEXT("n30", key="name", size=0.75);
// &n30 @WIRE(mode="straight") {#X3:1 %t19:p};
// %t20 = $IO_PORT @ATTACH &refclk => @PLACE(199, 0) => @ORIENT("R0");
// %t20 @TEXT("refclk", key="name", size=0.75);
// &refclk @WIRE(mode="straight") {#X3:2 %t20:p};
// %t21 = $IO_PORT @ATTACH &reset => @PLACE(199, -4) => @ORIENT("R0");
// %t21 @TEXT("reset", key="name", size=0.75);
// &reset @WIRE(mode="straight") {#X3:3 %t21:p};
// %t22 = $IO_PORT @ATTACH &n31 => @PLACE(221, 0) => @ORIENT("MY");
// %t22 @TEXT("n31", key="name", size=0.75);
// &n31 @WIRE(mode="straight") {#X3:4 %t22:p};
// %t23 = $SUPPLY @ATTACH &vdd => @PLACE(210, 13);
// &vdd @WIRE(mode="straight") {#X3:5 %t23:p};
// %t24 = $GROUND @ATTACH &vss => @PLACE(210, -13);
// &vss @WIRE(mode="straight") {#X3:6 %t24:p};
// %t25 = $IO_PORT @ATTACH &n32 => @PLACE(-11, -31) => @ORIENT("R0");
// %t25 @TEXT("n32", key="name", size=0.75);
// &n32 @WIRE(mode="straight") {#X4:1 %t25:p};
// %t26 = $IO_PORT @ATTACH &refclk => @PLACE(-11, -35) => @ORIENT("R0");
// %t26 @TEXT("refclk", key="name", size=0.75);
// &refclk @WIRE(mode="straight") {#X4:2 %t26:p};
// %t27 = $IO_PORT @ATTACH &reset => @PLACE(-11, -39) => @ORIENT("R0");
// %t27 @TEXT("reset", key="name", size=0.75);
// &reset @WIRE(mode="straight") {#X4:3 %t27:p};
// %t28 = $IO_PORT @ATTACH &n33 => @PLACE(11, -35) => @ORIENT("MY");
// %t28 @TEXT("n33", key="name", size=0.75);
// &n33 @WIRE(mode="straight") {#X4:4 %t28:p};
// %t29 = $SUPPLY @ATTACH &vdd => @PLACE(0, -22);
// &vdd @WIRE(mode="straight") {#X4:5 %t29:p};
// %t30 = $GROUND @ATTACH &vss => @PLACE(0, -48);
// &vss @WIRE(mode="straight") {#X4:6 %t30:p};
// %t31 = $IO_PORT @ATTACH &n34 => @PLACE(59, -31) => @ORIENT("R0");
// %t31 @TEXT("n34", key="name", size=0.75);
// &n34 @WIRE(mode="straight") {#X5:1 %t31:p};
// %t32 = $IO_PORT @ATTACH &refclk => @PLACE(59, -35) => @ORIENT("R0");
// %t32 @TEXT("refclk", key="name", size=0.75);
// &refclk @WIRE(mode="straight") {#X5:2 %t32:p};
// %t33 = $IO_PORT @ATTACH &reset => @PLACE(59, -39) => @ORIENT("R0");
// %t33 @TEXT("reset", key="name", size=0.75);
// &reset @WIRE(mode="straight") {#X5:3 %t33:p};
// %t34 = $IO_PORT @ATTACH &n35 => @PLACE(81, -35) => @ORIENT("MY");
// %t34 @TEXT("n35", key="name", size=0.75);
// &n35 @WIRE(mode="straight") {#X5:4 %t34:p};
// %t35 = $SUPPLY @ATTACH &vdd => @PLACE(70, -22);
// &vdd @WIRE(mode="straight") {#X5:5 %t35:p};
// %t36 = $GROUND @ATTACH &vss => @PLACE(70, -48);
// &vss @WIRE(mode="straight") {#X5:6 %t36:p};
// %t37 = $IO_PORT @ATTACH &n36 => @PLACE(129, -31) => @ORIENT("R0");
// %t37 @TEXT("n36", key="name", size=0.75);
// &n36 @WIRE(mode="straight") {#X6:1 %t37:p};
// %t38 = $IO_PORT @ATTACH &refclk => @PLACE(129, -35) => @ORIENT("R0");
// %t38 @TEXT("refclk", key="name", size=0.75);
// &refclk @WIRE(mode="straight") {#X6:2 %t38:p};
// %t39 = $IO_PORT @ATTACH &reset => @PLACE(129, -39) => @ORIENT("R0");
// %t39 @TEXT("reset", key="name", size=0.75);
// &reset @WIRE(mode="straight") {#X6:3 %t39:p};
// %t40 = $IO_PORT @ATTACH &n37 => @PLACE(151, -35) => @ORIENT("MY");
// %t40 @TEXT("n37", key="name", size=0.75);
// &n37 @WIRE(mode="straight") {#X6:4 %t40:p};
// %t41 = $SUPPLY @ATTACH &vdd => @PLACE(140, -22);
// &vdd @WIRE(mode="straight") {#X6:5 %t41:p};
// %t42 = $GROUND @ATTACH &vss => @PLACE(140, -48);
// &vss @WIRE(mode="straight") {#X6:6 %t42:p};
// %t43 = $IO_PORT @ATTACH &n38 => @PLACE(199, -31) => @ORIENT("R0");
// %t43 @TEXT("n38", key="name", size=0.75);
// &n38 @WIRE(mode="straight") {#X7:1 %t43:p};
// %t44 = $IO_PORT @ATTACH &refclk => @PLACE(199, -35) => @ORIENT("R0");
// %t44 @TEXT("refclk", key="name", size=0.75);
// &refclk @WIRE(mode="straight") {#X7:2 %t44:p};
// %t45 = $IO_PORT @ATTACH &reset => @PLACE(199, -39) => @ORIENT("R0");
// %t45 @TEXT("reset", key="name", size=0.75);
// &reset @WIRE(mode="straight") {#X7:3 %t45:p};
// %t46 = $IO_PORT @ATTACH &n39 => @PLACE(221, -35) => @ORIENT("MY");
// %t46 @TEXT("n39", key="name", size=0.75);
// &n39 @WIRE(mode="straight") {#X7:4 %t46:p};
// %t47 = $SUPPLY @ATTACH &vdd => @PLACE(210, -22);
// &vdd @WIRE(mode="straight") {#X7:5 %t47:p};
// %t48 = $GROUND @ATTACH &vss => @PLACE(210, -48);
// &vss @WIRE(mode="straight") {#X7:6 %t48:p};
// %t49 = $IO_PORT @ATTACH &n40 => @PLACE(-11, -66) => @ORIENT("R0");
// %t49 @TEXT("n40", key="name", size=0.75);
// &n40 @WIRE(mode="straight") {#X8:1 %t49:p};
// %t50 = $IO_PORT @ATTACH &refclk => @PLACE(-11, -70) => @ORIENT("R0");
// %t50 @TEXT("refclk", key="name", size=0.75);
// &refclk @WIRE(mode="straight") {#X8:2 %t50:p};
// %t51 = $IO_PORT @ATTACH &reset => @PLACE(-11, -74) => @ORIENT("R0");
// %t51 @TEXT("reset", key="name", size=0.75);
// &reset @WIRE(mode="straight") {#X8:3 %t51:p};
// %t52 = $IO_PORT @ATTACH &active_k0 => @PLACE(11, -70) => @ORIENT("MY");
// %t52 @TEXT("active_k0", key="name", size=0.75);
// &active_k0 @WIRE(mode="straight") {#X8:4 %t52:p};
// %t53 = $SUPPLY @ATTACH &vdd => @PLACE(0, -57);
// &vdd @WIRE(mode="straight") {#X8:5 %t53:p};
// %t54 = $GROUND @ATTACH &vss => @PLACE(0, -83);
// &vss @WIRE(mode="straight") {#X8:6 %t54:p};
// %t55 = $IO_PORT @ATTACH &n41 => @PLACE(59, -66) => @ORIENT("R0");
// %t55 @TEXT("n41", key="name", size=0.75);
// &n41 @WIRE(mode="straight") {#X9:1 %t55:p};
// %t56 = $IO_PORT @ATTACH &refclk => @PLACE(59, -70) => @ORIENT("R0");
// %t56 @TEXT("refclk", key="name", size=0.75);
// &refclk @WIRE(mode="straight") {#X9:2 %t56:p};
// %t57 = $IO_PORT @ATTACH &reset => @PLACE(59, -74) => @ORIENT("R0");
// %t57 @TEXT("reset", key="name", size=0.75);
// &reset @WIRE(mode="straight") {#X9:3 %t57:p};
// %t58 = $IO_PORT @ATTACH &active_k1 => @PLACE(81, -70) => @ORIENT("MY");
// %t58 @TEXT("active_k1", key="name", size=0.75);
// &active_k1 @WIRE(mode="straight") {#X9:4 %t58:p};
// %t59 = $SUPPLY @ATTACH &vdd => @PLACE(70, -57);
// &vdd @WIRE(mode="straight") {#X9:5 %t59:p};
// %t60 = $GROUND @ATTACH &vss => @PLACE(70, -83);
// &vss @WIRE(mode="straight") {#X9:6 %t60:p};
// %t61 = $IO_PORT @ATTACH &n42 => @PLACE(129, -66) => @ORIENT("R0");
// %t61 @TEXT("n42", key="name", size=0.75);
// &n42 @WIRE(mode="straight") {#X10:1 %t61:p};
// %t62 = $IO_PORT @ATTACH &refclk => @PLACE(129, -70) => @ORIENT("R0");
// %t62 @TEXT("refclk", key="name", size=0.75);
// &refclk @WIRE(mode="straight") {#X10:2 %t62:p};
// %t63 = $IO_PORT @ATTACH &reset => @PLACE(129, -74) => @ORIENT("R0");
// %t63 @TEXT("reset", key="name", size=0.75);
// &reset @WIRE(mode="straight") {#X10:3 %t63:p};
// %t64 = $IO_PORT @ATTACH &active_k2 => @PLACE(151, -70) => @ORIENT("MY");
// %t64 @TEXT("active_k2", key="name", size=0.75);
// &active_k2 @WIRE(mode="straight") {#X10:4 %t64:p};
// %t65 = $SUPPLY @ATTACH &vdd => @PLACE(140, -57);
// &vdd @WIRE(mode="straight") {#X10:5 %t65:p};
// %t66 = $GROUND @ATTACH &vss => @PLACE(140, -83);
// &vss @WIRE(mode="straight") {#X10:6 %t66:p};
// %t67 = $IO_PORT @ATTACH &n43 => @PLACE(199, -66) => @ORIENT("R0");
// %t67 @TEXT("n43", key="name", size=0.75);
// &n43 @WIRE(mode="straight") {#X11:1 %t67:p};
// %t68 = $IO_PORT @ATTACH &refclk => @PLACE(199, -70) => @ORIENT("R0");
// %t68 @TEXT("refclk", key="name", size=0.75);
// &refclk @WIRE(mode="straight") {#X11:2 %t68:p};
// %t69 = $IO_PORT @ATTACH &reset => @PLACE(199, -74) => @ORIENT("R0");
// %t69 @TEXT("reset", key="name", size=0.75);
// &reset @WIRE(mode="straight") {#X11:3 %t69:p};
// %t70 = $IO_PORT @ATTACH &active_k3 => @PLACE(221, -70) => @ORIENT("MY");
// %t70 @TEXT("active_k3", key="name", size=0.75);
// &active_k3 @WIRE(mode="straight") {#X11:4 %t70:p};
// %t71 = $SUPPLY @ATTACH &vdd => @PLACE(210, -57);
// &vdd @WIRE(mode="straight") {#X11:5 %t71:p};
// %t72 = $GROUND @ATTACH &vss => @PLACE(210, -83);
// &vss @WIRE(mode="straight") {#X11:6 %t72:p};
// %t73 = $IO_PORT @ATTACH &n44 => @PLACE(-11, -101) => @ORIENT("R0");
// %t73 @TEXT("n44", key="name", size=0.75);
// &n44 @WIRE(mode="straight") {#X12:1 %t73:p};
// %t74 = $IO_PORT @ATTACH &refclk => @PLACE(-11, -105) => @ORIENT("R0");
// %t74 @TEXT("refclk", key="name", size=0.75);
// &refclk @WIRE(mode="straight") {#X12:2 %t74:p};
// %t75 = $IO_PORT @ATTACH &reset => @PLACE(-11, -109) => @ORIENT("R0");
// %t75 @TEXT("reset", key="name", size=0.75);
// &reset @WIRE(mode="straight") {#X12:3 %t75:p};
// %t76 = $IO_PORT @ATTACH &active_k4 => @PLACE(11, -105) => @ORIENT("MY");
// %t76 @TEXT("active_k4", key="name", size=0.75);
// &active_k4 @WIRE(mode="straight") {#X12:4 %t76:p};
// %t77 = $SUPPLY @ATTACH &vdd => @PLACE(0, -92);
// &vdd @WIRE(mode="straight") {#X12:5 %t77:p};
// %t78 = $GROUND @ATTACH &vss => @PLACE(0, -118);
// &vss @WIRE(mode="straight") {#X12:6 %t78:p};
// %t79 = $IO_PORT @ATTACH &n45 => @PLACE(59, -101) => @ORIENT("R0");
// %t79 @TEXT("n45", key="name", size=0.75);
// &n45 @WIRE(mode="straight") {#X13:1 %t79:p};
// %t80 = $IO_PORT @ATTACH &refclk => @PLACE(59, -105) => @ORIENT("R0");
// %t80 @TEXT("refclk", key="name", size=0.75);
// &refclk @WIRE(mode="straight") {#X13:2 %t80:p};
// %t81 = $IO_PORT @ATTACH &reset => @PLACE(59, -109) => @ORIENT("R0");
// %t81 @TEXT("reset", key="name", size=0.75);
// &reset @WIRE(mode="straight") {#X13:3 %t81:p};
// %t82 = $IO_PORT @ATTACH &active_k5 => @PLACE(81, -105) => @ORIENT("MY");
// %t82 @TEXT("active_k5", key="name", size=0.75);
// &active_k5 @WIRE(mode="straight") {#X13:4 %t82:p};
// %t83 = $SUPPLY @ATTACH &vdd => @PLACE(70, -92);
// &vdd @WIRE(mode="straight") {#X13:5 %t83:p};
// %t84 = $GROUND @ATTACH &vss => @PLACE(70, -118);
// &vss @WIRE(mode="straight") {#X13:6 %t84:p};
// %t85 = $IO_PORT @ATTACH &n46 => @PLACE(129, -101) => @ORIENT("R0");
// %t85 @TEXT("n46", key="name", size=0.75);
// &n46 @WIRE(mode="straight") {#X14:1 %t85:p};
// %t86 = $IO_PORT @ATTACH &refclk => @PLACE(129, -105) => @ORIENT("R0");
// %t86 @TEXT("refclk", key="name", size=0.75);
// &refclk @WIRE(mode="straight") {#X14:2 %t86:p};
// %t87 = $IO_PORT @ATTACH &reset => @PLACE(129, -109) => @ORIENT("R0");
// %t87 @TEXT("reset", key="name", size=0.75);
// &reset @WIRE(mode="straight") {#X14:3 %t87:p};
// %t88 = $IO_PORT @ATTACH &n47 => @PLACE(151, -105) => @ORIENT("MY");
// %t88 @TEXT("n47", key="name", size=0.75);
// &n47 @WIRE(mode="straight") {#X14:4 %t88:p};
// %t89 = $SUPPLY @ATTACH &vdd => @PLACE(140, -92);
// &vdd @WIRE(mode="straight") {#X14:5 %t89:p};
// %t90 = $GROUND @ATTACH &vss => @PLACE(140, -118);
// &vss @WIRE(mode="straight") {#X14:6 %t90:p};
// %t91 = $IO_PORT @ATTACH &n48 => @PLACE(199, -101) => @ORIENT("R0");
// %t91 @TEXT("n48", key="name", size=0.75);
// &n48 @WIRE(mode="straight") {#X15:1 %t91:p};
// %t92 = $IO_PORT @ATTACH &refclk => @PLACE(199, -105) => @ORIENT("R0");
// %t92 @TEXT("refclk", key="name", size=0.75);
// &refclk @WIRE(mode="straight") {#X15:2 %t92:p};
// %t93 = $IO_PORT @ATTACH &reset => @PLACE(199, -109) => @ORIENT("R0");
// %t93 @TEXT("reset", key="name", size=0.75);
// &reset @WIRE(mode="straight") {#X15:3 %t93:p};
// %t94 = $IO_PORT @ATTACH &n49 => @PLACE(221, -105) => @ORIENT("MY");
// %t94 @TEXT("n49", key="name", size=0.75);
// &n49 @WIRE(mode="straight") {#X15:4 %t94:p};
// %t95 = $SUPPLY @ATTACH &vdd => @PLACE(210, -92);
// &vdd @WIRE(mode="straight") {#X15:5 %t95:p};
// %t96 = $GROUND @ATTACH &vss => @PLACE(210, -118);
// &vss @WIRE(mode="straight") {#X15:6 %t96:p};
// %t97 = $IO_PORT @ATTACH &n50 => @PLACE(-11, -136) => @ORIENT("R0");
// %t97 @TEXT("n50", key="name", size=0.75);
// &n50 @WIRE(mode="straight") {#X16:1 %t97:p};
// %t98 = $IO_PORT @ATTACH &refclk => @PLACE(-11, -140) => @ORIENT("R0");
// %t98 @TEXT("refclk", key="name", size=0.75);
// &refclk @WIRE(mode="straight") {#X16:2 %t98:p};
// %t99 = $IO_PORT @ATTACH &reset => @PLACE(-11, -144) => @ORIENT("R0");
// %t99 @TEXT("reset", key="name", size=0.75);
// &reset @WIRE(mode="straight") {#X16:3 %t99:p};
// %t100 = $IO_PORT @ATTACH &n51 => @PLACE(11, -140) => @ORIENT("MY");
// %t100 @TEXT("n51", key="name", size=0.75);
// &n51 @WIRE(mode="straight") {#X16:4 %t100:p};
// %t101 = $SUPPLY @ATTACH &vdd => @PLACE(0, -127);
// &vdd @WIRE(mode="straight") {#X16:5 %t101:p};
// %t102 = $GROUND @ATTACH &vss => @PLACE(0, -153);
// &vss @WIRE(mode="straight") {#X16:6 %t102:p};
// %t103 = $IO_PORT @ATTACH &n52 => @PLACE(59, -136) => @ORIENT("R0");
// %t103 @TEXT("n52", key="name", size=0.75);
// &n52 @WIRE(mode="straight") {#X17:1 %t103:p};
// %t104 = $IO_PORT @ATTACH &refclk => @PLACE(59, -140) => @ORIENT("R0");
// %t104 @TEXT("refclk", key="name", size=0.75);
// &refclk @WIRE(mode="straight") {#X17:2 %t104:p};
// %t105 = $IO_PORT @ATTACH &reset => @PLACE(59, -144) => @ORIENT("R0");
// %t105 @TEXT("reset", key="name", size=0.75);
// &reset @WIRE(mode="straight") {#X17:3 %t105:p};
// %t106 = $IO_PORT @ATTACH &n53 => @PLACE(81, -140) => @ORIENT("MY");
// %t106 @TEXT("n53", key="name", size=0.75);
// &n53 @WIRE(mode="straight") {#X17:4 %t106:p};
// %t107 = $SUPPLY @ATTACH &vdd => @PLACE(70, -127);
// &vdd @WIRE(mode="straight") {#X17:5 %t107:p};
// %t108 = $GROUND @ATTACH &vss => @PLACE(70, -153);
// &vss @WIRE(mode="straight") {#X17:6 %t108:p};
// %t109 = $IO_PORT @ATTACH &apply => @PLACE(129, -136) => @ORIENT("R0");
// %t109 @TEXT("apply", key="name", size=0.75);
// &apply @WIRE(mode="straight") {#X18:1 %t109:p};
// %t110 = $IO_PORT @ATTACH &refclk => @PLACE(129, -140) => @ORIENT("R0");
// %t110 @TEXT("refclk", key="name", size=0.75);
// &refclk @WIRE(mode="straight") {#X18:2 %t110:p};
// %t111 = $IO_PORT @ATTACH &reset => @PLACE(129, -144) => @ORIENT("R0");
// %t111 @TEXT("reset", key="name", size=0.75);
// &reset @WIRE(mode="straight") {#X18:3 %t111:p};
// %t112 = $IO_PORT @ATTACH &n54 => @PLACE(151, -140) => @ORIENT("MY");
// %t112 @TEXT("n54", key="name", size=0.75);
// &n54 @WIRE(mode="straight") {#X18:4 %t112:p};
// %t113 = $SUPPLY @ATTACH &vdd => @PLACE(140, -127);
// &vdd @WIRE(mode="straight") {#X18:5 %t113:p};
// %t114 = $GROUND @ATTACH &vss => @PLACE(140, -153);
// &vss @WIRE(mode="straight") {#X18:6 %t114:p};
// %t115 = $IO_PORT @ATTACH &n54 => @PLACE(199, -136) => @ORIENT("R0");
// %t115 @TEXT("n54", key="name", size=0.75);
// &n54 @WIRE(mode="straight") {#X19:1 %t115:p};
// %t116 = $IO_PORT @ATTACH &refclk => @PLACE(199, -140) => @ORIENT("R0");
// %t116 @TEXT("refclk", key="name", size=0.75);
// &refclk @WIRE(mode="straight") {#X19:2 %t116:p};
// %t117 = $IO_PORT @ATTACH &reset => @PLACE(199, -144) => @ORIENT("R0");
// %t117 @TEXT("reset", key="name", size=0.75);
// &reset @WIRE(mode="straight") {#X19:3 %t117:p};
// %t118 = $IO_PORT @ATTACH &n55 => @PLACE(221, -140) => @ORIENT("MY");
// %t118 @TEXT("n55", key="name", size=0.75);
// &n55 @WIRE(mode="straight") {#X19:4 %t118:p};
// %t119 = $SUPPLY @ATTACH &vdd => @PLACE(210, -127);
// &vdd @WIRE(mode="straight") {#X19:5 %t119:p};
// %t120 = $GROUND @ATTACH &vss => @PLACE(210, -153);
// &vss @WIRE(mode="straight") {#X19:6 %t120:p};
// %t121 = $IO_PORT @ATTACH &n55 => @PLACE(-11, -171) => @ORIENT("R0");
// %t121 @TEXT("n55", key="name", size=0.75);
// &n55 @WIRE(mode="straight") {#X20:1 %t121:p};
// %t122 = $IO_PORT @ATTACH &refclk => @PLACE(-11, -175) => @ORIENT("R0");
// %t122 @TEXT("refclk", key="name", size=0.75);
// &refclk @WIRE(mode="straight") {#X20:2 %t122:p};
// %t123 = $IO_PORT @ATTACH &reset => @PLACE(-11, -179) => @ORIENT("R0");
// %t123 @TEXT("reset", key="name", size=0.75);
// &reset @WIRE(mode="straight") {#X20:3 %t123:p};
// %t124 = $IO_PORT @ATTACH &n56 => @PLACE(11, -175) => @ORIENT("MY");
// %t124 @TEXT("n56", key="name", size=0.75);
// &n56 @WIRE(mode="straight") {#X20:4 %t124:p};
// %t125 = $SUPPLY @ATTACH &vdd => @PLACE(0, -162);
// &vdd @WIRE(mode="straight") {#X20:5 %t125:p};
// %t126 = $GROUND @ATTACH &vss => @PLACE(0, -188);
// &vss @WIRE(mode="straight") {#X20:6 %t126:p};
// %t127 = $IO_PORT @ATTACH &n57 => @PLACE(59, -171) => @ORIENT("R0");
// %t127 @TEXT("n57", key="name", size=0.75);
// &n57 @WIRE(mode="straight") {#X21:1 %t127:p};
// %t128 = $IO_PORT @ATTACH &refclk => @PLACE(59, -175) => @ORIENT("R0");
// %t128 @TEXT("refclk", key="name", size=0.75);
// &refclk @WIRE(mode="straight") {#X21:2 %t128:p};
// %t129 = $IO_PORT @ATTACH &reset => @PLACE(59, -179) => @ORIENT("R0");
// %t129 @TEXT("reset", key="name", size=0.75);
// &reset @WIRE(mode="straight") {#X21:3 %t129:p};
// %t130 = $IO_PORT @ATTACH &n58 => @PLACE(81, -175) => @ORIENT("MY");
// %t130 @TEXT("n58", key="name", size=0.75);
// &n58 @WIRE(mode="straight") {#X21:4 %t130:p};
// %t131 = $SUPPLY @ATTACH &vdd => @PLACE(70, -162);
// &vdd @WIRE(mode="straight") {#X21:5 %t131:p};
// %t132 = $GROUND @ATTACH &vss => @PLACE(70, -188);
// &vss @WIRE(mode="straight") {#X21:6 %t132:p};
// %t133 = $IO_PORT @ATTACH &n51 => @PLACE(129, -171) => @ORIENT("R0");
// %t133 @TEXT("n51", key="name", size=0.75);
// &n51 @WIRE(mode="straight") {#X22:1 %t133:p};
// %t134 = $IO_PORT @ATTACH &n59 => @PLACE(129, -175) => @ORIENT("R0");
// %t134 @TEXT("n59", key="name", size=0.75);
// &n59 @WIRE(mode="straight") {#X22:2 %t134:p};
// %t135 = $IO_PORT @ATTACH &n60 => @PLACE(129, -179) => @ORIENT("R0");
// %t135 @TEXT("n60", key="name", size=0.75);
// &n60 @WIRE(mode="straight") {#X22:3 %t135:p};
// %t136 = $IO_PORT @ATTACH &n50 => @PLACE(151, -175) => @ORIENT("MY");
// %t136 @TEXT("n50", key="name", size=0.75);
// &n50 @WIRE(mode="straight") {#X22:4 %t136:p};
// %t137 = $SUPPLY @ATTACH &vdd => @PLACE(140, -162);
// &vdd @WIRE(mode="straight") {#X22:5 %t137:p};
// %t138 = $GROUND @ATTACH &vss => @PLACE(140, -188);
// &vss @WIRE(mode="straight") {#X22:6 %t138:p};
// %t139 = $IO_PORT @ATTACH &n49 => @PLACE(199, -171) => @ORIENT("R0");
// %t139 @TEXT("n49", key="name", size=0.75);
// &n49 @WIRE(mode="straight") {#X23:1 %t139:p};
// %t140 = $IO_PORT @ATTACH &n61 => @PLACE(199, -175) => @ORIENT("R0");
// %t140 @TEXT("n61", key="name", size=0.75);
// &n61 @WIRE(mode="straight") {#X23:2 %t140:p};
// %t141 = $IO_PORT @ATTACH &n60 => @PLACE(199, -179) => @ORIENT("R0");
// %t141 @TEXT("n60", key="name", size=0.75);
// &n60 @WIRE(mode="straight") {#X23:3 %t141:p};
// %t142 = $IO_PORT @ATTACH &n48 => @PLACE(221, -175) => @ORIENT("MY");
// %t142 @TEXT("n48", key="name", size=0.75);
// &n48 @WIRE(mode="straight") {#X23:4 %t142:p};
// %t143 = $SUPPLY @ATTACH &vdd => @PLACE(210, -162);
// &vdd @WIRE(mode="straight") {#X23:5 %t143:p};
// %t144 = $GROUND @ATTACH &vss => @PLACE(210, -188);
// &vss @WIRE(mode="straight") {#X23:6 %t144:p};
// %t145 = $IO_PORT @ATTACH &n47 => @PLACE(289, 4) => @ORIENT("R0");
// %t145 @TEXT("n47", key="name", size=0.75);
// &n47 @WIRE(mode="straight") {#X24:1 %t145:p};
// %t146 = $IO_PORT @ATTACH &n62 => @PLACE(289, 0) => @ORIENT("R0");
// %t146 @TEXT("n62", key="name", size=0.75);
// &n62 @WIRE(mode="straight") {#X24:2 %t146:p};
// %t147 = $IO_PORT @ATTACH &n60 => @PLACE(289, -4) => @ORIENT("R0");
// %t147 @TEXT("n60", key="name", size=0.75);
// &n60 @WIRE(mode="straight") {#X24:3 %t147:p};
// %t148 = $IO_PORT @ATTACH &n46 => @PLACE(311, 0) => @ORIENT("MY");
// %t148 @TEXT("n46", key="name", size=0.75);
// &n46 @WIRE(mode="straight") {#X24:4 %t148:p};
// %t149 = $SUPPLY @ATTACH &vdd => @PLACE(300, 13);
// &vdd @WIRE(mode="straight") {#X24:5 %t149:p};
// %t150 = $GROUND @ATTACH &vss => @PLACE(300, -13);
// &vss @WIRE(mode="straight") {#X24:6 %t150:p};
// %t151 = $IO_PORT @ATTACH &active_k4 => @PLACE(359, 4) => @ORIENT("R0");
// %t151 @TEXT("active_k4", key="name", size=0.75);
// &active_k4 @WIRE(mode="straight") {#X25:1 %t151:p};
// %t152 = $IO_PORT @ATTACH &n37 => @PLACE(359, 0) => @ORIENT("R0");
// %t152 @TEXT("n37", key="name", size=0.75);
// &n37 @WIRE(mode="straight") {#X25:2 %t152:p};
// %t153 = $IO_PORT @ATTACH &n63 => @PLACE(359, -4) => @ORIENT("R0");
// %t153 @TEXT("n63", key="name", size=0.75);
// &n63 @WIRE(mode="straight") {#X25:3 %t153:p};
// %t154 = $IO_PORT @ATTACH &n44 => @PLACE(381, 0) => @ORIENT("MY");
// %t154 @TEXT("n44", key="name", size=0.75);
// &n44 @WIRE(mode="straight") {#X25:4 %t154:p};
// %t155 = $SUPPLY @ATTACH &vdd => @PLACE(370, 13);
// &vdd @WIRE(mode="straight") {#X25:5 %t155:p};
// %t156 = $GROUND @ATTACH &vss => @PLACE(370, -13);
// &vss @WIRE(mode="straight") {#X25:6 %t156:p};
// %t157 = $IO_PORT @ATTACH &active_k3 => @PLACE(429, 4) => @ORIENT("R0");
// %t157 @TEXT("active_k3", key="name", size=0.75);
// &active_k3 @WIRE(mode="straight") {#X26:1 %t157:p};
// %t158 = $IO_PORT @ATTACH &n35 => @PLACE(429, 0) => @ORIENT("R0");
// %t158 @TEXT("n35", key="name", size=0.75);
// &n35 @WIRE(mode="straight") {#X26:2 %t158:p};
// %t159 = $IO_PORT @ATTACH &n63 => @PLACE(429, -4) => @ORIENT("R0");
// %t159 @TEXT("n63", key="name", size=0.75);
// &n63 @WIRE(mode="straight") {#X26:3 %t159:p};
// %t160 = $IO_PORT @ATTACH &n43 => @PLACE(451, 0) => @ORIENT("MY");
// %t160 @TEXT("n43", key="name", size=0.75);
// &n43 @WIRE(mode="straight") {#X26:4 %t160:p};
// %t161 = $SUPPLY @ATTACH &vdd => @PLACE(440, 13);
// &vdd @WIRE(mode="straight") {#X26:5 %t161:p};
// %t162 = $GROUND @ATTACH &vss => @PLACE(440, -13);
// &vss @WIRE(mode="straight") {#X26:6 %t162:p};
// %t163 = $IO_PORT @ATTACH &active_k2 => @PLACE(499, 4) => @ORIENT("R0");
// %t163 @TEXT("active_k2", key="name", size=0.75);
// &active_k2 @WIRE(mode="straight") {#X27:1 %t163:p};
// %t164 = $IO_PORT @ATTACH &n33 => @PLACE(499, 0) => @ORIENT("R0");
// %t164 @TEXT("n33", key="name", size=0.75);
// &n33 @WIRE(mode="straight") {#X27:2 %t164:p};
// %t165 = $IO_PORT @ATTACH &n63 => @PLACE(499, -4) => @ORIENT("R0");
// %t165 @TEXT("n63", key="name", size=0.75);
// &n63 @WIRE(mode="straight") {#X27:3 %t165:p};
// %t166 = $IO_PORT @ATTACH &n42 => @PLACE(521, 0) => @ORIENT("MY");
// %t166 @TEXT("n42", key="name", size=0.75);
// &n42 @WIRE(mode="straight") {#X27:4 %t166:p};
// %t167 = $SUPPLY @ATTACH &vdd => @PLACE(510, 13);
// &vdd @WIRE(mode="straight") {#X27:5 %t167:p};
// %t168 = $GROUND @ATTACH &vss => @PLACE(510, -13);
// &vss @WIRE(mode="straight") {#X27:6 %t168:p};
// %t169 = $IO_PORT @ATTACH &active_k1 => @PLACE(289, -31) => @ORIENT("R0");
// %t169 @TEXT("active_k1", key="name", size=0.75);
// &active_k1 @WIRE(mode="straight") {#X28:1 %t169:p};
// %t170 = $IO_PORT @ATTACH &n31 => @PLACE(289, -35) => @ORIENT("R0");
// %t170 @TEXT("n31", key="name", size=0.75);
// &n31 @WIRE(mode="straight") {#X28:2 %t170:p};
// %t171 = $IO_PORT @ATTACH &n63 => @PLACE(289, -39) => @ORIENT("R0");
// %t171 @TEXT("n63", key="name", size=0.75);
// &n63 @WIRE(mode="straight") {#X28:3 %t171:p};
// %t172 = $IO_PORT @ATTACH &n41 => @PLACE(311, -35) => @ORIENT("MY");
// %t172 @TEXT("n41", key="name", size=0.75);
// &n41 @WIRE(mode="straight") {#X28:4 %t172:p};
// %t173 = $SUPPLY @ATTACH &vdd => @PLACE(300, -22);
// &vdd @WIRE(mode="straight") {#X28:5 %t173:p};
// %t174 = $GROUND @ATTACH &vss => @PLACE(300, -48);
// &vss @WIRE(mode="straight") {#X28:6 %t174:p};
// %t175 = $IO_PORT @ATTACH &active_k0 => @PLACE(359, -31) => @ORIENT("R0");
// %t175 @TEXT("active_k0", key="name", size=0.75);
// &active_k0 @WIRE(mode="straight") {#X29:1 %t175:p};
// %t176 = $IO_PORT @ATTACH &n29 => @PLACE(359, -35) => @ORIENT("R0");
// %t176 @TEXT("n29", key="name", size=0.75);
// &n29 @WIRE(mode="straight") {#X29:2 %t176:p};
// %t177 = $IO_PORT @ATTACH &n63 => @PLACE(359, -39) => @ORIENT("R0");
// %t177 @TEXT("n63", key="name", size=0.75);
// &n63 @WIRE(mode="straight") {#X29:3 %t177:p};
// %t178 = $IO_PORT @ATTACH &n40 => @PLACE(381, -35) => @ORIENT("MY");
// %t178 @TEXT("n40", key="name", size=0.75);
// &n40 @WIRE(mode="straight") {#X29:4 %t178:p};
// %t179 = $SUPPLY @ATTACH &vdd => @PLACE(370, -22);
// &vdd @WIRE(mode="straight") {#X29:5 %t179:p};
// %t180 = $GROUND @ATTACH &vss => @PLACE(370, -48);
// &vss @WIRE(mode="straight") {#X29:6 %t180:p};
// %t181 = $IO_PORT @ATTACH &n37 => @PLACE(429, -31) => @ORIENT("R0");
// %t181 @TEXT("n37", key="name", size=0.75);
// &n37 @WIRE(mode="straight") {#X30:1 %t181:p};
// %t182 = $IO_PORT @ATTACH &cfg_k4 => @PLACE(429, -35) => @ORIENT("R0");
// %t182 @TEXT("cfg_k4", key="name", size=0.75);
// &cfg_k4 @WIRE(mode="straight") {#X30:2 %t182:p};
// %t183 = $IO_PORT @ATTACH &n64 => @PLACE(429, -39) => @ORIENT("R0");
// %t183 @TEXT("n64", key="name", size=0.75);
// &n64 @WIRE(mode="straight") {#X30:3 %t183:p};
// %t184 = $IO_PORT @ATTACH &n36 => @PLACE(451, -35) => @ORIENT("MY");
// %t184 @TEXT("n36", key="name", size=0.75);
// &n36 @WIRE(mode="straight") {#X30:4 %t184:p};
// %t185 = $SUPPLY @ATTACH &vdd => @PLACE(440, -22);
// &vdd @WIRE(mode="straight") {#X30:5 %t185:p};
// %t186 = $GROUND @ATTACH &vss => @PLACE(440, -48);
// &vss @WIRE(mode="straight") {#X30:6 %t186:p};
// %t187 = $IO_PORT @ATTACH &n35 => @PLACE(499, -31) => @ORIENT("R0");
// %t187 @TEXT("n35", key="name", size=0.75);
// &n35 @WIRE(mode="straight") {#X31:1 %t187:p};
// %t188 = $IO_PORT @ATTACH &cfg_k3 => @PLACE(499, -35) => @ORIENT("R0");
// %t188 @TEXT("cfg_k3", key="name", size=0.75);
// &cfg_k3 @WIRE(mode="straight") {#X31:2 %t188:p};
// %t189 = $IO_PORT @ATTACH &n64 => @PLACE(499, -39) => @ORIENT("R0");
// %t189 @TEXT("n64", key="name", size=0.75);
// &n64 @WIRE(mode="straight") {#X31:3 %t189:p};
// %t190 = $IO_PORT @ATTACH &n34 => @PLACE(521, -35) => @ORIENT("MY");
// %t190 @TEXT("n34", key="name", size=0.75);
// &n34 @WIRE(mode="straight") {#X31:4 %t190:p};
// %t191 = $SUPPLY @ATTACH &vdd => @PLACE(510, -22);
// &vdd @WIRE(mode="straight") {#X31:5 %t191:p};
// %t192 = $GROUND @ATTACH &vss => @PLACE(510, -48);
// &vss @WIRE(mode="straight") {#X31:6 %t192:p};
// %t193 = $IO_PORT @ATTACH &n33 => @PLACE(289, -66) => @ORIENT("R0");
// %t193 @TEXT("n33", key="name", size=0.75);
// &n33 @WIRE(mode="straight") {#X32:1 %t193:p};
// %t194 = $IO_PORT @ATTACH &cfg_k2 => @PLACE(289, -70) => @ORIENT("R0");
// %t194 @TEXT("cfg_k2", key="name", size=0.75);
// &cfg_k2 @WIRE(mode="straight") {#X32:2 %t194:p};
// %t195 = $IO_PORT @ATTACH &n64 => @PLACE(289, -74) => @ORIENT("R0");
// %t195 @TEXT("n64", key="name", size=0.75);
// &n64 @WIRE(mode="straight") {#X32:3 %t195:p};
// %t196 = $IO_PORT @ATTACH &n32 => @PLACE(311, -70) => @ORIENT("MY");
// %t196 @TEXT("n32", key="name", size=0.75);
// &n32 @WIRE(mode="straight") {#X32:4 %t196:p};
// %t197 = $SUPPLY @ATTACH &vdd => @PLACE(300, -57);
// &vdd @WIRE(mode="straight") {#X32:5 %t197:p};
// %t198 = $GROUND @ATTACH &vss => @PLACE(300, -83);
// &vss @WIRE(mode="straight") {#X32:6 %t198:p};
// %t199 = $IO_PORT @ATTACH &n31 => @PLACE(359, -66) => @ORIENT("R0");
// %t199 @TEXT("n31", key="name", size=0.75);
// &n31 @WIRE(mode="straight") {#X33:1 %t199:p};
// %t200 = $IO_PORT @ATTACH &cfg_k1 => @PLACE(359, -70) => @ORIENT("R0");
// %t200 @TEXT("cfg_k1", key="name", size=0.75);
// &cfg_k1 @WIRE(mode="straight") {#X33:2 %t200:p};
// %t201 = $IO_PORT @ATTACH &n64 => @PLACE(359, -74) => @ORIENT("R0");
// %t201 @TEXT("n64", key="name", size=0.75);
// &n64 @WIRE(mode="straight") {#X33:3 %t201:p};
// %t202 = $IO_PORT @ATTACH &n30 => @PLACE(381, -70) => @ORIENT("MY");
// %t202 @TEXT("n30", key="name", size=0.75);
// &n30 @WIRE(mode="straight") {#X33:4 %t202:p};
// %t203 = $SUPPLY @ATTACH &vdd => @PLACE(370, -57);
// &vdd @WIRE(mode="straight") {#X33:5 %t203:p};
// %t204 = $GROUND @ATTACH &vss => @PLACE(370, -83);
// &vss @WIRE(mode="straight") {#X33:6 %t204:p};
// %t205 = $IO_PORT @ATTACH &n29 => @PLACE(429, -66) => @ORIENT("R0");
// %t205 @TEXT("n29", key="name", size=0.75);
// &n29 @WIRE(mode="straight") {#X34:1 %t205:p};
// %t206 = $IO_PORT @ATTACH &cfg_k0 => @PLACE(429, -70) => @ORIENT("R0");
// %t206 @TEXT("cfg_k0", key="name", size=0.75);
// &cfg_k0 @WIRE(mode="straight") {#X34:2 %t206:p};
// %t207 = $IO_PORT @ATTACH &n64 => @PLACE(429, -74) => @ORIENT("R0");
// %t207 @TEXT("n64", key="name", size=0.75);
// &n64 @WIRE(mode="straight") {#X34:3 %t207:p};
// %t208 = $IO_PORT @ATTACH &n28 => @PLACE(451, -70) => @ORIENT("MY");
// %t208 @TEXT("n28", key="name", size=0.75);
// &n28 @WIRE(mode="straight") {#X34:4 %t208:p};
// %t209 = $SUPPLY @ATTACH &vdd => @PLACE(440, -57);
// &vdd @WIRE(mode="straight") {#X34:5 %t209:p};
// %t210 = $GROUND @ATTACH &vss => @PLACE(440, -83);
// &vss @WIRE(mode="straight") {#X34:6 %t210:p};
// %t211 = $IO_PORT @ATTACH &invalid => @PLACE(499, -66) => @ORIENT("R0");
// %t211 @TEXT("invalid", key="name", size=0.75);
// &invalid @WIRE(mode="straight") {#X35:1 %t211:p};
// %t212 = $IO_PORT @ATTACH &n65 => @PLACE(499, -70) => @ORIENT("R0");
// %t212 @TEXT("n65", key="name", size=0.75);
// &n65 @WIRE(mode="straight") {#X35:2 %t212:p};
// %t213 = $IO_PORT @ATTACH &n66 => @PLACE(499, -74) => @ORIENT("R0");
// %t213 @TEXT("n66", key="name", size=0.75);
// &n66 @WIRE(mode="straight") {#X35:3 %t213:p};
// %t214 = $IO_PORT @ATTACH &n26 => @PLACE(521, -70) => @ORIENT("MY");
// %t214 @TEXT("n26", key="name", size=0.75);
// &n26 @WIRE(mode="straight") {#X35:4 %t214:p};
// %t215 = $SUPPLY @ATTACH &vdd => @PLACE(510, -57);
// &vdd @WIRE(mode="straight") {#X35:5 %t215:p};
// %t216 = $GROUND @ATTACH &vss => @PLACE(510, -83);
// &vss @WIRE(mode="straight") {#X35:6 %t216:p};
// %t217 = $IO_PORT @ATTACH &ready => @PLACE(289, -101) => @ORIENT("R0");
// %t217 @TEXT("ready", key="name", size=0.75);
// &ready @WIRE(mode="straight") {#X36:1 %t217:p};
// %t218 = $IO_PORT @ATTACH &n67 => @PLACE(289, -105) => @ORIENT("R0");
// %t218 @TEXT("n67", key="name", size=0.75);
// &n67 @WIRE(mode="straight") {#X36:2 %t218:p};
// %t219 = $IO_PORT @ATTACH &n66 => @PLACE(289, -109) => @ORIENT("R0");
// %t219 @TEXT("n66", key="name", size=0.75);
// &n66 @WIRE(mode="straight") {#X36:3 %t219:p};
// %t220 = $IO_PORT @ATTACH &n27 => @PLACE(311, -105) => @ORIENT("MY");
// %t220 @TEXT("n27", key="name", size=0.75);
// &n27 @WIRE(mode="straight") {#X36:4 %t220:p};
// %t221 = $SUPPLY @ATTACH &vdd => @PLACE(300, -92);
// &vdd @WIRE(mode="straight") {#X36:5 %t221:p};
// %t222 = $GROUND @ATTACH &vss => @PLACE(300, -118);
// &vss @WIRE(mode="straight") {#X36:6 %t222:p};
// %t223 = $IO_PORT @ATTACH &n39 => @PLACE(359, -101) => @ORIENT("R0");
// %t223 @TEXT("n39", key="name", size=0.75);
// &n39 @WIRE(mode="straight") {#X37:1 %t223:p};
// %t224 = $IO_PORT @ATTACH &cfg_k5 => @PLACE(359, -105) => @ORIENT("R0");
// %t224 @TEXT("cfg_k5", key="name", size=0.75);
// &cfg_k5 @WIRE(mode="straight") {#X37:2 %t224:p};
// %t225 = $IO_PORT @ATTACH &n64 => @PLACE(359, -109) => @ORIENT("R0");
// %t225 @TEXT("n64", key="name", size=0.75);
// &n64 @WIRE(mode="straight") {#X37:3 %t225:p};
// %t226 = $IO_PORT @ATTACH &n38 => @PLACE(381, -105) => @ORIENT("MY");
// %t226 @TEXT("n38", key="name", size=0.75);
// &n38 @WIRE(mode="straight") {#X37:4 %t226:p};
// %t227 = $SUPPLY @ATTACH &vdd => @PLACE(370, -92);
// &vdd @WIRE(mode="straight") {#X37:5 %t227:p};
// %t228 = $GROUND @ATTACH &vss => @PLACE(370, -118);
// &vss @WIRE(mode="straight") {#X37:6 %t228:p};
// %t229 = $IO_PORT @ATTACH &active_k5 => @PLACE(429, -101) => @ORIENT("R0");
// %t229 @TEXT("active_k5", key="name", size=0.75);
// &active_k5 @WIRE(mode="straight") {#X38:1 %t229:p};
// %t230 = $IO_PORT @ATTACH &n39 => @PLACE(429, -105) => @ORIENT("R0");
// %t230 @TEXT("n39", key="name", size=0.75);
// &n39 @WIRE(mode="straight") {#X38:2 %t230:p};
// %t231 = $IO_PORT @ATTACH &n63 => @PLACE(429, -109) => @ORIENT("R0");
// %t231 @TEXT("n63", key="name", size=0.75);
// &n63 @WIRE(mode="straight") {#X38:3 %t231:p};
// %t232 = $IO_PORT @ATTACH &n45 => @PLACE(451, -105) => @ORIENT("MY");
// %t232 @TEXT("n45", key="name", size=0.75);
// &n45 @WIRE(mode="straight") {#X38:4 %t232:p};
// %t233 = $SUPPLY @ATTACH &vdd => @PLACE(440, -92);
// &vdd @WIRE(mode="straight") {#X38:5 %t233:p};
// %t234 = $GROUND @ATTACH &vss => @PLACE(440, -118);
// &vss @WIRE(mode="straight") {#X38:6 %t234:p};
// %t235 = $IO_PORT @ATTACH &n53 => @PLACE(499, -101) => @ORIENT("R0");
// %t235 @TEXT("n53", key="name", size=0.75);
// &n53 @WIRE(mode="straight") {#X39:1 %t235:p};
// %t236 = $IO_PORT @ATTACH &n68 => @PLACE(499, -105) => @ORIENT("R0");
// %t236 @TEXT("n68", key="name", size=0.75);
// &n68 @WIRE(mode="straight") {#X39:2 %t236:p};
// %t237 = $IO_PORT @ATTACH &n60 => @PLACE(499, -109) => @ORIENT("R0");
// %t237 @TEXT("n60", key="name", size=0.75);
// &n60 @WIRE(mode="straight") {#X39:3 %t237:p};
// %t238 = $IO_PORT @ATTACH &n52 => @PLACE(521, -105) => @ORIENT("MY");
// %t238 @TEXT("n52", key="name", size=0.75);
// &n52 @WIRE(mode="straight") {#X39:4 %t238:p};
// %t239 = $SUPPLY @ATTACH &vdd => @PLACE(510, -92);
// &vdd @WIRE(mode="straight") {#X39:5 %t239:p};
// %t240 = $GROUND @ATTACH &vss => @PLACE(510, -118);
// &vss @WIRE(mode="straight") {#X39:6 %t240:p};
// %t241 = $IO_PORT @ATTACH &n47 => @PLACE(289, -140) => @ORIENT("R0");
// %t241 @TEXT("n47", key="name", size=0.75);
// &n47 @WIRE(mode="straight") {#X40:1 %t241:p};
// %t242 = $IO_PORT @ATTACH &n69 => @PLACE(311, -140) => @ORIENT("MY");
// %t242 @TEXT("n69", key="name", size=0.75);
// &n69 @WIRE(mode="straight") {#X40:2 %t242:p};
// %t243 = $SUPPLY @ATTACH &vdd => @PLACE(300, -131);
// &vdd @WIRE(mode="straight") {#X40:3 %t243:p};
// %t244 = $GROUND @ATTACH &vss => @PLACE(300, -149);
// &vss @WIRE(mode="straight") {#X40:4 %t244:p};
// %t245 = $IO_PORT @ATTACH &n31 => @PLACE(359, -140) => @ORIENT("R0");
// %t245 @TEXT("n31", key="name", size=0.75);
// &n31 @WIRE(mode="straight") {#X41:1 %t245:p};
// %t246 = $IO_PORT @ATTACH &n70 => @PLACE(381, -140) => @ORIENT("MY");
// %t246 @TEXT("n70", key="name", size=0.75);
// &n70 @WIRE(mode="straight") {#X41:2 %t246:p};
// %t247 = $SUPPLY @ATTACH &vdd => @PLACE(370, -131);
// &vdd @WIRE(mode="straight") {#X41:3 %t247:p};
// %t248 = $GROUND @ATTACH &vss => @PLACE(370, -149);
// &vss @WIRE(mode="straight") {#X41:4 %t248:p};
// %t249 = $IO_PORT @ATTACH &n33 => @PLACE(429, -140) => @ORIENT("R0");
// %t249 @TEXT("n33", key="name", size=0.75);
// &n33 @WIRE(mode="straight") {#X42:1 %t249:p};
// %t250 = $IO_PORT @ATTACH &n71 => @PLACE(451, -140) => @ORIENT("MY");
// %t250 @TEXT("n71", key="name", size=0.75);
// &n71 @WIRE(mode="straight") {#X42:2 %t250:p};
// %t251 = $SUPPLY @ATTACH &vdd => @PLACE(440, -131);
// &vdd @WIRE(mode="straight") {#X42:3 %t251:p};
// %t252 = $GROUND @ATTACH &vss => @PLACE(440, -149);
// &vss @WIRE(mode="straight") {#X42:4 %t252:p};
// %t253 = $IO_PORT @ATTACH &n39 => @PLACE(499, -140) => @ORIENT("R0");
// %t253 @TEXT("n39", key="name", size=0.75);
// &n39 @WIRE(mode="straight") {#X43:1 %t253:p};
// %t254 = $IO_PORT @ATTACH &n72 => @PLACE(521, -140) => @ORIENT("MY");
// %t254 @TEXT("n72", key="name", size=0.75);
// &n72 @WIRE(mode="straight") {#X43:2 %t254:p};
// %t255 = $SUPPLY @ATTACH &vdd => @PLACE(510, -131);
// &vdd @WIRE(mode="straight") {#X43:3 %t255:p};
// %t256 = $GROUND @ATTACH &vss => @PLACE(510, -149);
// &vss @WIRE(mode="straight") {#X43:4 %t256:p};
// %t257 = $IO_PORT @ATTACH &n37 => @PLACE(289, -175) => @ORIENT("R0");
// %t257 @TEXT("n37", key="name", size=0.75);
// &n37 @WIRE(mode="straight") {#X44:1 %t257:p};
// %t258 = $IO_PORT @ATTACH &n73 => @PLACE(311, -175) => @ORIENT("MY");
// %t258 @TEXT("n73", key="name", size=0.75);
// &n73 @WIRE(mode="straight") {#X44:2 %t258:p};
// %t259 = $SUPPLY @ATTACH &vdd => @PLACE(300, -166);
// &vdd @WIRE(mode="straight") {#X44:3 %t259:p};
// %t260 = $GROUND @ATTACH &vss => @PLACE(300, -184);
// &vss @WIRE(mode="straight") {#X44:4 %t260:p};
// %t261 = $IO_PORT @ATTACH &active_k1 => @PLACE(359, -175) => @ORIENT("R0");
// %t261 @TEXT("active_k1", key="name", size=0.75);
// &active_k1 @WIRE(mode="straight") {#X45:1 %t261:p};
// %t262 = $IO_PORT @ATTACH &n74 => @PLACE(381, -175) => @ORIENT("MY");
// %t262 @TEXT("n74", key="name", size=0.75);
// &n74 @WIRE(mode="straight") {#X45:2 %t262:p};
// %t263 = $SUPPLY @ATTACH &vdd => @PLACE(370, -166);
// &vdd @WIRE(mode="straight") {#X45:3 %t263:p};
// %t264 = $GROUND @ATTACH &vss => @PLACE(370, -184);
// &vss @WIRE(mode="straight") {#X45:4 %t264:p};
// %t265 = $IO_PORT @ATTACH &active_k0 => @PLACE(429, -175) => @ORIENT("R0");
// %t265 @TEXT("active_k0", key="name", size=0.75);
// &active_k0 @WIRE(mode="straight") {#X46:1 %t265:p};
// %t266 = $IO_PORT @ATTACH &n75 => @PLACE(451, -175) => @ORIENT("MY");
// %t266 @TEXT("n75", key="name", size=0.75);
// &n75 @WIRE(mode="straight") {#X46:2 %t266:p};
// %t267 = $SUPPLY @ATTACH &vdd => @PLACE(440, -166);
// &vdd @WIRE(mode="straight") {#X46:3 %t267:p};
// %t268 = $GROUND @ATTACH &vss => @PLACE(440, -184);
// &vss @WIRE(mode="straight") {#X46:4 %t268:p};
// %t269 = $IO_PORT @ATTACH &active_k5 => @PLACE(499, -175) => @ORIENT("R0");
// %t269 @TEXT("active_k5", key="name", size=0.75);
// &active_k5 @WIRE(mode="straight") {#X47:1 %t269:p};
// %t270 = $IO_PORT @ATTACH &n76 => @PLACE(521, -175) => @ORIENT("MY");
// %t270 @TEXT("n76", key="name", size=0.75);
// &n76 @WIRE(mode="straight") {#X47:2 %t270:p};
// %t271 = $SUPPLY @ATTACH &vdd => @PLACE(510, -166);
// &vdd @WIRE(mode="straight") {#X47:3 %t271:p};
// %t272 = $GROUND @ATTACH &vss => @PLACE(510, -184);
// &vss @WIRE(mode="straight") {#X47:4 %t272:p};
// %t273 = $IO_PORT @ATTACH &active_k3 => @PLACE(589, 0) => @ORIENT("R0");
// %t273 @TEXT("active_k3", key="name", size=0.75);
// &active_k3 @WIRE(mode="straight") {#X48:1 %t273:p};
// %t274 = $IO_PORT @ATTACH &n77 => @PLACE(611, 0) => @ORIENT("MY");
// %t274 @TEXT("n77", key="name", size=0.75);
// &n77 @WIRE(mode="straight") {#X48:2 %t274:p};
// %t275 = $SUPPLY @ATTACH &vdd => @PLACE(600, 9);
// &vdd @WIRE(mode="straight") {#X48:3 %t275:p};
// %t276 = $GROUND @ATTACH &vss => @PLACE(600, -9);
// &vss @WIRE(mode="straight") {#X48:4 %t276:p};
// %t277 = $IO_PORT @ATTACH &active_k2 => @PLACE(659, 0) => @ORIENT("R0");
// %t277 @TEXT("active_k2", key="name", size=0.75);
// &active_k2 @WIRE(mode="straight") {#X49:1 %t277:p};
// %t278 = $IO_PORT @ATTACH &n78 => @PLACE(681, 0) => @ORIENT("MY");
// %t278 @TEXT("n78", key="name", size=0.75);
// &n78 @WIRE(mode="straight") {#X49:2 %t278:p};
// %t279 = $SUPPLY @ATTACH &vdd => @PLACE(670, 9);
// &vdd @WIRE(mode="straight") {#X49:3 %t279:p};
// %t280 = $GROUND @ATTACH &vss => @PLACE(670, -9);
// &vss @WIRE(mode="straight") {#X49:4 %t280:p};
// %t281 = $IO_PORT @ATTACH &active_k4 => @PLACE(729, 0) => @ORIENT("R0");
// %t281 @TEXT("active_k4", key="name", size=0.75);
// &active_k4 @WIRE(mode="straight") {#X50:1 %t281:p};
// %t282 = $IO_PORT @ATTACH &n79 => @PLACE(751, 0) => @ORIENT("MY");
// %t282 @TEXT("n79", key="name", size=0.75);
// &n79 @WIRE(mode="straight") {#X50:2 %t282:p};
// %t283 = $SUPPLY @ATTACH &vdd => @PLACE(740, 9);
// &vdd @WIRE(mode="straight") {#X50:3 %t283:p};
// %t284 = $GROUND @ATTACH &vss => @PLACE(740, -9);
// &vss @WIRE(mode="straight") {#X50:4 %t284:p};
// %t285 = $IO_PORT @ATTACH &n51 => @PLACE(799, 0) => @ORIENT("R0");
// %t285 @TEXT("n51", key="name", size=0.75);
// &n51 @WIRE(mode="straight") {#X51:1 %t285:p};
// %t286 = $IO_PORT @ATTACH &n80 => @PLACE(821, 0) => @ORIENT("MY");
// %t286 @TEXT("n80", key="name", size=0.75);
// &n80 @WIRE(mode="straight") {#X51:2 %t286:p};
// %t287 = $SUPPLY @ATTACH &vdd => @PLACE(810, 9);
// &vdd @WIRE(mode="straight") {#X51:3 %t287:p};
// %t288 = $GROUND @ATTACH &vss => @PLACE(810, -9);
// &vss @WIRE(mode="straight") {#X51:4 %t288:p};
// %t289 = $IO_PORT @ATTACH &n81 => @PLACE(589, -35) => @ORIENT("R0");
// %t289 @TEXT("n81", key="name", size=0.75);
// &n81 @WIRE(mode="straight") {#X52:1 %t289:p};
// %t290 = $IO_PORT @ATTACH &n82 => @PLACE(611, -35) => @ORIENT("MY");
// %t290 @TEXT("n82", key="name", size=0.75);
// &n82 @WIRE(mode="straight") {#X52:2 %t290:p};
// %t291 = $SUPPLY @ATTACH &vdd => @PLACE(600, -26);
// &vdd @WIRE(mode="straight") {#X52:3 %t291:p};
// %t292 = $GROUND @ATTACH &vss => @PLACE(600, -44);
// &vss @WIRE(mode="straight") {#X52:4 %t292:p};
// %t293 = $IO_PORT @ATTACH &n83 => @PLACE(659, -35) => @ORIENT("R0");
// %t293 @TEXT("n83", key="name", size=0.75);
// &n83 @WIRE(mode="straight") {#X53:1 %t293:p};
// %t294 = $IO_PORT @ATTACH &n84 => @PLACE(681, -35) => @ORIENT("MY");
// %t294 @TEXT("n84", key="name", size=0.75);
// &n84 @WIRE(mode="straight") {#X53:2 %t294:p};
// %t295 = $SUPPLY @ATTACH &vdd => @PLACE(670, -26);
// &vdd @WIRE(mode="straight") {#X53:3 %t295:p};
// %t296 = $GROUND @ATTACH &vss => @PLACE(670, -44);
// &vss @WIRE(mode="straight") {#X53:4 %t296:p};
// %t297 = $IO_PORT @ATTACH &n85 => @PLACE(729, -35) => @ORIENT("R0");
// %t297 @TEXT("n85", key="name", size=0.75);
// &n85 @WIRE(mode="straight") {#X54:1 %t297:p};
// %t298 = $IO_PORT @ATTACH &n86 => @PLACE(751, -35) => @ORIENT("MY");
// %t298 @TEXT("n86", key="name", size=0.75);
// &n86 @WIRE(mode="straight") {#X54:2 %t298:p};
// %t299 = $SUPPLY @ATTACH &vdd => @PLACE(740, -26);
// &vdd @WIRE(mode="straight") {#X54:3 %t299:p};
// %t300 = $GROUND @ATTACH &vss => @PLACE(740, -44);
// &vss @WIRE(mode="straight") {#X54:4 %t300:p};
// %t301 = $IO_PORT @ATTACH &n87 => @PLACE(799, -35) => @ORIENT("R0");
// %t301 @TEXT("n87", key="name", size=0.75);
// &n87 @WIRE(mode="straight") {#X55:1 %t301:p};
// %t302 = $IO_PORT @ATTACH &n88 => @PLACE(821, -35) => @ORIENT("MY");
// %t302 @TEXT("n88", key="name", size=0.75);
// &n88 @WIRE(mode="straight") {#X55:2 %t302:p};
// %t303 = $SUPPLY @ATTACH &vdd => @PLACE(810, -26);
// &vdd @WIRE(mode="straight") {#X55:3 %t303:p};
// %t304 = $GROUND @ATTACH &vss => @PLACE(810, -44);
// &vss @WIRE(mode="straight") {#X55:4 %t304:p};
// %t305 = $IO_PORT @ATTACH &n89 => @PLACE(589, -70) => @ORIENT("R0");
// %t305 @TEXT("n89", key="name", size=0.75);
// &n89 @WIRE(mode="straight") {#X56:1 %t305:p};
// %t306 = $IO_PORT @ATTACH &n90 => @PLACE(611, -70) => @ORIENT("MY");
// %t306 @TEXT("n90", key="name", size=0.75);
// &n90 @WIRE(mode="straight") {#X56:2 %t306:p};
// %t307 = $SUPPLY @ATTACH &vdd => @PLACE(600, -61);
// &vdd @WIRE(mode="straight") {#X56:3 %t307:p};
// %t308 = $GROUND @ATTACH &vss => @PLACE(600, -79);
// &vss @WIRE(mode="straight") {#X56:4 %t308:p};
// %t309 = $IO_PORT @ATTACH &n91 => @PLACE(659, -70) => @ORIENT("R0");
// %t309 @TEXT("n91", key="name", size=0.75);
// &n91 @WIRE(mode="straight") {#X57:1 %t309:p};
// %t310 = $IO_PORT @ATTACH &n92 => @PLACE(681, -70) => @ORIENT("MY");
// %t310 @TEXT("n92", key="name", size=0.75);
// &n92 @WIRE(mode="straight") {#X57:2 %t310:p};
// %t311 = $SUPPLY @ATTACH &vdd => @PLACE(670, -61);
// &vdd @WIRE(mode="straight") {#X57:3 %t311:p};
// %t312 = $GROUND @ATTACH &vss => @PLACE(670, -79);
// &vss @WIRE(mode="straight") {#X57:4 %t312:p};
// %t313 = $IO_PORT @ATTACH &n93 => @PLACE(729, -70) => @ORIENT("R0");
// %t313 @TEXT("n93", key="name", size=0.75);
// &n93 @WIRE(mode="straight") {#X58:1 %t313:p};
// %t314 = $IO_PORT @ATTACH &n94 => @PLACE(751, -70) => @ORIENT("MY");
// %t314 @TEXT("n94", key="name", size=0.75);
// &n94 @WIRE(mode="straight") {#X58:2 %t314:p};
// %t315 = $SUPPLY @ATTACH &vdd => @PLACE(740, -61);
// &vdd @WIRE(mode="straight") {#X58:3 %t315:p};
// %t316 = $GROUND @ATTACH &vss => @PLACE(740, -79);
// &vss @WIRE(mode="straight") {#X58:4 %t316:p};
// %t317 = $IO_PORT @ATTACH &n95 => @PLACE(799, -70) => @ORIENT("R0");
// %t317 @TEXT("n95", key="name", size=0.75);
// &n95 @WIRE(mode="straight") {#X59:1 %t317:p};
// %t318 = $IO_PORT @ATTACH &n96 => @PLACE(821, -70) => @ORIENT("MY");
// %t318 @TEXT("n96", key="name", size=0.75);
// &n96 @WIRE(mode="straight") {#X59:2 %t318:p};
// %t319 = $SUPPLY @ATTACH &vdd => @PLACE(810, -61);
// &vdd @WIRE(mode="straight") {#X59:3 %t319:p};
// %t320 = $GROUND @ATTACH &vss => @PLACE(810, -79);
// &vss @WIRE(mode="straight") {#X59:4 %t320:p};
// %t321 = $IO_PORT @ATTACH &n97 => @PLACE(589, -105) => @ORIENT("R0");
// %t321 @TEXT("n97", key="name", size=0.75);
// &n97 @WIRE(mode="straight") {#X60:1 %t321:p};
// %t322 = $IO_PORT @ATTACH &n98 => @PLACE(611, -105) => @ORIENT("MY");
// %t322 @TEXT("n98", key="name", size=0.75);
// &n98 @WIRE(mode="straight") {#X60:2 %t322:p};
// %t323 = $SUPPLY @ATTACH &vdd => @PLACE(600, -96);
// &vdd @WIRE(mode="straight") {#X60:3 %t323:p};
// %t324 = $GROUND @ATTACH &vss => @PLACE(600, -114);
// &vss @WIRE(mode="straight") {#X60:4 %t324:p};
// %t325 = $IO_PORT @ATTACH &n99 => @PLACE(659, -105) => @ORIENT("R0");
// %t325 @TEXT("n99", key="name", size=0.75);
// &n99 @WIRE(mode="straight") {#X61:1 %t325:p};
// %t326 = $IO_PORT @ATTACH &n100 => @PLACE(681, -105) => @ORIENT("MY");
// %t326 @TEXT("n100", key="name", size=0.75);
// &n100 @WIRE(mode="straight") {#X61:2 %t326:p};
// %t327 = $SUPPLY @ATTACH &vdd => @PLACE(670, -96);
// &vdd @WIRE(mode="straight") {#X61:3 %t327:p};
// %t328 = $GROUND @ATTACH &vss => @PLACE(670, -114);
// &vss @WIRE(mode="straight") {#X61:4 %t328:p};
// %t329 = $IO_PORT @ATTACH &n101 => @PLACE(729, -105) => @ORIENT("R0");
// %t329 @TEXT("n101", key="name", size=0.75);
// &n101 @WIRE(mode="straight") {#X62:1 %t329:p};
// %t330 = $IO_PORT @ATTACH &n102 => @PLACE(751, -105) => @ORIENT("MY");
// %t330 @TEXT("n102", key="name", size=0.75);
// &n102 @WIRE(mode="straight") {#X62:2 %t330:p};
// %t331 = $SUPPLY @ATTACH &vdd => @PLACE(740, -96);
// &vdd @WIRE(mode="straight") {#X62:3 %t331:p};
// %t332 = $GROUND @ATTACH &vss => @PLACE(740, -114);
// &vss @WIRE(mode="straight") {#X62:4 %t332:p};
// %t333 = $IO_PORT @ATTACH &n103 => @PLACE(799, -105) => @ORIENT("R0");
// %t333 @TEXT("n103", key="name", size=0.75);
// &n103 @WIRE(mode="straight") {#X63:1 %t333:p};
// %t334 = $IO_PORT @ATTACH &n104 => @PLACE(821, -105) => @ORIENT("MY");
// %t334 @TEXT("n104", key="name", size=0.75);
// &n104 @WIRE(mode="straight") {#X63:2 %t334:p};
// %t335 = $SUPPLY @ATTACH &vdd => @PLACE(810, -96);
// &vdd @WIRE(mode="straight") {#X63:3 %t335:p};
// %t336 = $GROUND @ATTACH &vss => @PLACE(810, -114);
// &vss @WIRE(mode="straight") {#X63:4 %t336:p};
// %t337 = $IO_PORT @ATTACH &n105 => @PLACE(589, -140) => @ORIENT("R0");
// %t337 @TEXT("n105", key="name", size=0.75);
// &n105 @WIRE(mode="straight") {#X64:1 %t337:p};
// %t338 = $IO_PORT @ATTACH &n106 => @PLACE(611, -140) => @ORIENT("MY");
// %t338 @TEXT("n106", key="name", size=0.75);
// &n106 @WIRE(mode="straight") {#X64:2 %t338:p};
// %t339 = $SUPPLY @ATTACH &vdd => @PLACE(600, -131);
// &vdd @WIRE(mode="straight") {#X64:3 %t339:p};
// %t340 = $GROUND @ATTACH &vss => @PLACE(600, -149);
// &vss @WIRE(mode="straight") {#X64:4 %t340:p};
// %t341 = $IO_PORT @ATTACH &n49 => @PLACE(659, -138) => @ORIENT("R0");
// %t341 @TEXT("n49", key="name", size=0.75);
// &n49 @WIRE(mode="straight") {#X65:1 %t341:p};
// %t342 = $IO_PORT @ATTACH &n47 => @PLACE(659, -142) => @ORIENT("R0");
// %t342 @TEXT("n47", key="name", size=0.75);
// &n47 @WIRE(mode="straight") {#X65:2 %t342:p};
// %t343 = $IO_PORT @ATTACH &n107 => @PLACE(681, -140) => @ORIENT("MY");
// %t343 @TEXT("n107", key="name", size=0.75);
// &n107 @WIRE(mode="straight") {#X65:3 %t343:p};
// %t344 = $SUPPLY @ATTACH &vdd => @PLACE(670, -129);
// &vdd @WIRE(mode="straight") {#X65:4 %t344:p};
// %t345 = $GROUND @ATTACH &vss => @PLACE(670, -151);
// &vss @WIRE(mode="straight") {#X65:5 %t345:p};
// %t346 = $IO_PORT @ATTACH &n51 => @PLACE(729, -138) => @ORIENT("R0");
// %t346 @TEXT("n51", key="name", size=0.75);
// &n51 @WIRE(mode="straight") {#X66:1 %t346:p};
// %t347 = $IO_PORT @ATTACH &n108 => @PLACE(729, -142) => @ORIENT("R0");
// %t347 @TEXT("n108", key="name", size=0.75);
// &n108 @WIRE(mode="straight") {#X66:2 %t347:p};
// %t348 = $IO_PORT @ATTACH &n109 => @PLACE(751, -140) => @ORIENT("MY");
// %t348 @TEXT("n109", key="name", size=0.75);
// &n109 @WIRE(mode="straight") {#X66:3 %t348:p};
// %t349 = $SUPPLY @ATTACH &vdd => @PLACE(740, -129);
// &vdd @WIRE(mode="straight") {#X66:4 %t349:p};
// %t350 = $GROUND @ATTACH &vss => @PLACE(740, -151);
// &vss @WIRE(mode="straight") {#X66:5 %t350:p};
// %t351 = $IO_PORT @ATTACH &n53 => @PLACE(799, -138) => @ORIENT("R0");
// %t351 @TEXT("n53", key="name", size=0.75);
// &n53 @WIRE(mode="straight") {#X67:1 %t351:p};
// %t352 = $IO_PORT @ATTACH &n110 => @PLACE(799, -142) => @ORIENT("R0");
// %t352 @TEXT("n110", key="name", size=0.75);
// &n110 @WIRE(mode="straight") {#X67:2 %t352:p};
// %t353 = $IO_PORT @ATTACH &n111 => @PLACE(821, -140) => @ORIENT("MY");
// %t353 @TEXT("n111", key="name", size=0.75);
// &n111 @WIRE(mode="straight") {#X67:3 %t353:p};
// %t354 = $SUPPLY @ATTACH &vdd => @PLACE(810, -129);
// &vdd @WIRE(mode="straight") {#X67:4 %t354:p};
// %t355 = $GROUND @ATTACH &vss => @PLACE(810, -151);
// &vss @WIRE(mode="straight") {#X67:5 %t355:p};
// %t356 = $IO_PORT @ATTACH &n112 => @PLACE(589, -173) => @ORIENT("R0");
// %t356 @TEXT("n112", key="name", size=0.75);
// &n112 @WIRE(mode="straight") {#X68:1 %t356:p};
// %t357 = $IO_PORT @ATTACH &n113 => @PLACE(589, -177) => @ORIENT("R0");
// %t357 @TEXT("n113", key="name", size=0.75);
// &n113 @WIRE(mode="straight") {#X68:2 %t357:p};
// %t358 = $IO_PORT @ATTACH &n105 => @PLACE(611, -175) => @ORIENT("MY");
// %t358 @TEXT("n105", key="name", size=0.75);
// &n105 @WIRE(mode="straight") {#X68:3 %t358:p};
// %t359 = $SUPPLY @ATTACH &vdd => @PLACE(600, -164);
// &vdd @WIRE(mode="straight") {#X68:4 %t359:p};
// %t360 = $GROUND @ATTACH &vss => @PLACE(600, -186);
// &vss @WIRE(mode="straight") {#X68:5 %t360:p};
// %t361 = $IO_PORT @ATTACH &n114 => @PLACE(659, -173) => @ORIENT("R0");
// %t361 @TEXT("n114", key="name", size=0.75);
// &n114 @WIRE(mode="straight") {#X69:1 %t361:p};
// %t362 = $IO_PORT @ATTACH &n115 => @PLACE(659, -177) => @ORIENT("R0");
// %t362 @TEXT("n115", key="name", size=0.75);
// &n115 @WIRE(mode="straight") {#X69:2 %t362:p};
// %t363 = $IO_PORT @ATTACH &n113 => @PLACE(681, -175) => @ORIENT("MY");
// %t363 @TEXT("n113", key="name", size=0.75);
// &n113 @WIRE(mode="straight") {#X69:3 %t363:p};
// %t364 = $SUPPLY @ATTACH &vdd => @PLACE(670, -164);
// &vdd @WIRE(mode="straight") {#X69:4 %t364:p};
// %t365 = $GROUND @ATTACH &vss => @PLACE(670, -186);
// &vss @WIRE(mode="straight") {#X69:5 %t365:p};
// %t366 = $IO_PORT @ATTACH &active_k5 => @PLACE(729, -173) => @ORIENT("R0");
// %t366 @TEXT("active_k5", key="name", size=0.75);
// &active_k5 @WIRE(mode="straight") {#X70:1 %t366:p};
// %t367 = $IO_PORT @ATTACH &n116 => @PLACE(729, -177) => @ORIENT("R0");
// %t367 @TEXT("n116", key="name", size=0.75);
// &n116 @WIRE(mode="straight") {#X70:2 %t367:p};
// %t368 = $IO_PORT @ATTACH &n112 => @PLACE(751, -175) => @ORIENT("MY");
// %t368 @TEXT("n112", key="name", size=0.75);
// &n112 @WIRE(mode="straight") {#X70:3 %t368:p};
// %t369 = $SUPPLY @ATTACH &vdd => @PLACE(740, -164);
// &vdd @WIRE(mode="straight") {#X70:4 %t369:p};
// %t370 = $GROUND @ATTACH &vss => @PLACE(740, -186);
// &vss @WIRE(mode="straight") {#X70:5 %t370:p};
// %t371 = $IO_PORT @ATTACH &active_k3 => @PLACE(799, -173) => @ORIENT("R0");
// %t371 @TEXT("active_k3", key="name", size=0.75);
// &active_k3 @WIRE(mode="straight") {#X71:1 %t371:p};
// %t372 = $IO_PORT @ATTACH &active_k2 => @PLACE(799, -177) => @ORIENT("R0");
// %t372 @TEXT("active_k2", key="name", size=0.75);
// &active_k2 @WIRE(mode="straight") {#X71:2 %t372:p};
// %t373 = $IO_PORT @ATTACH &n117 => @PLACE(821, -175) => @ORIENT("MY");
// %t373 @TEXT("n117", key="name", size=0.75);
// &n117 @WIRE(mode="straight") {#X71:3 %t373:p};
// %t374 = $SUPPLY @ATTACH &vdd => @PLACE(810, -164);
// &vdd @WIRE(mode="straight") {#X71:4 %t374:p};
// %t375 = $GROUND @ATTACH &vss => @PLACE(810, -186);
// &vss @WIRE(mode="straight") {#X71:5 %t375:p};
// %t376 = $IO_PORT @ATTACH &n118 => @PLACE(889, 2) => @ORIENT("R0");
// %t376 @TEXT("n118", key="name", size=0.75);
// &n118 @WIRE(mode="straight") {#X72:1 %t376:p};
// %t377 = $IO_PORT @ATTACH &n119 => @PLACE(889, -2) => @ORIENT("R0");
// %t377 @TEXT("n119", key="name", size=0.75);
// &n119 @WIRE(mode="straight") {#X72:2 %t377:p};
// %t378 = $IO_PORT @ATTACH &n103 => @PLACE(911, 0) => @ORIENT("MY");
// %t378 @TEXT("n103", key="name", size=0.75);
// &n103 @WIRE(mode="straight") {#X72:3 %t378:p};
// %t379 = $SUPPLY @ATTACH &vdd => @PLACE(900, 11);
// &vdd @WIRE(mode="straight") {#X72:4 %t379:p};
// %t380 = $GROUND @ATTACH &vss => @PLACE(900, -11);
// &vss @WIRE(mode="straight") {#X72:5 %t380:p};
// %t381 = $IO_PORT @ATTACH &n120 => @PLACE(959, 2) => @ORIENT("R0");
// %t381 @TEXT("n120", key="name", size=0.75);
// &n120 @WIRE(mode="straight") {#X73:1 %t381:p};
// %t382 = $IO_PORT @ATTACH &n115 => @PLACE(959, -2) => @ORIENT("R0");
// %t382 @TEXT("n115", key="name", size=0.75);
// &n115 @WIRE(mode="straight") {#X73:2 %t382:p};
// %t383 = $IO_PORT @ATTACH &n119 => @PLACE(981, 0) => @ORIENT("MY");
// %t383 @TEXT("n119", key="name", size=0.75);
// &n119 @WIRE(mode="straight") {#X73:3 %t383:p};
// %t384 = $SUPPLY @ATTACH &vdd => @PLACE(970, 11);
// &vdd @WIRE(mode="straight") {#X73:4 %t384:p};
// %t385 = $GROUND @ATTACH &vss => @PLACE(970, -11);
// &vss @WIRE(mode="straight") {#X73:5 %t385:p};
// %t386 = $IO_PORT @ATTACH &n117 => @PLACE(1029, 2) => @ORIENT("R0");
// %t386 @TEXT("n117", key="name", size=0.75);
// &n117 @WIRE(mode="straight") {#X74:1 %t386:p};
// %t387 = $IO_PORT @ATTACH &n121 => @PLACE(1029, -2) => @ORIENT("R0");
// %t387 @TEXT("n121", key="name", size=0.75);
// &n121 @WIRE(mode="straight") {#X74:2 %t387:p};
// %t388 = $IO_PORT @ATTACH &n115 => @PLACE(1051, 0) => @ORIENT("MY");
// %t388 @TEXT("n115", key="name", size=0.75);
// &n115 @WIRE(mode="straight") {#X74:3 %t388:p};
// %t389 = $SUPPLY @ATTACH &vdd => @PLACE(1040, 11);
// &vdd @WIRE(mode="straight") {#X74:4 %t389:p};
// %t390 = $GROUND @ATTACH &vss => @PLACE(1040, -11);
// &vss @WIRE(mode="straight") {#X74:5 %t390:p};
// %t391 = $IO_PORT @ATTACH &n122 => @PLACE(1099, 2) => @ORIENT("R0");
// %t391 @TEXT("n122", key="name", size=0.75);
// &n122 @WIRE(mode="straight") {#X75:1 %t391:p};
// %t392 = $IO_PORT @ATTACH &n123 => @PLACE(1099, -2) => @ORIENT("R0");
// %t392 @TEXT("n123", key="name", size=0.75);
// &n123 @WIRE(mode="straight") {#X75:2 %t392:p};
// %t393 = $IO_PORT @ATTACH &n121 => @PLACE(1121, 0) => @ORIENT("MY");
// %t393 @TEXT("n121", key="name", size=0.75);
// &n121 @WIRE(mode="straight") {#X75:3 %t393:p};
// %t394 = $SUPPLY @ATTACH &vdd => @PLACE(1110, 11);
// &vdd @WIRE(mode="straight") {#X75:4 %t394:p};
// %t395 = $GROUND @ATTACH &vss => @PLACE(1110, -11);
// &vss @WIRE(mode="straight") {#X75:5 %t395:p};
// %t396 = $IO_PORT @ATTACH &active_k5 => @PLACE(889, -33) => @ORIENT("R0");
// %t396 @TEXT("active_k5", key="name", size=0.75);
// &active_k5 @WIRE(mode="straight") {#X76:1 %t396:p};
// %t397 = $IO_PORT @ATTACH &n79 => @PLACE(889, -37) => @ORIENT("R0");
// %t397 @TEXT("n79", key="name", size=0.75);
// &n79 @WIRE(mode="straight") {#X76:2 %t397:p};
// %t398 = $IO_PORT @ATTACH &n120 => @PLACE(911, -35) => @ORIENT("MY");
// %t398 @TEXT("n120", key="name", size=0.75);
// &n120 @WIRE(mode="straight") {#X76:3 %t398:p};
// %t399 = $SUPPLY @ATTACH &vdd => @PLACE(900, -24);
// &vdd @WIRE(mode="straight") {#X76:4 %t399:p};
// %t400 = $GROUND @ATTACH &vss => @PLACE(900, -46);
// &vss @WIRE(mode="straight") {#X76:5 %t400:p};
// %t401 = $IO_PORT @ATTACH &active_k5 => @PLACE(959, -33) => @ORIENT("R0");
// %t401 @TEXT("active_k5", key="name", size=0.75);
// &active_k5 @WIRE(mode="straight") {#X77:1 %t401:p};
// %t402 = $IO_PORT @ATTACH &active_k4 => @PLACE(959, -37) => @ORIENT("R0");
// %t402 @TEXT("active_k4", key="name", size=0.75);
// &active_k4 @WIRE(mode="straight") {#X77:2 %t402:p};
// %t403 = $IO_PORT @ATTACH &n118 => @PLACE(981, -35) => @ORIENT("MY");
// %t403 @TEXT("n118", key="name", size=0.75);
// &n118 @WIRE(mode="straight") {#X77:3 %t403:p};
// %t404 = $SUPPLY @ATTACH &vdd => @PLACE(970, -24);
// &vdd @WIRE(mode="straight") {#X77:4 %t404:p};
// %t405 = $GROUND @ATTACH &vss => @PLACE(970, -46);
// &vss @WIRE(mode="straight") {#X77:5 %t405:p};
// %t406 = $IO_PORT @ATTACH &active_k5 => @PLACE(1029, -33) => @ORIENT("R0");
// %t406 @TEXT("active_k5", key="name", size=0.75);
// &active_k5 @WIRE(mode="straight") {#X78:1 %t406:p};
// %t407 = $IO_PORT @ATTACH &n124 => @PLACE(1029, -37) => @ORIENT("R0");
// %t407 @TEXT("n124", key="name", size=0.75);
// &n124 @WIRE(mode="straight") {#X78:2 %t407:p};
// %t408 = $IO_PORT @ATTACH &n101 => @PLACE(1051, -35) => @ORIENT("MY");
// %t408 @TEXT("n101", key="name", size=0.75);
// &n101 @WIRE(mode="straight") {#X78:3 %t408:p};
// %t409 = $SUPPLY @ATTACH &vdd => @PLACE(1040, -24);
// &vdd @WIRE(mode="straight") {#X78:4 %t409:p};
// %t410 = $GROUND @ATTACH &vss => @PLACE(1040, -46);
// &vss @WIRE(mode="straight") {#X78:5 %t410:p};
// %t411 = $IO_PORT @ATTACH &n116 => @PLACE(1099, -33) => @ORIENT("R0");
// %t411 @TEXT("n116", key="name", size=0.75);
// &n116 @WIRE(mode="straight") {#X79:1 %t411:p};
// %t412 = $IO_PORT @ATTACH &n117 => @PLACE(1099, -37) => @ORIENT("R0");
// %t412 @TEXT("n117", key="name", size=0.75);
// &n117 @WIRE(mode="straight") {#X79:2 %t412:p};
// %t413 = $IO_PORT @ATTACH &n124 => @PLACE(1121, -35) => @ORIENT("MY");
// %t413 @TEXT("n124", key="name", size=0.75);
// &n124 @WIRE(mode="straight") {#X79:3 %t413:p};
// %t414 = $SUPPLY @ATTACH &vdd => @PLACE(1110, -24);
// &vdd @WIRE(mode="straight") {#X79:4 %t414:p};
// %t415 = $GROUND @ATTACH &vss => @PLACE(1110, -46);
// &vss @WIRE(mode="straight") {#X79:5 %t415:p};
// %t416 = $IO_PORT @ATTACH &n116 => @PLACE(889, -68) => @ORIENT("R0");
// %t416 @TEXT("n116", key="name", size=0.75);
// &n116 @WIRE(mode="straight") {#X80:1 %t416:p};
// %t417 = $IO_PORT @ATTACH &n125 => @PLACE(889, -72) => @ORIENT("R0");
// %t417 @TEXT("n125", key="name", size=0.75);
// &n125 @WIRE(mode="straight") {#X80:2 %t417:p};
// %t418 = $IO_PORT @ATTACH &n126 => @PLACE(911, -70) => @ORIENT("MY");
// %t418 @TEXT("n126", key="name", size=0.75);
// &n126 @WIRE(mode="straight") {#X80:3 %t418:p};
// %t419 = $SUPPLY @ATTACH &vdd => @PLACE(900, -59);
// &vdd @WIRE(mode="straight") {#X80:4 %t419:p};
// %t420 = $GROUND @ATTACH &vss => @PLACE(900, -81);
// &vss @WIRE(mode="straight") {#X80:5 %t420:p};
// %t421 = $IO_PORT @ATTACH &active_k5 => @PLACE(959, -68) => @ORIENT("R0");
// %t421 @TEXT("active_k5", key="name", size=0.75);
// &active_k5 @WIRE(mode="straight") {#X81:1 %t421:p};
// %t422 = $IO_PORT @ATTACH &n126 => @PLACE(959, -72) => @ORIENT("R0");
// %t422 @TEXT("n126", key="name", size=0.75);
// &n126 @WIRE(mode="straight") {#X81:2 %t422:p};
// %t423 = $IO_PORT @ATTACH &n99 => @PLACE(981, -70) => @ORIENT("MY");
// %t423 @TEXT("n99", key="name", size=0.75);
// &n99 @WIRE(mode="straight") {#X81:3 %t423:p};
// %t424 = $SUPPLY @ATTACH &vdd => @PLACE(970, -59);
// &vdd @WIRE(mode="straight") {#X81:4 %t424:p};
// %t425 = $GROUND @ATTACH &vss => @PLACE(970, -81);
// &vss @WIRE(mode="straight") {#X81:5 %t425:p};
// %t426 = $IO_PORT @ATTACH &n127 => @PLACE(1029, -68) => @ORIENT("R0");
// %t426 @TEXT("n127", key="name", size=0.75);
// &n127 @WIRE(mode="straight") {#X82:1 %t426:p};
// %t427 = $IO_PORT @ATTACH &n128 => @PLACE(1029, -72) => @ORIENT("R0");
// %t427 @TEXT("n128", key="name", size=0.75);
// &n128 @WIRE(mode="straight") {#X82:2 %t427:p};
// %t428 = $IO_PORT @ATTACH &n125 => @PLACE(1051, -70) => @ORIENT("MY");
// %t428 @TEXT("n125", key="name", size=0.75);
// &n125 @WIRE(mode="straight") {#X82:3 %t428:p};
// %t429 = $SUPPLY @ATTACH &vdd => @PLACE(1040, -59);
// &vdd @WIRE(mode="straight") {#X82:4 %t429:p};
// %t430 = $GROUND @ATTACH &vss => @PLACE(1040, -81);
// &vss @WIRE(mode="straight") {#X82:5 %t430:p};
// %t431 = $IO_PORT @ATTACH &n129 => @PLACE(1099, -68) => @ORIENT("R0");
// %t431 @TEXT("n129", key="name", size=0.75);
// &n129 @WIRE(mode="straight") {#X83:1 %t431:p};
// %t432 = $IO_PORT @ATTACH &n130 => @PLACE(1099, -72) => @ORIENT("R0");
// %t432 @TEXT("n130", key="name", size=0.75);
// &n130 @WIRE(mode="straight") {#X83:2 %t432:p};
// %t433 = $IO_PORT @ATTACH &n128 => @PLACE(1121, -70) => @ORIENT("MY");
// %t433 @TEXT("n128", key="name", size=0.75);
// &n128 @WIRE(mode="straight") {#X83:3 %t433:p};
// %t434 = $SUPPLY @ATTACH &vdd => @PLACE(1110, -59);
// &vdd @WIRE(mode="straight") {#X83:4 %t434:p};
// %t435 = $GROUND @ATTACH &vss => @PLACE(1110, -81);
// &vss @WIRE(mode="straight") {#X83:5 %t435:p};
// %t436 = $IO_PORT @ATTACH &n76 => @PLACE(889, -103) => @ORIENT("R0");
// %t436 @TEXT("n76", key="name", size=0.75);
// &n76 @WIRE(mode="straight") {#X84:1 %t436:p};
// %t437 = $IO_PORT @ATTACH &active_k4 => @PLACE(889, -107) => @ORIENT("R0");
// %t437 @TEXT("active_k4", key="name", size=0.75);
// &active_k4 @WIRE(mode="straight") {#X84:2 %t437:p};
// %t438 = $IO_PORT @ATTACH &n116 => @PLACE(911, -105) => @ORIENT("MY");
// %t438 @TEXT("n116", key="name", size=0.75);
// &n116 @WIRE(mode="straight") {#X84:3 %t438:p};
// %t439 = $SUPPLY @ATTACH &vdd => @PLACE(900, -94);
// &vdd @WIRE(mode="straight") {#X84:4 %t439:p};
// %t440 = $GROUND @ATTACH &vss => @PLACE(900, -116);
// &vss @WIRE(mode="straight") {#X84:5 %t440:p};
// %t441 = $IO_PORT @ATTACH &n77 => @PLACE(959, -103) => @ORIENT("R0");
// %t441 @TEXT("n77", key="name", size=0.75);
// &n77 @WIRE(mode="straight") {#X85:1 %t441:p};
// %t442 = $IO_PORT @ATTACH &n78 => @PLACE(959, -107) => @ORIENT("R0");
// %t442 @TEXT("n78", key="name", size=0.75);
// &n78 @WIRE(mode="straight") {#X85:2 %t442:p};
// %t443 = $IO_PORT @ATTACH &n129 => @PLACE(981, -105) => @ORIENT("MY");
// %t443 @TEXT("n129", key="name", size=0.75);
// &n129 @WIRE(mode="straight") {#X85:3 %t443:p};
// %t444 = $SUPPLY @ATTACH &vdd => @PLACE(970, -94);
// &vdd @WIRE(mode="straight") {#X85:4 %t444:p};
// %t445 = $GROUND @ATTACH &vss => @PLACE(970, -116);
// &vss @WIRE(mode="straight") {#X85:5 %t445:p};
// %t446 = $IO_PORT @ATTACH &active_k3 => @PLACE(1029, -103) => @ORIENT("R0");
// %t446 @TEXT("active_k3", key="name", size=0.75);
// &active_k3 @WIRE(mode="straight") {#X86:1 %t446:p};
// %t447 = $IO_PORT @ATTACH &n131 => @PLACE(1029, -107) => @ORIENT("R0");
// %t447 @TEXT("n131", key="name", size=0.75);
// &n131 @WIRE(mode="straight") {#X86:2 %t447:p};
// %t448 = $IO_PORT @ATTACH &n127 => @PLACE(1051, -105) => @ORIENT("MY");
// %t448 @TEXT("n127", key="name", size=0.75);
// &n127 @WIRE(mode="straight") {#X86:3 %t448:p};
// %t449 = $SUPPLY @ATTACH &vdd => @PLACE(1040, -94);
// &vdd @WIRE(mode="straight") {#X86:4 %t449:p};
// %t450 = $GROUND @ATTACH &vss => @PLACE(1040, -116);
// &vss @WIRE(mode="straight") {#X86:5 %t450:p};
// %t451 = $IO_PORT @ATTACH &active_k5 => @PLACE(1099, -103) => @ORIENT("R0");
// %t451 @TEXT("active_k5", key="name", size=0.75);
// &active_k5 @WIRE(mode="straight") {#X87:1 %t451:p};
// %t452 = $IO_PORT @ATTACH &n132 => @PLACE(1099, -107) => @ORIENT("R0");
// %t452 @TEXT("n132", key="name", size=0.75);
// &n132 @WIRE(mode="straight") {#X87:2 %t452:p};
// %t453 = $IO_PORT @ATTACH &n97 => @PLACE(1121, -105) => @ORIENT("MY");
// %t453 @TEXT("n97", key="name", size=0.75);
// &n97 @WIRE(mode="straight") {#X87:3 %t453:p};
// %t454 = $SUPPLY @ATTACH &vdd => @PLACE(1110, -94);
// &vdd @WIRE(mode="straight") {#X87:4 %t454:p};
// %t455 = $GROUND @ATTACH &vss => @PLACE(1110, -116);
// &vss @WIRE(mode="straight") {#X87:5 %t455:p};
// %t456 = $IO_PORT @ATTACH &n116 => @PLACE(889, -138) => @ORIENT("R0");
// %t456 @TEXT("n116", key="name", size=0.75);
// &n116 @WIRE(mode="straight") {#X88:1 %t456:p};
// %t457 = $IO_PORT @ATTACH &n133 => @PLACE(889, -142) => @ORIENT("R0");
// %t457 @TEXT("n133", key="name", size=0.75);
// &n133 @WIRE(mode="straight") {#X88:2 %t457:p};
// %t458 = $IO_PORT @ATTACH &n132 => @PLACE(911, -140) => @ORIENT("MY");
// %t458 @TEXT("n132", key="name", size=0.75);
// &n132 @WIRE(mode="straight") {#X88:3 %t458:p};
// %t459 = $SUPPLY @ATTACH &vdd => @PLACE(900, -129);
// &vdd @WIRE(mode="straight") {#X88:4 %t459:p};
// %t460 = $GROUND @ATTACH &vss => @PLACE(900, -151);
// &vss @WIRE(mode="straight") {#X88:5 %t460:p};
// %t461 = $IO_PORT @ATTACH &n106 => @PLACE(959, -138) => @ORIENT("R0");
// %t461 @TEXT("n106", key="name", size=0.75);
// &n106 @WIRE(mode="straight") {#X89:1 %t461:p};
// %t462 = $IO_PORT @ATTACH &n134 => @PLACE(959, -142) => @ORIENT("R0");
// %t462 @TEXT("n134", key="name", size=0.75);
// &n134 @WIRE(mode="straight") {#X89:2 %t462:p};
// %t463 = $IO_PORT @ATTACH &n135 => @PLACE(981, -140) => @ORIENT("MY");
// %t463 @TEXT("n135", key="name", size=0.75);
// &n135 @WIRE(mode="straight") {#X89:3 %t463:p};
// %t464 = $SUPPLY @ATTACH &vdd => @PLACE(970, -129);
// &vdd @WIRE(mode="straight") {#X89:4 %t464:p};
// %t465 = $GROUND @ATTACH &vss => @PLACE(970, -151);
// &vss @WIRE(mode="straight") {#X89:5 %t465:p};
// %t466 = $IO_PORT @ATTACH &n117 => @PLACE(1029, -138) => @ORIENT("R0");
// %t466 @TEXT("n117", key="name", size=0.75);
// &n117 @WIRE(mode="straight") {#X90:1 %t466:p};
// %t467 = $IO_PORT @ATTACH &n136 => @PLACE(1029, -142) => @ORIENT("R0");
// %t467 @TEXT("n136", key="name", size=0.75);
// &n136 @WIRE(mode="straight") {#X90:2 %t467:p};
// %t468 = $IO_PORT @ATTACH &n133 => @PLACE(1051, -140) => @ORIENT("MY");
// %t468 @TEXT("n133", key="name", size=0.75);
// &n133 @WIRE(mode="straight") {#X90:3 %t468:p};
// %t469 = $SUPPLY @ATTACH &vdd => @PLACE(1040, -129);
// &vdd @WIRE(mode="straight") {#X90:4 %t469:p};
// %t470 = $GROUND @ATTACH &vss => @PLACE(1040, -151);
// &vss @WIRE(mode="straight") {#X90:5 %t470:p};
// %t471 = $IO_PORT @ATTACH &n114 => @PLACE(1099, -138) => @ORIENT("R0");
// %t471 @TEXT("n114", key="name", size=0.75);
// &n114 @WIRE(mode="straight") {#X91:1 %t471:p};
// %t472 = $IO_PORT @ATTACH &n137 => @PLACE(1099, -142) => @ORIENT("R0");
// %t472 @TEXT("n137", key="name", size=0.75);
// &n137 @WIRE(mode="straight") {#X91:2 %t472:p};
// %t473 = $IO_PORT @ATTACH &n138 => @PLACE(1121, -140) => @ORIENT("MY");
// %t473 @TEXT("n138", key="name", size=0.75);
// &n138 @WIRE(mode="straight") {#X91:3 %t473:p};
// %t474 = $SUPPLY @ATTACH &vdd => @PLACE(1110, -129);
// &vdd @WIRE(mode="straight") {#X91:4 %t474:p};
// %t475 = $GROUND @ATTACH &vss => @PLACE(1110, -151);
// &vss @WIRE(mode="straight") {#X91:5 %t475:p};
// %t476 = $IO_PORT @ATTACH &n112 => @PLACE(889, -173) => @ORIENT("R0");
// %t476 @TEXT("n112", key="name", size=0.75);
// &n112 @WIRE(mode="straight") {#X92:1 %t476:p};
// %t477 = $IO_PORT @ATTACH &n138 => @PLACE(889, -177) => @ORIENT("R0");
// %t477 @TEXT("n138", key="name", size=0.75);
// &n138 @WIRE(mode="straight") {#X92:2 %t477:p};
// %t478 = $IO_PORT @ATTACH &n95 => @PLACE(911, -175) => @ORIENT("MY");
// %t478 @TEXT("n95", key="name", size=0.75);
// &n95 @WIRE(mode="straight") {#X92:3 %t478:p};
// %t479 = $SUPPLY @ATTACH &vdd => @PLACE(900, -164);
// &vdd @WIRE(mode="straight") {#X92:4 %t479:p};
// %t480 = $GROUND @ATTACH &vss => @PLACE(900, -186);
// &vss @WIRE(mode="straight") {#X92:5 %t480:p};
// %t481 = $IO_PORT @ATTACH &n117 => @PLACE(959, -173) => @ORIENT("R0");
// %t481 @TEXT("n117", key="name", size=0.75);
// &n117 @WIRE(mode="straight") {#X93:1 %t481:p};
// %t482 = $IO_PORT @ATTACH &active_k1 => @PLACE(959, -177) => @ORIENT("R0");
// %t482 @TEXT("active_k1", key="name", size=0.75);
// &active_k1 @WIRE(mode="straight") {#X93:2 %t482:p};
// %t483 = $IO_PORT @ATTACH &n137 => @PLACE(981, -175) => @ORIENT("MY");
// %t483 @TEXT("n137", key="name", size=0.75);
// &n137 @WIRE(mode="straight") {#X93:3 %t483:p};
// %t484 = $SUPPLY @ATTACH &vdd => @PLACE(970, -164);
// &vdd @WIRE(mode="straight") {#X93:4 %t484:p};
// %t485 = $GROUND @ATTACH &vss => @PLACE(970, -186);
// &vss @WIRE(mode="straight") {#X93:5 %t485:p};
// %t486 = $IO_PORT @ATTACH &n76 => @PLACE(1029, -173) => @ORIENT("R0");
// %t486 @TEXT("n76", key="name", size=0.75);
// &n76 @WIRE(mode="straight") {#X94:1 %t486:p};
// %t487 = $IO_PORT @ATTACH &n79 => @PLACE(1029, -177) => @ORIENT("R0");
// %t487 @TEXT("n79", key="name", size=0.75);
// &n79 @WIRE(mode="straight") {#X94:2 %t487:p};
// %t488 = $IO_PORT @ATTACH &n114 => @PLACE(1051, -175) => @ORIENT("MY");
// %t488 @TEXT("n114", key="name", size=0.75);
// &n114 @WIRE(mode="straight") {#X94:3 %t488:p};
// %t489 = $SUPPLY @ATTACH &vdd => @PLACE(1040, -164);
// &vdd @WIRE(mode="straight") {#X94:4 %t489:p};
// %t490 = $GROUND @ATTACH &vss => @PLACE(1040, -186);
// &vss @WIRE(mode="straight") {#X94:5 %t490:p};
// %t491 = $IO_PORT @ATTACH &active_k5 => @PLACE(1099, -173) => @ORIENT("R0");
// %t491 @TEXT("active_k5", key="name", size=0.75);
// &active_k5 @WIRE(mode="straight") {#X95:1 %t491:p};
// %t492 = $IO_PORT @ATTACH &n139 => @PLACE(1099, -177) => @ORIENT("R0");
// %t492 @TEXT("n139", key="name", size=0.75);
// &n139 @WIRE(mode="straight") {#X95:2 %t492:p};
// %t493 = $IO_PORT @ATTACH &n93 => @PLACE(1121, -175) => @ORIENT("MY");
// %t493 @TEXT("n93", key="name", size=0.75);
// &n93 @WIRE(mode="straight") {#X95:3 %t493:p};
// %t494 = $SUPPLY @ATTACH &vdd => @PLACE(1110, -164);
// &vdd @WIRE(mode="straight") {#X95:4 %t494:p};
// %t495 = $GROUND @ATTACH &vss => @PLACE(1110, -186);
// &vss @WIRE(mode="straight") {#X95:5 %t495:p};
// %t496 = $IO_PORT @ATTACH &n116 => @PLACE(-11, -238) => @ORIENT("R0");
// %t496 @TEXT("n116", key="name", size=0.75);
// &n116 @WIRE(mode="straight") {#X96:1 %t496:p};
// %t497 = $IO_PORT @ATTACH &n140 => @PLACE(-11, -242) => @ORIENT("R0");
// %t497 @TEXT("n140", key="name", size=0.75);
// &n140 @WIRE(mode="straight") {#X96:2 %t497:p};
// %t498 = $IO_PORT @ATTACH &n139 => @PLACE(11, -240) => @ORIENT("MY");
// %t498 @TEXT("n139", key="name", size=0.75);
// &n139 @WIRE(mode="straight") {#X96:3 %t498:p};
// %t499 = $SUPPLY @ATTACH &vdd => @PLACE(0, -229);
// &vdd @WIRE(mode="straight") {#X96:4 %t499:p};
// %t500 = $GROUND @ATTACH &vss => @PLACE(0, -251);
// &vss @WIRE(mode="straight") {#X96:5 %t500:p};
// %t501 = $IO_PORT @ATTACH &n127 => @PLACE(59, -238) => @ORIENT("R0");
// %t501 @TEXT("n127", key="name", size=0.75);
// &n127 @WIRE(mode="straight") {#X97:1 %t501:p};
// %t502 = $IO_PORT @ATTACH &n141 => @PLACE(59, -242) => @ORIENT("R0");
// %t502 @TEXT("n141", key="name", size=0.75);
// &n141 @WIRE(mode="straight") {#X97:2 %t502:p};
// %t503 = $IO_PORT @ATTACH &n140 => @PLACE(81, -240) => @ORIENT("MY");
// %t503 @TEXT("n140", key="name", size=0.75);
// &n140 @WIRE(mode="straight") {#X97:3 %t503:p};
// %t504 = $SUPPLY @ATTACH &vdd => @PLACE(70, -229);
// &vdd @WIRE(mode="straight") {#X97:4 %t504:p};
// %t505 = $GROUND @ATTACH &vss => @PLACE(70, -251);
// &vss @WIRE(mode="straight") {#X97:5 %t505:p};
// %t506 = $IO_PORT @ATTACH &n129 => @PLACE(129, -238) => @ORIENT("R0");
// %t506 @TEXT("n129", key="name", size=0.75);
// &n129 @WIRE(mode="straight") {#X98:1 %t506:p};
// %t507 = $IO_PORT @ATTACH &active_k1 => @PLACE(129, -242) => @ORIENT("R0");
// %t507 @TEXT("active_k1", key="name", size=0.75);
// &active_k1 @WIRE(mode="straight") {#X98:2 %t507:p};
// %t508 = $IO_PORT @ATTACH &n141 => @PLACE(151, -240) => @ORIENT("MY");
// %t508 @TEXT("n141", key="name", size=0.75);
// &n141 @WIRE(mode="straight") {#X98:3 %t508:p};
// %t509 = $SUPPLY @ATTACH &vdd => @PLACE(140, -229);
// &vdd @WIRE(mode="straight") {#X98:4 %t509:p};
// %t510 = $GROUND @ATTACH &vss => @PLACE(140, -251);
// &vss @WIRE(mode="straight") {#X98:5 %t510:p};
// %t511 = $IO_PORT @ATTACH &n77 => @PLACE(199, -238) => @ORIENT("R0");
// %t511 @TEXT("n77", key="name", size=0.75);
// &n77 @WIRE(mode="straight") {#X99:1 %t511:p};
// %t512 = $IO_PORT @ATTACH &active_k2 => @PLACE(199, -242) => @ORIENT("R0");
// %t512 @TEXT("active_k2", key="name", size=0.75);
// &active_k2 @WIRE(mode="straight") {#X99:2 %t512:p};
// %t513 = $IO_PORT @ATTACH &n131 => @PLACE(221, -240) => @ORIENT("MY");
// %t513 @TEXT("n131", key="name", size=0.75);
// &n131 @WIRE(mode="straight") {#X99:3 %t513:p};
// %t514 = $SUPPLY @ATTACH &vdd => @PLACE(210, -229);
// &vdd @WIRE(mode="straight") {#X99:4 %t514:p};
// %t515 = $GROUND @ATTACH &vss => @PLACE(210, -251);
// &vss @WIRE(mode="straight") {#X99:5 %t515:p};
// %t516 = $IO_PORT @ATTACH &n102 => @PLACE(-11, -273) => @ORIENT("R0");
// %t516 @TEXT("n102", key="name", size=0.75);
// &n102 @WIRE(mode="straight") {#X100:1 %t516:p};
// %t517 = $IO_PORT @ATTACH &n142 => @PLACE(-11, -277) => @ORIENT("R0");
// %t517 @TEXT("n142", key="name", size=0.75);
// &n142 @WIRE(mode="straight") {#X100:2 %t517:p};
// %t518 = $IO_PORT @ATTACH &n143 => @PLACE(11, -275) => @ORIENT("MY");
// %t518 @TEXT("n143", key="name", size=0.75);
// &n143 @WIRE(mode="straight") {#X100:3 %t518:p};
// %t519 = $SUPPLY @ATTACH &vdd => @PLACE(0, -264);
// &vdd @WIRE(mode="straight") {#X100:4 %t519:p};
// %t520 = $GROUND @ATTACH &vss => @PLACE(0, -286);
// &vss @WIRE(mode="straight") {#X100:5 %t520:p};
// %t521 = $IO_PORT @ATTACH &n114 => @PLACE(59, -273) => @ORIENT("R0");
// %t521 @TEXT("n114", key="name", size=0.75);
// &n114 @WIRE(mode="straight") {#X101:1 %t521:p};
// %t522 = $IO_PORT @ATTACH &n117 => @PLACE(59, -277) => @ORIENT("R0");
// %t522 @TEXT("n117", key="name", size=0.75);
// &n117 @WIRE(mode="straight") {#X101:2 %t522:p};
// %t523 = $IO_PORT @ATTACH &n144 => @PLACE(81, -275) => @ORIENT("MY");
// %t523 @TEXT("n144", key="name", size=0.75);
// &n144 @WIRE(mode="straight") {#X101:3 %t523:p};
// %t524 = $SUPPLY @ATTACH &vdd => @PLACE(70, -264);
// &vdd @WIRE(mode="straight") {#X101:4 %t524:p};
// %t525 = $GROUND @ATTACH &vss => @PLACE(70, -286);
// &vss @WIRE(mode="straight") {#X101:5 %t525:p};
// %t526 = $IO_PORT @ATTACH &n112 => @PLACE(129, -273) => @ORIENT("R0");
// %t526 @TEXT("n112", key="name", size=0.75);
// &n112 @WIRE(mode="straight") {#X102:1 %t526:p};
// %t527 = $IO_PORT @ATTACH &n144 => @PLACE(129, -277) => @ORIENT("R0");
// %t527 @TEXT("n144", key="name", size=0.75);
// &n144 @WIRE(mode="straight") {#X102:2 %t527:p};
// %t528 = $IO_PORT @ATTACH &n91 => @PLACE(151, -275) => @ORIENT("MY");
// %t528 @TEXT("n91", key="name", size=0.75);
// &n91 @WIRE(mode="straight") {#X102:3 %t528:p};
// %t529 = $SUPPLY @ATTACH &vdd => @PLACE(140, -264);
// &vdd @WIRE(mode="straight") {#X102:4 %t529:p};
// %t530 = $GROUND @ATTACH &vss => @PLACE(140, -286);
// &vss @WIRE(mode="straight") {#X102:5 %t530:p};
// %t531 = $IO_PORT @ATTACH &n112 => @PLACE(199, -273) => @ORIENT("R0");
// %t531 @TEXT("n112", key="name", size=0.75);
// &n112 @WIRE(mode="straight") {#X103:1 %t531:p};
// %t532 = $IO_PORT @ATTACH &n145 => @PLACE(199, -277) => @ORIENT("R0");
// %t532 @TEXT("n145", key="name", size=0.75);
// &n145 @WIRE(mode="straight") {#X103:2 %t532:p};
// %t533 = $IO_PORT @ATTACH &n89 => @PLACE(221, -275) => @ORIENT("MY");
// %t533 @TEXT("n89", key="name", size=0.75);
// &n89 @WIRE(mode="straight") {#X103:3 %t533:p};
// %t534 = $SUPPLY @ATTACH &vdd => @PLACE(210, -264);
// &vdd @WIRE(mode="straight") {#X103:4 %t534:p};
// %t535 = $GROUND @ATTACH &vss => @PLACE(210, -286);
// &vss @WIRE(mode="straight") {#X103:5 %t535:p};
// %t536 = $IO_PORT @ATTACH &n114 => @PLACE(-11, -308) => @ORIENT("R0");
// %t536 @TEXT("n114", key="name", size=0.75);
// &n114 @WIRE(mode="straight") {#X104:1 %t536:p};
// %t537 = $IO_PORT @ATTACH &n146 => @PLACE(-11, -312) => @ORIENT("R0");
// %t537 @TEXT("n146", key="name", size=0.75);
// &n146 @WIRE(mode="straight") {#X104:2 %t537:p};
// %t538 = $IO_PORT @ATTACH &n145 => @PLACE(11, -310) => @ORIENT("MY");
// %t538 @TEXT("n145", key="name", size=0.75);
// &n145 @WIRE(mode="straight") {#X104:3 %t538:p};
// %t539 = $SUPPLY @ATTACH &vdd => @PLACE(0, -299);
// &vdd @WIRE(mode="straight") {#X104:4 %t539:p};
// %t540 = $GROUND @ATTACH &vss => @PLACE(0, -321);
// &vss @WIRE(mode="straight") {#X104:5 %t540:p};
// %t541 = $IO_PORT @ATTACH &n117 => @PLACE(59, -308) => @ORIENT("R0");
// %t541 @TEXT("n117", key="name", size=0.75);
// &n117 @WIRE(mode="straight") {#X105:1 %t541:p};
// %t542 = $IO_PORT @ATTACH &n123 => @PLACE(59, -312) => @ORIENT("R0");
// %t542 @TEXT("n123", key="name", size=0.75);
// &n123 @WIRE(mode="straight") {#X105:2 %t542:p};
// %t543 = $IO_PORT @ATTACH &n146 => @PLACE(81, -310) => @ORIENT("MY");
// %t543 @TEXT("n146", key="name", size=0.75);
// &n146 @WIRE(mode="straight") {#X105:3 %t543:p};
// %t544 = $SUPPLY @ATTACH &vdd => @PLACE(70, -299);
// &vdd @WIRE(mode="straight") {#X105:4 %t544:p};
// %t545 = $GROUND @ATTACH &vss => @PLACE(70, -321);
// &vss @WIRE(mode="straight") {#X105:5 %t545:p};
// %t546 = $IO_PORT @ATTACH &n100 => @PLACE(129, -308) => @ORIENT("R0");
// %t546 @TEXT("n100", key="name", size=0.75);
// &n100 @WIRE(mode="straight") {#X106:1 %t546:p};
// %t547 = $IO_PORT @ATTACH &n147 => @PLACE(129, -312) => @ORIENT("R0");
// %t547 @TEXT("n147", key="name", size=0.75);
// &n147 @WIRE(mode="straight") {#X106:2 %t547:p};
// %t548 = $IO_PORT @ATTACH &n148 => @PLACE(151, -310) => @ORIENT("MY");
// %t548 @TEXT("n148", key="name", size=0.75);
// &n148 @WIRE(mode="straight") {#X106:3 %t548:p};
// %t549 = $SUPPLY @ATTACH &vdd => @PLACE(140, -299);
// &vdd @WIRE(mode="straight") {#X106:4 %t549:p};
// %t550 = $GROUND @ATTACH &vss => @PLACE(140, -321);
// &vss @WIRE(mode="straight") {#X106:5 %t550:p};
// %t551 = $IO_PORT @ATTACH &active_k1 => @PLACE(199, -308) => @ORIENT("R0");
// %t551 @TEXT("active_k1", key="name", size=0.75);
// &active_k1 @WIRE(mode="straight") {#X107:1 %t551:p};
// %t552 = $IO_PORT @ATTACH &n149 => @PLACE(199, -312) => @ORIENT("R0");
// %t552 @TEXT("n149", key="name", size=0.75);
// &n149 @WIRE(mode="straight") {#X107:2 %t552:p};
// %t553 = $IO_PORT @ATTACH &n123 => @PLACE(221, -310) => @ORIENT("MY");
// %t553 @TEXT("n123", key="name", size=0.75);
// &n123 @WIRE(mode="straight") {#X107:3 %t553:p};
// %t554 = $SUPPLY @ATTACH &vdd => @PLACE(210, -299);
// &vdd @WIRE(mode="straight") {#X107:4 %t554:p};
// %t555 = $GROUND @ATTACH &vss => @PLACE(210, -321);
// &vss @WIRE(mode="straight") {#X107:5 %t555:p};
// %t556 = $IO_PORT @ATTACH &n74 => @PLACE(-11, -343) => @ORIENT("R0");
// %t556 @TEXT("n74", key="name", size=0.75);
// &n74 @WIRE(mode="straight") {#X108:1 %t556:p};
// %t557 = $IO_PORT @ATTACH &active_k0 => @PLACE(-11, -347) => @ORIENT("R0");
// %t557 @TEXT("active_k0", key="name", size=0.75);
// &active_k0 @WIRE(mode="straight") {#X108:2 %t557:p};
// %t558 = $IO_PORT @ATTACH &n149 => @PLACE(11, -345) => @ORIENT("MY");
// %t558 @TEXT("n149", key="name", size=0.75);
// &n149 @WIRE(mode="straight") {#X108:3 %t558:p};
// %t559 = $SUPPLY @ATTACH &vdd => @PLACE(0, -334);
// &vdd @WIRE(mode="straight") {#X108:4 %t559:p};
// %t560 = $GROUND @ATTACH &vss => @PLACE(0, -356);
// &vss @WIRE(mode="straight") {#X108:5 %t560:p};
// %t561 = $IO_PORT @ATTACH &n112 => @PLACE(59, -343) => @ORIENT("R0");
// %t561 @TEXT("n112", key="name", size=0.75);
// &n112 @WIRE(mode="straight") {#X109:1 %t561:p};
// %t562 = $IO_PORT @ATTACH &n150 => @PLACE(59, -347) => @ORIENT("R0");
// %t562 @TEXT("n150", key="name", size=0.75);
// &n150 @WIRE(mode="straight") {#X109:2 %t562:p};
// %t563 = $IO_PORT @ATTACH &n87 => @PLACE(81, -345) => @ORIENT("MY");
// %t563 @TEXT("n87", key="name", size=0.75);
// &n87 @WIRE(mode="straight") {#X109:3 %t563:p};
// %t564 = $SUPPLY @ATTACH &vdd => @PLACE(70, -334);
// &vdd @WIRE(mode="straight") {#X109:4 %t564:p};
// %t565 = $GROUND @ATTACH &vss => @PLACE(70, -356);
// &vss @WIRE(mode="straight") {#X109:5 %t565:p};
// %t566 = $IO_PORT @ATTACH &n114 => @PLACE(129, -343) => @ORIENT("R0");
// %t566 @TEXT("n114", key="name", size=0.75);
// &n114 @WIRE(mode="straight") {#X110:1 %t566:p};
// %t567 = $IO_PORT @ATTACH &n151 => @PLACE(129, -347) => @ORIENT("R0");
// %t567 @TEXT("n151", key="name", size=0.75);
// &n151 @WIRE(mode="straight") {#X110:2 %t567:p};
// %t568 = $IO_PORT @ATTACH &n150 => @PLACE(151, -345) => @ORIENT("MY");
// %t568 @TEXT("n150", key="name", size=0.75);
// &n150 @WIRE(mode="straight") {#X110:3 %t568:p};
// %t569 = $SUPPLY @ATTACH &vdd => @PLACE(140, -334);
// &vdd @WIRE(mode="straight") {#X110:4 %t569:p};
// %t570 = $GROUND @ATTACH &vss => @PLACE(140, -356);
// &vss @WIRE(mode="straight") {#X110:5 %t570:p};
// %t571 = $IO_PORT @ATTACH &n117 => @PLACE(199, -343) => @ORIENT("R0");
// %t571 @TEXT("n117", key="name", size=0.75);
// &n117 @WIRE(mode="straight") {#X111:1 %t571:p};
// %t572 = $IO_PORT @ATTACH &n152 => @PLACE(199, -347) => @ORIENT("R0");
// %t572 @TEXT("n152", key="name", size=0.75);
// &n152 @WIRE(mode="straight") {#X111:2 %t572:p};
// %t573 = $IO_PORT @ATTACH &n151 => @PLACE(221, -345) => @ORIENT("MY");
// %t573 @TEXT("n151", key="name", size=0.75);
// &n151 @WIRE(mode="straight") {#X111:3 %t573:p};
// %t574 = $SUPPLY @ATTACH &vdd => @PLACE(210, -334);
// &vdd @WIRE(mode="straight") {#X111:4 %t574:p};
// %t575 = $GROUND @ATTACH &vss => @PLACE(210, -356);
// &vss @WIRE(mode="straight") {#X111:5 %t575:p};
// %t576 = $IO_PORT @ATTACH &n122 => @PLACE(-11, -378) => @ORIENT("R0");
// %t576 @TEXT("n122", key="name", size=0.75);
// &n122 @WIRE(mode="straight") {#X112:1 %t576:p};
// %t577 = $IO_PORT @ATTACH &active_k1 => @PLACE(-11, -382) => @ORIENT("R0");
// %t577 @TEXT("active_k1", key="name", size=0.75);
// &active_k1 @WIRE(mode="straight") {#X112:2 %t577:p};
// %t578 = $IO_PORT @ATTACH &n152 => @PLACE(11, -380) => @ORIENT("MY");
// %t578 @TEXT("n152", key="name", size=0.75);
// &n152 @WIRE(mode="straight") {#X112:3 %t578:p};
// %t579 = $SUPPLY @ATTACH &vdd => @PLACE(0, -369);
// &vdd @WIRE(mode="straight") {#X112:4 %t579:p};
// %t580 = $GROUND @ATTACH &vss => @PLACE(0, -391);
// &vss @WIRE(mode="straight") {#X112:5 %t580:p};
// %t581 = $IO_PORT @ATTACH &active_k3 => @PLACE(59, -378) => @ORIENT("R0");
// %t581 @TEXT("active_k3", key="name", size=0.75);
// &active_k3 @WIRE(mode="straight") {#X113:1 %t581:p};
// %t582 = $IO_PORT @ATTACH &n78 => @PLACE(59, -382) => @ORIENT("R0");
// %t582 @TEXT("n78", key="name", size=0.75);
// &n78 @WIRE(mode="straight") {#X113:2 %t582:p};
// %t583 = $IO_PORT @ATTACH &n122 => @PLACE(81, -380) => @ORIENT("MY");
// %t583 @TEXT("n122", key="name", size=0.75);
// &n122 @WIRE(mode="straight") {#X113:3 %t583:p};
// %t584 = $SUPPLY @ATTACH &vdd => @PLACE(70, -369);
// &vdd @WIRE(mode="straight") {#X113:4 %t584:p};
// %t585 = $GROUND @ATTACH &vss => @PLACE(70, -391);
// &vss @WIRE(mode="straight") {#X113:5 %t585:p};
// %t586 = $IO_PORT @ATTACH &n112 => @PLACE(129, -378) => @ORIENT("R0");
// %t586 @TEXT("n112", key="name", size=0.75);
// &n112 @WIRE(mode="straight") {#X114:1 %t586:p};
// %t587 = $IO_PORT @ATTACH &n153 => @PLACE(129, -382) => @ORIENT("R0");
// %t587 @TEXT("n153", key="name", size=0.75);
// &n153 @WIRE(mode="straight") {#X114:2 %t587:p};
// %t588 = $IO_PORT @ATTACH &n85 => @PLACE(151, -380) => @ORIENT("MY");
// %t588 @TEXT("n85", key="name", size=0.75);
// &n85 @WIRE(mode="straight") {#X114:3 %t588:p};
// %t589 = $SUPPLY @ATTACH &vdd => @PLACE(140, -369);
// &vdd @WIRE(mode="straight") {#X114:4 %t589:p};
// %t590 = $GROUND @ATTACH &vss => @PLACE(140, -391);
// &vss @WIRE(mode="straight") {#X114:5 %t590:p};
// %t591 = $IO_PORT @ATTACH &n114 => @PLACE(199, -378) => @ORIENT("R0");
// %t591 @TEXT("n114", key="name", size=0.75);
// &n114 @WIRE(mode="straight") {#X115:1 %t591:p};
// %t592 = $IO_PORT @ATTACH &n133 => @PLACE(199, -382) => @ORIENT("R0");
// %t592 @TEXT("n133", key="name", size=0.75);
// &n133 @WIRE(mode="straight") {#X115:2 %t592:p};
// %t593 = $IO_PORT @ATTACH &n153 => @PLACE(221, -380) => @ORIENT("MY");
// %t593 @TEXT("n153", key="name", size=0.75);
// &n153 @WIRE(mode="straight") {#X115:3 %t593:p};
// %t594 = $SUPPLY @ATTACH &vdd => @PLACE(210, -369);
// &vdd @WIRE(mode="straight") {#X115:4 %t594:p};
// %t595 = $GROUND @ATTACH &vss => @PLACE(210, -391);
// &vss @WIRE(mode="straight") {#X115:5 %t595:p};
// %t596 = $IO_PORT @ATTACH &active_k1 => @PLACE(-11, -413) => @ORIENT("R0");
// %t596 @TEXT("active_k1", key="name", size=0.75);
// &active_k1 @WIRE(mode="straight") {#X116:1 %t596:p};
// %t597 = $IO_PORT @ATTACH &active_k0 => @PLACE(-11, -417) => @ORIENT("R0");
// %t597 @TEXT("active_k0", key="name", size=0.75);
// &active_k0 @WIRE(mode="straight") {#X116:2 %t597:p};
// %t598 = $IO_PORT @ATTACH &n130 => @PLACE(11, -415) => @ORIENT("MY");
// %t598 @TEXT("n130", key="name", size=0.75);
// &n130 @WIRE(mode="straight") {#X116:3 %t598:p};
// %t599 = $SUPPLY @ATTACH &vdd => @PLACE(0, -404);
// &vdd @WIRE(mode="straight") {#X116:4 %t599:p};
// %t600 = $GROUND @ATTACH &vss => @PLACE(0, -426);
// &vss @WIRE(mode="straight") {#X116:5 %t600:p};
// %t601 = $IO_PORT @ATTACH &n96 => @PLACE(59, -413) => @ORIENT("R0");
// %t601 @TEXT("n96", key="name", size=0.75);
// &n96 @WIRE(mode="straight") {#X117:1 %t601:p};
// %t602 = $IO_PORT @ATTACH &n154 => @PLACE(59, -417) => @ORIENT("R0");
// %t602 @TEXT("n154", key="name", size=0.75);
// &n154 @WIRE(mode="straight") {#X117:2 %t602:p};
// %t603 = $IO_PORT @ATTACH &n155 => @PLACE(81, -415) => @ORIENT("MY");
// %t603 @TEXT("n155", key="name", size=0.75);
// &n155 @WIRE(mode="straight") {#X117:3 %t603:p};
// %t604 = $SUPPLY @ATTACH &vdd => @PLACE(70, -404);
// &vdd @WIRE(mode="straight") {#X117:4 %t604:p};
// %t605 = $GROUND @ATTACH &vss => @PLACE(70, -426);
// &vss @WIRE(mode="straight") {#X117:5 %t605:p};
// %t606 = $IO_PORT @ATTACH &n156 => @PLACE(129, -413) => @ORIENT("R0");
// %t606 @TEXT("n156", key="name", size=0.75);
// &n156 @WIRE(mode="straight") {#X118:1 %t606:p};
// %t607 = $IO_PORT @ATTACH &n157 => @PLACE(129, -417) => @ORIENT("R0");
// %t607 @TEXT("n157", key="name", size=0.75);
// &n157 @WIRE(mode="straight") {#X118:2 %t607:p};
// %t608 = $IO_PORT @ATTACH &n83 => @PLACE(151, -415) => @ORIENT("MY");
// %t608 @TEXT("n83", key="name", size=0.75);
// &n83 @WIRE(mode="straight") {#X118:3 %t608:p};
// %t609 = $SUPPLY @ATTACH &vdd => @PLACE(140, -404);
// &vdd @WIRE(mode="straight") {#X118:4 %t609:p};
// %t610 = $GROUND @ATTACH &vss => @PLACE(140, -426);
// &vss @WIRE(mode="straight") {#X118:5 %t610:p};
// %t611 = $IO_PORT @ATTACH &n158 => @PLACE(199, -413) => @ORIENT("R0");
// %t611 @TEXT("n158", key="name", size=0.75);
// &n158 @WIRE(mode="straight") {#X119:1 %t611:p};
// %t612 = $IO_PORT @ATTACH &n159 => @PLACE(199, -417) => @ORIENT("R0");
// %t612 @TEXT("n159", key="name", size=0.75);
// &n159 @WIRE(mode="straight") {#X119:2 %t612:p};
// %t613 = $IO_PORT @ATTACH &n157 => @PLACE(221, -415) => @ORIENT("MY");
// %t613 @TEXT("n157", key="name", size=0.75);
// &n157 @WIRE(mode="straight") {#X119:3 %t613:p};
// %t614 = $SUPPLY @ATTACH &vdd => @PLACE(210, -404);
// &vdd @WIRE(mode="straight") {#X119:4 %t614:p};
// %t615 = $GROUND @ATTACH &vss => @PLACE(210, -426);
// &vss @WIRE(mode="straight") {#X119:5 %t615:p};
// %t616 = $IO_PORT @ATTACH &n160 => @PLACE(289, -238) => @ORIENT("R0");
// %t616 @TEXT("n160", key="name", size=0.75);
// &n160 @WIRE(mode="straight") {#X120:1 %t616:p};
// %t617 = $IO_PORT @ATTACH &n161 => @PLACE(289, -242) => @ORIENT("R0");
// %t617 @TEXT("n161", key="name", size=0.75);
// &n161 @WIRE(mode="straight") {#X120:2 %t617:p};
// %t618 = $IO_PORT @ATTACH &n159 => @PLACE(311, -240) => @ORIENT("MY");
// %t618 @TEXT("n159", key="name", size=0.75);
// &n159 @WIRE(mode="straight") {#X120:3 %t618:p};
// %t619 = $SUPPLY @ATTACH &vdd => @PLACE(300, -229);
// &vdd @WIRE(mode="straight") {#X120:4 %t619:p};
// %t620 = $GROUND @ATTACH &vss => @PLACE(300, -251);
// &vss @WIRE(mode="straight") {#X120:5 %t620:p};
// %t621 = $IO_PORT @ATTACH &n39 => @PLACE(359, -238) => @ORIENT("R0");
// %t621 @TEXT("n39", key="name", size=0.75);
// &n39 @WIRE(mode="straight") {#X121:1 %t621:p};
// %t622 = $IO_PORT @ATTACH &n162 => @PLACE(359, -242) => @ORIENT("R0");
// %t622 @TEXT("n162", key="name", size=0.75);
// &n162 @WIRE(mode="straight") {#X121:2 %t622:p};
// %t623 = $IO_PORT @ATTACH &n156 => @PLACE(381, -240) => @ORIENT("MY");
// %t623 @TEXT("n156", key="name", size=0.75);
// &n156 @WIRE(mode="straight") {#X121:3 %t623:p};
// %t624 = $SUPPLY @ATTACH &vdd => @PLACE(370, -229);
// &vdd @WIRE(mode="straight") {#X121:4 %t624:p};
// %t625 = $GROUND @ATTACH &vss => @PLACE(370, -251);
// &vss @WIRE(mode="straight") {#X121:5 %t625:p};
// %t626 = $IO_PORT @ATTACH &n72 => @PLACE(429, -238) => @ORIENT("R0");
// %t626 @TEXT("n72", key="name", size=0.75);
// &n72 @WIRE(mode="straight") {#X122:1 %t626:p};
// %t627 = $IO_PORT @ATTACH &n37 => @PLACE(429, -242) => @ORIENT("R0");
// %t627 @TEXT("n37", key="name", size=0.75);
// &n37 @WIRE(mode="straight") {#X122:2 %t627:p};
// %t628 = $IO_PORT @ATTACH &n162 => @PLACE(451, -240) => @ORIENT("MY");
// %t628 @TEXT("n162", key="name", size=0.75);
// &n162 @WIRE(mode="straight") {#X122:3 %t628:p};
// %t629 = $SUPPLY @ATTACH &vdd => @PLACE(440, -229);
// &vdd @WIRE(mode="straight") {#X122:4 %t629:p};
// %t630 = $GROUND @ATTACH &vss => @PLACE(440, -251);
// &vss @WIRE(mode="straight") {#X122:5 %t630:p};
// %t631 = $IO_PORT @ATTACH &n31 => @PLACE(499, -238) => @ORIENT("R0");
// %t631 @TEXT("n31", key="name", size=0.75);
// &n31 @WIRE(mode="straight") {#X123:1 %t631:p};
// %t632 = $IO_PORT @ATTACH &n163 => @PLACE(499, -242) => @ORIENT("R0");
// %t632 @TEXT("n163", key="name", size=0.75);
// &n163 @WIRE(mode="straight") {#X123:2 %t632:p};
// %t633 = $IO_PORT @ATTACH &n164 => @PLACE(521, -240) => @ORIENT("MY");
// %t633 @TEXT("n164", key="name", size=0.75);
// &n164 @WIRE(mode="straight") {#X123:3 %t633:p};
// %t634 = $SUPPLY @ATTACH &vdd => @PLACE(510, -229);
// &vdd @WIRE(mode="straight") {#X123:4 %t634:p};
// %t635 = $GROUND @ATTACH &vss => @PLACE(510, -251);
// &vss @WIRE(mode="straight") {#X123:5 %t635:p};
// %t636 = $IO_PORT @ATTACH &n165 => @PLACE(289, -273) => @ORIENT("R0");
// %t636 @TEXT("n165", key="name", size=0.75);
// &n165 @WIRE(mode="straight") {#X124:1 %t636:p};
// %t637 = $IO_PORT @ATTACH &n159 => @PLACE(289, -277) => @ORIENT("R0");
// %t637 @TEXT("n159", key="name", size=0.75);
// &n159 @WIRE(mode="straight") {#X124:2 %t637:p};
// %t638 = $IO_PORT @ATTACH &n166 => @PLACE(311, -275) => @ORIENT("MY");
// %t638 @TEXT("n166", key="name", size=0.75);
// &n166 @WIRE(mode="straight") {#X124:3 %t638:p};
// %t639 = $SUPPLY @ATTACH &vdd => @PLACE(300, -264);
// &vdd @WIRE(mode="straight") {#X124:4 %t639:p};
// %t640 = $GROUND @ATTACH &vss => @PLACE(300, -286);
// &vss @WIRE(mode="straight") {#X124:5 %t640:p};
// %t641 = $IO_PORT @ATTACH &n167 => @PLACE(359, -273) => @ORIENT("R0");
// %t641 @TEXT("n167", key="name", size=0.75);
// &n167 @WIRE(mode="straight") {#X125:1 %t641:p};
// %t642 = $IO_PORT @ATTACH &n166 => @PLACE(359, -277) => @ORIENT("R0");
// %t642 @TEXT("n166", key="name", size=0.75);
// &n166 @WIRE(mode="straight") {#X125:2 %t642:p};
// %t643 = $IO_PORT @ATTACH &n81 => @PLACE(381, -275) => @ORIENT("MY");
// %t643 @TEXT("n81", key="name", size=0.75);
// &n81 @WIRE(mode="straight") {#X125:3 %t643:p};
// %t644 = $SUPPLY @ATTACH &vdd => @PLACE(370, -264);
// &vdd @WIRE(mode="straight") {#X125:4 %t644:p};
// %t645 = $GROUND @ATTACH &vss => @PLACE(370, -286);
// &vss @WIRE(mode="straight") {#X125:5 %t645:p};
// %t646 = $IO_PORT @ATTACH &n168 => @PLACE(429, -273) => @ORIENT("R0");
// %t646 @TEXT("n168", key="name", size=0.75);
// &n168 @WIRE(mode="straight") {#X126:1 %t646:p};
// %t647 = $IO_PORT @ATTACH &n164 => @PLACE(429, -277) => @ORIENT("R0");
// %t647 @TEXT("n164", key="name", size=0.75);
// &n164 @WIRE(mode="straight") {#X126:2 %t647:p};
// %t648 = $IO_PORT @ATTACH &n161 => @PLACE(451, -275) => @ORIENT("MY");
// %t648 @TEXT("n161", key="name", size=0.75);
// &n161 @WIRE(mode="straight") {#X126:3 %t648:p};
// %t649 = $SUPPLY @ATTACH &vdd => @PLACE(440, -264);
// &vdd @WIRE(mode="straight") {#X126:4 %t649:p};
// %t650 = $GROUND @ATTACH &vss => @PLACE(440, -286);
// &vss @WIRE(mode="straight") {#X126:5 %t650:p};
// %t651 = $IO_PORT @ATTACH &n39 => @PLACE(499, -273) => @ORIENT("R0");
// %t651 @TEXT("n39", key="name", size=0.75);
// &n39 @WIRE(mode="straight") {#X127:1 %t651:p};
// %t652 = $IO_PORT @ATTACH &n37 => @PLACE(499, -277) => @ORIENT("R0");
// %t652 @TEXT("n37", key="name", size=0.75);
// &n37 @WIRE(mode="straight") {#X127:2 %t652:p};
// %t653 = $IO_PORT @ATTACH &n167 => @PLACE(521, -275) => @ORIENT("MY");
// %t653 @TEXT("n167", key="name", size=0.75);
// &n167 @WIRE(mode="straight") {#X127:3 %t653:p};
// %t654 = $SUPPLY @ATTACH &vdd => @PLACE(510, -264);
// &vdd @WIRE(mode="straight") {#X127:4 %t654:p};
// %t655 = $GROUND @ATTACH &vss => @PLACE(510, -286);
// &vss @WIRE(mode="straight") {#X127:5 %t655:p};
// %t656 = $IO_PORT @ATTACH &n35 => @PLACE(289, -308) => @ORIENT("R0");
// %t656 @TEXT("n35", key="name", size=0.75);
// &n35 @WIRE(mode="straight") {#X128:1 %t656:p};
// %t657 = $IO_PORT @ATTACH &n33 => @PLACE(289, -312) => @ORIENT("R0");
// %t657 @TEXT("n33", key="name", size=0.75);
// &n33 @WIRE(mode="straight") {#X128:2 %t657:p};
// %t658 = $IO_PORT @ATTACH &n160 => @PLACE(311, -310) => @ORIENT("MY");
// %t658 @TEXT("n160", key="name", size=0.75);
// &n160 @WIRE(mode="straight") {#X128:3 %t658:p};
// %t659 = $SUPPLY @ATTACH &vdd => @PLACE(300, -299);
// &vdd @WIRE(mode="straight") {#X128:4 %t659:p};
// %t660 = $GROUND @ATTACH &vss => @PLACE(300, -321);
// &vss @WIRE(mode="straight") {#X128:5 %t660:p};
// %t661 = $IO_PORT @ATTACH &n70 => @PLACE(359, -308) => @ORIENT("R0");
// %t661 @TEXT("n70", key="name", size=0.75);
// &n70 @WIRE(mode="straight") {#X129:1 %t661:p};
// %t662 = $IO_PORT @ATTACH &n29 => @PLACE(359, -312) => @ORIENT("R0");
// %t662 @TEXT("n29", key="name", size=0.75);
// &n29 @WIRE(mode="straight") {#X129:2 %t662:p};
// %t663 = $IO_PORT @ATTACH &n163 => @PLACE(381, -310) => @ORIENT("MY");
// %t663 @TEXT("n163", key="name", size=0.75);
// &n163 @WIRE(mode="straight") {#X129:3 %t663:p};
// %t664 = $SUPPLY @ATTACH &vdd => @PLACE(370, -299);
// &vdd @WIRE(mode="straight") {#X129:4 %t664:p};
// %t665 = $GROUND @ATTACH &vss => @PLACE(370, -321);
// &vss @WIRE(mode="straight") {#X129:5 %t665:p};
// %t666 = $IO_PORT @ATTACH &n51 => @PLACE(429, -308) => @ORIENT("R0");
// %t666 @TEXT("n51", key="name", size=0.75);
// &n51 @WIRE(mode="straight") {#X130:1 %t666:p};
// %t667 = $IO_PORT @ATTACH &n108 => @PLACE(429, -312) => @ORIENT("R0");
// %t667 @TEXT("n108", key="name", size=0.75);
// &n108 @WIRE(mode="straight") {#X130:2 %t667:p};
// %t668 = $IO_PORT @ATTACH &n110 => @PLACE(451, -310) => @ORIENT("MY");
// %t668 @TEXT("n110", key="name", size=0.75);
// &n110 @WIRE(mode="straight") {#X130:3 %t668:p};
// %t669 = $SUPPLY @ATTACH &vdd => @PLACE(440, -299);
// &vdd @WIRE(mode="straight") {#X130:4 %t669:p};
// %t670 = $GROUND @ATTACH &vss => @PLACE(440, -321);
// &vss @WIRE(mode="straight") {#X130:5 %t670:p};
// %t671 = $IO_PORT @ATTACH &n49 => @PLACE(499, -308) => @ORIENT("R0");
// %t671 @TEXT("n49", key="name", size=0.75);
// &n49 @WIRE(mode="straight") {#X131:1 %t671:p};
// %t672 = $IO_PORT @ATTACH &n47 => @PLACE(499, -312) => @ORIENT("R0");
// %t672 @TEXT("n47", key="name", size=0.75);
// &n47 @WIRE(mode="straight") {#X131:2 %t672:p};
// %t673 = $IO_PORT @ATTACH &n108 => @PLACE(521, -310) => @ORIENT("MY");
// %t673 @TEXT("n108", key="name", size=0.75);
// &n108 @WIRE(mode="straight") {#X131:3 %t673:p};
// %t674 = $SUPPLY @ATTACH &vdd => @PLACE(510, -299);
// &vdd @WIRE(mode="straight") {#X131:4 %t674:p};
// %t675 = $GROUND @ATTACH &vss => @PLACE(510, -321);
// &vss @WIRE(mode="straight") {#X131:5 %t675:p};
// %t676 = $IO_PORT @ATTACH &n92 => @PLACE(289, -343) => @ORIENT("R0");
// %t676 @TEXT("n92", key="name", size=0.75);
// &n92 @WIRE(mode="straight") {#X132:1 %t676:p};
// %t677 = $IO_PORT @ATTACH &n169 => @PLACE(289, -347) => @ORIENT("R0");
// %t677 @TEXT("n169", key="name", size=0.75);
// &n169 @WIRE(mode="straight") {#X132:2 %t677:p};
// %t678 = $IO_PORT @ATTACH &n170 => @PLACE(311, -345) => @ORIENT("MY");
// %t678 @TEXT("n170", key="name", size=0.75);
// &n170 @WIRE(mode="straight") {#X132:3 %t678:p};
// %t679 = $SUPPLY @ATTACH &vdd => @PLACE(300, -334);
// &vdd @WIRE(mode="straight") {#X132:4 %t679:p};
// %t680 = $GROUND @ATTACH &vss => @PLACE(300, -356);
// &vss @WIRE(mode="straight") {#X132:5 %t680:p};
// %t681 = $IO_PORT @ATTACH &n88 => @PLACE(359, -343) => @ORIENT("R0");
// %t681 @TEXT("n88", key="name", size=0.75);
// &n88 @WIRE(mode="straight") {#X133:1 %t681:p};
// %t682 = $IO_PORT @ATTACH &n171 => @PLACE(359, -347) => @ORIENT("R0");
// %t682 @TEXT("n171", key="name", size=0.75);
// &n171 @WIRE(mode="straight") {#X133:2 %t682:p};
// %t683 = $IO_PORT @ATTACH &n172 => @PLACE(381, -345) => @ORIENT("MY");
// %t683 @TEXT("n172", key="name", size=0.75);
// &n172 @WIRE(mode="straight") {#X133:3 %t683:p};
// %t684 = $SUPPLY @ATTACH &vdd => @PLACE(370, -334);
// &vdd @WIRE(mode="straight") {#X133:4 %t684:p};
// %t685 = $GROUND @ATTACH &vss => @PLACE(370, -356);
// &vss @WIRE(mode="straight") {#X133:5 %t685:p};
// %t686 = $IO_PORT @ATTACH &n84 => @PLACE(429, -343) => @ORIENT("R0");
// %t686 @TEXT("n84", key="name", size=0.75);
// &n84 @WIRE(mode="straight") {#X134:1 %t686:p};
// %t687 = $IO_PORT @ATTACH &n173 => @PLACE(429, -347) => @ORIENT("R0");
// %t687 @TEXT("n173", key="name", size=0.75);
// &n173 @WIRE(mode="straight") {#X134:2 %t687:p};
// %t688 = $IO_PORT @ATTACH &n174 => @PLACE(451, -345) => @ORIENT("MY");
// %t688 @TEXT("n174", key="name", size=0.75);
// &n174 @WIRE(mode="straight") {#X134:3 %t688:p};
// %t689 = $SUPPLY @ATTACH &vdd => @PLACE(440, -334);
// &vdd @WIRE(mode="straight") {#X134:4 %t689:p};
// %t690 = $GROUND @ATTACH &vss => @PLACE(440, -356);
// &vss @WIRE(mode="straight") {#X134:5 %t690:p};
// %t691 = $IO_PORT @ATTACH &n175 => @PLACE(499, -343) => @ORIENT("R0");
// %t691 @TEXT("n175", key="name", size=0.75);
// &n175 @WIRE(mode="straight") {#X135:1 %t691:p};
// %t692 = $IO_PORT @ATTACH &n176 => @PLACE(499, -347) => @ORIENT("R0");
// %t692 @TEXT("n176", key="name", size=0.75);
// &n176 @WIRE(mode="straight") {#X135:2 %t692:p};
// %t693 = $IO_PORT @ATTACH &n66 => @PLACE(521, -345) => @ORIENT("MY");
// %t693 @TEXT("n66", key="name", size=0.75);
// &n66 @WIRE(mode="straight") {#X135:3 %t693:p};
// %t694 = $SUPPLY @ATTACH &vdd => @PLACE(510, -334);
// &vdd @WIRE(mode="straight") {#X135:4 %t694:p};
// %t695 = $GROUND @ATTACH &vss => @PLACE(510, -356);
// &vss @WIRE(mode="straight") {#X135:5 %t695:p};
// %t696 = $IO_PORT @ATTACH &n64 => @PLACE(289, -378) => @ORIENT("R0");
// %t696 @TEXT("n64", key="name", size=0.75);
// &n64 @WIRE(mode="straight") {#X136:1 %t696:p};
// %t697 = $IO_PORT @ATTACH &n177 => @PLACE(289, -382) => @ORIENT("R0");
// %t697 @TEXT("n177", key="name", size=0.75);
// &n177 @WIRE(mode="straight") {#X136:2 %t697:p};
// %t698 = $IO_PORT @ATTACH &n175 => @PLACE(311, -380) => @ORIENT("MY");
// %t698 @TEXT("n175", key="name", size=0.75);
// &n175 @WIRE(mode="straight") {#X136:3 %t698:p};
// %t699 = $SUPPLY @ATTACH &vdd => @PLACE(300, -369);
// &vdd @WIRE(mode="straight") {#X136:4 %t699:p};
// %t700 = $GROUND @ATTACH &vss => @PLACE(300, -391);
// &vss @WIRE(mode="straight") {#X136:5 %t700:p};
// %t701 = $IO_PORT @ATTACH &n58 => @PLACE(359, -378) => @ORIENT("R0");
// %t701 @TEXT("n58", key="name", size=0.75);
// &n58 @WIRE(mode="straight") {#X137:1 %t701:p};
// %t702 = $IO_PORT @ATTACH &n64 => @PLACE(359, -382) => @ORIENT("R0");
// %t702 @TEXT("n64", key="name", size=0.75);
// &n64 @WIRE(mode="straight") {#X137:2 %t702:p};
// %t703 = $IO_PORT @ATTACH &n176 => @PLACE(381, -380) => @ORIENT("MY");
// %t703 @TEXT("n176", key="name", size=0.75);
// &n176 @WIRE(mode="straight") {#X137:3 %t703:p};
// %t704 = $SUPPLY @ATTACH &vdd => @PLACE(370, -369);
// &vdd @WIRE(mode="straight") {#X137:4 %t704:p};
// %t705 = $GROUND @ATTACH &vss => @PLACE(370, -391);
// &vss @WIRE(mode="straight") {#X137:5 %t705:p};
// %t706 = $IO_PORT @ATTACH &n178 => @PLACE(429, -378) => @ORIENT("R0");
// %t706 @TEXT("n178", key="name", size=0.75);
// &n178 @WIRE(mode="straight") {#X138:1 %t706:p};
// %t707 = $IO_PORT @ATTACH &n58 => @PLACE(429, -382) => @ORIENT("R0");
// %t707 @TEXT("n58", key="name", size=0.75);
// &n58 @WIRE(mode="straight") {#X138:2 %t707:p};
// %t708 = $IO_PORT @ATTACH &n179 => @PLACE(451, -380) => @ORIENT("MY");
// %t708 @TEXT("n179", key="name", size=0.75);
// &n179 @WIRE(mode="straight") {#X138:3 %t708:p};
// %t709 = $SUPPLY @ATTACH &vdd => @PLACE(440, -369);
// &vdd @WIRE(mode="straight") {#X138:4 %t709:p};
// %t710 = $GROUND @ATTACH &vss => @PLACE(440, -391);
// &vss @WIRE(mode="straight") {#X138:5 %t710:p};
// %t711 = $IO_PORT @ATTACH &n179 => @PLACE(499, -378) => @ORIENT("R0");
// %t711 @TEXT("n179", key="name", size=0.75);
// &n179 @WIRE(mode="straight") {#X139:1 %t711:p};
// %t712 = $IO_PORT @ATTACH &n180 => @PLACE(499, -382) => @ORIENT("R0");
// %t712 @TEXT("n180", key="name", size=0.75);
// &n180 @WIRE(mode="straight") {#X139:2 %t712:p};
// %t713 = $IO_PORT @ATTACH &n63 => @PLACE(521, -380) => @ORIENT("MY");
// %t713 @TEXT("n63", key="name", size=0.75);
// &n63 @WIRE(mode="straight") {#X139:3 %t713:p};
// %t714 = $SUPPLY @ATTACH &vdd => @PLACE(510, -369);
// &vdd @WIRE(mode="straight") {#X139:4 %t714:p};
// %t715 = $GROUND @ATTACH &vss => @PLACE(510, -391);
// &vss @WIRE(mode="straight") {#X139:5 %t715:p};
// %t716 = $IO_PORT @ATTACH &n181 => @PLACE(289, -413) => @ORIENT("R0");
// %t716 @TEXT("n181", key="name", size=0.75);
// &n181 @WIRE(mode="straight") {#X140:1 %t716:p};
// %t717 = $IO_PORT @ATTACH &n176 => @PLACE(289, -417) => @ORIENT("R0");
// %t717 @TEXT("n176", key="name", size=0.75);
// &n176 @WIRE(mode="straight") {#X140:2 %t717:p};
// %t718 = $IO_PORT @ATTACH &n60 => @PLACE(311, -415) => @ORIENT("MY");
// %t718 @TEXT("n60", key="name", size=0.75);
// &n60 @WIRE(mode="straight") {#X140:3 %t718:p};
// %t719 = $SUPPLY @ATTACH &vdd => @PLACE(300, -404);
// &vdd @WIRE(mode="straight") {#X140:4 %t719:p};
// %t720 = $GROUND @ATTACH &vss => @PLACE(300, -426);
// &vss @WIRE(mode="straight") {#X140:5 %t720:p};
// %t721 = $IO_PORT @ATTACH &n64 => @PLACE(359, -413) => @ORIENT("R0");
// %t721 @TEXT("n64", key="name", size=0.75);
// &n64 @WIRE(mode="straight") {#X141:1 %t721:p};
// %t722 = $IO_PORT @ATTACH &n182 => @PLACE(359, -417) => @ORIENT("R0");
// %t722 @TEXT("n182", key="name", size=0.75);
// &n182 @WIRE(mode="straight") {#X141:2 %t722:p};
// %t723 = $IO_PORT @ATTACH &n181 => @PLACE(381, -415) => @ORIENT("MY");
// %t723 @TEXT("n181", key="name", size=0.75);
// &n181 @WIRE(mode="straight") {#X141:3 %t723:p};
// %t724 = $SUPPLY @ATTACH &vdd => @PLACE(370, -404);
// &vdd @WIRE(mode="straight") {#X141:4 %t724:p};
// %t725 = $GROUND @ATTACH &vss => @PLACE(370, -426);
// &vss @WIRE(mode="straight") {#X141:5 %t725:p};
// %t726 = $IO_PORT @ATTACH &n75 => @PLACE(429, -413) => @ORIENT("R0");
// %t726 @TEXT("n75", key="name", size=0.75);
// &n75 @WIRE(mode="straight") {#X142:1 %t726:p};
// %t727 = $IO_PORT @ATTACH &active_k1 => @PLACE(429, -417) => @ORIENT("R0");
// %t727 @TEXT("active_k1", key="name", size=0.75);
// &active_k1 @WIRE(mode="straight") {#X142:2 %t727:p};
// %t728 = $IO_PORT @ATTACH &n183 => @PLACE(451, -415) => @ORIENT("MY");
// %t728 @TEXT("n183", key="name", size=0.75);
// &n183 @WIRE(mode="straight") {#X142:3 %t728:p};
// %t729 = $SUPPLY @ATTACH &vdd => @PLACE(440, -404);
// &vdd @WIRE(mode="straight") {#X142:4 %t729:p};
// %t730 = $GROUND @ATTACH &vss => @PLACE(440, -426);
// &vss @WIRE(mode="straight") {#X142:5 %t730:p};
// %t731 = $IO_PORT @ATTACH &active_k2 => @PLACE(499, -413) => @ORIENT("R0");
// %t731 @TEXT("active_k2", key="name", size=0.75);
// &active_k2 @WIRE(mode="straight") {#X143:1 %t731:p};
// %t732 = $IO_PORT @ATTACH &n77 => @PLACE(499, -417) => @ORIENT("R0");
// %t732 @TEXT("n77", key="name", size=0.75);
// &n77 @WIRE(mode="straight") {#X143:2 %t732:p};
// %t733 = $IO_PORT @ATTACH &n184 => @PLACE(521, -415) => @ORIENT("MY");
// %t733 @TEXT("n184", key="name", size=0.75);
// &n184 @WIRE(mode="straight") {#X143:3 %t733:p};
// %t734 = $SUPPLY @ATTACH &vdd => @PLACE(510, -404);
// &vdd @WIRE(mode="straight") {#X143:4 %t734:p};
// %t735 = $GROUND @ATTACH &vss => @PLACE(510, -426);
// &vss @WIRE(mode="straight") {#X143:5 %t735:p};
// %t736 = $IO_PORT @ATTACH &active_k4 => @PLACE(589, -238) => @ORIENT("R0");
// %t736 @TEXT("active_k4", key="name", size=0.75);
// &active_k4 @WIRE(mode="straight") {#X144:1 %t736:p};
// %t737 = $IO_PORT @ATTACH &active_k5 => @PLACE(589, -242) => @ORIENT("R0");
// %t737 @TEXT("active_k5", key="name", size=0.75);
// &active_k5 @WIRE(mode="straight") {#X144:2 %t737:p};
// %t738 = $IO_PORT @ATTACH &n185 => @PLACE(611, -240) => @ORIENT("MY");
// %t738 @TEXT("n185", key="name", size=0.75);
// &n185 @WIRE(mode="straight") {#X144:3 %t738:p};
// %t739 = $SUPPLY @ATTACH &vdd => @PLACE(600, -229);
// &vdd @WIRE(mode="straight") {#X144:4 %t739:p};
// %t740 = $GROUND @ATTACH &vss => @PLACE(600, -251);
// &vss @WIRE(mode="straight") {#X144:5 %t740:p};
// %t741 = $IO_PORT @ATTACH &n183 => @PLACE(659, -238) => @ORIENT("R0");
// %t741 @TEXT("n183", key="name", size=0.75);
// &n183 @WIRE(mode="straight") {#X145:1 %t741:p};
// %t742 = $IO_PORT @ATTACH &n184 => @PLACE(659, -242) => @ORIENT("R0");
// %t742 @TEXT("n184", key="name", size=0.75);
// &n184 @WIRE(mode="straight") {#X145:2 %t742:p};
// %t743 = $IO_PORT @ATTACH &n186 => @PLACE(681, -240) => @ORIENT("MY");
// %t743 @TEXT("n186", key="name", size=0.75);
// &n186 @WIRE(mode="straight") {#X145:3 %t743:p};
// %t744 = $SUPPLY @ATTACH &vdd => @PLACE(670, -229);
// &vdd @WIRE(mode="straight") {#X145:4 %t744:p};
// %t745 = $GROUND @ATTACH &vss => @PLACE(670, -251);
// &vss @WIRE(mode="straight") {#X145:5 %t745:p};
// %t746 = $IO_PORT @ATTACH &n186 => @PLACE(729, -238) => @ORIENT("R0");
// %t746 @TEXT("n186", key="name", size=0.75);
// &n186 @WIRE(mode="straight") {#X146:1 %t746:p};
// %t747 = $IO_PORT @ATTACH &n185 => @PLACE(729, -242) => @ORIENT("R0");
// %t747 @TEXT("n185", key="name", size=0.75);
// &n185 @WIRE(mode="straight") {#X146:2 %t747:p};
// %t748 = $IO_PORT @ATTACH &n187 => @PLACE(751, -240) => @ORIENT("MY");
// %t748 @TEXT("n187", key="name", size=0.75);
// &n187 @WIRE(mode="straight") {#X146:3 %t748:p};
// %t749 = $SUPPLY @ATTACH &vdd => @PLACE(740, -229);
// &vdd @WIRE(mode="straight") {#X146:4 %t749:p};
// %t750 = $GROUND @ATTACH &vss => @PLACE(740, -251);
// &vss @WIRE(mode="straight") {#X146:5 %t750:p};
// %t751 = $IO_PORT @ATTACH &n69 => @PLACE(799, -238) => @ORIENT("R0");
// %t751 @TEXT("n69", key="name", size=0.75);
// &n69 @WIRE(mode="straight") {#X147:1 %t751:p};
// %t752 = $IO_PORT @ATTACH &n49 => @PLACE(799, -242) => @ORIENT("R0");
// %t752 @TEXT("n49", key="name", size=0.75);
// &n49 @WIRE(mode="straight") {#X147:2 %t752:p};
// %t753 = $IO_PORT @ATTACH &n188 => @PLACE(821, -240) => @ORIENT("MY");
// %t753 @TEXT("n188", key="name", size=0.75);
// &n188 @WIRE(mode="straight") {#X147:3 %t753:p};
// %t754 = $SUPPLY @ATTACH &vdd => @PLACE(810, -229);
// &vdd @WIRE(mode="straight") {#X147:4 %t754:p};
// %t755 = $GROUND @ATTACH &vss => @PLACE(810, -251);
// &vss @WIRE(mode="straight") {#X147:5 %t755:p};
// %t756 = $IO_PORT @ATTACH &n51 => @PLACE(589, -273) => @ORIENT("R0");
// %t756 @TEXT("n51", key="name", size=0.75);
// &n51 @WIRE(mode="straight") {#X148:1 %t756:p};
// %t757 = $IO_PORT @ATTACH &n53 => @PLACE(589, -277) => @ORIENT("R0");
// %t757 @TEXT("n53", key="name", size=0.75);
// &n53 @WIRE(mode="straight") {#X148:2 %t757:p};
// %t758 = $IO_PORT @ATTACH &n189 => @PLACE(611, -275) => @ORIENT("MY");
// %t758 @TEXT("n189", key="name", size=0.75);
// &n189 @WIRE(mode="straight") {#X148:3 %t758:p};
// %t759 = $SUPPLY @ATTACH &vdd => @PLACE(600, -264);
// &vdd @WIRE(mode="straight") {#X148:4 %t759:p};
// %t760 = $GROUND @ATTACH &vss => @PLACE(600, -286);
// &vss @WIRE(mode="straight") {#X148:5 %t760:p};
// %t761 = $IO_PORT @ATTACH &n188 => @PLACE(659, -273) => @ORIENT("R0");
// %t761 @TEXT("n188", key="name", size=0.75);
// &n188 @WIRE(mode="straight") {#X149:1 %t761:p};
// %t762 = $IO_PORT @ATTACH &n189 => @PLACE(659, -277) => @ORIENT("R0");
// %t762 @TEXT("n189", key="name", size=0.75);
// &n189 @WIRE(mode="straight") {#X149:2 %t762:p};
// %t763 = $IO_PORT @ATTACH &n190 => @PLACE(681, -275) => @ORIENT("MY");
// %t763 @TEXT("n190", key="name", size=0.75);
// &n190 @WIRE(mode="straight") {#X149:3 %t763:p};
// %t764 = $SUPPLY @ATTACH &vdd => @PLACE(670, -264);
// &vdd @WIRE(mode="straight") {#X149:4 %t764:p};
// %t765 = $GROUND @ATTACH &vss => @PLACE(670, -286);
// &vss @WIRE(mode="straight") {#X149:5 %t765:p};
// %t766 = $IO_PORT @ATTACH &n69 => @PLACE(729, -273) => @ORIENT("R0");
// %t766 @TEXT("n69", key="name", size=0.75);
// &n69 @WIRE(mode="straight") {#X150:1 %t766:p};
// %t767 = $IO_PORT @ATTACH &n191 => @PLACE(729, -277) => @ORIENT("R0");
// %t767 @TEXT("n191", key="name", size=0.75);
// &n191 @WIRE(mode="straight") {#X150:2 %t767:p};
// %t768 = $IO_PORT @ATTACH &n192 => @PLACE(751, -275) => @ORIENT("MY");
// %t768 @TEXT("n192", key="name", size=0.75);
// &n192 @WIRE(mode="straight") {#X150:3 %t768:p};
// %t769 = $SUPPLY @ATTACH &vdd => @PLACE(740, -264);
// &vdd @WIRE(mode="straight") {#X150:4 %t769:p};
// %t770 = $GROUND @ATTACH &vss => @PLACE(740, -286);
// &vss @WIRE(mode="straight") {#X150:5 %t770:p};
// %t771 = $IO_PORT @ATTACH &n80 => @PLACE(799, -273) => @ORIENT("R0");
// %t771 @TEXT("n80", key="name", size=0.75);
// &n80 @WIRE(mode="straight") {#X151:1 %t771:p};
// %t772 = $IO_PORT @ATTACH &n53 => @PLACE(799, -277) => @ORIENT("R0");
// %t772 @TEXT("n53", key="name", size=0.75);
// &n53 @WIRE(mode="straight") {#X151:2 %t772:p};
// %t773 = $IO_PORT @ATTACH &n193 => @PLACE(821, -275) => @ORIENT("MY");
// %t773 @TEXT("n193", key="name", size=0.75);
// &n193 @WIRE(mode="straight") {#X151:3 %t773:p};
// %t774 = $SUPPLY @ATTACH &vdd => @PLACE(810, -264);
// &vdd @WIRE(mode="straight") {#X151:4 %t774:p};
// %t775 = $GROUND @ATTACH &vss => @PLACE(810, -286);
// &vss @WIRE(mode="straight") {#X151:5 %t775:p};
// %t776 = $IO_PORT @ATTACH &n192 => @PLACE(589, -308) => @ORIENT("R0");
// %t776 @TEXT("n192", key="name", size=0.75);
// &n192 @WIRE(mode="straight") {#X152:1 %t776:p};
// %t777 = $IO_PORT @ATTACH &n193 => @PLACE(589, -312) => @ORIENT("R0");
// %t777 @TEXT("n193", key="name", size=0.75);
// &n193 @WIRE(mode="straight") {#X152:2 %t777:p};
// %t778 = $IO_PORT @ATTACH &n182 => @PLACE(611, -310) => @ORIENT("MY");
// %t778 @TEXT("n182", key="name", size=0.75);
// &n182 @WIRE(mode="straight") {#X152:3 %t778:p};
// %t779 = $SUPPLY @ATTACH &vdd => @PLACE(600, -299);
// &vdd @WIRE(mode="straight") {#X152:4 %t779:p};
// %t780 = $GROUND @ATTACH &vss => @PLACE(600, -321);
// &vss @WIRE(mode="straight") {#X152:5 %t780:p};
// %t781 = $IO_PORT @ATTACH &n194 => @PLACE(659, -308) => @ORIENT("R0");
// %t781 @TEXT("n194", key="name", size=0.75);
// &n194 @WIRE(mode="straight") {#X153:1 %t781:p};
// %t782 = $IO_PORT @ATTACH &n114 => @PLACE(659, -312) => @ORIENT("R0");
// %t782 @TEXT("n114", key="name", size=0.75);
// &n114 @WIRE(mode="straight") {#X153:2 %t782:p};
// %t783 = $IO_PORT @ATTACH &n134 => @PLACE(681, -310) => @ORIENT("MY");
// %t783 @TEXT("n134", key="name", size=0.75);
// &n134 @WIRE(mode="straight") {#X153:3 %t783:p};
// %t784 = $SUPPLY @ATTACH &vdd => @PLACE(670, -299);
// &vdd @WIRE(mode="straight") {#X153:4 %t784:p};
// %t785 = $GROUND @ATTACH &vss => @PLACE(670, -321);
// &vss @WIRE(mode="straight") {#X153:5 %t785:p};
// %t786 = $IO_PORT @ATTACH &n195 => @PLACE(729, -308) => @ORIENT("R0");
// %t786 @TEXT("n195", key="name", size=0.75);
// &n195 @WIRE(mode="straight") {#X154:1 %t786:p};
// %t787 = $IO_PORT @ATTACH &n134 => @PLACE(729, -312) => @ORIENT("R0");
// %t787 @TEXT("n134", key="name", size=0.75);
// &n134 @WIRE(mode="straight") {#X154:2 %t787:p};
// %t788 = $IO_PORT @ATTACH &n196 => @PLACE(751, -310) => @ORIENT("MY");
// %t788 @TEXT("n196", key="name", size=0.75);
// &n196 @WIRE(mode="straight") {#X154:3 %t788:p};
// %t789 = $SUPPLY @ATTACH &vdd => @PLACE(740, -299);
// &vdd @WIRE(mode="straight") {#X154:4 %t789:p};
// %t790 = $GROUND @ATTACH &vss => @PLACE(740, -321);
// &vss @WIRE(mode="straight") {#X154:5 %t790:p};
// %t791 = $IO_PORT @ATTACH &n149 => @PLACE(799, -308) => @ORIENT("R0");
// %t791 @TEXT("n149", key="name", size=0.75);
// &n149 @WIRE(mode="straight") {#X155:1 %t791:p};
// %t792 = $IO_PORT @ATTACH &n122 => @PLACE(799, -312) => @ORIENT("R0");
// %t792 @TEXT("n122", key="name", size=0.75);
// &n122 @WIRE(mode="straight") {#X155:2 %t792:p};
// %t793 = $IO_PORT @ATTACH &n194 => @PLACE(821, -310) => @ORIENT("MY");
// %t793 @TEXT("n194", key="name", size=0.75);
// &n194 @WIRE(mode="straight") {#X155:3 %t793:p};
// %t794 = $SUPPLY @ATTACH &vdd => @PLACE(810, -299);
// &vdd @WIRE(mode="straight") {#X155:4 %t794:p};
// %t795 = $GROUND @ATTACH &vss => @PLACE(810, -321);
// &vss @WIRE(mode="straight") {#X155:5 %t795:p};
// %t796 = $IO_PORT @ATTACH &n194 => @PLACE(589, -343) => @ORIENT("R0");
// %t796 @TEXT("n194", key="name", size=0.75);
// &n194 @WIRE(mode="straight") {#X156:1 %t796:p};
// %t797 = $IO_PORT @ATTACH &n120 => @PLACE(589, -347) => @ORIENT("R0");
// %t797 @TEXT("n120", key="name", size=0.75);
// &n120 @WIRE(mode="straight") {#X156:2 %t797:p};
// %t798 = $IO_PORT @ATTACH &n197 => @PLACE(611, -345) => @ORIENT("MY");
// %t798 @TEXT("n197", key="name", size=0.75);
// &n197 @WIRE(mode="straight") {#X156:3 %t798:p};
// %t799 = $SUPPLY @ATTACH &vdd => @PLACE(600, -334);
// &vdd @WIRE(mode="straight") {#X156:4 %t799:p};
// %t800 = $GROUND @ATTACH &vss => @PLACE(600, -356);
// &vss @WIRE(mode="straight") {#X156:5 %t800:p};
// %t801 = $IO_PORT @ATTACH &n104 => @PLACE(659, -343) => @ORIENT("R0");
// %t801 @TEXT("n104", key="name", size=0.75);
// &n104 @WIRE(mode="straight") {#X157:1 %t801:p};
// %t802 = $IO_PORT @ATTACH &n197 => @PLACE(659, -347) => @ORIENT("R0");
// %t802 @TEXT("n197", key="name", size=0.75);
// &n197 @WIRE(mode="straight") {#X157:2 %t802:p};
// %t803 = $IO_PORT @ATTACH &n198 => @PLACE(681, -345) => @ORIENT("MY");
// %t803 @TEXT("n198", key="name", size=0.75);
// &n198 @WIRE(mode="straight") {#X157:3 %t803:p};
// %t804 = $SUPPLY @ATTACH &vdd => @PLACE(670, -334);
// &vdd @WIRE(mode="straight") {#X157:4 %t804:p};
// %t805 = $GROUND @ATTACH &vss => @PLACE(670, -356);
// &vss @WIRE(mode="straight") {#X157:5 %t805:p};
// %t806 = $IO_PORT @ATTACH &n75 => @PLACE(729, -343) => @ORIENT("R0");
// %t806 @TEXT("n75", key="name", size=0.75);
// &n75 @WIRE(mode="straight") {#X158:1 %t806:p};
// %t807 = $IO_PORT @ATTACH &n74 => @PLACE(729, -347) => @ORIENT("R0");
// %t807 @TEXT("n74", key="name", size=0.75);
// &n74 @WIRE(mode="straight") {#X158:2 %t807:p};
// %t808 = $IO_PORT @ATTACH &n199 => @PLACE(751, -345) => @ORIENT("MY");
// %t808 @TEXT("n199", key="name", size=0.75);
// &n199 @WIRE(mode="straight") {#X158:3 %t808:p};
// %t809 = $SUPPLY @ATTACH &vdd => @PLACE(740, -334);
// &vdd @WIRE(mode="straight") {#X158:4 %t809:p};
// %t810 = $GROUND @ATTACH &vss => @PLACE(740, -356);
// &vss @WIRE(mode="straight") {#X158:5 %t810:p};
// %t811 = $IO_PORT @ATTACH &n199 => @PLACE(799, -343) => @ORIENT("R0");
// %t811 @TEXT("n199", key="name", size=0.75);
// &n199 @WIRE(mode="straight") {#X159:1 %t811:p};
// %t812 = $IO_PORT @ATTACH &n117 => @PLACE(799, -347) => @ORIENT("R0");
// %t812 @TEXT("n117", key="name", size=0.75);
// &n117 @WIRE(mode="straight") {#X159:2 %t812:p};
// %t813 = $IO_PORT @ATTACH &n200 => @PLACE(821, -345) => @ORIENT("MY");
// %t813 @TEXT("n200", key="name", size=0.75);
// &n200 @WIRE(mode="straight") {#X159:3 %t813:p};
// %t814 = $SUPPLY @ATTACH &vdd => @PLACE(810, -334);
// &vdd @WIRE(mode="straight") {#X159:4 %t814:p};
// %t815 = $GROUND @ATTACH &vss => @PLACE(810, -356);
// &vss @WIRE(mode="straight") {#X159:5 %t815:p};
// %t816 = $IO_PORT @ATTACH &n200 => @PLACE(589, -378) => @ORIENT("R0");
// %t816 @TEXT("n200", key="name", size=0.75);
// &n200 @WIRE(mode="straight") {#X160:1 %t816:p};
// %t817 = $IO_PORT @ATTACH &n116 => @PLACE(589, -382) => @ORIENT("R0");
// %t817 @TEXT("n116", key="name", size=0.75);
// &n116 @WIRE(mode="straight") {#X160:2 %t817:p};
// %t818 = $IO_PORT @ATTACH &n142 => @PLACE(611, -380) => @ORIENT("MY");
// %t818 @TEXT("n142", key="name", size=0.75);
// &n142 @WIRE(mode="straight") {#X160:3 %t818:p};
// %t819 = $SUPPLY @ATTACH &vdd => @PLACE(600, -369);
// &vdd @WIRE(mode="straight") {#X160:4 %t819:p};
// %t820 = $GROUND @ATTACH &vss => @PLACE(600, -391);
// &vss @WIRE(mode="straight") {#X160:5 %t820:p};
// %t821 = $IO_PORT @ATTACH &n201 => @PLACE(659, -378) => @ORIENT("R0");
// %t821 @TEXT("n201", key="name", size=0.75);
// &n201 @WIRE(mode="straight") {#X161:1 %t821:p};
// %t822 = $IO_PORT @ATTACH &n142 => @PLACE(659, -382) => @ORIENT("R0");
// %t822 @TEXT("n142", key="name", size=0.75);
// &n142 @WIRE(mode="straight") {#X161:2 %t822:p};
// %t823 = $IO_PORT @ATTACH &n202 => @PLACE(681, -380) => @ORIENT("MY");
// %t823 @TEXT("n202", key="name", size=0.75);
// &n202 @WIRE(mode="straight") {#X161:3 %t823:p};
// %t824 = $SUPPLY @ATTACH &vdd => @PLACE(670, -369);
// &vdd @WIRE(mode="straight") {#X161:4 %t824:p};
// %t825 = $GROUND @ATTACH &vss => @PLACE(670, -391);
// &vss @WIRE(mode="straight") {#X161:5 %t825:p};
// %t826 = $IO_PORT @ATTACH &n128 => @PLACE(729, -378) => @ORIENT("R0");
// %t826 @TEXT("n128", key="name", size=0.75);
// &n128 @WIRE(mode="straight") {#X162:1 %t826:p};
// %t827 = $IO_PORT @ATTACH &n116 => @PLACE(729, -382) => @ORIENT("R0");
// %t827 @TEXT("n116", key="name", size=0.75);
// &n116 @WIRE(mode="straight") {#X162:2 %t827:p};
// %t828 = $IO_PORT @ATTACH &n147 => @PLACE(751, -380) => @ORIENT("MY");
// %t828 @TEXT("n147", key="name", size=0.75);
// &n147 @WIRE(mode="straight") {#X162:3 %t828:p};
// %t829 = $SUPPLY @ATTACH &vdd => @PLACE(740, -369);
// &vdd @WIRE(mode="straight") {#X162:4 %t829:p};
// %t830 = $GROUND @ATTACH &vss => @PLACE(740, -391);
// &vss @WIRE(mode="straight") {#X162:5 %t830:p};
// %t831 = $IO_PORT @ATTACH &n203 => @PLACE(799, -378) => @ORIENT("R0");
// %t831 @TEXT("n203", key="name", size=0.75);
// &n203 @WIRE(mode="straight") {#X163:1 %t831:p};
// %t832 = $IO_PORT @ATTACH &n147 => @PLACE(799, -382) => @ORIENT("R0");
// %t832 @TEXT("n147", key="name", size=0.75);
// &n147 @WIRE(mode="straight") {#X163:2 %t832:p};
// %t833 = $IO_PORT @ATTACH &n204 => @PLACE(821, -380) => @ORIENT("MY");
// %t833 @TEXT("n204", key="name", size=0.75);
// &n204 @WIRE(mode="straight") {#X163:3 %t833:p};
// %t834 = $SUPPLY @ATTACH &vdd => @PLACE(810, -369);
// &vdd @WIRE(mode="straight") {#X163:4 %t834:p};
// %t835 = $GROUND @ATTACH &vss => @PLACE(810, -391);
// &vss @WIRE(mode="straight") {#X163:5 %t835:p};
// %t836 = $IO_PORT @ATTACH &n130 => @PLACE(589, -413) => @ORIENT("R0");
// %t836 @TEXT("n130", key="name", size=0.75);
// &n130 @WIRE(mode="straight") {#X164:1 %t836:p};
// %t837 = $IO_PORT @ATTACH &n122 => @PLACE(589, -417) => @ORIENT("R0");
// %t837 @TEXT("n122", key="name", size=0.75);
// &n122 @WIRE(mode="straight") {#X164:2 %t837:p};
// %t838 = $IO_PORT @ATTACH &n136 => @PLACE(611, -415) => @ORIENT("MY");
// %t838 @TEXT("n136", key="name", size=0.75);
// &n136 @WIRE(mode="straight") {#X164:3 %t838:p};
// %t839 = $SUPPLY @ATTACH &vdd => @PLACE(600, -404);
// &vdd @WIRE(mode="straight") {#X164:4 %t839:p};
// %t840 = $GROUND @ATTACH &vss => @PLACE(600, -426);
// &vss @WIRE(mode="straight") {#X164:5 %t840:p};
// %t841 = $IO_PORT @ATTACH &n136 => @PLACE(659, -413) => @ORIENT("R0");
// %t841 @TEXT("n136", key="name", size=0.75);
// &n136 @WIRE(mode="straight") {#X165:1 %t841:p};
// %t842 = $IO_PORT @ATTACH &n116 => @PLACE(659, -417) => @ORIENT("R0");
// %t842 @TEXT("n116", key="name", size=0.75);
// &n116 @WIRE(mode="straight") {#X165:2 %t842:p};
// %t843 = $IO_PORT @ATTACH &n205 => @PLACE(681, -415) => @ORIENT("MY");
// %t843 @TEXT("n205", key="name", size=0.75);
// &n205 @WIRE(mode="straight") {#X165:3 %t843:p};
// %t844 = $SUPPLY @ATTACH &vdd => @PLACE(670, -404);
// &vdd @WIRE(mode="straight") {#X165:4 %t844:p};
// %t845 = $GROUND @ATTACH &vss => @PLACE(670, -426);
// &vss @WIRE(mode="straight") {#X165:5 %t845:p};
// %t846 = $IO_PORT @ATTACH &n98 => @PLACE(729, -413) => @ORIENT("R0");
// %t846 @TEXT("n98", key="name", size=0.75);
// &n98 @WIRE(mode="straight") {#X166:1 %t846:p};
// %t847 = $IO_PORT @ATTACH &n205 => @PLACE(729, -417) => @ORIENT("R0");
// %t847 @TEXT("n205", key="name", size=0.75);
// &n205 @WIRE(mode="straight") {#X166:2 %t847:p};
// %t848 = $IO_PORT @ATTACH &n206 => @PLACE(751, -415) => @ORIENT("MY");
// %t848 @TEXT("n206", key="name", size=0.75);
// &n206 @WIRE(mode="straight") {#X166:3 %t848:p};
// %t849 = $SUPPLY @ATTACH &vdd => @PLACE(740, -404);
// &vdd @WIRE(mode="straight") {#X166:4 %t849:p};
// %t850 = $GROUND @ATTACH &vss => @PLACE(740, -426);
// &vss @WIRE(mode="straight") {#X166:5 %t850:p};
// %t851 = $IO_PORT @ATTACH &n207 => @PLACE(799, -413) => @ORIENT("R0");
// %t851 @TEXT("n207", key="name", size=0.75);
// &n207 @WIRE(mode="straight") {#X167:1 %t851:p};
// %t852 = $IO_PORT @ATTACH &n117 => @PLACE(799, -417) => @ORIENT("R0");
// %t852 @TEXT("n117", key="name", size=0.75);
// &n117 @WIRE(mode="straight") {#X167:2 %t852:p};
// %t853 = $IO_PORT @ATTACH &n208 => @PLACE(821, -415) => @ORIENT("MY");
// %t853 @TEXT("n208", key="name", size=0.75);
// &n208 @WIRE(mode="straight") {#X167:3 %t853:p};
// %t854 = $SUPPLY @ATTACH &vdd => @PLACE(810, -404);
// &vdd @WIRE(mode="straight") {#X167:4 %t854:p};
// %t855 = $GROUND @ATTACH &vss => @PLACE(810, -426);
// &vss @WIRE(mode="straight") {#X167:5 %t855:p};
// %t856 = $IO_PORT @ATTACH &n208 => @PLACE(889, -238) => @ORIENT("R0");
// %t856 @TEXT("n208", key="name", size=0.75);
// &n208 @WIRE(mode="straight") {#X168:1 %t856:p};
// %t857 = $IO_PORT @ATTACH &n114 => @PLACE(889, -242) => @ORIENT("R0");
// %t857 @TEXT("n114", key="name", size=0.75);
// &n114 @WIRE(mode="straight") {#X168:2 %t857:p};
// %t858 = $IO_PORT @ATTACH &n154 => @PLACE(911, -240) => @ORIENT("MY");
// %t858 @TEXT("n154", key="name", size=0.75);
// &n154 @WIRE(mode="straight") {#X168:3 %t858:p};
// %t859 = $SUPPLY @ATTACH &vdd => @PLACE(900, -229);
// &vdd @WIRE(mode="straight") {#X168:4 %t859:p};
// %t860 = $GROUND @ATTACH &vss => @PLACE(900, -251);
// &vss @WIRE(mode="straight") {#X168:5 %t860:p};
// %t861 = $IO_PORT @ATTACH &n209 => @PLACE(959, -238) => @ORIENT("R0");
// %t861 @TEXT("n209", key="name", size=0.75);
// &n209 @WIRE(mode="straight") {#X169:1 %t861:p};
// %t862 = $IO_PORT @ATTACH &n154 => @PLACE(959, -242) => @ORIENT("R0");
// %t862 @TEXT("n154", key="name", size=0.75);
// &n154 @WIRE(mode="straight") {#X169:2 %t862:p};
// %t863 = $IO_PORT @ATTACH &n210 => @PLACE(981, -240) => @ORIENT("MY");
// %t863 @TEXT("n210", key="name", size=0.75);
// &n210 @WIRE(mode="straight") {#X169:3 %t863:p};
// %t864 = $SUPPLY @ATTACH &vdd => @PLACE(970, -229);
// &vdd @WIRE(mode="straight") {#X169:4 %t864:p};
// %t865 = $GROUND @ATTACH &vss => @PLACE(970, -251);
// &vss @WIRE(mode="straight") {#X169:5 %t865:p};
// %t866 = $IO_PORT @ATTACH &n75 => @PLACE(1029, -238) => @ORIENT("R0");
// %t866 @TEXT("n75", key="name", size=0.75);
// &n75 @WIRE(mode="straight") {#X170:1 %t866:p};
// %t867 = $IO_PORT @ATTACH &active_k1 => @PLACE(1029, -242) => @ORIENT("R0");
// %t867 @TEXT("active_k1", key="name", size=0.75);
// &active_k1 @WIRE(mode="straight") {#X170:2 %t867:p};
// %t868 = $IO_PORT @ATTACH &n207 => @PLACE(1051, -240) => @ORIENT("MY");
// %t868 @TEXT("n207", key="name", size=0.75);
// &n207 @WIRE(mode="straight") {#X170:3 %t868:p};
// %t869 = $SUPPLY @ATTACH &vdd => @PLACE(1040, -229);
// &vdd @WIRE(mode="straight") {#X170:4 %t869:p};
// %t870 = $GROUND @ATTACH &vss => @PLACE(1040, -251);
// &vss @WIRE(mode="straight") {#X170:5 %t870:p};
// %t871 = $IO_PORT @ATTACH &n207 => @PLACE(1099, -238) => @ORIENT("R0");
// %t871 @TEXT("n207", key="name", size=0.75);
// &n207 @WIRE(mode="straight") {#X171:1 %t871:p};
// %t872 = $IO_PORT @ATTACH &n129 => @PLACE(1099, -242) => @ORIENT("R0");
// %t872 @TEXT("n129", key="name", size=0.75);
// &n129 @WIRE(mode="straight") {#X171:2 %t872:p};
// %t873 = $IO_PORT @ATTACH &n211 => @PLACE(1121, -240) => @ORIENT("MY");
// %t873 @TEXT("n211", key="name", size=0.75);
// &n211 @WIRE(mode="straight") {#X171:3 %t873:p};
// %t874 = $SUPPLY @ATTACH &vdd => @PLACE(1110, -229);
// &vdd @WIRE(mode="straight") {#X171:4 %t874:p};
// %t875 = $GROUND @ATTACH &vss => @PLACE(1110, -251);
// &vss @WIRE(mode="straight") {#X171:5 %t875:p};
// %t876 = $IO_PORT @ATTACH &n211 => @PLACE(889, -273) => @ORIENT("R0");
// %t876 @TEXT("n211", key="name", size=0.75);
// &n211 @WIRE(mode="straight") {#X172:1 %t876:p};
// %t877 = $IO_PORT @ATTACH &n116 => @PLACE(889, -277) => @ORIENT("R0");
// %t877 @TEXT("n116", key="name", size=0.75);
// &n116 @WIRE(mode="straight") {#X172:2 %t877:p};
// %t878 = $IO_PORT @ATTACH &n212 => @PLACE(911, -275) => @ORIENT("MY");
// %t878 @TEXT("n212", key="name", size=0.75);
// &n212 @WIRE(mode="straight") {#X172:3 %t878:p};
// %t879 = $SUPPLY @ATTACH &vdd => @PLACE(900, -264);
// &vdd @WIRE(mode="straight") {#X172:4 %t879:p};
// %t880 = $GROUND @ATTACH &vss => @PLACE(900, -286);
// &vss @WIRE(mode="straight") {#X172:5 %t880:p};
// %t881 = $IO_PORT @ATTACH &n94 => @PLACE(959, -273) => @ORIENT("R0");
// %t881 @TEXT("n94", key="name", size=0.75);
// &n94 @WIRE(mode="straight") {#X173:1 %t881:p};
// %t882 = $IO_PORT @ATTACH &n212 => @PLACE(959, -277) => @ORIENT("R0");
// %t882 @TEXT("n212", key="name", size=0.75);
// &n212 @WIRE(mode="straight") {#X173:2 %t882:p};
// %t883 = $IO_PORT @ATTACH &n213 => @PLACE(981, -275) => @ORIENT("MY");
// %t883 @TEXT("n213", key="name", size=0.75);
// &n213 @WIRE(mode="straight") {#X173:3 %t883:p};
// %t884 = $SUPPLY @ATTACH &vdd => @PLACE(970, -264);
// &vdd @WIRE(mode="straight") {#X173:4 %t884:p};
// %t885 = $GROUND @ATTACH &vss => @PLACE(970, -286);
// &vss @WIRE(mode="straight") {#X173:5 %t885:p};
// %t886 = $IO_PORT @ATTACH &n200 => @PLACE(1029, -273) => @ORIENT("R0");
// %t886 @TEXT("n200", key="name", size=0.75);
// &n200 @WIRE(mode="straight") {#X174:1 %t886:p};
// %t887 = $IO_PORT @ATTACH &n114 => @PLACE(1029, -277) => @ORIENT("R0");
// %t887 @TEXT("n114", key="name", size=0.75);
// &n114 @WIRE(mode="straight") {#X174:2 %t887:p};
// %t888 = $IO_PORT @ATTACH &n169 => @PLACE(1051, -275) => @ORIENT("MY");
// %t888 @TEXT("n169", key="name", size=0.75);
// &n169 @WIRE(mode="straight") {#X174:3 %t888:p};
// %t889 = $SUPPLY @ATTACH &vdd => @PLACE(1040, -264);
// &vdd @WIRE(mode="straight") {#X174:4 %t889:p};
// %t890 = $GROUND @ATTACH &vss => @PLACE(1040, -286);
// &vss @WIRE(mode="straight") {#X174:5 %t890:p};
// %t891 = $IO_PORT @ATTACH &n214 => @PLACE(1099, -273) => @ORIENT("R0");
// %t891 @TEXT("n214", key="name", size=0.75);
// &n214 @WIRE(mode="straight") {#X175:1 %t891:p};
// %t892 = $IO_PORT @ATTACH &n169 => @PLACE(1099, -277) => @ORIENT("R0");
// %t892 @TEXT("n169", key="name", size=0.75);
// &n169 @WIRE(mode="straight") {#X175:2 %t892:p};
// %t893 = $IO_PORT @ATTACH &n215 => @PLACE(1121, -275) => @ORIENT("MY");
// %t893 @TEXT("n215", key="name", size=0.75);
// &n215 @WIRE(mode="straight") {#X175:3 %t893:p};
// %t894 = $SUPPLY @ATTACH &vdd => @PLACE(1110, -264);
// &vdd @WIRE(mode="straight") {#X175:4 %t894:p};
// %t895 = $GROUND @ATTACH &vss => @PLACE(1110, -286);
// &vss @WIRE(mode="straight") {#X175:5 %t895:p};
// %t896 = $IO_PORT @ATTACH &n149 => @PLACE(889, -308) => @ORIENT("R0");
// %t896 @TEXT("n149", key="name", size=0.75);
// &n149 @WIRE(mode="straight") {#X176:1 %t896:p};
// %t897 = $IO_PORT @ATTACH &n117 => @PLACE(889, -312) => @ORIENT("R0");
// %t897 @TEXT("n117", key="name", size=0.75);
// &n117 @WIRE(mode="straight") {#X176:2 %t897:p};
// %t898 = $IO_PORT @ATTACH &n216 => @PLACE(911, -310) => @ORIENT("MY");
// %t898 @TEXT("n216", key="name", size=0.75);
// &n216 @WIRE(mode="straight") {#X176:3 %t898:p};
// %t899 = $SUPPLY @ATTACH &vdd => @PLACE(900, -299);
// &vdd @WIRE(mode="straight") {#X176:4 %t899:p};
// %t900 = $GROUND @ATTACH &vss => @PLACE(900, -321);
// &vss @WIRE(mode="straight") {#X176:5 %t900:p};
// %t901 = $IO_PORT @ATTACH &n216 => @PLACE(959, -308) => @ORIENT("R0");
// %t901 @TEXT("n216", key="name", size=0.75);
// &n216 @WIRE(mode="straight") {#X177:1 %t901:p};
// %t902 = $IO_PORT @ATTACH &n114 => @PLACE(959, -312) => @ORIENT("R0");
// %t902 @TEXT("n114", key="name", size=0.75);
// &n114 @WIRE(mode="straight") {#X177:2 %t902:p};
// %t903 = $IO_PORT @ATTACH &n217 => @PLACE(981, -310) => @ORIENT("MY");
// %t903 @TEXT("n217", key="name", size=0.75);
// &n217 @WIRE(mode="straight") {#X177:3 %t903:p};
// %t904 = $SUPPLY @ATTACH &vdd => @PLACE(970, -299);
// &vdd @WIRE(mode="straight") {#X177:4 %t904:p};
// %t905 = $GROUND @ATTACH &vss => @PLACE(970, -321);
// &vss @WIRE(mode="straight") {#X177:5 %t905:p};
// %t906 = $IO_PORT @ATTACH &n90 => @PLACE(1029, -308) => @ORIENT("R0");
// %t906 @TEXT("n90", key="name", size=0.75);
// &n90 @WIRE(mode="straight") {#X178:1 %t906:p};
// %t907 = $IO_PORT @ATTACH &n217 => @PLACE(1029, -312) => @ORIENT("R0");
// %t907 @TEXT("n217", key="name", size=0.75);
// &n217 @WIRE(mode="straight") {#X178:2 %t907:p};
// %t908 = $IO_PORT @ATTACH &n218 => @PLACE(1051, -310) => @ORIENT("MY");
// %t908 @TEXT("n218", key="name", size=0.75);
// &n218 @WIRE(mode="straight") {#X178:3 %t908:p};
// %t909 = $SUPPLY @ATTACH &vdd => @PLACE(1040, -299);
// &vdd @WIRE(mode="straight") {#X178:4 %t909:p};
// %t910 = $GROUND @ATTACH &vss => @PLACE(1040, -321);
// &vss @WIRE(mode="straight") {#X178:5 %t910:p};
// %t911 = $IO_PORT @ATTACH &n207 => @PLACE(1099, -308) => @ORIENT("R0");
// %t911 @TEXT("n207", key="name", size=0.75);
// &n207 @WIRE(mode="straight") {#X179:1 %t911:p};
// %t912 = $IO_PORT @ATTACH &n122 => @PLACE(1099, -312) => @ORIENT("R0");
// %t912 @TEXT("n122", key="name", size=0.75);
// &n122 @WIRE(mode="straight") {#X179:2 %t912:p};
// %t913 = $IO_PORT @ATTACH &n219 => @PLACE(1121, -310) => @ORIENT("MY");
// %t913 @TEXT("n219", key="name", size=0.75);
// &n219 @WIRE(mode="straight") {#X179:3 %t913:p};
// %t914 = $SUPPLY @ATTACH &vdd => @PLACE(1110, -299);
// &vdd @WIRE(mode="straight") {#X179:4 %t914:p};
// %t915 = $GROUND @ATTACH &vss => @PLACE(1110, -321);
// &vss @WIRE(mode="straight") {#X179:5 %t915:p};
// %t916 = $IO_PORT @ATTACH &n219 => @PLACE(889, -343) => @ORIENT("R0");
// %t916 @TEXT("n219", key="name", size=0.75);
// &n219 @WIRE(mode="straight") {#X180:1 %t916:p};
// %t917 = $IO_PORT @ATTACH &n114 => @PLACE(889, -347) => @ORIENT("R0");
// %t917 @TEXT("n114", key="name", size=0.75);
// &n114 @WIRE(mode="straight") {#X180:2 %t917:p};
// %t918 = $IO_PORT @ATTACH &n171 => @PLACE(911, -345) => @ORIENT("MY");
// %t918 @TEXT("n171", key="name", size=0.75);
// &n171 @WIRE(mode="straight") {#X180:3 %t918:p};
// %t919 = $SUPPLY @ATTACH &vdd => @PLACE(900, -334);
// &vdd @WIRE(mode="straight") {#X180:4 %t919:p};
// %t920 = $GROUND @ATTACH &vss => @PLACE(900, -356);
// &vss @WIRE(mode="straight") {#X180:5 %t920:p};
// %t921 = $IO_PORT @ATTACH &n220 => @PLACE(959, -343) => @ORIENT("R0");
// %t921 @TEXT("n220", key="name", size=0.75);
// &n220 @WIRE(mode="straight") {#X181:1 %t921:p};
// %t922 = $IO_PORT @ATTACH &n171 => @PLACE(959, -347) => @ORIENT("R0");
// %t922 @TEXT("n171", key="name", size=0.75);
// &n171 @WIRE(mode="straight") {#X181:2 %t922:p};
// %t923 = $IO_PORT @ATTACH &n221 => @PLACE(981, -345) => @ORIENT("MY");
// %t923 @TEXT("n221", key="name", size=0.75);
// &n221 @WIRE(mode="straight") {#X181:3 %t923:p};
// %t924 = $SUPPLY @ATTACH &vdd => @PLACE(970, -334);
// &vdd @WIRE(mode="straight") {#X181:4 %t924:p};
// %t925 = $GROUND @ATTACH &vss => @PLACE(970, -356);
// &vss @WIRE(mode="straight") {#X181:5 %t925:p};
// %t926 = $IO_PORT @ATTACH &n136 => @PLACE(1029, -343) => @ORIENT("R0");
// %t926 @TEXT("n136", key="name", size=0.75);
// &n136 @WIRE(mode="straight") {#X182:1 %t926:p};
// %t927 = $IO_PORT @ATTACH &n114 => @PLACE(1029, -347) => @ORIENT("R0");
// %t927 @TEXT("n114", key="name", size=0.75);
// &n114 @WIRE(mode="straight") {#X182:2 %t927:p};
// %t928 = $IO_PORT @ATTACH &n222 => @PLACE(1051, -345) => @ORIENT("MY");
// %t928 @TEXT("n222", key="name", size=0.75);
// &n222 @WIRE(mode="straight") {#X182:3 %t928:p};
// %t929 = $SUPPLY @ATTACH &vdd => @PLACE(1040, -334);
// &vdd @WIRE(mode="straight") {#X182:4 %t929:p};
// %t930 = $GROUND @ATTACH &vss => @PLACE(1040, -356);
// &vss @WIRE(mode="straight") {#X182:5 %t930:p};
// %t931 = $IO_PORT @ATTACH &n86 => @PLACE(1099, -343) => @ORIENT("R0");
// %t931 @TEXT("n86", key="name", size=0.75);
// &n86 @WIRE(mode="straight") {#X183:1 %t931:p};
// %t932 = $IO_PORT @ATTACH &n222 => @PLACE(1099, -347) => @ORIENT("R0");
// %t932 @TEXT("n222", key="name", size=0.75);
// &n222 @WIRE(mode="straight") {#X183:2 %t932:p};
// %t933 = $IO_PORT @ATTACH &n223 => @PLACE(1121, -345) => @ORIENT("MY");
// %t933 @TEXT("n223", key="name", size=0.75);
// &n223 @WIRE(mode="straight") {#X183:3 %t933:p};
// %t934 = $SUPPLY @ATTACH &vdd => @PLACE(1110, -334);
// &vdd @WIRE(mode="straight") {#X183:4 %t934:p};
// %t935 = $GROUND @ATTACH &vss => @PLACE(1110, -356);
// &vss @WIRE(mode="straight") {#X183:5 %t935:p};
// %t936 = $IO_PORT @ATTACH &n71 => @PLACE(889, -378) => @ORIENT("R0");
// %t936 @TEXT("n71", key="name", size=0.75);
// &n71 @WIRE(mode="straight") {#X184:1 %t936:p};
// %t937 = $IO_PORT @ATTACH &n35 => @PLACE(889, -382) => @ORIENT("R0");
// %t937 @TEXT("n35", key="name", size=0.75);
// &n35 @WIRE(mode="straight") {#X184:2 %t937:p};
// %t938 = $IO_PORT @ATTACH &n168 => @PLACE(911, -380) => @ORIENT("MY");
// %t938 @TEXT("n168", key="name", size=0.75);
// &n168 @WIRE(mode="straight") {#X184:3 %t938:p};
// %t939 = $SUPPLY @ATTACH &vdd => @PLACE(900, -369);
// &vdd @WIRE(mode="straight") {#X184:4 %t939:p};
// %t940 = $GROUND @ATTACH &vss => @PLACE(900, -391);
// &vss @WIRE(mode="straight") {#X184:5 %t940:p};
// %t941 = $IO_PORT @ATTACH &n73 => @PLACE(959, -378) => @ORIENT("R0");
// %t941 @TEXT("n73", key="name", size=0.75);
// &n73 @WIRE(mode="straight") {#X185:1 %t941:p};
// %t942 = $IO_PORT @ATTACH &n72 => @PLACE(959, -382) => @ORIENT("R0");
// %t942 @TEXT("n72", key="name", size=0.75);
// &n72 @WIRE(mode="straight") {#X185:2 %t942:p};
// %t943 = $IO_PORT @ATTACH &n158 => @PLACE(981, -380) => @ORIENT("MY");
// %t943 @TEXT("n158", key="name", size=0.75);
// &n158 @WIRE(mode="straight") {#X185:3 %t943:p};
// %t944 = $SUPPLY @ATTACH &vdd => @PLACE(970, -369);
// &vdd @WIRE(mode="straight") {#X185:4 %t944:p};
// %t945 = $GROUND @ATTACH &vss => @PLACE(970, -391);
// &vss @WIRE(mode="straight") {#X185:5 %t945:p};
// %t946 = $IO_PORT @ATTACH &n163 => @PLACE(1029, -378) => @ORIENT("R0");
// %t946 @TEXT("n163", key="name", size=0.75);
// &n163 @WIRE(mode="straight") {#X186:1 %t946:p};
// %t947 = $IO_PORT @ATTACH &n168 => @PLACE(1029, -382) => @ORIENT("R0");
// %t947 @TEXT("n168", key="name", size=0.75);
// &n168 @WIRE(mode="straight") {#X186:2 %t947:p};
// %t948 = $IO_PORT @ATTACH &n224 => @PLACE(1051, -380) => @ORIENT("MY");
// %t948 @TEXT("n224", key="name", size=0.75);
// &n224 @WIRE(mode="straight") {#X186:3 %t948:p};
// %t949 = $SUPPLY @ATTACH &vdd => @PLACE(1040, -369);
// &vdd @WIRE(mode="straight") {#X186:4 %t949:p};
// %t950 = $GROUND @ATTACH &vss => @PLACE(1040, -391);
// &vss @WIRE(mode="straight") {#X186:5 %t950:p};
// %t951 = $IO_PORT @ATTACH &n224 => @PLACE(1099, -378) => @ORIENT("R0");
// %t951 @TEXT("n224", key="name", size=0.75);
// &n224 @WIRE(mode="straight") {#X187:1 %t951:p};
// %t952 = $IO_PORT @ATTACH &n158 => @PLACE(1099, -382) => @ORIENT("R0");
// %t952 @TEXT("n158", key="name", size=0.75);
// &n158 @WIRE(mode="straight") {#X187:2 %t952:p};
// %t953 = $IO_PORT @ATTACH &n173 => @PLACE(1121, -380) => @ORIENT("MY");
// %t953 @TEXT("n173", key="name", size=0.75);
// &n173 @WIRE(mode="straight") {#X187:3 %t953:p};
// %t954 = $SUPPLY @ATTACH &vdd => @PLACE(1110, -369);
// &vdd @WIRE(mode="straight") {#X187:4 %t954:p};
// %t955 = $GROUND @ATTACH &vss => @PLACE(1110, -391);
// &vss @WIRE(mode="straight") {#X187:5 %t955:p};
// %t956 = $IO_PORT @ATTACH &n225 => @PLACE(889, -413) => @ORIENT("R0");
// %t956 @TEXT("n225", key="name", size=0.75);
// &n225 @WIRE(mode="straight") {#X188:1 %t956:p};
// %t957 = $IO_PORT @ATTACH &n173 => @PLACE(889, -417) => @ORIENT("R0");
// %t957 @TEXT("n173", key="name", size=0.75);
// &n173 @WIRE(mode="straight") {#X188:2 %t957:p};
// %t958 = $IO_PORT @ATTACH &n226 => @PLACE(911, -415) => @ORIENT("MY");
// %t958 @TEXT("n226", key="name", size=0.75);
// &n226 @WIRE(mode="straight") {#X188:3 %t958:p};
// %t959 = $SUPPLY @ATTACH &vdd => @PLACE(900, -404);
// &vdd @WIRE(mode="straight") {#X188:4 %t959:p};
// %t960 = $GROUND @ATTACH &vss => @PLACE(900, -426);
// &vss @WIRE(mode="straight") {#X188:5 %t960:p};
// %t961 = $IO_PORT @ATTACH &n73 => @PLACE(959, -413) => @ORIENT("R0");
// %t961 @TEXT("n73", key="name", size=0.75);
// &n73 @WIRE(mode="straight") {#X189:1 %t961:p};
// %t962 = $IO_PORT @ATTACH &n39 => @PLACE(959, -417) => @ORIENT("R0");
// %t962 @TEXT("n39", key="name", size=0.75);
// &n39 @WIRE(mode="straight") {#X189:2 %t962:p};
// %t963 = $IO_PORT @ATTACH &n165 => @PLACE(981, -415) => @ORIENT("MY");
// %t963 @TEXT("n165", key="name", size=0.75);
// &n165 @WIRE(mode="straight") {#X189:3 %t963:p};
// %t964 = $SUPPLY @ATTACH &vdd => @PLACE(970, -404);
// &vdd @WIRE(mode="straight") {#X189:4 %t964:p};
// %t965 = $GROUND @ATTACH &vss => @PLACE(970, -426);
// &vss @WIRE(mode="straight") {#X189:5 %t965:p};
// %t966 = $IO_PORT @ATTACH &n224 => @PLACE(1029, -413) => @ORIENT("R0");
// %t966 @TEXT("n224", key="name", size=0.75);
// &n224 @WIRE(mode="straight") {#X190:1 %t966:p};
// %t967 = $IO_PORT @ATTACH &n165 => @PLACE(1029, -417) => @ORIENT("R0");
// %t967 @TEXT("n165", key="name", size=0.75);
// &n165 @WIRE(mode="straight") {#X190:2 %t967:p};
// %t968 = $IO_PORT @ATTACH &n227 => @PLACE(1051, -415) => @ORIENT("MY");
// %t968 @TEXT("n227", key="name", size=0.75);
// &n227 @WIRE(mode="straight") {#X190:3 %t968:p};
// %t969 = $SUPPLY @ATTACH &vdd => @PLACE(1040, -404);
// &vdd @WIRE(mode="straight") {#X190:4 %t969:p};
// %t970 = $GROUND @ATTACH &vss => @PLACE(1040, -426);
// &vss @WIRE(mode="straight") {#X190:5 %t970:p};
// %t971 = $IO_PORT @ATTACH &n82 => @PLACE(1099, -413) => @ORIENT("R0");
// %t971 @TEXT("n82", key="name", size=0.75);
// &n82 @WIRE(mode="straight") {#X191:1 %t971:p};
// %t972 = $IO_PORT @ATTACH &n227 => @PLACE(1099, -417) => @ORIENT("R0");
// %t972 @TEXT("n227", key="name", size=0.75);
// &n227 @WIRE(mode="straight") {#X191:2 %t972:p};
// %t973 = $IO_PORT @ATTACH &n228 => @PLACE(1121, -415) => @ORIENT("MY");
// %t973 @TEXT("n228", key="name", size=0.75);
// &n228 @WIRE(mode="straight") {#X191:3 %t973:p};
// %t974 = $SUPPLY @ATTACH &vdd => @PLACE(1110, -404);
// &vdd @WIRE(mode="straight") {#X191:4 %t974:p};
// %t975 = $GROUND @ATTACH &vss => @PLACE(1110, -426);
// &vss @WIRE(mode="straight") {#X191:5 %t975:p};
// %t976 = $IO_PORT @ATTACH &n187 => @PLACE(-11, -480) => @ORIENT("R0");
// %t976 @TEXT("n187", key="name", size=0.75);
// &n187 @WIRE(mode="straight") {#X192:1 %t976:p};
// %t977 = $IO_PORT @ATTACH &n229 => @PLACE(11, -480) => @ORIENT("MY");
// %t977 @TEXT("n229", key="name", size=0.75);
// &n229 @WIRE(mode="straight") {#X192:2 %t977:p};
// %t978 = $SUPPLY @ATTACH &vdd => @PLACE(0, -471);
// &vdd @WIRE(mode="straight") {#X192:3 %t978:p};
// %t979 = $GROUND @ATTACH &vss => @PLACE(0, -489);
// &vss @WIRE(mode="straight") {#X192:4 %t979:p};
// %t980 = $IO_PORT @ATTACH &ready => @PLACE(59, -480) => @ORIENT("R0");
// %t980 @TEXT("ready", key="name", size=0.75);
// &ready @WIRE(mode="straight") {#X193:1 %t980:p};
// %t981 = $IO_PORT @ATTACH &n230 => @PLACE(81, -480) => @ORIENT("MY");
// %t981 @TEXT("n230", key="name", size=0.75);
// &n230 @WIRE(mode="straight") {#X193:2 %t981:p};
// %t982 = $SUPPLY @ATTACH &vdd => @PLACE(70, -471);
// &vdd @WIRE(mode="straight") {#X193:3 %t982:p};
// %t983 = $GROUND @ATTACH &vss => @PLACE(70, -489);
// &vss @WIRE(mode="straight") {#X193:4 %t983:p};
// %t984 = $IO_PORT @ATTACH &n56 => @PLACE(129, -480) => @ORIENT("R0");
// %t984 @TEXT("n56", key="name", size=0.75);
// &n56 @WIRE(mode="straight") {#X194:1 %t984:p};
// %t985 = $IO_PORT @ATTACH &n231 => @PLACE(151, -480) => @ORIENT("MY");
// %t985 @TEXT("n231", key="name", size=0.75);
// &n231 @WIRE(mode="straight") {#X194:2 %t985:p};
// %t986 = $SUPPLY @ATTACH &vdd => @PLACE(140, -471);
// &vdd @WIRE(mode="straight") {#X194:3 %t986:p};
// %t987 = $GROUND @ATTACH &vss => @PLACE(140, -489);
// &vss @WIRE(mode="straight") {#X194:4 %t987:p};
// %t988 = $IO_PORT @ATTACH &n190 => @PLACE(199, -480) => @ORIENT("R0");
// %t988 @TEXT("n190", key="name", size=0.75);
// &n190 @WIRE(mode="straight") {#X195:1 %t988:p};
// %t989 = $IO_PORT @ATTACH &n180 => @PLACE(221, -480) => @ORIENT("MY");
// %t989 @TEXT("n180", key="name", size=0.75);
// &n180 @WIRE(mode="straight") {#X195:2 %t989:p};
// %t990 = $SUPPLY @ATTACH &vdd => @PLACE(210, -471);
// &vdd @WIRE(mode="straight") {#X195:3 %t990:p};
// %t991 = $GROUND @ATTACH &vss => @PLACE(210, -489);
// &vss @WIRE(mode="straight") {#X195:4 %t991:p};
// %t992 = $IO_PORT @ATTACH &n182 => @PLACE(-11, -515) => @ORIENT("R0");
// %t992 @TEXT("n182", key="name", size=0.75);
// &n182 @WIRE(mode="straight") {#X196:1 %t992:p};
// %t993 = $IO_PORT @ATTACH &n177 => @PLACE(11, -515) => @ORIENT("MY");
// %t993 @TEXT("n177", key="name", size=0.75);
// &n177 @WIRE(mode="straight") {#X196:2 %t993:p};
// %t994 = $SUPPLY @ATTACH &vdd => @PLACE(0, -506);
// &vdd @WIRE(mode="straight") {#X196:3 %t994:p};
// %t995 = $GROUND @ATTACH &vss => @PLACE(0, -524);
// &vss @WIRE(mode="straight") {#X196:4 %t995:p};
// %t996 = $IO_PORT @ATTACH &n232 => @PLACE(59, -515) => @ORIENT("R0");
// %t996 @TEXT("n232", key="name", size=0.75);
// &n232 @WIRE(mode="straight") {#X197:1 %t996:p};
// %t997 = $IO_PORT @ATTACH &n233 => @PLACE(81, -515) => @ORIENT("MY");
// %t997 @TEXT("n233", key="name", size=0.75);
// &n233 @WIRE(mode="straight") {#X197:2 %t997:p};
// %t998 = $SUPPLY @ATTACH &vdd => @PLACE(70, -506);
// &vdd @WIRE(mode="straight") {#X197:3 %t998:p};
// %t999 = $GROUND @ATTACH &vss => @PLACE(70, -524);
// &vss @WIRE(mode="straight") {#X197:4 %t999:p};
// %t1000 = $IO_PORT @ATTACH &n196 => @PLACE(129, -513) => @ORIENT("R0");
// %t1000 @TEXT("n196", key="name", size=0.75);
// &n196 @WIRE(mode="straight") {#X198:1 %t1000:p};
// %t1001 = $IO_PORT @ATTACH &n198 => @PLACE(129, -517) => @ORIENT("R0");
// %t1001 @TEXT("n198", key="name", size=0.75);
// &n198 @WIRE(mode="straight") {#X198:2 %t1001:p};
// %t1002 = $IO_PORT @ATTACH &n234 => @PLACE(151, -515) => @ORIENT("MY");
// %t1002 @TEXT("n234", key="name", size=0.75);
// &n234 @WIRE(mode="straight") {#X198:3 %t1002:p};
// %t1003 = $SUPPLY @ATTACH &vdd => @PLACE(140, -504);
// &vdd @WIRE(mode="straight") {#X198:4 %t1003:p};
// %t1004 = $GROUND @ATTACH &vss => @PLACE(140, -526);
// &vss @WIRE(mode="straight") {#X198:5 %t1004:p};
// %t1005 = $IO_PORT @ATTACH &n234 => @PLACE(199, -513) => @ORIENT("R0");
// %t1005 @TEXT("n234", key="name", size=0.75);
// &n234 @WIRE(mode="straight") {#X199:1 %t1005:p};
// %t1006 = $IO_PORT @ATTACH &n202 => @PLACE(199, -517) => @ORIENT("R0");
// %t1006 @TEXT("n202", key="name", size=0.75);
// &n202 @WIRE(mode="straight") {#X199:2 %t1006:p};
// %t1007 = $IO_PORT @ATTACH &select_m0 => @PLACE(221, -515) => @ORIENT("MY");
// %t1007 @TEXT("select_m0", key="name", size=0.75);
// &select_m0 @WIRE(mode="straight") {#X199:3 %t1007:p};
// %t1008 = $SUPPLY @ATTACH &vdd => @PLACE(210, -504);
// &vdd @WIRE(mode="straight") {#X199:4 %t1008:p};
// %t1009 = $GROUND @ATTACH &vss => @PLACE(210, -526);
// &vss @WIRE(mode="straight") {#X199:5 %t1009:p};
// %t1010 = $IO_PORT @ATTACH &n234 => @PLACE(-11, -548) => @ORIENT("R0");
// %t1010 @TEXT("n234", key="name", size=0.75);
// &n234 @WIRE(mode="straight") {#X200:1 %t1010:p};
// %t1011 = $IO_PORT @ATTACH &n204 => @PLACE(-11, -552) => @ORIENT("R0");
// %t1011 @TEXT("n204", key="name", size=0.75);
// &n204 @WIRE(mode="straight") {#X200:2 %t1011:p};
// %t1012 = $IO_PORT @ATTACH &n235 => @PLACE(11, -550) => @ORIENT("MY");
// %t1012 @TEXT("n235", key="name", size=0.75);
// &n235 @WIRE(mode="straight") {#X200:3 %t1012:p};
// %t1013 = $SUPPLY @ATTACH &vdd => @PLACE(0, -539);
// &vdd @WIRE(mode="straight") {#X200:4 %t1013:p};
// %t1014 = $GROUND @ATTACH &vss => @PLACE(0, -561);
// &vss @WIRE(mode="straight") {#X200:5 %t1014:p};
// %t1015 = $IO_PORT @ATTACH &n235 => @PLACE(59, -548) => @ORIENT("R0");
// %t1015 @TEXT("n235", key="name", size=0.75);
// &n235 @WIRE(mode="straight") {#X201:1 %t1015:p};
// %t1016 = $IO_PORT @ATTACH &n206 => @PLACE(59, -552) => @ORIENT("R0");
// %t1016 @TEXT("n206", key="name", size=0.75);
// &n206 @WIRE(mode="straight") {#X201:2 %t1016:p};
// %t1017 = $IO_PORT @ATTACH &select_m1 => @PLACE(81, -550) => @ORIENT("MY");
// %t1017 @TEXT("select_m1", key="name", size=0.75);
// &select_m1 @WIRE(mode="straight") {#X201:3 %t1017:p};
// %t1018 = $SUPPLY @ATTACH &vdd => @PLACE(70, -539);
// &vdd @WIRE(mode="straight") {#X201:4 %t1018:p};
// %t1019 = $GROUND @ATTACH &vss => @PLACE(70, -561);
// &vss @WIRE(mode="straight") {#X201:5 %t1019:p};
// %t1020 = $IO_PORT @ATTACH &n234 => @PLACE(129, -548) => @ORIENT("R0");
// %t1020 @TEXT("n234", key="name", size=0.75);
// &n234 @WIRE(mode="straight") {#X202:1 %t1020:p};
// %t1021 = $IO_PORT @ATTACH &n210 => @PLACE(129, -552) => @ORIENT("R0");
// %t1021 @TEXT("n210", key="name", size=0.75);
// &n210 @WIRE(mode="straight") {#X202:2 %t1021:p};
// %t1022 = $IO_PORT @ATTACH &n236 => @PLACE(151, -550) => @ORIENT("MY");
// %t1022 @TEXT("n236", key="name", size=0.75);
// &n236 @WIRE(mode="straight") {#X202:3 %t1022:p};
// %t1023 = $SUPPLY @ATTACH &vdd => @PLACE(140, -539);
// &vdd @WIRE(mode="straight") {#X202:4 %t1023:p};
// %t1024 = $GROUND @ATTACH &vss => @PLACE(140, -561);
// &vss @WIRE(mode="straight") {#X202:5 %t1024:p};
// %t1025 = $IO_PORT @ATTACH &n236 => @PLACE(199, -548) => @ORIENT("R0");
// %t1025 @TEXT("n236", key="name", size=0.75);
// &n236 @WIRE(mode="straight") {#X203:1 %t1025:p};
// %t1026 = $IO_PORT @ATTACH &n213 => @PLACE(199, -552) => @ORIENT("R0");
// %t1026 @TEXT("n213", key="name", size=0.75);
// &n213 @WIRE(mode="straight") {#X203:2 %t1026:p};
// %t1027 = $IO_PORT @ATTACH &select_m2 => @PLACE(221, -550) => @ORIENT("MY");
// %t1027 @TEXT("select_m2", key="name", size=0.75);
// &select_m2 @WIRE(mode="straight") {#X203:3 %t1027:p};
// %t1028 = $SUPPLY @ATTACH &vdd => @PLACE(210, -539);
// &vdd @WIRE(mode="straight") {#X203:4 %t1028:p};
// %t1029 = $GROUND @ATTACH &vss => @PLACE(210, -561);
// &vss @WIRE(mode="straight") {#X203:5 %t1029:p};
// %t1030 = $IO_PORT @ATTACH &n234 => @PLACE(-11, -583) => @ORIENT("R0");
// %t1030 @TEXT("n234", key="name", size=0.75);
// &n234 @WIRE(mode="straight") {#X204:1 %t1030:p};
// %t1031 = $IO_PORT @ATTACH &n215 => @PLACE(-11, -587) => @ORIENT("R0");
// %t1031 @TEXT("n215", key="name", size=0.75);
// &n215 @WIRE(mode="straight") {#X204:2 %t1031:p};
// %t1032 = $IO_PORT @ATTACH &n237 => @PLACE(11, -585) => @ORIENT("MY");
// %t1032 @TEXT("n237", key="name", size=0.75);
// &n237 @WIRE(mode="straight") {#X204:3 %t1032:p};
// %t1033 = $SUPPLY @ATTACH &vdd => @PLACE(0, -574);
// &vdd @WIRE(mode="straight") {#X204:4 %t1033:p};
// %t1034 = $GROUND @ATTACH &vss => @PLACE(0, -596);
// &vss @WIRE(mode="straight") {#X204:5 %t1034:p};
// %t1035 = $IO_PORT @ATTACH &n237 => @PLACE(59, -583) => @ORIENT("R0");
// %t1035 @TEXT("n237", key="name", size=0.75);
// &n237 @WIRE(mode="straight") {#X205:1 %t1035:p};
// %t1036 = $IO_PORT @ATTACH &n218 => @PLACE(59, -587) => @ORIENT("R0");
// %t1036 @TEXT("n218", key="name", size=0.75);
// &n218 @WIRE(mode="straight") {#X205:2 %t1036:p};
// %t1037 = $IO_PORT @ATTACH &select_m3 => @PLACE(81, -585) => @ORIENT("MY");
// %t1037 @TEXT("select_m3", key="name", size=0.75);
// &select_m3 @WIRE(mode="straight") {#X205:3 %t1037:p};
// %t1038 = $SUPPLY @ATTACH &vdd => @PLACE(70, -574);
// &vdd @WIRE(mode="straight") {#X205:4 %t1038:p};
// %t1039 = $GROUND @ATTACH &vss => @PLACE(70, -596);
// &vss @WIRE(mode="straight") {#X205:5 %t1039:p};
// %t1040 = $IO_PORT @ATTACH &n234 => @PLACE(129, -583) => @ORIENT("R0");
// %t1040 @TEXT("n234", key="name", size=0.75);
// &n234 @WIRE(mode="straight") {#X206:1 %t1040:p};
// %t1041 = $IO_PORT @ATTACH &n221 => @PLACE(129, -587) => @ORIENT("R0");
// %t1041 @TEXT("n221", key="name", size=0.75);
// &n221 @WIRE(mode="straight") {#X206:2 %t1041:p};
// %t1042 = $IO_PORT @ATTACH &n238 => @PLACE(151, -585) => @ORIENT("MY");
// %t1042 @TEXT("n238", key="name", size=0.75);
// &n238 @WIRE(mode="straight") {#X206:3 %t1042:p};
// %t1043 = $SUPPLY @ATTACH &vdd => @PLACE(140, -574);
// &vdd @WIRE(mode="straight") {#X206:4 %t1043:p};
// %t1044 = $GROUND @ATTACH &vss => @PLACE(140, -596);
// &vss @WIRE(mode="straight") {#X206:5 %t1044:p};
// %t1045 = $IO_PORT @ATTACH &n238 => @PLACE(199, -583) => @ORIENT("R0");
// %t1045 @TEXT("n238", key="name", size=0.75);
// &n238 @WIRE(mode="straight") {#X207:1 %t1045:p};
// %t1046 = $IO_PORT @ATTACH &n223 => @PLACE(199, -587) => @ORIENT("R0");
// %t1046 @TEXT("n223", key="name", size=0.75);
// &n223 @WIRE(mode="straight") {#X207:2 %t1046:p};
// %t1047 = $IO_PORT @ATTACH &select_m4 => @PLACE(221, -585) => @ORIENT("MY");
// %t1047 @TEXT("select_m4", key="name", size=0.75);
// &select_m4 @WIRE(mode="straight") {#X207:3 %t1047:p};
// %t1048 = $SUPPLY @ATTACH &vdd => @PLACE(210, -574);
// &vdd @WIRE(mode="straight") {#X207:4 %t1048:p};
// %t1049 = $GROUND @ATTACH &vss => @PLACE(210, -596);
// &vss @WIRE(mode="straight") {#X207:5 %t1049:p};
// %t1050 = $IO_PORT @ATTACH &n234 => @PLACE(-11, -618) => @ORIENT("R0");
// %t1050 @TEXT("n234", key="name", size=0.75);
// &n234 @WIRE(mode="straight") {#X208:1 %t1050:p};
// %t1051 = $IO_PORT @ATTACH &n229 => @PLACE(-11, -622) => @ORIENT("R0");
// %t1051 @TEXT("n229", key="name", size=0.75);
// &n229 @WIRE(mode="straight") {#X208:2 %t1051:p};
// %t1052 = $IO_PORT @ATTACH &select_m5 => @PLACE(11, -620) => @ORIENT("MY");
// %t1052 @TEXT("select_m5", key="name", size=0.75);
// &select_m5 @WIRE(mode="straight") {#X208:3 %t1052:p};
// %t1053 = $SUPPLY @ATTACH &vdd => @PLACE(0, -609);
// &vdd @WIRE(mode="straight") {#X208:4 %t1053:p};
// %t1054 = $GROUND @ATTACH &vss => @PLACE(0, -631);
// &vss @WIRE(mode="straight") {#X208:5 %t1054:p};
// %t1055 = $IO_PORT @ATTACH &reset => @PLACE(59, -618) => @ORIENT("R0");
// %t1055 @TEXT("reset", key="name", size=0.75);
// &reset @WIRE(mode="straight") {#X209:1 %t1055:p};
// %t1056 = $IO_PORT @ATTACH &n230 => @PLACE(59, -622) => @ORIENT("R0");
// %t1056 @TEXT("n230", key="name", size=0.75);
// &n230 @WIRE(mode="straight") {#X209:2 %t1056:p};
// %t1057 = $IO_PORT @ATTACH &divider_reset => @PLACE(81, -620) => @ORIENT("MY");
// %t1057 @TEXT("divider_reset", key="name", size=0.75);
// &divider_reset @WIRE(mode="straight") {#X209:3 %t1057:p};
// %t1058 = $SUPPLY @ATTACH &vdd => @PLACE(70, -609);
// &vdd @WIRE(mode="straight") {#X209:4 %t1058:p};
// %t1059 = $GROUND @ATTACH &vss => @PLACE(70, -631);
// &vss @WIRE(mode="straight") {#X209:5 %t1059:p};
// %t1060 = $IO_PORT @ATTACH &n55 => @PLACE(129, -618) => @ORIENT("R0");
// %t1060 @TEXT("n55", key="name", size=0.75);
// &n55 @WIRE(mode="straight") {#X210:1 %t1060:p};
// %t1061 = $IO_PORT @ATTACH &n231 => @PLACE(129, -622) => @ORIENT("R0");
// %t1061 @TEXT("n231", key="name", size=0.75);
// &n231 @WIRE(mode="straight") {#X210:2 %t1061:p};
// %t1062 = $IO_PORT @ATTACH &n64 => @PLACE(151, -620) => @ORIENT("MY");
// %t1062 @TEXT("n64", key="name", size=0.75);
// &n64 @WIRE(mode="straight") {#X210:3 %t1062:p};
// %t1063 = $SUPPLY @ATTACH &vdd => @PLACE(140, -609);
// &vdd @WIRE(mode="straight") {#X210:4 %t1063:p};
// %t1064 = $GROUND @ATTACH &vss => @PLACE(140, -631);
// &vss @WIRE(mode="straight") {#X210:5 %t1064:p};
// %t1065 = $IO_PORT @ATTACH &n226 => @PLACE(199, -618) => @ORIENT("R0");
// %t1065 @TEXT("n226", key="name", size=0.75);
// &n226 @WIRE(mode="straight") {#X211:1 %t1065:p};
// %t1066 = $IO_PORT @ATTACH &n228 => @PLACE(199, -622) => @ORIENT("R0");
// %t1066 @TEXT("n228", key="name", size=0.75);
// &n228 @WIRE(mode="straight") {#X211:2 %t1066:p};
// %t1067 = $IO_PORT @ATTACH &n232 => @PLACE(221, -620) => @ORIENT("MY");
// %t1067 @TEXT("n232", key="name", size=0.75);
// &n232 @WIRE(mode="straight") {#X211:3 %t1067:p};
// %t1068 = $SUPPLY @ATTACH &vdd => @PLACE(210, -609);
// &vdd @WIRE(mode="straight") {#X211:4 %t1068:p};
// %t1069 = $GROUND @ATTACH &vss => @PLACE(210, -631);
// &vss @WIRE(mode="straight") {#X211:5 %t1069:p};
// %t1070 = $IO_PORT @ATTACH &vss => @PLACE(-11, -651) => @ORIENT("R0");
// %t1070 @TEXT("vss", key="name", size=0.75);
// &vss @WIRE(mode="straight") {#X212:1 %t1070:p};
// %t1071 = $IO_PORT @ATTACH &n182 => @PLACE(-11, -655) => @ORIENT("R0");
// %t1071 @TEXT("n182", key="name", size=0.75);
// &n182 @WIRE(mode="straight") {#X212:2 %t1071:p};
// %t1072 = $IO_PORT @ATTACH &n58 => @PLACE(-11, -659) => @ORIENT("R0");
// %t1072 @TEXT("n58", key="name", size=0.75);
// &n58 @WIRE(mode="straight") {#X212:3 %t1072:p};
// %t1073 = $IO_PORT @ATTACH &n239 => @PLACE(11, -655) => @ORIENT("MY");
// %t1073 @TEXT("n239", key="name", size=0.75);
// &n239 @WIRE(mode="straight") {#X212:4 %t1073:p};
// %t1074 = $SUPPLY @ATTACH &vdd => @PLACE(0, -642);
// &vdd @WIRE(mode="straight") {#X212:5 %t1074:p};
// %t1075 = $GROUND @ATTACH &vss => @PLACE(0, -668);
// &vss @WIRE(mode="straight") {#X212:6 %t1075:p};
// %t1076 = $IO_PORT @ATTACH &n239 => @PLACE(59, -651) => @ORIENT("R0");
// %t1076 @TEXT("n239", key="name", size=0.75);
// &n239 @WIRE(mode="straight") {#X213:1 %t1076:p};
// %t1077 = $IO_PORT @ATTACH &vdd => @PLACE(59, -655) => @ORIENT("R0");
// %t1077 @TEXT("vdd", key="name", size=0.75);
// &vdd @WIRE(mode="straight") {#X213:2 %t1077:p};
// %t1078 = $IO_PORT @ATTACH &n64 => @PLACE(59, -659) => @ORIENT("R0");
// %t1078 @TEXT("n64", key="name", size=0.75);
// &n64 @WIRE(mode="straight") {#X213:3 %t1078:p};
// %t1079 = $IO_PORT @ATTACH &n57 => @PLACE(81, -655) => @ORIENT("MY");
// %t1079 @TEXT("n57", key="name", size=0.75);
// &n57 @WIRE(mode="straight") {#X213:4 %t1079:p};
// %t1080 = $SUPPLY @ATTACH &vdd => @PLACE(70, -642);
// &vdd @WIRE(mode="straight") {#X213:5 %t1080:p};
// %t1081 = $GROUND @ATTACH &vss => @PLACE(70, -668);
// &vss @WIRE(mode="straight") {#X213:6 %t1081:p};
// %t1082 = $IO_PORT @ATTACH &nx => @PLACE(129, -651) => @ORIENT("R0");
// %t1082 @TEXT("nx", key="name", size=0.75);
// &nx @WIRE(mode="straight") {#X214:1 %t1082:p};
// %t1083 = $IO_PORT @ATTACH &n69 => @PLACE(129, -655) => @ORIENT("R0");
// %t1083 @TEXT("n69", key="name", size=0.75);
// &n69 @WIRE(mode="straight") {#X214:2 %t1083:p};
// %t1084 = $IO_PORT @ATTACH &n182 => @PLACE(129, -659) => @ORIENT("R0");
// %t1084 @TEXT("n182", key="name", size=0.75);
// &n182 @WIRE(mode="straight") {#X214:3 %t1084:p};
// %t1085 = $IO_PORT @ATTACH &n240 => @PLACE(151, -655) => @ORIENT("MY");
// %t1085 @TEXT("n240", key="name", size=0.75);
// &n240 @WIRE(mode="straight") {#X214:4 %t1085:p};
// %t1086 = $SUPPLY @ATTACH &vdd => @PLACE(140, -642);
// &vdd @WIRE(mode="straight") {#X214:5 %t1086:p};
// %t1087 = $GROUND @ATTACH &vss => @PLACE(140, -668);
// &vss @WIRE(mode="straight") {#X214:6 %t1087:p};
// %t1088 = $IO_PORT @ATTACH &nx => @PLACE(199, -651) => @ORIENT("R0");
// %t1088 @TEXT("nx", key="name", size=0.75);
// &nx @WIRE(mode="straight") {#X215:1 %t1088:p};
// %t1089 = $IO_PORT @ATTACH &n107 => @PLACE(199, -655) => @ORIENT("R0");
// %t1089 @TEXT("n107", key="name", size=0.75);
// &n107 @WIRE(mode="straight") {#X215:2 %t1089:p};
// %t1090 = $IO_PORT @ATTACH &n182 => @PLACE(199, -659) => @ORIENT("R0");
// %t1090 @TEXT("n182", key="name", size=0.75);
// &n182 @WIRE(mode="straight") {#X215:3 %t1090:p};
// %t1091 = $IO_PORT @ATTACH &n241 => @PLACE(221, -655) => @ORIENT("MY");
// %t1091 @TEXT("n241", key="name", size=0.75);
// &n241 @WIRE(mode="straight") {#X215:4 %t1091:p};
// %t1092 = $SUPPLY @ATTACH &vdd => @PLACE(210, -642);
// &vdd @WIRE(mode="straight") {#X215:5 %t1092:p};
// %t1093 = $GROUND @ATTACH &vss => @PLACE(210, -668);
// &vss @WIRE(mode="straight") {#X215:6 %t1093:p};
// %t1094 = $IO_PORT @ATTACH &nx => @PLACE(289, -476) => @ORIENT("R0");
// %t1094 @TEXT("nx", key="name", size=0.75);
// &nx @WIRE(mode="straight") {#X216:1 %t1094:p};
// %t1095 = $IO_PORT @ATTACH &n109 => @PLACE(289, -480) => @ORIENT("R0");
// %t1095 @TEXT("n109", key="name", size=0.75);
// &n109 @WIRE(mode="straight") {#X216:2 %t1095:p};
// %t1096 = $IO_PORT @ATTACH &n182 => @PLACE(289, -484) => @ORIENT("R0");
// %t1096 @TEXT("n182", key="name", size=0.75);
// &n182 @WIRE(mode="straight") {#X216:3 %t1096:p};
// %t1097 = $IO_PORT @ATTACH &n242 => @PLACE(311, -480) => @ORIENT("MY");
// %t1097 @TEXT("n242", key="name", size=0.75);
// &n242 @WIRE(mode="straight") {#X216:4 %t1097:p};
// %t1098 = $SUPPLY @ATTACH &vdd => @PLACE(300, -467);
// &vdd @WIRE(mode="straight") {#X216:5 %t1098:p};
// %t1099 = $GROUND @ATTACH &vss => @PLACE(300, -493);
// &vss @WIRE(mode="straight") {#X216:6 %t1099:p};
// %t1100 = $IO_PORT @ATTACH &nx => @PLACE(359, -476) => @ORIENT("R0");
// %t1100 @TEXT("nx", key="name", size=0.75);
// &nx @WIRE(mode="straight") {#X217:1 %t1100:p};
// %t1101 = $IO_PORT @ATTACH &n111 => @PLACE(359, -480) => @ORIENT("R0");
// %t1101 @TEXT("n111", key="name", size=0.75);
// &n111 @WIRE(mode="straight") {#X217:2 %t1101:p};
// %t1102 = $IO_PORT @ATTACH &n182 => @PLACE(359, -484) => @ORIENT("R0");
// %t1102 @TEXT("n182", key="name", size=0.75);
// &n182 @WIRE(mode="straight") {#X217:3 %t1102:p};
// %t1103 = $IO_PORT @ATTACH &n243 => @PLACE(381, -480) => @ORIENT("MY");
// %t1103 @TEXT("n243", key="name", size=0.75);
// &n243 @WIRE(mode="straight") {#X217:4 %t1103:p};
// %t1104 = $SUPPLY @ATTACH &vdd => @PLACE(370, -467);
// &vdd @WIRE(mode="straight") {#X217:5 %t1104:p};
// %t1105 = $GROUND @ATTACH &vss => @PLACE(370, -493);
// &vss @WIRE(mode="straight") {#X217:6 %t1105:p};
// %t1106 = $IO_PORT @ATTACH &nx => @PLACE(429, -476) => @ORIENT("R0");
// %t1106 @TEXT("nx", key="name", size=0.75);
// &nx @WIRE(mode="straight") {#X218:1 %t1106:p};
// %t1107 = $IO_PORT @ATTACH &n240 => @PLACE(429, -480) => @ORIENT("R0");
// %t1107 @TEXT("n240", key="name", size=0.75);
// &n240 @WIRE(mode="straight") {#X218:2 %t1107:p};
// %t1108 = $IO_PORT @ATTACH &n58 => @PLACE(429, -484) => @ORIENT("R0");
// %t1108 @TEXT("n58", key="name", size=0.75);
// &n58 @WIRE(mode="straight") {#X218:3 %t1108:p};
// %t1109 = $IO_PORT @ATTACH &n244 => @PLACE(451, -480) => @ORIENT("MY");
// %t1109 @TEXT("n244", key="name", size=0.75);
// &n244 @WIRE(mode="straight") {#X218:4 %t1109:p};
// %t1110 = $SUPPLY @ATTACH &vdd => @PLACE(440, -467);
// &vdd @WIRE(mode="straight") {#X218:5 %t1110:p};
// %t1111 = $GROUND @ATTACH &vss => @PLACE(440, -493);
// &vss @WIRE(mode="straight") {#X218:6 %t1111:p};
// %t1112 = $IO_PORT @ATTACH &nx => @PLACE(499, -476) => @ORIENT("R0");
// %t1112 @TEXT("nx", key="name", size=0.75);
// &nx @WIRE(mode="straight") {#X219:1 %t1112:p};
// %t1113 = $IO_PORT @ATTACH &n241 => @PLACE(499, -480) => @ORIENT("R0");
// %t1113 @TEXT("n241", key="name", size=0.75);
// &n241 @WIRE(mode="straight") {#X219:2 %t1113:p};
// %t1114 = $IO_PORT @ATTACH &n58 => @PLACE(499, -484) => @ORIENT("R0");
// %t1114 @TEXT("n58", key="name", size=0.75);
// &n58 @WIRE(mode="straight") {#X219:3 %t1114:p};
// %t1115 = $IO_PORT @ATTACH &n245 => @PLACE(521, -480) => @ORIENT("MY");
// %t1115 @TEXT("n245", key="name", size=0.75);
// &n245 @WIRE(mode="straight") {#X219:4 %t1115:p};
// %t1116 = $SUPPLY @ATTACH &vdd => @PLACE(510, -467);
// &vdd @WIRE(mode="straight") {#X219:5 %t1116:p};
// %t1117 = $GROUND @ATTACH &vss => @PLACE(510, -493);
// &vss @WIRE(mode="straight") {#X219:6 %t1117:p};
// %t1118 = $IO_PORT @ATTACH &nx => @PLACE(289, -511) => @ORIENT("R0");
// %t1118 @TEXT("nx", key="name", size=0.75);
// &nx @WIRE(mode="straight") {#X220:1 %t1118:p};
// %t1119 = $IO_PORT @ATTACH &n242 => @PLACE(289, -515) => @ORIENT("R0");
// %t1119 @TEXT("n242", key="name", size=0.75);
// &n242 @WIRE(mode="straight") {#X220:2 %t1119:p};
// %t1120 = $IO_PORT @ATTACH &n58 => @PLACE(289, -519) => @ORIENT("R0");
// %t1120 @TEXT("n58", key="name", size=0.75);
// &n58 @WIRE(mode="straight") {#X220:3 %t1120:p};
// %t1121 = $IO_PORT @ATTACH &n246 => @PLACE(311, -515) => @ORIENT("MY");
// %t1121 @TEXT("n246", key="name", size=0.75);
// &n246 @WIRE(mode="straight") {#X220:4 %t1121:p};
// %t1122 = $SUPPLY @ATTACH &vdd => @PLACE(300, -502);
// &vdd @WIRE(mode="straight") {#X220:5 %t1122:p};
// %t1123 = $GROUND @ATTACH &vss => @PLACE(300, -528);
// &vss @WIRE(mode="straight") {#X220:6 %t1123:p};
// %t1124 = $IO_PORT @ATTACH &nx => @PLACE(359, -511) => @ORIENT("R0");
// %t1124 @TEXT("nx", key="name", size=0.75);
// &nx @WIRE(mode="straight") {#X221:1 %t1124:p};
// %t1125 = $IO_PORT @ATTACH &n243 => @PLACE(359, -515) => @ORIENT("R0");
// %t1125 @TEXT("n243", key="name", size=0.75);
// &n243 @WIRE(mode="straight") {#X221:2 %t1125:p};
// %t1126 = $IO_PORT @ATTACH &n58 => @PLACE(359, -519) => @ORIENT("R0");
// %t1126 @TEXT("n58", key="name", size=0.75);
// &n58 @WIRE(mode="straight") {#X221:3 %t1126:p};
// %t1127 = $IO_PORT @ATTACH &n247 => @PLACE(381, -515) => @ORIENT("MY");
// %t1127 @TEXT("n247", key="name", size=0.75);
// &n247 @WIRE(mode="straight") {#X221:4 %t1127:p};
// %t1128 = $SUPPLY @ATTACH &vdd => @PLACE(370, -502);
// &vdd @WIRE(mode="straight") {#X221:5 %t1128:p};
// %t1129 = $GROUND @ATTACH &vss => @PLACE(370, -528);
// &vss @WIRE(mode="straight") {#X221:6 %t1129:p};
// %t1130 = $IO_PORT @ATTACH &n244 => @PLACE(429, -511) => @ORIENT("R0");
// %t1130 @TEXT("n244", key="name", size=0.75);
// &n244 @WIRE(mode="straight") {#X222:1 %t1130:p};
// %t1131 = $IO_PORT @ATTACH &vss => @PLACE(429, -515) => @ORIENT("R0");
// %t1131 @TEXT("vss", key="name", size=0.75);
// &vss @WIRE(mode="straight") {#X222:2 %t1131:p};
// %t1132 = $IO_PORT @ATTACH &n64 => @PLACE(429, -519) => @ORIENT("R0");
// %t1132 @TEXT("n64", key="name", size=0.75);
// &n64 @WIRE(mode="straight") {#X222:3 %t1132:p};
// %t1133 = $IO_PORT @ATTACH &n62 => @PLACE(451, -515) => @ORIENT("MY");
// %t1133 @TEXT("n62", key="name", size=0.75);
// &n62 @WIRE(mode="straight") {#X222:4 %t1133:p};
// %t1134 = $SUPPLY @ATTACH &vdd => @PLACE(440, -502);
// &vdd @WIRE(mode="straight") {#X222:5 %t1134:p};
// %t1135 = $GROUND @ATTACH &vss => @PLACE(440, -528);
// &vss @WIRE(mode="straight") {#X222:6 %t1135:p};
// %t1136 = $IO_PORT @ATTACH &n245 => @PLACE(499, -511) => @ORIENT("R0");
// %t1136 @TEXT("n245", key="name", size=0.75);
// &n245 @WIRE(mode="straight") {#X223:1 %t1136:p};
// %t1137 = $IO_PORT @ATTACH &vss => @PLACE(499, -515) => @ORIENT("R0");
// %t1137 @TEXT("vss", key="name", size=0.75);
// &vss @WIRE(mode="straight") {#X223:2 %t1137:p};
// %t1138 = $IO_PORT @ATTACH &n64 => @PLACE(499, -519) => @ORIENT("R0");
// %t1138 @TEXT("n64", key="name", size=0.75);
// &n64 @WIRE(mode="straight") {#X223:3 %t1138:p};
// %t1139 = $IO_PORT @ATTACH &n61 => @PLACE(521, -515) => @ORIENT("MY");
// %t1139 @TEXT("n61", key="name", size=0.75);
// &n61 @WIRE(mode="straight") {#X223:4 %t1139:p};
// %t1140 = $SUPPLY @ATTACH &vdd => @PLACE(510, -502);
// &vdd @WIRE(mode="straight") {#X223:5 %t1140:p};
// %t1141 = $GROUND @ATTACH &vss => @PLACE(510, -528);
// &vss @WIRE(mode="straight") {#X223:6 %t1141:p};
// %t1142 = $IO_PORT @ATTACH &n246 => @PLACE(289, -546) => @ORIENT("R0");
// %t1142 @TEXT("n246", key="name", size=0.75);
// &n246 @WIRE(mode="straight") {#X224:1 %t1142:p};
// %t1143 = $IO_PORT @ATTACH &vss => @PLACE(289, -550) => @ORIENT("R0");
// %t1143 @TEXT("vss", key="name", size=0.75);
// &vss @WIRE(mode="straight") {#X224:2 %t1143:p};
// %t1144 = $IO_PORT @ATTACH &n64 => @PLACE(289, -554) => @ORIENT("R0");
// %t1144 @TEXT("n64", key="name", size=0.75);
// &n64 @WIRE(mode="straight") {#X224:3 %t1144:p};
// %t1145 = $IO_PORT @ATTACH &n59 => @PLACE(311, -550) => @ORIENT("MY");
// %t1145 @TEXT("n59", key="name", size=0.75);
// &n59 @WIRE(mode="straight") {#X224:4 %t1145:p};
// %t1146 = $SUPPLY @ATTACH &vdd => @PLACE(300, -537);
// &vdd @WIRE(mode="straight") {#X224:5 %t1146:p};
// %t1147 = $GROUND @ATTACH &vss => @PLACE(300, -563);
// &vss @WIRE(mode="straight") {#X224:6 %t1147:p};
// %t1148 = $IO_PORT @ATTACH &n247 => @PLACE(359, -546) => @ORIENT("R0");
// %t1148 @TEXT("n247", key="name", size=0.75);
// &n247 @WIRE(mode="straight") {#X225:1 %t1148:p};
// %t1149 = $IO_PORT @ATTACH &vss => @PLACE(359, -550) => @ORIENT("R0");
// %t1149 @TEXT("vss", key="name", size=0.75);
// &vss @WIRE(mode="straight") {#X225:2 %t1149:p};
// %t1150 = $IO_PORT @ATTACH &n64 => @PLACE(359, -554) => @ORIENT("R0");
// %t1150 @TEXT("n64", key="name", size=0.75);
// &n64 @WIRE(mode="straight") {#X225:3 %t1150:p};
// %t1151 = $IO_PORT @ATTACH &n68 => @PLACE(381, -550) => @ORIENT("MY");
// %t1151 @TEXT("n68", key="name", size=0.75);
// &n68 @WIRE(mode="straight") {#X225:4 %t1151:p};
// %t1152 = $SUPPLY @ATTACH &vdd => @PLACE(370, -537);
// &vdd @WIRE(mode="straight") {#X225:5 %t1152:p};
// %t1153 = $GROUND @ATTACH &vss => @PLACE(370, -563);
// &vss @WIRE(mode="straight") {#X225:6 %t1153:p};
// %t1154 = $IO_PORT @ATTACH &n233 => @PLACE(429, -546) => @ORIENT("R0");
// %t1154 @TEXT("n233", key="name", size=0.75);
// &n233 @WIRE(mode="straight") {#X226:1 %t1154:p};
// %t1155 = $IO_PORT @ATTACH &nx => @PLACE(429, -550) => @ORIENT("R0");
// %t1155 @TEXT("nx", key="name", size=0.75);
// &nx @WIRE(mode="straight") {#X226:2 %t1155:p};
// %t1156 = $IO_PORT @ATTACH &n182 => @PLACE(429, -554) => @ORIENT("R0");
// %t1156 @TEXT("n182", key="name", size=0.75);
// &n182 @WIRE(mode="straight") {#X226:3 %t1156:p};
// %t1157 = $IO_PORT @ATTACH &n248 => @PLACE(451, -550) => @ORIENT("MY");
// %t1157 @TEXT("n248", key="name", size=0.75);
// &n248 @WIRE(mode="straight") {#X226:4 %t1157:p};
// %t1158 = $SUPPLY @ATTACH &vdd => @PLACE(440, -537);
// &vdd @WIRE(mode="straight") {#X226:5 %t1158:p};
// %t1159 = $GROUND @ATTACH &vss => @PLACE(440, -563);
// &vss @WIRE(mode="straight") {#X226:6 %t1159:p};
// %t1160 = $IO_PORT @ATTACH &nx => @PLACE(499, -546) => @ORIENT("R0");
// %t1160 @TEXT("nx", key="name", size=0.75);
// &nx @WIRE(mode="straight") {#X227:1 %t1160:p};
// %t1161 = $IO_PORT @ATTACH &n248 => @PLACE(499, -550) => @ORIENT("R0");
// %t1161 @TEXT("n248", key="name", size=0.75);
// &n248 @WIRE(mode="straight") {#X227:2 %t1161:p};
// %t1162 = $IO_PORT @ATTACH &n58 => @PLACE(499, -554) => @ORIENT("R0");
// %t1162 @TEXT("n58", key="name", size=0.75);
// &n58 @WIRE(mode="straight") {#X227:3 %t1162:p};
// %t1163 = $IO_PORT @ATTACH &n249 => @PLACE(521, -550) => @ORIENT("MY");
// %t1163 @TEXT("n249", key="name", size=0.75);
// &n249 @WIRE(mode="straight") {#X227:4 %t1163:p};
// %t1164 = $SUPPLY @ATTACH &vdd => @PLACE(510, -537);
// &vdd @WIRE(mode="straight") {#X227:5 %t1164:p};
// %t1165 = $GROUND @ATTACH &vss => @PLACE(510, -563);
// &vss @WIRE(mode="straight") {#X227:6 %t1165:p};
// %t1166 = $IO_PORT @ATTACH &n249 => @PLACE(289, -581) => @ORIENT("R0");
// %t1166 @TEXT("n249", key="name", size=0.75);
// &n249 @WIRE(mode="straight") {#X228:1 %t1166:p};
// %t1167 = $IO_PORT @ATTACH &vss => @PLACE(289, -585) => @ORIENT("R0");
// %t1167 @TEXT("vss", key="name", size=0.75);
// &vss @WIRE(mode="straight") {#X228:2 %t1167:p};
// %t1168 = $IO_PORT @ATTACH &n64 => @PLACE(289, -589) => @ORIENT("R0");
// %t1168 @TEXT("n64", key="name", size=0.75);
// &n64 @WIRE(mode="straight") {#X228:3 %t1168:p};
// %t1169 = $IO_PORT @ATTACH &n65 => @PLACE(311, -585) => @ORIENT("MY");
// %t1169 @TEXT("n65", key="name", size=0.75);
// &n65 @WIRE(mode="straight") {#X228:4 %t1169:p};
// %t1170 = $SUPPLY @ATTACH &vdd => @PLACE(300, -572);
// &vdd @WIRE(mode="straight") {#X228:5 %t1170:p};
// %t1171 = $GROUND @ATTACH &vss => @PLACE(300, -598);
// &vss @WIRE(mode="straight") {#X228:6 %t1171:p};
// %t1172 = $IO_PORT @ATTACH &n232 => @PLACE(359, -581) => @ORIENT("R0");
// %t1172 @TEXT("n232", key="name", size=0.75);
// &n232 @WIRE(mode="straight") {#X229:1 %t1172:p};
// %t1173 = $IO_PORT @ATTACH &nx => @PLACE(359, -585) => @ORIENT("R0");
// %t1173 @TEXT("nx", key="name", size=0.75);
// &nx @WIRE(mode="straight") {#X229:2 %t1173:p};
// %t1174 = $IO_PORT @ATTACH &n182 => @PLACE(359, -589) => @ORIENT("R0");
// %t1174 @TEXT("n182", key="name", size=0.75);
// &n182 @WIRE(mode="straight") {#X229:3 %t1174:p};
// %t1175 = $IO_PORT @ATTACH &n250 => @PLACE(381, -585) => @ORIENT("MY");
// %t1175 @TEXT("n250", key="name", size=0.75);
// &n250 @WIRE(mode="straight") {#X229:4 %t1175:p};
// %t1176 = $SUPPLY @ATTACH &vdd => @PLACE(370, -572);
// &vdd @WIRE(mode="straight") {#X229:5 %t1176:p};
// %t1177 = $GROUND @ATTACH &vss => @PLACE(370, -598);
// &vss @WIRE(mode="straight") {#X229:6 %t1177:p};
// %t1178 = $IO_PORT @ATTACH &nx => @PLACE(429, -581) => @ORIENT("R0");
// %t1178 @TEXT("nx", key="name", size=0.75);
// &nx @WIRE(mode="straight") {#X230:1 %t1178:p};
// %t1179 = $IO_PORT @ATTACH &n250 => @PLACE(429, -585) => @ORIENT("R0");
// %t1179 @TEXT("n250", key="name", size=0.75);
// &n250 @WIRE(mode="straight") {#X230:2 %t1179:p};
// %t1180 = $IO_PORT @ATTACH &n58 => @PLACE(429, -589) => @ORIENT("R0");
// %t1180 @TEXT("n58", key="name", size=0.75);
// &n58 @WIRE(mode="straight") {#X230:3 %t1180:p};
// %t1181 = $IO_PORT @ATTACH &n251 => @PLACE(451, -585) => @ORIENT("MY");
// %t1181 @TEXT("n251", key="name", size=0.75);
// &n251 @WIRE(mode="straight") {#X230:4 %t1181:p};
// %t1182 = $SUPPLY @ATTACH &vdd => @PLACE(440, -572);
// &vdd @WIRE(mode="straight") {#X230:5 %t1182:p};
// %t1183 = $GROUND @ATTACH &vss => @PLACE(440, -598);
// &vss @WIRE(mode="straight") {#X230:6 %t1183:p};
// %t1184 = $IO_PORT @ATTACH &n251 => @PLACE(499, -581) => @ORIENT("R0");
// %t1184 @TEXT("n251", key="name", size=0.75);
// &n251 @WIRE(mode="straight") {#X231:1 %t1184:p};
// %t1185 = $IO_PORT @ATTACH &vss => @PLACE(499, -585) => @ORIENT("R0");
// %t1185 @TEXT("vss", key="name", size=0.75);
// &vss @WIRE(mode="straight") {#X231:2 %t1185:p};
// %t1186 = $IO_PORT @ATTACH &n64 => @PLACE(499, -589) => @ORIENT("R0");
// %t1186 @TEXT("n64", key="name", size=0.75);
// &n64 @WIRE(mode="straight") {#X231:3 %t1186:p};
// %t1187 = $IO_PORT @ATTACH &n67 => @PLACE(521, -585) => @ORIENT("MY");
// %t1187 @TEXT("n67", key="name", size=0.75);
// &n67 @WIRE(mode="straight") {#X231:4 %t1187:p};
// %t1188 = $SUPPLY @ATTACH &vdd => @PLACE(510, -572);
// &vdd @WIRE(mode="straight") {#X231:5 %t1188:p};
// %t1189 = $GROUND @ATTACH &vss => @PLACE(510, -598);
// &vss @WIRE(mode="straight") {#X231:6 %t1189:p};
// %t1190 = $IO_PORT @ATTACH &n49 => @PLACE(289, -620) => @ORIENT("R0");
// %t1190 @TEXT("n49", key="name", size=0.75);
// &n49 @WIRE(mode="straight") {#X232:1 %t1190:p};
// %t1191 = $IO_PORT @ATTACH &n191 => @PLACE(311, -620) => @ORIENT("MY");
// %t1191 @TEXT("n191", key="name", size=0.75);
// &n191 @WIRE(mode="straight") {#X232:2 %t1191:p};
// %t1192 = $SUPPLY @ATTACH &vdd => @PLACE(300, -611);
// &vdd @WIRE(mode="straight") {#X232:3 %t1192:p};
// %t1193 = $GROUND @ATTACH &vss => @PLACE(300, -629);
// &vss @WIRE(mode="straight") {#X232:4 %t1193:p};
// %t1194 = $IO_PORT @ATTACH &n64 => @PLACE(359, -620) => @ORIENT("R0");
// %t1194 @TEXT("n64", key="name", size=0.75);
// &n64 @WIRE(mode="straight") {#X233:1 %t1194:p};
// %t1195 = $IO_PORT @ATTACH &n178 => @PLACE(381, -620) => @ORIENT("MY");
// %t1195 @TEXT("n178", key="name", size=0.75);
// &n178 @WIRE(mode="straight") {#X233:2 %t1195:p};
// %t1196 = $SUPPLY @ATTACH &vdd => @PLACE(370, -611);
// &vdd @WIRE(mode="straight") {#X233:3 %t1196:p};
// %t1197 = $GROUND @ATTACH &vss => @PLACE(370, -629);
// &vss @WIRE(mode="straight") {#X233:4 %t1197:p};
// %t1198 = $IO_PORT @ATTACH &n135 => @PLACE(429, -620) => @ORIENT("R0");
// %t1198 @TEXT("n135", key="name", size=0.75);
// &n135 @WIRE(mode="straight") {#X234:1 %t1198:p};
// %t1199 = $IO_PORT @ATTACH &n195 => @PLACE(451, -620) => @ORIENT("MY");
// %t1199 @TEXT("n195", key="name", size=0.75);
// &n195 @WIRE(mode="straight") {#X234:2 %t1199:p};
// %t1200 = $SUPPLY @ATTACH &vdd => @PLACE(440, -611);
// &vdd @WIRE(mode="straight") {#X234:3 %t1200:p};
// %t1201 = $GROUND @ATTACH &vss => @PLACE(440, -629);
// &vss @WIRE(mode="straight") {#X234:4 %t1201:p};
// %t1202 = $IO_PORT @ATTACH &n143 => @PLACE(499, -620) => @ORIENT("R0");
// %t1202 @TEXT("n143", key="name", size=0.75);
// &n143 @WIRE(mode="straight") {#X235:1 %t1202:p};
// %t1203 = $IO_PORT @ATTACH &n201 => @PLACE(521, -620) => @ORIENT("MY");
// %t1203 @TEXT("n201", key="name", size=0.75);
// &n201 @WIRE(mode="straight") {#X235:2 %t1203:p};
// %t1204 = $SUPPLY @ATTACH &vdd => @PLACE(510, -611);
// &vdd @WIRE(mode="straight") {#X235:3 %t1204:p};
// %t1205 = $GROUND @ATTACH &vss => @PLACE(510, -629);
// &vss @WIRE(mode="straight") {#X235:4 %t1205:p};
// %t1206 = $IO_PORT @ATTACH &n148 => @PLACE(289, -655) => @ORIENT("R0");
// %t1206 @TEXT("n148", key="name", size=0.75);
// &n148 @WIRE(mode="straight") {#X236:1 %t1206:p};
// %t1207 = $IO_PORT @ATTACH &n203 => @PLACE(311, -655) => @ORIENT("MY");
// %t1207 @TEXT("n203", key="name", size=0.75);
// &n203 @WIRE(mode="straight") {#X236:2 %t1207:p};
// %t1208 = $SUPPLY @ATTACH &vdd => @PLACE(300, -646);
// &vdd @WIRE(mode="straight") {#X236:3 %t1208:p};
// %t1209 = $GROUND @ATTACH &vss => @PLACE(300, -664);
// &vss @WIRE(mode="straight") {#X236:4 %t1209:p};
// %t1210 = $IO_PORT @ATTACH &n155 => @PLACE(359, -655) => @ORIENT("R0");
// %t1210 @TEXT("n155", key="name", size=0.75);
// &n155 @WIRE(mode="straight") {#X237:1 %t1210:p};
// %t1211 = $IO_PORT @ATTACH &n209 => @PLACE(381, -655) => @ORIENT("MY");
// %t1211 @TEXT("n209", key="name", size=0.75);
// &n209 @WIRE(mode="straight") {#X237:2 %t1211:p};
// %t1212 = $SUPPLY @ATTACH &vdd => @PLACE(370, -646);
// &vdd @WIRE(mode="straight") {#X237:3 %t1212:p};
// %t1213 = $GROUND @ATTACH &vss => @PLACE(370, -664);
// &vss @WIRE(mode="straight") {#X237:4 %t1213:p};
// %t1214 = $IO_PORT @ATTACH &n170 => @PLACE(429, -655) => @ORIENT("R0");
// %t1214 @TEXT("n170", key="name", size=0.75);
// &n170 @WIRE(mode="straight") {#X238:1 %t1214:p};
// %t1215 = $IO_PORT @ATTACH &n214 => @PLACE(451, -655) => @ORIENT("MY");
// %t1215 @TEXT("n214", key="name", size=0.75);
// &n214 @WIRE(mode="straight") {#X238:2 %t1215:p};
// %t1216 = $SUPPLY @ATTACH &vdd => @PLACE(440, -646);
// &vdd @WIRE(mode="straight") {#X238:3 %t1216:p};
// %t1217 = $GROUND @ATTACH &vss => @PLACE(440, -664);
// &vss @WIRE(mode="straight") {#X238:4 %t1217:p};
// %t1218 = $IO_PORT @ATTACH &n172 => @PLACE(499, -655) => @ORIENT("R0");
// %t1218 @TEXT("n172", key="name", size=0.75);
// &n172 @WIRE(mode="straight") {#X239:1 %t1218:p};
// %t1219 = $IO_PORT @ATTACH &n220 => @PLACE(521, -655) => @ORIENT("MY");
// %t1219 @TEXT("n220", key="name", size=0.75);
// &n220 @WIRE(mode="straight") {#X239:2 %t1219:p};
// %t1220 = $SUPPLY @ATTACH &vdd => @PLACE(510, -646);
// &vdd @WIRE(mode="straight") {#X239:3 %t1220:p};
// %t1221 = $GROUND @ATTACH &vss => @PLACE(510, -664);
// &vss @WIRE(mode="straight") {#X239:4 %t1221:p};
// %t1222 = $IO_PORT @ATTACH &n174 => @PLACE(589, -480) => @ORIENT("R0");
// %t1222 @TEXT("n174", key="name", size=0.75);
// &n174 @WIRE(mode="straight") {#X240:1 %t1222:p};
// %t1223 = $IO_PORT @ATTACH &n225 => @PLACE(611, -480) => @ORIENT("MY");
// %t1223 @TEXT("n225", key="name", size=0.75);
// &n225 @WIRE(mode="straight") {#X240:2 %t1223:p};
// %t1224 = $SUPPLY @ATTACH &vdd => @PLACE(600, -471);
// &vdd @WIRE(mode="straight") {#X240:3 %t1224:p};
// %t1225 = $GROUND @ATTACH &vss => @PLACE(600, -489);
// &vss @WIRE(mode="straight") {#X240:4 %t1225:p};
// (-16, 32) @TEXT("57  Configuration | 241 instances", size=1.2, halign="start");
// (-16, 28) @TEXT("Same-name tags connect locally. Open blocks for transistor details.", size=0.8, halign="start");
// }
ends tx_pll_config_pdk110_57
