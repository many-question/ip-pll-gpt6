// FLL / recenter | frozen callback110 / recenter109 | RNL 0.3
// @RNL(type="header") { @VERSION("0.3"); @USE-PACKAGE(name="rnl-std-fill") {} }
simulator lang=spectre
subckt tx_fll_recenter109_v14_pdk110_69 (refclk reset target_k0 target_k1 target_k2 target_k3 target_k4 target_k5 measured0 measured1 measured2 measured3 measured4 measured5 measured6 measured7 measured8 measured9 measured10 measured11 measured12 measured13 coarse0 coarse1 coarse2 coarse3 coarse4 coarse5 coarse6 coarse7 dac0 dac1 dac2 dac3 dac4 dac5 count_gate count_reset enable range_error state_out0 state_out1 state_out2 vdd vss)
X0 (n45 refclk reset dac0 vdd vss) tx_dff_r1_pdk110_70
X1 (n46 refclk reset dac1 vdd vss) tx_dff_r1_pdk110_70
X2 (n47 refclk reset dac2 vdd vss) tx_dff_r0_pdk110_58
X3 (n48 refclk reset dac3 vdd vss) tx_dff_r1_pdk110_70
X4 (n49 refclk reset dac4 vdd vss) tx_dff_r0_pdk110_58
X5 (n50 refclk reset n51 vdd vss) tx_dff_r0_pdk110_58
X6 (n52 refclk reset count_gate vdd vss) tx_dff_r0_pdk110_58
X7 (n53 refclk reset n54 vdd vss) tx_dff_r0_pdk110_58
X8 (n55 refclk reset count_reset vdd vss) tx_dff_r1_pdk110_70
X9 (n56 refclk reset dac5 vdd vss) tx_dff_r0_pdk110_58
X10 (n57 refclk reset n58 vdd vss) tx_dff_r0_pdk110_58
X11 (n59 refclk reset n60 vdd vss) tx_dff_r0_pdk110_58
X12 (n61 refclk reset n62 vdd vss) tx_dff_r0_pdk110_58
X13 (n63 refclk reset n64 vdd vss) tx_dff_r0_pdk110_58
X14 (n65 refclk reset n66 vdd vss) tx_dff_r0_pdk110_58
X15 (n67 refclk reset n68 vdd vss) tx_dff_r0_pdk110_58
X16 (n69 refclk reset n70 vdd vss) tx_dff_r0_pdk110_58
X17 (n71 refclk reset n72 vdd vss) tx_dff_r1_pdk110_70
X18 (n73 refclk reset enable vdd vss) tx_dff_r0_pdk110_58
X19 (n74 refclk reset n75 vdd vss) tx_dff_r1_pdk110_70
X20 (n76 refclk reset n77 vdd vss) tx_dff_r1_pdk110_70
X21 (n78 refclk reset n79 vdd vss) tx_dff_r0_pdk110_58
X22 (n80 refclk reset n81 vdd vss) tx_dff_r1_pdk110_70
X23 (n82 refclk reset n83 vdd vss) tx_dff_r0_pdk110_58
X24 (n84 refclk reset n85 vdd vss) tx_dff_r0_pdk110_58
X25 (n86 refclk reset range_error vdd vss) tx_dff_r0_pdk110_58
X26 (n87 refclk reset n88 vdd vss) tx_dff_r0_pdk110_58
X27 (n89 refclk reset state_out0 vdd vss) tx_dff_r0_pdk110_58
X28 (n90 refclk reset state_out1 vdd vss) tx_dff_r0_pdk110_58
X29 (n91 refclk reset state_out2 vdd vss) tx_dff_r0_pdk110_58
X30 (n92 refclk reset n93 vdd vss) tx_dff_r0_pdk110_58
X31 (n94 refclk reset n95 vdd vss) tx_dff_r0_pdk110_58
X32 (n96 refclk reset n97 vdd vss) tx_dff_r0_pdk110_58
X33 (n98 refclk reset n99 vdd vss) tx_dff_r0_pdk110_58
X34 (n100 refclk reset n101 vdd vss) tx_dff_r0_pdk110_58
X35 (n102 refclk reset n103 vdd vss) tx_dff_r0_pdk110_58
X36 (n104 refclk reset n105 vdd vss) tx_dff_r0_pdk110_58
X37 (n106 refclk reset n107 vdd vss) tx_dff_r0_pdk110_58
X38 (n108 refclk reset n109 vdd vss) tx_dff_r0_pdk110_58
X39 (n110 refclk reset n111 vdd vss) tx_dff_r0_pdk110_58
X40 (n112 refclk reset n113 vdd vss) tx_dff_r0_pdk110_58
X41 (n114 refclk reset n115 vdd vss) tx_dff_r0_pdk110_58
X42 (n116 refclk reset n117 vdd vss) tx_dff_r0_pdk110_58
X43 (n118 refclk reset coarse0 vdd vss) tx_dff_r0_pdk110_58
X44 (n119 refclk reset coarse1 vdd vss) tx_dff_r0_pdk110_58
X45 (n120 refclk reset coarse2 vdd vss) tx_dff_r0_pdk110_58
X46 (n121 refclk reset coarse3 vdd vss) tx_dff_r0_pdk110_58
X47 (n122 refclk reset coarse4 vdd vss) tx_dff_r0_pdk110_58
X48 (n123 refclk reset coarse5 vdd vss) tx_dff_r0_pdk110_58
X49 (n124 refclk reset coarse6 vdd vss) tx_dff_r0_pdk110_58
X50 (n125 refclk reset coarse7 vdd vss) tx_dff_r0_pdk110_58
X51 (n126 refclk reset n127 vdd vss) tx_dff_r1_pdk110_70
X52 (n128 refclk reset n129 vdd vss) tx_dff_r0_pdk110_58
X53 (n130 refclk reset n131 vdd vss) tx_dff_r1_pdk110_70
X54 (n132 refclk reset n133 vdd vss) tx_dff_r0_pdk110_58
X55 (n134 refclk reset n135 vdd vss) tx_dff_r1_pdk110_70
X56 (n136 refclk reset n137 vdd vss) tx_dff_r1_pdk110_70
X57 (n95 n138 n139 n94 vdd vss) tx_mux_pdk110_64
X58 (n93 n140 n139 n92 vdd vss) tx_mux_pdk110_64
X59 (state_out1 n141 n142 n90 vdd vss) tx_mux_pdk110_64
X60 (state_out0 n143 n142 n89 vdd vss) tx_mux_pdk110_64
X61 (n83 n144 n145 n82 vdd vss) tx_mux_pdk110_64
X62 (n81 n146 n145 n80 vdd vss) tx_mux_pdk110_64
X63 (n79 n147 n145 n78 vdd vss) tx_mux_pdk110_64
X64 (n77 n148 n145 n76 vdd vss) tx_mux_pdk110_64
X65 (n75 n149 n145 n74 vdd vss) tx_mux_pdk110_64
X66 (n70 n150 n151 n69 vdd vss) tx_mux_pdk110_64
X67 (n68 n152 n151 n67 vdd vss) tx_mux_pdk110_64
X68 (n66 n153 n151 n65 vdd vss) tx_mux_pdk110_64
X69 (n64 n154 n151 n63 vdd vss) tx_mux_pdk110_64
X70 (n62 n155 n151 n61 vdd vss) tx_mux_pdk110_64
X71 (n60 n156 n151 n59 vdd vss) tx_mux_pdk110_64
X72 (n58 n157 n151 n57 vdd vss) tx_mux_pdk110_64
X73 (dac4 n158 n159 n49 vdd vss) tx_mux_pdk110_64
X74 (dac3 n160 n159 n48 vdd vss) tx_mux_pdk110_64
X75 (dac2 n161 n159 n47 vdd vss) tx_mux_pdk110_64
X76 (dac1 n162 n159 n46 vdd vss) tx_mux_pdk110_64
X77 (dac0 n163 n159 n45 vdd vss) tx_mux_pdk110_64
X78 (n135 n164 n165 n134 vdd vss) tx_mux_pdk110_64
X79 (n133 n166 n165 n132 vdd vss) tx_mux_pdk110_64
X80 (n131 n167 n165 n130 vdd vss) tx_mux_pdk110_64
X81 (n129 n168 n165 n128 vdd vss) tx_mux_pdk110_64
X82 (n127 n169 n165 n126 vdd vss) tx_mux_pdk110_64
X83 (coarse6 n170 n171 n124 vdd vss) tx_mux_pdk110_64
X84 (coarse5 n172 n171 n123 vdd vss) tx_mux_pdk110_64
X85 (coarse4 n173 n171 n122 vdd vss) tx_mux_pdk110_64
X86 (coarse3 n174 n171 n121 vdd vss) tx_mux_pdk110_64
X87 (coarse2 n175 n171 n120 vdd vss) tx_mux_pdk110_64
X88 (coarse1 n176 n171 n119 vdd vss) tx_mux_pdk110_64
X89 (coarse0 n177 n171 n118 vdd vss) tx_mux_pdk110_64
X90 (n117 n178 n179 n116 vdd vss) tx_mux_pdk110_64
X91 (coarse7 n180 n171 n125 vdd vss) tx_mux_pdk110_64
X92 (n137 n181 n165 n136 vdd vss) tx_mux_pdk110_64
X93 (dac5 n182 n183 n56 vdd vss) tx_mux_pdk110_64
X94 (n51 vdd n184 n50 vdd vss) tx_mux_pdk110_64
X95 (count_gate n185 n186 n52 vdd vss) tx_mux_pdk110_64
X96 (n54 vdd n187 n53 vdd vss) tx_mux_pdk110_64
X97 (count_reset n188 n189 n55 vdd vss) tx_mux_pdk110_64
X98 (n72 n190 n151 n71 vdd vss) tx_mux_pdk110_64
X99 (enable n191 n192 n73 vdd vss) tx_mux_pdk110_64
X100 (n85 n193 n145 n84 vdd vss) tx_mux_pdk110_64
X101 (range_error n194 n195 n86 vdd vss) tx_mux_pdk110_64
X102 (n88 n196 n197 n87 vdd vss) tx_mux_pdk110_64
X103 (state_out2 n198 n142 n91 vdd vss) tx_mux_pdk110_64
X104 (n97 n199 n139 n96 vdd vss) tx_mux_pdk110_64
X105 (n115 n200 n201 n114 vdd vss) tx_mux_pdk110_64
X106 (n202 n111 n203 n110 vdd vss) tx_mux_pdk110_64
X107 (n204 n109 n203 n108 vdd vss) tx_mux_pdk110_64
X108 (n205 n107 n203 n106 vdd vss) tx_mux_pdk110_64
X109 (n206 n105 n203 n104 vdd vss) tx_mux_pdk110_64
X110 (n207 n103 n203 n102 vdd vss) tx_mux_pdk110_64
X111 (n208 n101 n203 n100 vdd vss) tx_mux_pdk110_64
X112 (n209 n99 n203 n98 vdd vss) tx_mux_pdk110_64
X113 (n210 n113 n203 n112 vdd vss) tx_mux_pdk110_64
X114 (dac3 n211 vdd vss) pll_inv_pdk110_7
X115 (n212 n213 vdd vss) pll_inv_pdk110_7
X116 (n214 n215 vdd vss) pll_inv_pdk110_7
X117 (n216 n217 vdd vss) pll_inv_pdk110_7
X118 (n218 n219 vdd vss) pll_inv_pdk110_7
X119 (n220 n221 vdd vss) pll_inv_pdk110_7
X120 (n222 n223 vdd vss) pll_inv_pdk110_7
X121 (target_k0 n224 vdd vss) pll_inv_pdk110_7
X122 (state_out1 n225 vdd vss) pll_inv_pdk110_7
X123 (state_out0 n226 vdd vss) pll_inv_pdk110_7
X124 (n58 n227 vdd vss) pll_inv_pdk110_7
X125 (n97 n228 vdd vss) pll_inv_pdk110_7
X126 (state_out2 n229 vdd vss) pll_inv_pdk110_7
X127 (n107 n230 vdd vss) pll_inv_pdk110_7
X128 (n88 n231 vdd vss) pll_inv_pdk110_7
X129 (n232 n233 vdd vss) pll_inv_pdk110_7
X130 (n234 n235 vdd vss) pll_inv_pdk110_7
X131 (n236 n237 vdd vss) pll_inv_pdk110_7
X132 (n238 n239 vdd vss) pll_inv_pdk110_7
X133 (n240 n241 vdd vss) pll_inv_pdk110_7
X134 (n117 n242 vdd vss) pll_inv_pdk110_7
X135 (n243 n244 vdd vss) pll_inv_pdk110_7
X136 (measured3 n245 vdd vss) pll_inv_pdk110_7
X137 (measured2 n246 vdd vss) pll_inv_pdk110_7
X138 (n247 n248 vdd vss) pll_inv_pdk110_7
X139 (n249 n250 vdd vss) pll_inv_pdk110_7
X140 (n251 n252 vdd vss) pll_inv_pdk110_7
X141 (n253 n254 vdd vss) pll_inv_pdk110_7
X142 (n255 n256 vdd vss) pll_inv_pdk110_7
X143 (n257 n258 vdd vss) pll_inv_pdk110_7
X144 (n259 n260 vdd vss) pll_inv_pdk110_7
X145 (n261 n262 vdd vss) pll_inv_pdk110_7
X146 (n263 n264 vdd vss) pll_inv_pdk110_7
X147 (n51 n265 vdd vss) pll_inv_pdk110_7
X148 (n99 n266 vdd vss) pll_inv_pdk110_7
X149 (dac0 n267 vdd vss) pll_inv_pdk110_7
X150 (target_k2 n268 vdd vss) pll_inv_pdk110_7
X151 (n269 n270 vdd vss) pll_inv_pdk110_7
X152 (n271 n272 vdd vss) pll_inv_pdk110_7
X153 (n273 n274 vdd vss) pll_inv_pdk110_7
X154 (n275 n276 vdd vss) pll_inv_pdk110_7
X155 (n277 n278 vdd vss) pll_inv_pdk110_7
X156 (n279 n280 vdd vss) pll_inv_pdk110_7
X157 (n281 n282 vdd vss) pll_inv_pdk110_7
X158 (n283 n284 vdd vss) pll_inv_pdk110_7
X159 (n285 n286 vdd vss) pll_inv_pdk110_7
X160 (n287 n288 vdd vss) pll_inv_pdk110_7
X161 (n289 n290 vdd vss) pll_inv_pdk110_7
X162 (n291 n292 vdd vss) pll_inv_pdk110_7
X163 (n293 n294 vdd vss) pll_inv_pdk110_7
X164 (coarse7 n295 vdd vss) pll_inv_pdk110_7
X165 (coarse0 n296 vdd vss) pll_inv_pdk110_7
X166 (coarse0 n227 n297 vdd vss) tx_and_pdk110_47
X167 (coarse1 n298 n299 vdd vss) tx_and_pdk110_47
X168 (coarse2 n300 n301 vdd vss) tx_and_pdk110_47
X169 (coarse3 n302 n303 vdd vss) tx_and_pdk110_47
X170 (coarse4 n304 n305 vdd vss) tx_and_pdk110_47
X171 (coarse5 n306 n307 vdd vss) tx_and_pdk110_47
X172 (coarse6 n308 n309 vdd vss) tx_and_pdk110_47
X173 (coarse7 n310 n311 vdd vss) tx_and_pdk110_47
X174 (dac0 n227 n312 vdd vss) tx_and_pdk110_47
X175 (dac1 n298 n313 vdd vss) tx_and_pdk110_47
X176 (dac2 n300 n314 vdd vss) tx_and_pdk110_47
X177 (dac3 n302 n315 vdd vss) tx_and_pdk110_47
X178 (dac4 n304 n316 vdd vss) tx_and_pdk110_47
X179 (dac5 n306 n317 vdd vss) tx_and_pdk110_47
X180 (n105 n88 n318 vdd vss) tx_xor_pdk110_66
X181 (n107 n88 n319 vdd vss) tx_xor_pdk110_66
X182 (n109 n117 n320 vdd vss) tx_xor_pdk110_66
X183 (n111 n117 n321 vdd vss) tx_xor_pdk110_66
X184 (n322 n60 n323 vdd vss) tx_or_pdk110_67
X185 (n251 n62 n324 vdd vss) tx_or_pdk110_67
X186 (n325 n64 n326 vdd vss) tx_or_pdk110_67
X187 (n327 n66 n328 vdd vss) tx_or_pdk110_67
X188 (n329 n68 n330 vdd vss) tx_or_pdk110_67
X189 (n331 n70 n332 vdd vss) tx_or_pdk110_67
X190 (n333 n72 n334 vdd vss) tx_or_pdk110_67
X191 (n335 n60 n336 vdd vss) tx_or_pdk110_67
X192 (n337 n62 n338 vdd vss) tx_or_pdk110_67
X193 (n339 n64 n340 vdd vss) tx_or_pdk110_67
X194 (n341 n66 n342 vdd vss) tx_or_pdk110_67
X195 (n343 n68 n344 vdd vss) tx_or_pdk110_67
X196 (n254 n345 n346 vdd vss) tx_or_pdk110_67
X197 (n250 n347 n348 vdd vss) tx_or_pdk110_67
X198 (n349 n350 n351 vdd vss) tx_or_pdk110_67
X199 (n352 n353 n354 vdd vss) tx_or_pdk110_67
X200 (dac1 dac0 n355 vdd vss) tx_xor_pdk110_66
X201 (dac2 n356 n357 vdd vss) tx_xor_pdk110_66
X202 (dac4 n358 n359 vdd vss) tx_xor_pdk110_66
X203 (dac5 n360 n361 vdd vss) tx_xor_pdk110_66
X204 (n362 n363 n364 vdd vss) tx_xor_pdk110_66
X205 (n365 n366 n367 vdd vss) tx_xor_pdk110_66
X206 (n368 n369 n370 vdd vss) tx_xor_pdk110_66
X207 (n371 n372 n373 vdd vss) tx_xor_pdk110_66
X208 (n374 n375 n376 vdd vss) tx_xor_pdk110_66
X209 (n377 n378 n379 vdd vss) tx_xor_pdk110_66
X210 (n380 n381 n212 vdd vss) tx_xor_pdk110_66
X211 (n382 n383 n216 vdd vss) tx_xor_pdk110_66
X212 (n384 n385 n214 vdd vss) tx_xor_pdk110_66
X213 (n386 n387 n218 vdd vss) tx_xor_pdk110_66
X214 (n388 n389 n220 vdd vss) tx_xor_pdk110_66
X215 (n213 n390 n391 vdd vss) tx_xor_pdk110_66
X216 (n217 n392 n393 vdd vss) tx_xor_pdk110_66
X217 (n215 n394 n395 vdd vss) tx_xor_pdk110_66
X218 (n219 n396 n397 vdd vss) tx_xor_pdk110_66
X219 (n221 n398 n399 vdd vss) tx_xor_pdk110_66
X220 (n223 n400 n401 vdd vss) tx_xor_pdk110_66
X221 (n402 n403 n404 vdd vss) tx_xor_pdk110_66
X222 (n246 n405 n406 vdd vss) tx_xor_pdk110_66
X223 (n245 n407 n408 vdd vss) tx_xor_pdk110_66
X224 (n409 n410 n411 vdd vss) tx_xor_pdk110_66
X225 (n412 n413 n414 vdd vss) tx_xor_pdk110_66
X226 (n415 n416 n417 vdd vss) tx_xor_pdk110_66
X227 (n418 n419 n420 vdd vss) tx_xor_pdk110_66
X228 (n421 n422 n423 vdd vss) tx_xor_pdk110_66
X229 (n424 n425 n426 vdd vss) tx_xor_pdk110_66
X230 (n427 n428 n429 vdd vss) tx_xor_pdk110_66
X231 (n430 n431 n432 vdd vss) tx_xor_pdk110_66
X232 (n433 n434 n435 vdd vss) tx_xor_pdk110_66
X233 (n436 n437 n438 vdd vss) tx_xor_pdk110_66
X234 (n439 n440 n441 vdd vss) tx_xor_pdk110_66
X235 (n442 n443 n444 vdd vss) tx_xor_pdk110_66
X236 (n445 n446 n447 vdd vss) tx_xor_pdk110_66
X237 (n448 n449 n450 vdd vss) tx_xor_pdk110_66
X238 (n451 n452 n453 vdd vss) tx_xor_pdk110_66
X239 (n454 n455 n456 vdd vss) tx_xor_pdk110_66
X240 (n457 n458 n459 vdd vss) tx_xor_pdk110_66
X241 (target_k5 n460 n461 vdd vss) tx_xor_pdk110_66
X242 (target_k1 target_k0 n462 vdd vss) tx_xor_pdk110_66
X243 (n463 n464 n465 vdd vss) tx_xor_pdk110_66
X244 (n466 n467 n468 vdd vss) tx_xor_pdk110_66
X245 (n469 n470 n471 vdd vss) tx_xor_pdk110_66
X246 (target_k4 n472 n473 vdd vss) tx_xor_pdk110_66
X247 (target_k5 n474 n475 vdd vss) tx_xor_pdk110_66
X248 (n454 n476 n477 vdd vss) tx_xor_pdk110_66
X249 (n457 n478 n479 vdd vss) tx_xor_pdk110_66
X250 (target_k5 n480 n481 vdd vss) tx_xor_pdk110_66
X251 (n482 n449 n483 vdd vss) tx_xor_pdk110_66
X252 (n484 n485 n486 vdd vss) tx_xor_pdk110_66
X253 (n487 n488 n489 vdd vss) tx_xor_pdk110_66
X254 (n490 n491 n492 vdd vss) tx_xor_pdk110_66
X255 (n479 n493 n494 vdd vss) tx_xor_pdk110_66
X256 (n481 n495 n496 vdd vss) tx_xor_pdk110_66
X257 (n497 n498 n499 vdd vss) tx_xor_pdk110_66
X258 (n500 dac0 n501 vdd vss) tx_xor_pdk110_66
X259 (n211 n502 n503 vdd vss) tx_xor_pdk110_66
X260 (n504 n505 n506 vdd vss) tx_xor_pdk110_66
X261 (n507 n508 n509 vdd vss) tx_xor_pdk110_66
X262 (n510 n511 n512 vdd vss) tx_xor_pdk110_66
X263 (n325 n251 n513 vdd vss) tx_xor_pdk110_66
X264 (n327 n514 n515 vdd vss) tx_xor_pdk110_66
X265 (n329 n516 n517 vdd vss) tx_xor_pdk110_66
X266 (n331 n518 n519 vdd vss) tx_xor_pdk110_66
X267 (n333 n520 n521 vdd vss) tx_xor_pdk110_66
X268 (n522 n523 n524 vdd vss) tx_xor_pdk110_66
X269 (coarse1 coarse0 n525 vdd vss) tx_xor_pdk110_66
X270 (coarse2 n526 n527 vdd vss) tx_xor_pdk110_66
X271 (coarse3 n528 n529 vdd vss) tx_xor_pdk110_66
X272 (coarse4 n530 n531 vdd vss) tx_xor_pdk110_66
X273 (coarse5 n532 n533 vdd vss) tx_xor_pdk110_66
X274 (coarse6 n534 n535 vdd vss) tx_xor_pdk110_66
X275 (coarse7 n536 n537 vdd vss) tx_xor_pdk110_66
X276 (n538 coarse0 n539 vdd vss) tx_xor_pdk110_66
X277 (n540 n541 n542 vdd vss) tx_xor_pdk110_66
X278 (n543 n544 n545 vdd vss) tx_xor_pdk110_66
X279 (n546 n547 n548 vdd vss) tx_xor_pdk110_66
X280 (n549 n550 n551 vdd vss) tx_xor_pdk110_66
X281 (n552 n553 n554 vdd vss) tx_xor_pdk110_66
X282 (n295 n555 n556 vdd vss) tx_xor_pdk110_66
X283 (n95 n93 n557 vdd vss) tx_xor_pdk110_66
X284 (n97 n558 n559 vdd vss) tx_xor_pdk110_66
X285 (n560 n561 n562 vdd vss) tx_xor_pdk110_66
X286 (n563 n564 n565 vdd vss) tx_xor_pdk110_66
X287 (n566 n567 n568 vdd vss) tx_xor_pdk110_66
X288 (n569 n570 n571 vdd vss) tx_xor_pdk110_66
X289 (n572 n573 n574 vdd vss) tx_xor_pdk110_66
X290 (n575 n576 n577 vdd vss) tx_xor_pdk110_66
X291 (n578 n579 n580 vdd vss) tx_xor_pdk110_66
X292 (dac3 n581 n582 vdd vss) tx_xor_pdk110_66
X293 (n101 n99 n583 vdd vss) tx_xor_pdk110_66
X294 (n103 n584 n585 vdd vss) tx_xor_pdk110_66
X295 (n105 n586 n587 vdd vss) tx_xor_pdk110_66
X296 (n107 n588 n589 vdd vss) tx_xor_pdk110_66
X297 (n109 n590 n591 vdd vss) tx_xor_pdk110_66
X298 (n111 n592 n593 vdd vss) tx_xor_pdk110_66
X299 (n113 n594 n595 vdd vss) tx_xor_pdk110_66
X300 (n596 n356 n358 vdd vss) tx_and_pdk110_47
X301 (dac4 n358 n360 vdd vss) tx_and_pdk110_47
X302 (n267 n127 n363 vdd vss) tx_and_pdk110_47
X303 (n355 n129 n597 vdd vss) tx_and_pdk110_47
X304 (n357 n131 n598 vdd vss) tx_and_pdk110_47
X305 (n582 n133 n599 vdd vss) tx_and_pdk110_47
X306 (n359 n135 n600 vdd vss) tx_and_pdk110_47
X307 (n361 n137 n601 vdd vss) tx_and_pdk110_47
X308 (n355 n129 n362 vdd vss) tx_xor_pdk110_66
X309 (n357 n131 n365 vdd vss) tx_xor_pdk110_66
X310 (n582 n133 n368 vdd vss) tx_xor_pdk110_66
X311 (n359 n135 n371 vdd vss) tx_xor_pdk110_66
X312 (n361 n137 n374 vdd vss) tx_xor_pdk110_66
X313 (n600 n602 n375 vdd vss) tx_or_pdk110_67
X314 (n598 n603 n369 vdd vss) tx_or_pdk110_67
X315 (n365 n366 n603 vdd vss) tx_and_pdk110_47
X316 (n604 n605 n378 vdd vss) tx_or_pdk110_67
X317 (n606 n372 n605 vdd vss) tx_and_pdk110_47
X318 (n607 n608 n372 vdd vss) tx_or_pdk110_67
X319 (n609 n366 n608 vdd vss) tx_and_pdk110_47
X320 (n374 n371 n606 vdd vss) tx_and_pdk110_47
X321 (n601 n610 n604 vdd vss) tx_or_pdk110_67
X322 (n374 n600 n610 vdd vss) tx_and_pdk110_47
X323 (n368 n365 n609 vdd vss) tx_and_pdk110_47
X324 (n599 n611 n607 vdd vss) tx_or_pdk110_67
X325 (n368 n598 n611 vdd vss) tx_and_pdk110_47
X326 (n371 n372 n602 vdd vss) tx_and_pdk110_47
X327 (n597 n612 n366 vdd vss) tx_or_pdk110_67
X328 (n362 n363 n612 vdd vss) tx_and_pdk110_47
X329 (n75 dac0 n381 vdd vss) tx_and_pdk110_47
X330 (n77 dac1 n613 vdd vss) tx_and_pdk110_47
X331 (n79 dac2 n614 vdd vss) tx_and_pdk110_47
X332 (n81 dac3 n615 vdd vss) tx_and_pdk110_47
X333 (n83 dac4 n616 vdd vss) tx_and_pdk110_47
X334 (n85 dac5 n617 vdd vss) tx_and_pdk110_47
X335 (n75 dac0 n390 vdd vss) tx_xor_pdk110_66
X336 (n77 dac1 n380 vdd vss) tx_xor_pdk110_66
X337 (n79 dac2 n382 vdd vss) tx_xor_pdk110_66
X338 (n81 dac3 n384 vdd vss) tx_xor_pdk110_66
X339 (n83 dac4 n386 vdd vss) tx_xor_pdk110_66
X340 (n85 dac5 n388 vdd vss) tx_xor_pdk110_66
X341 (n616 n618 n389 vdd vss) tx_or_pdk110_67
X342 (n614 n619 n385 vdd vss) tx_or_pdk110_67
X343 (n382 n383 n619 vdd vss) tx_and_pdk110_47
X344 (n620 n621 n222 vdd vss) tx_or_pdk110_67
X345 (n622 n387 n621 vdd vss) tx_and_pdk110_47
X346 (n623 n624 n387 vdd vss) tx_or_pdk110_67
X347 (n625 n383 n624 vdd vss) tx_and_pdk110_47
X348 (n388 n386 n622 vdd vss) tx_and_pdk110_47
X349 (n617 n626 n620 vdd vss) tx_or_pdk110_67
X350 (n388 n616 n626 vdd vss) tx_and_pdk110_47
X351 (n384 n382 n625 vdd vss) tx_and_pdk110_47
X352 (n615 n627 n623 vdd vss) tx_or_pdk110_67
X353 (n384 n614 n627 vdd vss) tx_and_pdk110_47
X354 (n386 n387 n618 vdd vss) tx_and_pdk110_47
X355 (n613 n628 n383 vdd vss) tx_or_pdk110_67
X356 (n380 n381 n628 vdd vss) tx_and_pdk110_47
X357 (n218 n629 n398 vdd vss) tx_or_pdk110_67
X358 (n216 n630 n394 vdd vss) tx_or_pdk110_67
X359 (n217 n392 n630 vdd vss) tx_and_pdk110_47
X360 (n631 n632 n400 vdd vss) tx_or_pdk110_67
X361 (n633 n396 n632 vdd vss) tx_and_pdk110_47
X362 (n634 n635 n396 vdd vss) tx_or_pdk110_67
X363 (n636 n392 n635 vdd vss) tx_and_pdk110_47
X364 (n221 n219 n633 vdd vss) tx_and_pdk110_47
X365 (n220 n637 n631 vdd vss) tx_or_pdk110_67
X366 (n221 n218 n637 vdd vss) tx_and_pdk110_47
X367 (n215 n217 n636 vdd vss) tx_and_pdk110_47
X368 (n214 n638 n634 vdd vss) tx_or_pdk110_67
X369 (n215 n216 n638 vdd vss) tx_and_pdk110_47
X370 (n219 n396 n629 vdd vss) tx_and_pdk110_47
X371 (n212 n639 n392 vdd vss) tx_or_pdk110_67
X372 (n213 n390 n639 vdd vss) tx_and_pdk110_47
X373 (n640 n641 n642 vdd vss) tx_and_pdk110_47
X374 (n643 n644 n645 vdd vss) tx_and_pdk110_47
X375 (n646 n647 n648 vdd vss) tx_and_pdk110_47
X376 (n649 n650 n651 vdd vss) tx_and_pdk110_47
X377 (n652 n653 n654 vdd vss) tx_and_pdk110_47
X378 (n655 n656 n657 vdd vss) tx_and_pdk110_47
X379 (n658 n659 n660 vdd vss) tx_and_pdk110_47
X380 (n661 n662 n663 vdd vss) tx_and_pdk110_47
X381 (n664 n665 n666 vdd vss) tx_and_pdk110_47
X382 (n640 n641 n409 vdd vss) tx_xor_pdk110_66
X383 (n643 n644 n412 vdd vss) tx_xor_pdk110_66
X384 (n646 n647 n415 vdd vss) tx_xor_pdk110_66
X385 (n649 n650 n418 vdd vss) tx_xor_pdk110_66
X386 (n652 n653 n421 vdd vss) tx_xor_pdk110_66
X387 (n655 n656 n424 vdd vss) tx_xor_pdk110_66
X388 (n658 n659 n427 vdd vss) tx_xor_pdk110_66
X389 (n661 n662 n430 vdd vss) tx_xor_pdk110_66
X390 (n664 n665 n433 vdd vss) tx_xor_pdk110_66
X391 (n667 n668 n436 vdd vss) tx_xor_pdk110_66
X392 (n642 n669 n413 vdd vss) tx_or_pdk110_67
X393 (n409 n410 n669 vdd vss) tx_and_pdk110_47
X394 (n654 n670 n425 vdd vss) tx_or_pdk110_67
X395 (n246 n405 n407 vdd vss) tx_and_pdk110_47
X396 (n648 n671 n419 vdd vss) tx_or_pdk110_67
X397 (n427 n428 n672 vdd vss) tx_and_pdk110_47
X398 (n673 n674 n428 vdd vss) tx_or_pdk110_67
X399 (n675 n422 n674 vdd vss) tx_and_pdk110_47
X400 (n660 n672 n431 vdd vss) tx_or_pdk110_67
X401 (n676 n677 n416 vdd vss) tx_or_pdk110_67
X402 (n678 n410 n677 vdd vss) tx_and_pdk110_47
X403 (n415 n416 n671 vdd vss) tx_and_pdk110_47
X404 (n679 n680 n434 vdd vss) tx_or_pdk110_67
X405 (n681 n422 n680 vdd vss) tx_and_pdk110_47
X406 (n433 n434 n682 vdd vss) tx_and_pdk110_47
X407 (n683 n684 n422 vdd vss) tx_or_pdk110_67
X408 (n685 n410 n684 vdd vss) tx_and_pdk110_47
X409 (n686 n675 n681 vdd vss) tx_and_pdk110_47
X410 (n687 n688 n679 vdd vss) tx_or_pdk110_67
X411 (n686 n673 n688 vdd vss) tx_and_pdk110_47
X412 (n689 n678 n685 vdd vss) tx_and_pdk110_47
X413 (n690 n691 n683 vdd vss) tx_or_pdk110_67
X414 (n689 n676 n691 vdd vss) tx_and_pdk110_47
X415 (n666 n682 n437 vdd vss) tx_or_pdk110_67
X416 (n430 n427 n686 vdd vss) tx_and_pdk110_47
X417 (n663 n692 n687 vdd vss) tx_or_pdk110_67
X418 (n430 n660 n692 vdd vss) tx_and_pdk110_47
X419 (n424 n421 n675 vdd vss) tx_and_pdk110_47
X420 (n657 n693 n673 vdd vss) tx_or_pdk110_67
X421 (n424 n654 n693 vdd vss) tx_and_pdk110_47
X422 (n418 n415 n689 vdd vss) tx_and_pdk110_47
X423 (n651 n694 n690 vdd vss) tx_or_pdk110_67
X424 (n418 n648 n694 vdd vss) tx_and_pdk110_47
X425 (n412 n409 n678 vdd vss) tx_and_pdk110_47
X426 (n645 n695 n676 vdd vss) tx_or_pdk110_67
X427 (n412 n642 n695 vdd vss) tx_and_pdk110_47
X428 (n421 n422 n670 vdd vss) tx_and_pdk110_47
X429 (measured4 n696 n697 vdd vss) tx_and_pdk110_47
X430 (measured5 n698 n442 vdd vss) tx_xor_pdk110_66
X431 (measured7 n699 n504 vdd vss) tx_xor_pdk110_66
X432 (measured12 n700 n566 vdd vss) tx_xor_pdk110_66
X433 (measured5 n698 n701 vdd vss) tx_and_pdk110_47
X434 (measured11 n702 n703 vdd vss) tx_and_pdk110_47
X435 (measured12 n700 n704 vdd vss) tx_and_pdk110_47
X436 (measured11 n702 n510 vdd vss) tx_xor_pdk110_66
X437 (n705 n706 n564 vdd vss) tx_or_pdk110_67
X438 (n707 n708 n508 vdd vss) tx_or_pdk110_67
X439 (n709 n710 n511 vdd vss) tx_or_pdk110_67
X440 (n566 n567 n711 vdd vss) tx_and_pdk110_47
X441 (n712 n713 n561 vdd vss) tx_or_pdk110_67
X442 (n704 n711 n570 vdd vss) tx_or_pdk110_67
X443 (n714 n715 n440 vdd vss) tx_or_pdk110_67
X444 (n569 n566 n716 vdd vss) tx_and_pdk110_47
X445 (n703 n717 n718 vdd vss) tx_or_pdk110_67
X446 (n563 n560 n719 vdd vss) tx_and_pdk110_47
X447 (n720 n721 n707 vdd vss) tx_or_pdk110_67
X448 (n722 n723 n724 vdd vss) tx_or_pdk110_67
X449 (n442 n439 n725 vdd vss) tx_and_pdk110_47
X450 (n701 n726 n727 vdd vss) tx_or_pdk110_67
X451 (n245 measured2 n728 vdd vss) tx_and_pdk110_47
X452 (n560 n561 n706 vdd vss) tx_and_pdk110_47
X453 (target_k4 target_k5 n729 vdd vss) tx_and_pdk110_47
X454 (target_k1 target_k2 n448 vdd vss) tx_xor_pdk110_66
X455 (target_k2 target_k3 n451 vdd vss) tx_xor_pdk110_66
X456 (target_k3 target_k4 n454 vdd vss) tx_xor_pdk110_66
X457 (target_k4 target_k5 n457 vdd vss) tx_xor_pdk110_66
X458 (n730 n731 n458 vdd vss) tx_or_pdk110_67
X459 (n732 n733 n452 vdd vss) tx_or_pdk110_67
X460 (target_k5 n460 n734 vdd vss) tx_and_pdk110_47
X461 (n735 n736 n460 vdd vss) tx_or_pdk110_67
X462 (n737 n455 n736 vdd vss) tx_and_pdk110_47
X463 (n448 n449 n733 vdd vss) tx_and_pdk110_47
X464 (n738 n739 n455 vdd vss) tx_or_pdk110_67
X465 (n740 n449 n739 vdd vss) tx_and_pdk110_47
X466 (n457 n454 n737 vdd vss) tx_and_pdk110_47
X467 (n729 n741 n735 vdd vss) tx_or_pdk110_67
X468 (n457 n730 n741 vdd vss) tx_and_pdk110_47
X469 (n451 n448 n740 vdd vss) tx_and_pdk110_47
X470 (n742 n743 n738 vdd vss) tx_or_pdk110_67
X471 (n451 n732 n743 vdd vss) tx_and_pdk110_47
X472 (n454 n455 n731 vdd vss) tx_and_pdk110_47
X473 (target_k5 n744 n263 vdd vss) tx_or_pdk110_67
X474 (n745 n746 n744 vdd vss) tx_and_pdk110_47
X475 (n747 target_k4 n745 vdd vss) tx_and_pdk110_47
X476 (n745 n748 n749 vdd vss) tx_and_pdk110_47
X477 (target_k5 n749 n261 vdd vss) tx_or_pdk110_67
X478 (n750 n751 n748 vdd vss) tx_or_pdk110_67
X479 (n752 target_k1 n751 vdd vss) tx_and_pdk110_47
X480 (target_k3 n753 n750 vdd vss) tx_or_pdk110_67
X481 (n754 target_k2 n753 vdd vss) tx_and_pdk110_47
X482 (target_k0 target_k2 n464 vdd vss) tx_and_pdk110_47
X483 (target_k1 target_k3 n755 vdd vss) tx_and_pdk110_47
X484 (target_k2 target_k4 n756 vdd vss) tx_and_pdk110_47
X485 (target_k3 target_k5 n757 vdd vss) tx_and_pdk110_47
X486 (target_k0 target_k2 n758 vdd vss) tx_xor_pdk110_66
X487 (target_k1 target_k3 n463 vdd vss) tx_xor_pdk110_66
X488 (target_k2 target_k4 n466 vdd vss) tx_xor_pdk110_66
X489 (target_k3 target_k5 n469 vdd vss) tx_xor_pdk110_66
X490 (n756 n759 n470 vdd vss) tx_or_pdk110_67
X491 (target_k4 n472 n474 vdd vss) tx_and_pdk110_47
X492 (n760 n761 n472 vdd vss) tx_or_pdk110_67
X493 (n762 n467 n761 vdd vss) tx_and_pdk110_47
X494 (n763 n764 n765 vdd vss) tx_or_pdk110_67
X495 (n766 n467 n764 vdd vss) tx_and_pdk110_47
X496 (n729 n762 n766 vdd vss) tx_and_pdk110_47
X497 (n729 n760 n763 vdd vss) tx_and_pdk110_47
X498 (n469 n466 n762 vdd vss) tx_and_pdk110_47
X499 (n757 n767 n760 vdd vss) tx_or_pdk110_67
X500 (n469 n756 n767 vdd vss) tx_and_pdk110_47
X501 (n755 n768 n467 vdd vss) tx_or_pdk110_67
X502 (n463 n464 n768 vdd vss) tx_and_pdk110_47
X503 (n466 n467 n759 vdd vss) tx_and_pdk110_47
X504 (n769 n770 n771 vdd vss) tx_and_pdk110_47
X505 (n772 n771 n259 vdd vss) tx_or_pdk110_67
X506 (n742 n773 n770 vdd vss) tx_and_pdk110_47
X507 (target_k5 n745 n772 vdd vss) tx_or_pdk110_67
X508 (target_k1 n774 n773 vdd vss) tx_or_pdk110_67
X509 (target_k1 target_k2 n732 vdd vss) tx_and_pdk110_47
X510 (target_k3 target_k4 n730 vdd vss) tx_and_pdk110_47
X511 (n742 n775 n476 vdd vss) tx_or_pdk110_67
X512 (n457 n478 n776 vdd vss) tx_and_pdk110_47
X513 (n777 n778 n478 vdd vss) tx_or_pdk110_67
X514 (n779 n452 n778 vdd vss) tx_and_pdk110_47
X515 (n729 n776 n480 vdd vss) tx_or_pdk110_67
X516 (n780 n781 n497 vdd vss) tx_or_pdk110_67
X517 (n782 n452 n781 vdd vss) tx_and_pdk110_47
X518 (n783 n779 n782 vdd vss) tx_and_pdk110_47
X519 (n784 n785 n780 vdd vss) tx_or_pdk110_67
X520 (n783 n777 n785 vdd vss) tx_and_pdk110_47
X521 (target_k5 n457 n783 vdd vss) tx_and_pdk110_47
X522 (target_k5 n729 n784 vdd vss) tx_and_pdk110_47
X523 (n454 n451 n779 vdd vss) tx_and_pdk110_47
X524 (n730 n786 n777 vdd vss) tx_or_pdk110_67
X525 (n454 n742 n786 vdd vss) tx_and_pdk110_47
X526 (n451 n452 n775 vdd vss) tx_and_pdk110_47
X527 (n772 n787 n257 vdd vss) tx_or_pdk110_67
X528 (n769 n746 n787 vdd vss) tx_and_pdk110_47
X529 (n742 n788 n746 vdd vss) tx_or_pdk110_67
X530 (target_k0 target_k1 n449 vdd vss) tx_and_pdk110_47
X531 (n462 target_k2 n789 vdd vss) tx_and_pdk110_47
X532 (n450 target_k3 n790 vdd vss) tx_and_pdk110_47
X533 (n453 target_k4 n791 vdd vss) tx_and_pdk110_47
X534 (n477 target_k5 n792 vdd vss) tx_and_pdk110_47
X535 (n462 target_k2 n482 vdd vss) tx_xor_pdk110_66
X536 (n450 target_k3 n484 vdd vss) tx_xor_pdk110_66
X537 (n453 target_k4 n487 vdd vss) tx_xor_pdk110_66
X538 (n477 target_k5 n490 vdd vss) tx_xor_pdk110_66
X539 (n791 n793 n491 vdd vss) tx_or_pdk110_67
X540 (n789 n794 n485 vdd vss) tx_or_pdk110_67
X541 (n479 n493 n495 vdd vss) tx_and_pdk110_47
X542 (n795 n796 n493 vdd vss) tx_or_pdk110_67
X543 (n797 n488 n796 vdd vss) tx_and_pdk110_47
X544 (n482 n449 n794 vdd vss) tx_and_pdk110_47
X545 (n798 n799 n498 vdd vss) tx_or_pdk110_67
X546 (n800 n488 n799 vdd vss) tx_and_pdk110_47
X547 (n497 n498 n801 vdd vss) tx_and_pdk110_47
X548 (n802 n797 n800 vdd vss) tx_and_pdk110_47
X549 (n802 n795 n798 vdd vss) tx_and_pdk110_47
X550 (n803 n804 n488 vdd vss) tx_or_pdk110_67
X551 (n805 n449 n804 vdd vss) tx_and_pdk110_47
X552 (n481 n479 n802 vdd vss) tx_and_pdk110_47
X553 (n490 n487 n797 vdd vss) tx_and_pdk110_47
X554 (n792 n806 n795 vdd vss) tx_or_pdk110_67
X555 (n490 n791 n806 vdd vss) tx_and_pdk110_47
X556 (n484 n482 n805 vdd vss) tx_and_pdk110_47
X557 (n790 n807 n803 vdd vss) tx_or_pdk110_67
X558 (n484 n789 n807 vdd vss) tx_and_pdk110_47
X559 (n487 n488 n793 vdd vss) tx_and_pdk110_47
X560 (n808 n809 n255 vdd vss) tx_or_pdk110_67
X561 (n810 n358 n809 vdd vss) tx_and_pdk110_47
X562 (n578 n575 n810 vdd vss) tx_and_pdk110_47
X563 (dac5 n811 n808 vdd vss) tx_or_pdk110_67
X564 (n578 dac4 n811 vdd vss) tx_and_pdk110_47
X565 (n572 n573 n812 vdd vss) tx_and_pdk110_47
X566 (n813 n576 n253 vdd vss) tx_and_pdk110_47
X567 (n814 n573 n815 vdd vss) tx_and_pdk110_47
X568 (dac5 dac4 n813 vdd vss) tx_and_pdk110_47
X569 (measured8 n816 n705 vdd vss) tx_and_pdk110_47
X570 (measured9 n817 n720 vdd vss) tx_and_pdk110_47
X571 (measured10 n818 n709 vdd vss) tx_and_pdk110_47
X572 (measured8 n816 n560 vdd vss) tx_xor_pdk110_66
X573 (measured10 n818 n507 vdd vss) tx_xor_pdk110_66
X574 (n697 n819 n443 vdd vss) tx_or_pdk110_67
X575 (n820 n821 n505 vdd vss) tx_or_pdk110_67
X576 (n822 n823 n824 vdd vss) tx_or_pdk110_67
X577 (n716 n567 n823 vdd vss) tx_and_pdk110_47
X578 (n507 n508 n710 vdd vss) tx_and_pdk110_47
X579 (n719 n561 n708 vdd vss) tx_and_pdk110_47
X580 (n727 n825 n446 vdd vss) tx_or_pdk110_67
X581 (n725 n440 n825 vdd vss) tx_and_pdk110_47
X582 (n826 n719 n827 vdd vss) tx_and_pdk110_47
X583 (n718 n828 n829 vdd vss) tx_or_pdk110_67
X584 (n826 n707 n828 vdd vss) tx_and_pdk110_47
X585 (n830 n725 n831 vdd vss) tx_and_pdk110_47
X586 (n830 n727 n832 vdd vss) tx_and_pdk110_47
X587 (n833 n834 n822 vdd vss) tx_or_pdk110_67
X588 (n569 n704 n834 vdd vss) tx_and_pdk110_47
X589 (n504 n820 n723 vdd vss) tx_and_pdk110_47
X590 (n333 n520 n523 vdd vss) tx_and_pdk110_47
X591 (n329 n516 n518 vdd vss) tx_and_pdk110_47
X592 (n325 n251 n514 vdd vss) tx_and_pdk110_47
X593 (n835 n516 n249 vdd vss) tx_and_pdk110_47
X594 (n836 n251 n516 vdd vss) tx_and_pdk110_47
X595 (n522 n333 n837 vdd vss) tx_and_pdk110_47
X596 (n327 n325 n836 vdd vss) tx_and_pdk110_47
X597 (n838 n516 n520 vdd vss) tx_and_pdk110_47
X598 (coarse2 n526 n528 vdd vss) tx_and_pdk110_47
X599 (coarse4 n530 n532 vdd vss) tx_and_pdk110_47
X600 (n839 n530 n534 vdd vss) tx_and_pdk110_47
X601 (coarse6 n534 n536 vdd vss) tx_and_pdk110_47
X602 (n840 n526 n530 vdd vss) tx_and_pdk110_47
X603 (coarse5 coarse4 n839 vdd vss) tx_and_pdk110_47
X604 (coarse3 coarse2 n840 vdd vss) tx_and_pdk110_47
X605 (coarse1 coarse0 n526 vdd vss) tx_and_pdk110_47
X606 (coarse2 n841 n544 vdd vss) tx_or_pdk110_67
X607 (n540 n541 n841 vdd vss) tx_and_pdk110_47
X608 (n546 n547 n842 vdd vss) tx_and_pdk110_47
X609 (n843 n844 n553 vdd vss) tx_or_pdk110_67
X610 (n845 n547 n844 vdd vss) tx_and_pdk110_47
X611 (n552 n553 n846 vdd vss) tx_and_pdk110_47
X612 (coarse6 n846 n555 vdd vss) tx_or_pdk110_67
X613 (n847 n848 n547 vdd vss) tx_or_pdk110_67
X614 (n849 n541 n848 vdd vss) tx_and_pdk110_47
X615 (n549 n546 n845 vdd vss) tx_and_pdk110_47
X616 (coarse5 n850 n843 vdd vss) tx_or_pdk110_67
X617 (n549 coarse4 n850 vdd vss) tx_and_pdk110_47
X618 (n543 n540 n849 vdd vss) tx_and_pdk110_47
X619 (coarse3 n851 n847 vdd vss) tx_or_pdk110_67
X620 (n543 coarse2 n851 vdd vss) tx_and_pdk110_47
X621 (coarse4 n842 n550 vdd vss) tx_or_pdk110_67
X622 (coarse1 n852 n541 vdd vss) tx_or_pdk110_67
X623 (n538 coarse0 n852 vdd vss) tx_and_pdk110_47
X624 (n95 n93 n558 vdd vss) tx_and_pdk110_47
X625 (n853 n854 n247 vdd vss) tx_or_pdk110_67
X626 (n855 n856 n854 vdd vss) tx_and_pdk110_47
X627 (n857 n858 n853 vdd vss) tx_or_pdk110_67
X628 (n859 n860 n858 vdd vss) tx_and_pdk110_47
X629 (n861 n862 n856 vdd vss) tx_or_pdk110_67
X630 (n863 n864 n862 vdd vss) tx_and_pdk110_47
X631 (n865 n866 n860 vdd vss) tx_or_pdk110_67
X632 (n867 n868 n866 vdd vss) tx_and_pdk110_47
X633 (n869 n870 n861 vdd vss) tx_or_pdk110_67
X634 (n871 n872 n870 vdd vss) tx_and_pdk110_47
X635 (n873 n874 n864 vdd vss) tx_or_pdk110_67
X636 (n875 n876 n874 vdd vss) tx_and_pdk110_47
X637 (n271 n877 n857 vdd vss) tx_or_pdk110_67
X638 (n272 n273 n877 vdd vss) tx_and_pdk110_47
X639 (n275 n878 n865 vdd vss) tx_or_pdk110_67
X640 (n276 n277 n878 vdd vss) tx_and_pdk110_47
X641 (n280 n282 n879 vdd vss) tx_and_pdk110_47
X642 (n279 n880 n868 vdd vss) tx_or_pdk110_67
X643 (n280 n281 n880 vdd vss) tx_and_pdk110_47
X644 (n283 n881 n869 vdd vss) tx_or_pdk110_67
X645 (n284 n285 n881 vdd vss) tx_and_pdk110_47
X646 (n287 n882 n872 vdd vss) tx_or_pdk110_67
X647 (n288 n289 n882 vdd vss) tx_and_pdk110_47
X648 (n292 n294 n875 vdd vss) tx_and_pdk110_47
X649 (n291 n883 n873 vdd vss) tx_or_pdk110_67
X650 (n292 n293 n883 vdd vss) tx_and_pdk110_47
X651 (n269 n884 n876 vdd vss) tx_or_pdk110_67
X652 (n270 measured0 n884 vdd vss) tx_and_pdk110_47
X653 (measured6 n885 n820 vdd vss) tx_and_pdk110_47
X654 (measured7 n699 n722 vdd vss) tx_and_pdk110_47
X655 (measured13 n886 n833 vdd vss) tx_and_pdk110_47
X656 (measured4 n696 n439 vdd vss) tx_xor_pdk110_66
X657 (measured6 n885 n445 vdd vss) tx_xor_pdk110_66
X658 (measured9 n817 n563 vdd vss) tx_xor_pdk110_66
X659 (measured13 n886 n569 vdd vss) tx_xor_pdk110_66
X660 (n439 n440 n819 vdd vss) tx_and_pdk110_47
X661 (n445 n446 n821 vdd vss) tx_and_pdk110_47
X662 (n829 n887 n567 vdd vss) tx_or_pdk110_67
X663 (n827 n561 n887 vdd vss) tx_and_pdk110_47
X664 (n831 n440 n713 vdd vss) tx_and_pdk110_47
X665 (n724 n832 n712 vdd vss) tx_or_pdk110_67
X666 (n510 n507 n826 vdd vss) tx_and_pdk110_47
X667 (n510 n709 n717 vdd vss) tx_and_pdk110_47
X668 (n563 n705 n721 vdd vss) tx_and_pdk110_47
X669 (n504 n445 n830 vdd vss) tx_and_pdk110_47
X670 (n442 n697 n726 vdd vss) tx_and_pdk110_47
X671 (measured3 n728 n714 vdd vss) tx_or_pdk110_67
X672 (dac0 n888 n889 vdd vss) tx_and_pdk110_47
X673 (dac1 n890 n891 vdd vss) tx_and_pdk110_47
X674 (dac2 n892 n893 vdd vss) tx_and_pdk110_47
X675 (dac3 n894 n895 vdd vss) tx_and_pdk110_47
X676 (dac4 n896 n897 vdd vss) tx_and_pdk110_47
X677 (dac5 n898 n899 vdd vss) tx_and_pdk110_47
X678 (dac0 n888 n900 vdd vss) tx_xor_pdk110_66
X679 (dac1 n890 n901 vdd vss) tx_xor_pdk110_66
X680 (dac2 n892 n902 vdd vss) tx_xor_pdk110_66
X681 (dac3 n894 n903 vdd vss) tx_xor_pdk110_66
X682 (dac4 n896 n904 vdd vss) tx_xor_pdk110_66
X683 (dac5 n898 n905 vdd vss) tx_xor_pdk110_66
X684 (n906 n907 n908 vdd vss) tx_or_pdk110_67
X685 (n909 n910 n907 vdd vss) tx_and_pdk110_47
X686 (n911 n912 n910 vdd vss) tx_or_pdk110_67
X687 (n913 n914 n912 vdd vss) tx_and_pdk110_47
X688 (n905 n904 n909 vdd vss) tx_and_pdk110_47
X689 (n899 n915 n906 vdd vss) tx_or_pdk110_67
X690 (n905 n897 n915 vdd vss) tx_and_pdk110_47
X691 (n895 n916 n911 vdd vss) tx_or_pdk110_67
X692 (n903 n893 n916 vdd vss) tx_and_pdk110_47
X693 (n891 n917 n914 vdd vss) tx_or_pdk110_67
X694 (n901 n918 n917 vdd vss) tx_and_pdk110_47
X695 (n889 n900 n918 vdd vss) tx_or_pdk110_67
X696 (n575 n576 n919 vdd vss) tx_and_pdk110_47
X697 (dac4 n919 n579 vdd vss) tx_or_pdk110_67
X698 (n920 n815 n576 vdd vss) tx_or_pdk110_67
X699 (dac3 n921 n920 vdd vss) tx_or_pdk110_67
X700 (n211 dac2 n921 vdd vss) tx_and_pdk110_47
X701 (dac2 n812 n502 vdd vss) tx_or_pdk110_67
X702 (dac1 n922 n573 vdd vss) tx_or_pdk110_67
X703 (n500 dac0 n922 vdd vss) tx_and_pdk110_47
X704 (dac0 n923 n924 vdd vss) tx_and_pdk110_47
X705 (dac1 n925 n926 vdd vss) tx_and_pdk110_47
X706 (dac2 n927 n928 vdd vss) tx_and_pdk110_47
X707 (dac3 n929 n930 vdd vss) tx_and_pdk110_47
X708 (dac4 n931 n932 vdd vss) tx_and_pdk110_47
X709 (dac5 n933 n934 vdd vss) tx_and_pdk110_47
X710 (dac0 n923 n935 vdd vss) tx_xor_pdk110_66
X711 (dac1 n925 n936 vdd vss) tx_xor_pdk110_66
X712 (dac2 n927 n937 vdd vss) tx_xor_pdk110_66
X713 (dac3 n929 n938 vdd vss) tx_xor_pdk110_66
X714 (dac4 n931 n939 vdd vss) tx_xor_pdk110_66
X715 (dac5 n933 n940 vdd vss) tx_xor_pdk110_66
X716 (n941 n942 n943 vdd vss) tx_or_pdk110_67
X717 (n944 n945 n942 vdd vss) tx_and_pdk110_47
X718 (n946 n947 n945 vdd vss) tx_or_pdk110_67
X719 (n948 n949 n947 vdd vss) tx_and_pdk110_47
X720 (n940 n939 n944 vdd vss) tx_and_pdk110_47
X721 (n934 n950 n941 vdd vss) tx_or_pdk110_67
X722 (n940 n932 n950 vdd vss) tx_and_pdk110_47
X723 (n938 n937 n948 vdd vss) tx_and_pdk110_47
X724 (n930 n951 n946 vdd vss) tx_or_pdk110_67
X725 (n938 n928 n951 vdd vss) tx_and_pdk110_47
X726 (n926 n952 n949 vdd vss) tx_or_pdk110_67
X727 (n936 n953 n952 vdd vss) tx_and_pdk110_47
X728 (n924 n935 n953 vdd vss) tx_or_pdk110_67
X729 (dac2 n356 n581 vdd vss) tx_and_pdk110_47
X730 (n813 n358 n377 vdd vss) tx_and_pdk110_47
X731 (dac3 dac2 n596 vdd vss) tx_and_pdk110_47
X732 (dac1 dac0 n356 vdd vss) tx_and_pdk110_47
X733 (n103 n584 n586 vdd vss) tx_and_pdk110_47
X734 (n107 n588 n590 vdd vss) tx_and_pdk110_47
X735 (n954 n588 n592 vdd vss) tx_and_pdk110_47
X736 (n111 n592 n594 vdd vss) tx_and_pdk110_47
X737 (n955 n584 n588 vdd vss) tx_and_pdk110_47
X738 (n109 n107 n954 vdd vss) tx_and_pdk110_47
X739 (n105 n103 n955 vdd vss) tx_and_pdk110_47
X740 (n101 n99 n584 vdd vss) tx_and_pdk110_47
X741 (n956 n957 n958 vdd vss) tx_or_pdk110_67
X742 (n956 n237 n959 vdd vss) tx_or_pdk110_67
X743 (n956 n960 n961 vdd vss) tx_or_pdk110_67
X744 (n242 n265 n962 vdd vss) tx_or_pdk110_67
X745 (n231 n238 n963 vdd vss) tx_or_pdk110_67
X746 (n962 n963 n956 vdd vss) tx_or_pdk110_67
X747 (n956 n235 n964 vdd vss) tx_or_pdk110_67
X748 (n117 n265 n965 vdd vss) tx_or_pdk110_67
X749 (n965 n966 n967 vdd vss) tx_or_pdk110_67
X750 (n233 n117 n968 vdd vss) tx_and_pdk110_47
X751 (n238 n184 n969 vdd vss) tx_and_pdk110_47
X752 (n968 n970 n971 vdd vss) tx_and_pdk110_47
X753 (n971 n969 n187 vdd vss) tx_and_pdk110_47
X754 (n972 n973 n974 vdd vss) tx_and_pdk110_47
X755 (n974 n184 n151 vdd vss) tx_and_pdk110_47
X756 (n966 n242 n975 vdd vss) tx_or_pdk110_67
X757 (n265 n88 n976 vdd vss) tx_or_pdk110_67
X758 (n975 n976 n977 vdd vss) tx_or_pdk110_67
X759 (n977 n978 n979 vdd vss) tx_or_pdk110_67
X760 (n979 n159 n183 vdd vss) tx_and_pdk110_47
X761 (n962 n980 n972 vdd vss) tx_or_pdk110_67
X762 (n962 n231 n973 vdd vss) tx_or_pdk110_67
X763 (n981 n982 n983 vdd vss) tx_and_pdk110_47
X764 (n984 n985 n986 vdd vss) tx_and_pdk110_47
X765 (n987 n988 n989 vdd vss) tx_and_pdk110_47
X766 (n990 n991 n992 vdd vss) tx_and_pdk110_47
X767 (n993 n994 n995 vdd vss) tx_and_pdk110_47
X768 (n983 n986 n996 vdd vss) tx_and_pdk110_47
X769 (n989 n992 n997 vdd vss) tx_and_pdk110_47
X770 (n996 n997 n998 vdd vss) tx_and_pdk110_47
X771 (n998 n995 n192 vdd vss) tx_and_pdk110_47
X772 (n999 n1000 n994 vdd vss) tx_or_pdk110_67
X773 (n1001 n1002 n982 vdd vss) tx_or_pdk110_67
X774 (n351 n243 n1003 vdd vss) tx_or_pdk110_67
X775 (n1004 n1002 n984 vdd vss) tx_or_pdk110_67
X776 (n1005 n1002 n985 vdd vss) tx_or_pdk110_67
X777 (n237 n1002 n1006 vdd vss) tx_or_pdk110_67
X778 (n1007 n1006 n987 vdd vss) tx_or_pdk110_67
X779 (n1008 n1002 n988 vdd vss) tx_or_pdk110_67
X780 (n88 n1002 n990 vdd vss) tx_or_pdk110_67
X781 (n51 n1002 n991 vdd vss) tx_or_pdk110_67
X782 (n117 n1002 n993 vdd vss) tx_or_pdk110_67
X783 (n1009 n1010 n1011 vdd vss) tx_and_pdk110_47
X784 (n1012 n1013 n1014 vdd vss) tx_and_pdk110_47
X785 (n1011 n1014 n1015 vdd vss) tx_and_pdk110_47
X786 (n1015 n1016 n1017 vdd vss) tx_and_pdk110_47
X787 (n1017 n1018 n145 vdd vss) tx_and_pdk110_47
X788 (n1019 n233 n1013 vdd vss) tx_or_pdk110_67
X789 (n963 n241 n1009 vdd vss) tx_or_pdk110_67
X790 (n963 n351 n1010 vdd vss) tx_or_pdk110_67
X791 (n963 n237 n1012 vdd vss) tx_or_pdk110_67
X792 (n963 n960 n1020 vdd vss) tx_or_pdk110_67
X793 (n963 n235 n1021 vdd vss) tx_or_pdk110_67
X794 (n88 n966 n1022 vdd vss) tx_or_pdk110_67
X795 (n1001 n1004 n1023 vdd vss) tx_and_pdk110_47
X796 (n1005 n1024 n1025 vdd vss) tx_and_pdk110_47
X797 (n1008 n117 n1026 vdd vss) tx_and_pdk110_47
X798 (n51 n88 n970 vdd vss) tx_and_pdk110_47
X799 (n1023 n1025 n1027 vdd vss) tx_and_pdk110_47
X800 (n1026 n970 n1028 vdd vss) tx_and_pdk110_47
X801 (n1027 n1028 n1029 vdd vss) tx_and_pdk110_47
X802 (n1029 n184 n195 vdd vss) tx_and_pdk110_47
X803 (n239 n232 n1001 vdd vss) tx_or_pdk110_67
X804 (n1007 n1003 n1004 vdd vss) tx_or_pdk110_67
X805 (n238 n1030 n1007 vdd vss) tx_or_pdk110_67
X806 (n1031 n240 n1032 vdd vss) tx_or_pdk110_67
X807 (n1007 n1032 n1005 vdd vss) tx_or_pdk110_67
X808 (n1007 n237 n1024 vdd vss) tx_or_pdk110_67
X809 (n238 n235 n1008 vdd vss) tx_or_pdk110_67
X810 (n1033 n994 n1034 vdd vss) tx_and_pdk110_47
X811 (n1035 n1036 n1037 vdd vss) tx_and_pdk110_47
X812 (n1034 n1037 n1038 vdd vss) tx_and_pdk110_47
X813 (n1038 n1039 n142 vdd vss) tx_and_pdk110_47
X814 (n1040 n1041 n1035 vdd vss) tx_or_pdk110_67
X815 (n1042 n1043 n1036 vdd vss) tx_or_pdk110_67
X816 (n1044 n1045 n1039 vdd vss) tx_or_pdk110_67
X817 (n1013 n1020 n1046 vdd vss) tx_and_pdk110_47
X818 (n1021 n1022 n1047 vdd vss) tx_and_pdk110_47
X819 (n117 n51 n1048 vdd vss) tx_and_pdk110_47
X820 (n1046 n1047 n1049 vdd vss) tx_and_pdk110_47
X821 (n1048 n184 n197 vdd vss) tx_and_pdk110_47
X822 (n1049 n197 n139 vdd vss) tx_and_pdk110_47
X823 (n1020 n1021 n1050 vdd vss) tx_and_pdk110_47
X824 (n1022 n117 n1051 vdd vss) tx_and_pdk110_47
X825 (n51 n184 n1018 vdd vss) tx_and_pdk110_47
X826 (n1050 n1051 n1016 vdd vss) tx_and_pdk110_47
X827 (n1016 n1018 n201 vdd vss) tx_and_pdk110_47
X828 (n184 n1052 n203 vdd vss) tx_or_pdk110_67
X829 (n1052 n1053 n1054 vdd vss) tx_or_pdk110_67
X830 (n1054 n1055 n1056 vdd vss) tx_or_pdk110_67
X831 (n224 target_k1 n1057 vdd vss) tx_or_pdk110_67
X832 (target_k2 n754 n1058 vdd vss) tx_or_pdk110_67
X833 (target_k4 target_k5 n1059 vdd vss) tx_or_pdk110_67
X834 (n1057 n1058 n1060 vdd vss) tx_or_pdk110_67
X835 (n1060 n1059 n1061 vdd vss) tx_or_pdk110_67
X836 (n1062 n318 n1063 vdd vss) tx_or_pdk110_67
X837 (n319 n109 n1064 vdd vss) tx_or_pdk110_67
X838 (n1065 n1063 n1066 vdd vss) tx_or_pdk110_67
X839 (n1064 n1067 n1068 vdd vss) tx_or_pdk110_67
X840 (n1066 n1068 n1069 vdd vss) tx_or_pdk110_67
X841 (n230 n320 n1070 vdd vss) tx_or_pdk110_67
X842 (n321 n113 n1071 vdd vss) tx_or_pdk110_67
X843 (n1070 n1071 n1072 vdd vss) tx_or_pdk110_67
X844 (n1073 n1072 n1074 vdd vss) tx_or_pdk110_67
X845 (n99 n1075 n1076 vdd vss) tx_or_pdk110_67
X846 (n103 n105 n1077 vdd vss) tx_or_pdk110_67
X847 (n107 n109 n1078 vdd vss) tx_or_pdk110_67
X848 (n1076 n1077 n1079 vdd vss) tx_or_pdk110_67
X849 (n1078 n1067 n1080 vdd vss) tx_or_pdk110_67
X850 (n1079 n1080 n1081 vdd vss) tx_or_pdk110_67
X851 (n296 n538 n1082 vdd vss) tx_or_pdk110_67
X852 (n540 n543 n1083 vdd vss) tx_or_pdk110_67
X853 (n546 n549 n1084 vdd vss) tx_or_pdk110_67
X854 (n552 n295 n1085 vdd vss) tx_or_pdk110_67
X855 (n1082 n1083 n1086 vdd vss) tx_or_pdk110_67
X856 (n1084 n1085 n1087 vdd vss) tx_or_pdk110_67
X857 (n1086 n1087 n1088 vdd vss) tx_or_pdk110_67
X858 (n1089 n1090 n1091 vdd vss) tx_or_pdk110_67
X859 (n1091 n228 n960 vdd vss) tx_or_pdk110_67
X860 (n227 n60 n1092 vdd vss) tx_or_pdk110_67
X861 (n62 n64 n1093 vdd vss) tx_or_pdk110_67
X862 (n66 n68 n1094 vdd vss) tx_or_pdk110_67
X863 (n70 n72 n1095 vdd vss) tx_or_pdk110_67
X864 (n1092 n1093 n1096 vdd vss) tx_or_pdk110_67
X865 (n1094 n1095 n1097 vdd vss) tx_or_pdk110_67
X866 (n1096 n1097 n980 vdd vss) tx_or_pdk110_67
X867 (n266 n1075 n1065 vdd vss) tx_or_pdk110_67
X868 (n1062 n1098 n1099 vdd vss) tx_or_pdk110_67
X869 (n230 n109 n1100 vdd vss) tx_or_pdk110_67
X870 (n111 n113 n1067 vdd vss) tx_or_pdk110_67
X871 (n1065 n1099 n1073 vdd vss) tx_or_pdk110_67
X872 (n1100 n1067 n1101 vdd vss) tx_or_pdk110_67
X873 (n1073 n1101 n1102 vdd vss) tx_or_pdk110_67
X874 (n1103 n229 n1000 vdd vss) tx_or_pdk110_67
X875 (n1104 n229 n1033 vdd vss) tx_or_pdk110_67
X876 (state_out0 n225 n1105 vdd vss) tx_or_pdk110_67
X877 (n1105 state_out2 n1041 vdd vss) tx_or_pdk110_67
X878 (n226 state_out1 n1104 vdd vss) tx_or_pdk110_67
X879 (n1104 state_out2 n1043 vdd vss) tx_or_pdk110_67
X880 (n226 n225 n1106 vdd vss) tx_or_pdk110_67
X881 (n1106 state_out2 n1002 vdd vss) tx_or_pdk110_67
X882 (n1031 n350 n1107 vdd vss) tx_or_pdk110_67
X883 (n405 n715 n410 vdd vss) tx_and_pdk110_47
X884 (n410 n831 n1108 vdd vss) tx_and_pdk110_47
X885 (n827 n716 n1109 vdd vss) tx_and_pdk110_47
X886 (n264 n1110 n1111 vdd vss) tx_or_pdk110_67
X887 (n788 n745 n1110 vdd vss) tx_and_pdk110_47
X888 (n262 n1112 n1113 vdd vss) tx_or_pdk110_67
X889 (n224 target_k1 n1114 vdd vss) tx_and_pdk110_47
X890 (n268 n754 n752 vdd vss) tx_and_pdk110_47
X891 (n1114 n752 n1115 vdd vss) tx_and_pdk110_47
X892 (n1115 n745 n1112 vdd vss) tx_and_pdk110_47
X893 (n260 n1116 n1117 vdd vss) tx_or_pdk110_67
X894 (target_k0 n1118 n774 vdd vss) tx_and_pdk110_47
X895 (target_k2 target_k3 n742 vdd vss) tx_and_pdk110_47
X896 (n774 n742 n1119 vdd vss) tx_and_pdk110_47
X897 (n1119 n769 n1116 vdd vss) tx_and_pdk110_47
X898 (n258 n1120 n1121 vdd vss) tx_or_pdk110_67
X899 (n268 target_k3 n1122 vdd vss) tx_and_pdk110_47
X900 (n1123 n747 n769 vdd vss) tx_and_pdk110_47
X901 (n449 n1122 n788 vdd vss) tx_and_pdk110_47
X902 (n788 n769 n1120 vdd vss) tx_and_pdk110_47
X903 (n256 n809 n1124 vdd vss) tx_or_pdk110_67
X904 (n572 n211 n814 vdd vss) tx_and_pdk110_47
X905 (n922 n814 n1125 vdd vss) tx_and_pdk110_47
X906 (n1125 n813 n345 vdd vss) tx_and_pdk110_47
X907 (n1126 n345 n1127 vdd vss) tx_or_pdk110_67
X908 (n1128 n251 n1129 vdd vss) tx_and_pdk110_47
X909 (n329 n331 n838 vdd vss) tx_and_pdk110_47
X910 (n1129 n836 n1130 vdd vss) tx_and_pdk110_47
X911 (n838 n837 n835 vdd vss) tx_and_pdk110_47
X912 (n1130 n835 n347 vdd vss) tx_and_pdk110_47
X913 (n1131 n347 n1132 vdd vss) tx_or_pdk110_67
X914 (n290 n288 n1133 vdd vss) tx_and_pdk110_47
X915 (n286 n284 n871 vdd vss) tx_and_pdk110_47
X916 (n278 n276 n867 vdd vss) tx_and_pdk110_47
X917 (n274 n272 n859 vdd vss) tx_and_pdk110_47
X918 (n884 n875 n1134 vdd vss) tx_and_pdk110_47
X919 (n1133 n871 n863 vdd vss) tx_and_pdk110_47
X920 (n879 n867 n1135 vdd vss) tx_and_pdk110_47
X921 (n1134 n863 n1136 vdd vss) tx_and_pdk110_47
X922 (n1135 n859 n855 vdd vss) tx_and_pdk110_47
X923 (n1136 n855 n1137 vdd vss) tx_and_pdk110_47
X924 (n248 n1137 n236 vdd vss) tx_or_pdk110_67
X925 (n403 n402 n405 vdd vss) tx_and_pdk110_47
X926 (n246 n245 n715 vdd vss) tx_and_pdk110_47
X927 (n1108 n1109 n350 vdd vss) tx_and_pdk110_47
X928 (n900 n901 n1138 vdd vss) tx_and_pdk110_47
X929 (n902 n903 n913 vdd vss) tx_and_pdk110_47
X930 (n1138 n913 n1139 vdd vss) tx_and_pdk110_47
X931 (n1139 n909 n1140 vdd vss) tx_and_pdk110_47
X932 (n1141 n1140 n243 vdd vss) tx_or_pdk110_67
X933 (n935 n936 n1142 vdd vss) tx_and_pdk110_47
X934 (n1142 n948 n1143 vdd vss) tx_and_pdk110_47
X935 (n1143 n944 n353 vdd vss) tx_and_pdk110_47
X936 (n1144 n353 n240 vdd vss) tx_or_pdk110_67
X937 (n1145 n184 n179 vdd vss) tx_and_pdk110_47
X938 (n1146 n1147 n1148 vdd vss) tx_and_pdk110_47
X939 (n1149 n184 n1150 vdd vss) tx_and_pdk110_47
X940 (n1148 n1150 n171 vdd vss) tx_and_pdk110_47
X941 (n962 n233 n1146 vdd vss) tx_or_pdk110_67
X942 (n962 n238 n1147 vdd vss) tx_or_pdk110_67
X943 (n962 n88 n1149 vdd vss) tx_or_pdk110_67
X944 (n1151 n1152 n1153 vdd vss) tx_and_pdk110_47
X945 (n1153 n1014 n1154 vdd vss) tx_and_pdk110_47
X946 (n1154 n1016 n1155 vdd vss) tx_and_pdk110_47
X947 (n1155 n1018 n165 vdd vss) tx_and_pdk110_47
X948 (n963 n244 n1151 vdd vss) tx_or_pdk110_67
X949 (n963 n1031 n1152 vdd vss) tx_or_pdk110_67
X950 (n1145 n1156 n1157 vdd vss) tx_and_pdk110_47
X951 (n1158 n958 n1159 vdd vss) tx_and_pdk110_47
X952 (n959 n961 n1160 vdd vss) tx_and_pdk110_47
X953 (n964 n967 n1161 vdd vss) tx_and_pdk110_47
X954 (n1157 n1159 n1162 vdd vss) tx_and_pdk110_47
X955 (n1160 n1161 n1163 vdd vss) tx_and_pdk110_47
X956 (n1162 n1163 n1164 vdd vss) tx_and_pdk110_47
X957 (n1164 n184 n159 vdd vss) tx_and_pdk110_47
X958 (n51 n1165 n1145 vdd vss) tx_or_pdk110_67
X959 (n231 n239 n1019 vdd vss) tx_or_pdk110_67
X960 (n962 n1019 n1166 vdd vss) tx_or_pdk110_67
X961 (n1166 n233 n1156 vdd vss) tx_or_pdk110_67
X962 (n351 n244 n1167 vdd vss) tx_or_pdk110_67
X963 (n956 n1167 n1158 vdd vss) tx_or_pdk110_67
X964 (n1031 n241 n957 vdd vss) tx_or_pdk110_67
X965 (coarse0 coarse1 n1168 vdd vss) tx_or_pdk110_67
X966 (coarse2 coarse3 n1169 vdd vss) tx_or_pdk110_67
X967 (coarse4 coarse5 n1170 vdd vss) tx_or_pdk110_67
X968 (coarse6 coarse7 n1171 vdd vss) tx_or_pdk110_67
X969 (n1168 n1169 n1172 vdd vss) tx_or_pdk110_67
X970 (n1170 n1171 n1173 vdd vss) tx_or_pdk110_67
X971 (n1172 n1173 n1174 vdd vss) tx_or_pdk110_67
X972 (n1053 n1175 n1176 vdd vss) tx_or_pdk110_67
X973 (n1177 n1176 n1178 vdd vss) tx_or_pdk110_67
X974 (n1178 n203 n1179 vdd vss) tx_or_pdk110_67
X975 (n1180 n1181 n1182 vdd vss) tx_or_pdk110_67
X976 (n1183 n1184 n1185 vdd vss) tx_or_pdk110_67
X977 (n1182 n1185 n1186 vdd vss) tx_or_pdk110_67
X978 (n1187 n1188 n1189 vdd vss) tx_or_pdk110_67
X979 (n1190 n1191 n1192 vdd vss) tx_or_pdk110_67
X980 (n1189 n1192 n1193 vdd vss) tx_or_pdk110_67
X981 (n1194 n1195 n1196 vdd vss) tx_or_pdk110_67
X982 (n1197 n1198 n1199 vdd vss) tx_or_pdk110_67
X983 (n1196 n1199 n1200 vdd vss) tx_or_pdk110_67
X984 (n1201 n1202 n1203 vdd vss) tx_or_pdk110_67
X985 (n1204 n1205 n1206 vdd vss) tx_or_pdk110_67
X986 (n1203 n1206 n1207 vdd vss) tx_or_pdk110_67
X987 (n1208 n1209 n1210 vdd vss) tx_or_pdk110_67
X988 (n1211 n1212 n1213 vdd vss) tx_or_pdk110_67
X989 (n1210 n1213 n1214 vdd vss) tx_or_pdk110_67
X990 (n1215 n1216 n1217 vdd vss) tx_or_pdk110_67
X991 (n1218 n1219 n1220 vdd vss) tx_or_pdk110_67
X992 (n1217 n1220 n1221 vdd vss) tx_or_pdk110_67
X993 (n1222 n1223 n1224 vdd vss) tx_or_pdk110_67
X994 (n1225 n1226 n1227 vdd vss) tx_or_pdk110_67
X995 (n1224 n1227 n1228 vdd vss) tx_or_pdk110_67
X996 (n1229 n1230 n1231 vdd vss) tx_or_pdk110_67
X997 (n1232 n1233 n1234 vdd vss) tx_or_pdk110_67
X998 (n1231 n1234 n1235 vdd vss) tx_or_pdk110_67
X999 (n1052 n1175 n1236 vdd vss) tx_or_pdk110_67
X1000 (n184 n1053 n1237 vdd vss) tx_or_pdk110_67
X1001 (n1238 n1055 n1177 vdd vss) tx_or_pdk110_67
X1002 (n1236 n1237 n1239 vdd vss) tx_or_pdk110_67
X1003 (n1239 n1177 n1240 vdd vss) tx_or_pdk110_67
X1004 (n1241 n1242 n1243 vdd vss) tx_or_pdk110_67
X1005 (n1244 n1245 n1246 vdd vss) tx_or_pdk110_67
X1006 (n1247 n1243 n1248 vdd vss) tx_or_pdk110_67
X1007 (n1248 n1246 n1249 vdd vss) tx_or_pdk110_67
X1008 (n1250 n1251 n1252 vdd vss) tx_or_pdk110_67
X1009 (n1253 n1242 n1254 vdd vss) tx_or_pdk110_67
X1010 (n1254 n1252 n1255 vdd vss) tx_or_pdk110_67
X1011 (n1256 n1257 n1258 vdd vss) tx_or_pdk110_67
X1012 (n1244 n1251 n1259 vdd vss) tx_or_pdk110_67
X1013 (n1247 n1258 n1260 vdd vss) tx_or_pdk110_67
X1014 (n1260 n1259 n1261 vdd vss) tx_or_pdk110_67
X1015 (n1175 n184 n981 vdd vss) tx_or_pdk110_67
X1016 (n1262 n1263 n1264 vdd vss) tx_or_pdk110_67
X1017 (n1055 n203 n189 vdd vss) tx_or_pdk110_67
X1018 (n1265 n203 n1266 vdd vss) tx_or_pdk110_67
X1019 (n1238 n1056 n186 vdd vss) tx_or_pdk110_67
X1020 (state_out0 state_out1 n1103 vdd vss) tx_or_pdk110_67
X1021 (n1103 state_out2 n1045 vdd vss) tx_or_pdk110_67
X1022 (n1069 n1044 vdd vss) pll_inv_pdk110_7
X1023 (n1074 n1042 vdd vss) pll_inv_pdk110_7
X1024 (n1081 n1040 vdd vss) pll_inv_pdk110_7
X1025 (n1088 n1267 vdd vss) pll_inv_pdk110_7
X1026 (n1174 n1268 vdd vss) pll_inv_pdk110_7
X1027 (n960 n1030 vdd vss) pll_inv_pdk110_7
X1028 (n1102 n999 vdd vss) pll_inv_pdk110_7
X1029 (range_error n1269 vdd vss) pll_inv_pdk110_7
X1030 (n1000 n1175 vdd vss) pll_inv_pdk110_7
X1031 (n1033 n1052 vdd vss) pll_inv_pdk110_7
X1032 (n1041 n1053 vdd vss) pll_inv_pdk110_7
X1033 (n1043 n1238 vdd vss) pll_inv_pdk110_7
X1034 (n1045 n1055 vdd vss) pll_inv_pdk110_7
X1035 (n1002 n184 vdd vss) pll_inv_pdk110_7
X1036 (n1124 n1031 n1270 vdd vss) tx_and_pdk110_47
X1037 (n1127 n349 n1271 vdd vss) tx_and_pdk110_47
X1038 (n1270 n1271 n238 vdd vss) tx_or_pdk110_67
X1039 (n54 n1030 n1272 vdd vss) tx_or_pdk110_67
X1040 (n1270 n1267 n1273 vdd vss) tx_and_pdk110_47
X1041 (n1272 n1273 n1274 vdd vss) tx_or_pdk110_67
X1042 (n1271 n1268 n1275 vdd vss) tx_and_pdk110_47
X1043 (n1274 n1275 n232 vdd vss) tx_or_pdk110_67
X1044 (n236 n115 n234 vdd vss) tx_and_pdk110_47
X1045 (vss target_k0 n1111 n1276 vdd vss) tx_mux_pdk110_64
X1046 (target_k0 n462 n1111 n1277 vdd vss) tx_mux_pdk110_64
X1047 (target_k1 n450 n1111 n1278 vdd vss) tx_mux_pdk110_64
X1048 (target_k2 n453 n1111 n1279 vdd vss) tx_mux_pdk110_64
X1049 (target_k3 n456 n1111 n1280 vdd vss) tx_mux_pdk110_64
X1050 (target_k4 n459 n1111 n1281 vdd vss) tx_mux_pdk110_64
X1051 (target_k5 n461 n1111 n1282 vdd vss) tx_mux_pdk110_64
X1052 (vss n734 n1111 n1283 vdd vss) tx_mux_pdk110_64
X1053 (n1276 vss n1113 n1284 vdd vss) tx_mux_pdk110_64
X1054 (n1277 vss n1113 n1285 vdd vss) tx_mux_pdk110_64
X1055 (n1278 target_k0 n1113 n1286 vdd vss) tx_mux_pdk110_64
X1056 (n1279 target_k1 n1113 n1287 vdd vss) tx_mux_pdk110_64
X1057 (n1280 target_k2 n1113 n1288 vdd vss) tx_mux_pdk110_64
X1058 (n1281 target_k3 n1113 n1289 vdd vss) tx_mux_pdk110_64
X1059 (n1282 target_k4 n1113 n1290 vdd vss) tx_mux_pdk110_64
X1060 (n1283 target_k5 n1113 n1291 vdd vss) tx_mux_pdk110_64
X1061 (n1284 target_k0 n1117 n1292 vdd vss) tx_mux_pdk110_64
X1062 (n1285 target_k1 n1117 n1293 vdd vss) tx_mux_pdk110_64
X1063 (n1286 n758 n1117 n1294 vdd vss) tx_mux_pdk110_64
X1064 (n1287 n465 n1117 n1295 vdd vss) tx_mux_pdk110_64
X1065 (n1288 n468 n1117 n1296 vdd vss) tx_mux_pdk110_64
X1066 (n1289 n471 n1117 n1297 vdd vss) tx_mux_pdk110_64
X1067 (n1290 n473 n1117 n1298 vdd vss) tx_mux_pdk110_64
X1068 (n1291 n475 n1117 n1299 vdd vss) tx_mux_pdk110_64
X1069 (vss n765 n1117 n1300 vdd vss) tx_mux_pdk110_64
X1070 (n1292 vss n1121 n1301 vdd vss) tx_mux_pdk110_64
X1071 (n1293 target_k0 n1121 n1302 vdd vss) tx_mux_pdk110_64
X1072 (n1294 n462 n1121 n1303 vdd vss) tx_mux_pdk110_64
X1073 (n1295 n450 n1121 n1304 vdd vss) tx_mux_pdk110_64
X1074 (n1296 n453 n1121 n1305 vdd vss) tx_mux_pdk110_64
X1075 (n1297 n477 n1121 n1306 vdd vss) tx_mux_pdk110_64
X1076 (n1298 n479 n1121 n1307 vdd vss) tx_mux_pdk110_64
X1077 (n1299 n481 n1121 n1308 vdd vss) tx_mux_pdk110_64
X1078 (n1300 n497 n1121 n1309 vdd vss) tx_mux_pdk110_64
X1079 (target_k0 n1301 n1061 n1310 vdd vss) tx_mux_pdk110_64
X1080 (n462 n1302 n1061 n1311 vdd vss) tx_mux_pdk110_64
X1081 (n483 n1303 n1061 n1312 vdd vss) tx_mux_pdk110_64
X1082 (n486 n1304 n1061 n1313 vdd vss) tx_mux_pdk110_64
X1083 (n489 n1305 n1061 n1314 vdd vss) tx_mux_pdk110_64
X1084 (n492 n1306 n1061 n1315 vdd vss) tx_mux_pdk110_64
X1085 (n494 n1307 n1061 n1316 vdd vss) tx_mux_pdk110_64
X1086 (n496 n1308 n1061 n1317 vdd vss) tx_mux_pdk110_64
X1087 (n499 n1309 n1061 n1318 vdd vss) tx_mux_pdk110_64
X1088 (n801 vss n1061 n1319 vdd vss) tx_mux_pdk110_64
X1089 (n1310 vss n117 n640 vdd vss) tx_mux_pdk110_64
X1090 (n1311 vss n117 n643 vdd vss) tx_mux_pdk110_64
X1091 (n1312 n1310 n117 n646 vdd vss) tx_mux_pdk110_64
X1092 (n1313 n1311 n117 n649 vdd vss) tx_mux_pdk110_64
X1093 (n1314 n1312 n117 n652 vdd vss) tx_mux_pdk110_64
X1094 (n1315 n1313 n117 n655 vdd vss) tx_mux_pdk110_64
X1095 (n1316 n1314 n117 n658 vdd vss) tx_mux_pdk110_64
X1096 (n1317 n1315 n117 n661 vdd vss) tx_mux_pdk110_64
X1097 (n1318 n1316 n117 n664 vdd vss) tx_mux_pdk110_64
X1098 (n1319 n1317 n117 n667 vdd vss) tx_mux_pdk110_64
X1099 (n1031 n1107 n117 n978 vdd vss) tx_mux_pdk110_64
X1100 (n297 coarse0 n978 n322 vdd vss) tx_mux_pdk110_64
X1101 (n299 coarse1 n978 n251 vdd vss) tx_mux_pdk110_64
X1102 (n301 coarse2 n978 n325 vdd vss) tx_mux_pdk110_64
X1103 (n303 coarse3 n978 n327 vdd vss) tx_mux_pdk110_64
X1104 (n305 coarse4 n978 n329 vdd vss) tx_mux_pdk110_64
X1105 (n307 coarse5 n978 n331 vdd vss) tx_mux_pdk110_64
X1106 (n309 coarse6 n978 n333 vdd vss) tx_mux_pdk110_64
X1107 (n311 coarse7 n978 n522 vdd vss) tx_mux_pdk110_64
X1108 (dac0 n312 n978 n335 vdd vss) tx_mux_pdk110_64
X1109 (dac1 n313 n978 n337 vdd vss) tx_mux_pdk110_64
X1110 (dac2 n314 n978 n339 vdd vss) tx_mux_pdk110_64
X1111 (dac3 n315 n978 n341 vdd vss) tx_mux_pdk110_64
X1112 (dac4 n316 n978 n343 vdd vss) tx_mux_pdk110_64
X1113 (vss n317 n978 n1320 vdd vss) tx_mux_pdk110_64
X1114 (n404 measured1 n1107 n269 vdd vss) tx_mux_pdk110_64
X1115 (n406 measured2 n1107 n293 vdd vss) tx_mux_pdk110_64
X1116 (n408 measured3 n1107 n291 vdd vss) tx_mux_pdk110_64
X1117 (n411 n441 n1107 n289 vdd vss) tx_mux_pdk110_64
X1118 (n414 n444 n1107 n287 vdd vss) tx_mux_pdk110_64
X1119 (n417 n447 n1107 n285 vdd vss) tx_mux_pdk110_64
X1120 (n420 n506 n1107 n283 vdd vss) tx_mux_pdk110_64
X1121 (n423 n562 n1107 n281 vdd vss) tx_mux_pdk110_64
X1122 (n426 n565 n1107 n279 vdd vss) tx_mux_pdk110_64
X1123 (n429 n509 n1107 n277 vdd vss) tx_mux_pdk110_64
X1124 (n432 n512 n1107 n275 vdd vss) tx_mux_pdk110_64
X1125 (n435 n568 n1107 n273 vdd vss) tx_mux_pdk110_64
X1126 (n438 n571 n1107 n271 vdd vss) tx_mux_pdk110_64
X1127 (n322 vdd n1132 n1321 vdd vss) tx_mux_pdk110_64
X1128 (n252 vdd n1132 n1322 vdd vss) tx_mux_pdk110_64
X1129 (n513 vdd n1132 n1323 vdd vss) tx_mux_pdk110_64
X1130 (n515 vdd n1132 n1324 vdd vss) tx_mux_pdk110_64
X1131 (n517 vdd n1132 n1325 vdd vss) tx_mux_pdk110_64
X1132 (n519 vdd n1132 n1326 vdd vss) tx_mux_pdk110_64
X1133 (n521 vdd n1132 n1327 vdd vss) tx_mux_pdk110_64
X1134 (n524 vdd n1132 n1328 vdd vss) tx_mux_pdk110_64
X1135 (n539 n525 n1270 n1329 vdd vss) tx_mux_pdk110_64
X1136 (n542 n527 n1270 n1330 vdd vss) tx_mux_pdk110_64
X1137 (n545 n529 n1270 n1331 vdd vss) tx_mux_pdk110_64
X1138 (n548 n531 n1270 n1332 vdd vss) tx_mux_pdk110_64
X1139 (n551 n533 n1270 n1333 vdd vss) tx_mux_pdk110_64
X1140 (n554 n535 n1270 n1334 vdd vss) tx_mux_pdk110_64
X1141 (n556 n537 n1270 n1335 vdd vss) tx_mux_pdk110_64
X1142 (n267 vss n243 n1336 vdd vss) tx_mux_pdk110_64
X1143 (n501 vss n243 n1337 vdd vss) tx_mux_pdk110_64
X1144 (n574 vss n243 n1338 vdd vss) tx_mux_pdk110_64
X1145 (n503 vss n243 n1339 vdd vss) tx_mux_pdk110_64
X1146 (n577 vss n243 n1340 vdd vss) tx_mux_pdk110_64
X1147 (n580 vss n243 n1341 vdd vss) tx_mux_pdk110_64
X1148 (n1336 vss n351 n1342 vdd vss) tx_mux_pdk110_64
X1149 (n1337 vss n351 n1343 vdd vss) tx_mux_pdk110_64
X1150 (n1338 vss n351 n1344 vdd vss) tx_mux_pdk110_64
X1151 (n1339 vss n351 n1345 vdd vss) tx_mux_pdk110_64
X1152 (n1340 vss n351 n1346 vdd vss) tx_mux_pdk110_64
X1153 (n1341 vss n351 n1347 vdd vss) tx_mux_pdk110_64
X1154 (n1342 vss n236 n1348 vdd vss) tx_mux_pdk110_64
X1155 (n1343 vss n236 n1349 vdd vss) tx_mux_pdk110_64
X1156 (n1344 vss n236 n1350 vdd vss) tx_mux_pdk110_64
X1157 (n1345 vss n236 n1351 vdd vss) tx_mux_pdk110_64
X1158 (n1346 vss n236 n1352 vdd vss) tx_mux_pdk110_64
X1159 (n1347 vss n236 n1353 vdd vss) tx_mux_pdk110_64
X1160 (vss n1348 n960 n1354 vdd vss) tx_mux_pdk110_64
X1161 (vss n1349 n960 n1355 vdd vss) tx_mux_pdk110_64
X1162 (vss n1350 n960 n1356 vdd vss) tx_mux_pdk110_64
X1163 (vss n1351 n960 n1357 vdd vss) tx_mux_pdk110_64
X1164 (vss n1352 n960 n1358 vdd vss) tx_mux_pdk110_64
X1165 (vss n1353 n960 n1359 vdd vss) tx_mux_pdk110_64
X1166 (n1354 vss n234 n1360 vdd vss) tx_mux_pdk110_64
X1167 (n1355 vss n234 n1361 vdd vss) tx_mux_pdk110_64
X1168 (n1356 vss n234 n1362 vdd vss) tx_mux_pdk110_64
X1169 (n1357 vss n234 n1363 vdd vss) tx_mux_pdk110_64
X1170 (n1358 vss n234 n1364 vdd vss) tx_mux_pdk110_64
X1171 (n1359 vss n234 n1365 vdd vss) tx_mux_pdk110_64
X1172 (n1360 n1366 n238 n1367 vdd vss) tx_mux_pdk110_64
X1173 (n1361 n1368 n238 n1369 vdd vss) tx_mux_pdk110_64
X1174 (n1362 n1366 n238 n1370 vdd vss) tx_mux_pdk110_64
X1175 (n1363 n1368 n238 n1371 vdd vss) tx_mux_pdk110_64
X1176 (n1364 n1366 n238 n1372 vdd vss) tx_mux_pdk110_64
X1177 (n1365 n1366 n238 n1373 vdd vss) tx_mux_pdk110_64
X1178 (n1374 n1367 n88 n169 vdd vss) tx_mux_pdk110_64
X1179 (n1375 n1369 n88 n168 vdd vss) tx_mux_pdk110_64
X1180 (n1374 n1370 n88 n167 vdd vss) tx_mux_pdk110_64
X1181 (n1375 n1371 n88 n166 vdd vss) tx_mux_pdk110_64
X1182 (n1374 n1372 n88 n164 vdd vss) tx_mux_pdk110_64
X1183 (n1374 n1373 n88 n181 vdd vss) tx_mux_pdk110_64
X1184 (vdd vss n980 n1374 vdd vss) tx_mux_pdk110_64
X1185 (n267 vss n240 n1376 vdd vss) tx_mux_pdk110_64
X1186 (n355 vss n240 n1377 vdd vss) tx_mux_pdk110_64
X1187 (n357 vss n240 n1378 vdd vss) tx_mux_pdk110_64
X1188 (n582 vss n240 n1379 vdd vss) tx_mux_pdk110_64
X1189 (n359 vss n240 n1380 vdd vss) tx_mux_pdk110_64
X1190 (n361 vss n240 n1381 vdd vss) tx_mux_pdk110_64
X1191 (vss n1376 n351 n1382 vdd vss) tx_mux_pdk110_64
X1192 (vss n1377 n351 n1383 vdd vss) tx_mux_pdk110_64
X1193 (vss n1378 n351 n1384 vdd vss) tx_mux_pdk110_64
X1194 (vss n1379 n351 n1385 vdd vss) tx_mux_pdk110_64
X1195 (vss n1380 n351 n1386 vdd vss) tx_mux_pdk110_64
X1196 (vss n1381 n351 n1387 vdd vss) tx_mux_pdk110_64
X1197 (n1382 vss n236 n1388 vdd vss) tx_mux_pdk110_64
X1198 (n1383 vss n236 n1389 vdd vss) tx_mux_pdk110_64
X1199 (n1384 vss n236 n1390 vdd vss) tx_mux_pdk110_64
X1200 (n1385 vss n236 n1391 vdd vss) tx_mux_pdk110_64
X1201 (n1386 vss n236 n1392 vdd vss) tx_mux_pdk110_64
X1202 (n1387 vss n236 n1393 vdd vss) tx_mux_pdk110_64
X1203 (vss n1388 n960 n1394 vdd vss) tx_mux_pdk110_64
X1204 (vss n1389 n960 n1395 vdd vss) tx_mux_pdk110_64
X1205 (vss n1390 n960 n1396 vdd vss) tx_mux_pdk110_64
X1206 (vss n1391 n960 n1397 vdd vss) tx_mux_pdk110_64
X1207 (vss n1392 n960 n1398 vdd vss) tx_mux_pdk110_64
X1208 (vss n1393 n960 n1399 vdd vss) tx_mux_pdk110_64
X1209 (n1394 vss n234 n1400 vdd vss) tx_mux_pdk110_64
X1210 (n1395 vss n234 n1401 vdd vss) tx_mux_pdk110_64
X1211 (n1396 vss n234 n1402 vdd vss) tx_mux_pdk110_64
X1212 (n1397 vss n234 n1403 vdd vss) tx_mux_pdk110_64
X1213 (n1398 vss n234 n1404 vdd vss) tx_mux_pdk110_64
X1214 (n1399 vss n234 n1405 vdd vss) tx_mux_pdk110_64
X1215 (vdd vss n232 n1366 vdd vss) tx_mux_pdk110_64
X1216 (n1400 n1366 n238 n1406 vdd vss) tx_mux_pdk110_64
X1217 (n1401 n1366 n238 n1407 vdd vss) tx_mux_pdk110_64
X1218 (n1402 n1368 n238 n1408 vdd vss) tx_mux_pdk110_64
X1219 (n1403 n1366 n238 n1409 vdd vss) tx_mux_pdk110_64
X1220 (n1404 n1368 n238 n1410 vdd vss) tx_mux_pdk110_64
X1221 (n1405 n1368 n238 n1411 vdd vss) tx_mux_pdk110_64
X1222 (n1374 n1406 n88 n149 vdd vss) tx_mux_pdk110_64
X1223 (n1374 n1407 n88 n148 vdd vss) tx_mux_pdk110_64
X1224 (n1375 n1408 n88 n147 vdd vss) tx_mux_pdk110_64
X1225 (n1374 n1409 n88 n146 vdd vss) tx_mux_pdk110_64
X1226 (n1375 n1410 n88 n144 vdd vss) tx_mux_pdk110_64
X1227 (n1375 n1411 n88 n193 vdd vss) tx_mux_pdk110_64
X1228 (vss n1089 n960 n1412 vdd vss) tx_mux_pdk110_64
X1229 (vss n557 n960 n1413 vdd vss) tx_mux_pdk110_64
X1230 (vss n559 n960 n1414 vdd vss) tx_mux_pdk110_64
X1231 (n1412 vss n234 n1415 vdd vss) tx_mux_pdk110_64
X1232 (n1413 vss n234 n1416 vdd vss) tx_mux_pdk110_64
X1233 (n1414 vss n234 n1417 vdd vss) tx_mux_pdk110_64
X1234 (n1089 vss n232 n1418 vdd vss) tx_mux_pdk110_64
X1235 (n557 vss n232 n1419 vdd vss) tx_mux_pdk110_64
X1236 (n559 vss n232 n1420 vdd vss) tx_mux_pdk110_64
X1237 (n1415 n1418 n238 n1421 vdd vss) tx_mux_pdk110_64
X1238 (n1416 n1419 n238 n1422 vdd vss) tx_mux_pdk110_64
X1239 (n1417 n1420 n238 n1423 vdd vss) tx_mux_pdk110_64
X1240 (n1375 n1421 n88 n140 vdd vss) tx_mux_pdk110_64
X1241 (n1375 n1422 n88 n138 vdd vss) tx_mux_pdk110_64
X1242 (n1375 n1423 n88 n199 vdd vss) tx_mux_pdk110_64
X1243 (vss n236 n960 n1424 vdd vss) tx_mux_pdk110_64
X1244 (n1424 vss n234 n1425 vdd vss) tx_mux_pdk110_64
X1245 (n1425 vss n238 n1426 vdd vss) tx_mux_pdk110_64
X1246 (n1375 n1426 n88 n200 vdd vss) tx_mux_pdk110_64
X1247 (n966 vdd n88 n196 vdd vss) tx_mux_pdk110_64
X1248 (vss n60 n980 n1427 vdd vss) tx_mux_pdk110_64
X1249 (vss n62 n980 n1428 vdd vss) tx_mux_pdk110_64
X1250 (vss n64 n980 n1429 vdd vss) tx_mux_pdk110_64
X1251 (vss n66 n980 n1430 vdd vss) tx_mux_pdk110_64
X1252 (vss n68 n980 n1431 vdd vss) tx_mux_pdk110_64
X1253 (vss n70 n980 n1432 vdd vss) tx_mux_pdk110_64
X1254 (vss n72 n980 n1433 vdd vss) tx_mux_pdk110_64
X1255 (vss vss n980 n1434 vdd vss) tx_mux_pdk110_64
X1256 (n1427 vss n88 n1435 vdd vss) tx_mux_pdk110_64
X1257 (n1428 vss n88 n1436 vdd vss) tx_mux_pdk110_64
X1258 (n1429 vss n88 n1437 vdd vss) tx_mux_pdk110_64
X1259 (n1430 vss n88 n1438 vdd vss) tx_mux_pdk110_64
X1260 (n1431 vss n88 n1439 vdd vss) tx_mux_pdk110_64
X1261 (n1432 vss n88 n1440 vdd vss) tx_mux_pdk110_64
X1262 (n1433 vss n88 n1441 vdd vss) tx_mux_pdk110_64
X1263 (n1434 vss n88 n1442 vdd vss) tx_mux_pdk110_64
X1264 (vss n60 n980 n1443 vdd vss) tx_mux_pdk110_64
X1265 (vss n62 n980 n1444 vdd vss) tx_mux_pdk110_64
X1266 (vss n64 n980 n1445 vdd vss) tx_mux_pdk110_64
X1267 (vss n66 n980 n1446 vdd vss) tx_mux_pdk110_64
X1268 (vss n68 n980 n1447 vdd vss) tx_mux_pdk110_64
X1269 (vdd n70 n980 n1448 vdd vss) tx_mux_pdk110_64
X1270 (vss n72 n980 n1449 vdd vss) tx_mux_pdk110_64
X1271 (n1443 n1435 n117 n1450 vdd vss) tx_mux_pdk110_64
X1272 (n1444 n1436 n117 n1451 vdd vss) tx_mux_pdk110_64
X1273 (n1445 n1437 n117 n1452 vdd vss) tx_mux_pdk110_64
X1274 (n1446 n1438 n117 n1453 vdd vss) tx_mux_pdk110_64
X1275 (n1447 n1439 n117 n1454 vdd vss) tx_mux_pdk110_64
X1276 (n1448 n1440 n117 n1455 vdd vss) tx_mux_pdk110_64
X1277 (n1449 n1441 n117 n1456 vdd vss) tx_mux_pdk110_64
X1278 (vss n1442 n117 n1457 vdd vss) tx_mux_pdk110_64
X1279 (n978 n1165 vdd vss) pll_inv_pdk110_7
X1280 (vss n1450 n51 n157 vdd vss) tx_mux_pdk110_64
X1281 (vss n1451 n51 n156 vdd vss) tx_mux_pdk110_64
X1282 (vss n1452 n51 n155 vdd vss) tx_mux_pdk110_64
X1283 (vss n1453 n51 n154 vdd vss) tx_mux_pdk110_64
X1284 (vss n1454 n51 n153 vdd vss) tx_mux_pdk110_64
X1285 (n1165 n1455 n51 n152 vdd vss) tx_mux_pdk110_64
X1286 (vss n1456 n51 n150 vdd vss) tx_mux_pdk110_64
X1287 (n978 n1457 n51 n190 vdd vss) tx_mux_pdk110_64
X1288 (n980 n966 vdd vss) pll_inv_pdk110_7
X1289 (n966 vdd n117 n1458 vdd vss) tx_mux_pdk110_64
X1290 (n1459 n1458 n51 n178 vdd vss) tx_mux_pdk110_64
X1291 (vss n266 n1102 n1460 vdd vss) tx_mux_pdk110_64
X1292 (vss n583 n1102 n1461 vdd vss) tx_mux_pdk110_64
X1293 (vss n585 n1102 n1462 vdd vss) tx_mux_pdk110_64
X1294 (vss n587 n1102 n1463 vdd vss) tx_mux_pdk110_64
X1295 (vss n589 n1102 n1464 vdd vss) tx_mux_pdk110_64
X1296 (vss n591 n1102 n1465 vdd vss) tx_mux_pdk110_64
X1297 (vss n593 n1102 n1466 vdd vss) tx_mux_pdk110_64
X1298 (vss n595 n1102 n1467 vdd vss) tx_mux_pdk110_64
X1299 (vss n266 n1081 n1468 vdd vss) tx_mux_pdk110_64
X1300 (vss n583 n1081 n1469 vdd vss) tx_mux_pdk110_64
X1301 (vss n585 n1081 n1470 vdd vss) tx_mux_pdk110_64
X1302 (vss n587 n1081 n1471 vdd vss) tx_mux_pdk110_64
X1303 (vss n589 n1081 n1472 vdd vss) tx_mux_pdk110_64
X1304 (vss n591 n1081 n1473 vdd vss) tx_mux_pdk110_64
X1305 (vss n593 n1081 n1474 vdd vss) tx_mux_pdk110_64
X1306 (vss n595 n1081 n1475 vdd vss) tx_mux_pdk110_64
X1307 (vss n266 n1074 n1476 vdd vss) tx_mux_pdk110_64
X1308 (vss n583 n1074 n1477 vdd vss) tx_mux_pdk110_64
X1309 (vss n585 n1074 n1478 vdd vss) tx_mux_pdk110_64
X1310 (vss n587 n1074 n1479 vdd vss) tx_mux_pdk110_64
X1311 (vss n589 n1074 n1480 vdd vss) tx_mux_pdk110_64
X1312 (vss n591 n1074 n1481 vdd vss) tx_mux_pdk110_64
X1313 (vss n593 n1074 n1482 vdd vss) tx_mux_pdk110_64
X1314 (vss n595 n1074 n1483 vdd vss) tx_mux_pdk110_64
X1315 (vss n266 n1069 n1484 vdd vss) tx_mux_pdk110_64
X1316 (vss n583 n1069 n1485 vdd vss) tx_mux_pdk110_64
X1317 (vss n585 n1069 n1486 vdd vss) tx_mux_pdk110_64
X1318 (vss n587 n1069 n1487 vdd vss) tx_mux_pdk110_64
X1319 (vss n589 n1069 n1488 vdd vss) tx_mux_pdk110_64
X1320 (vss n591 n1069 n1489 vdd vss) tx_mux_pdk110_64
X1321 (vss n593 n1069 n1490 vdd vss) tx_mux_pdk110_64
X1322 (vss n595 n1069 n1491 vdd vss) tx_mux_pdk110_64
X1323 (vdd vss n1102 n1492 vdd vss) tx_mux_pdk110_64
X1324 (vss vss n1102 n1493 vdd vss) tx_mux_pdk110_64
X1325 (n243 n240 n351 n1494 vdd vss) tx_mux_pdk110_64
X1326 (n1494 vss n236 n1495 vdd vss) tx_mux_pdk110_64
X1327 (vdd n1495 n960 n1496 vdd vss) tx_mux_pdk110_64
X1328 (n1496 vss n234 n1497 vdd vss) tx_mux_pdk110_64
X1329 (n1496 vdd n234 n1498 vdd vss) tx_mux_pdk110_64
X1330 (n1497 n232 n238 n1499 vdd vss) tx_mux_pdk110_64
X1331 (n1498 n232 n238 n1500 vdd vss) tx_mux_pdk110_64
X1332 (vss n1499 n88 n1501 vdd vss) tx_mux_pdk110_64
X1333 (vss n1500 n88 n1502 vdd vss) tx_mux_pdk110_64
X1334 (vss n1501 n117 n1503 vdd vss) tx_mux_pdk110_64
X1335 (vss n1502 n117 n1504 vdd vss) tx_mux_pdk110_64
X1336 (vss n1503 n51 n1505 vdd vss) tx_mux_pdk110_64
X1337 (vss n1504 n51 n1506 vdd vss) tx_mux_pdk110_64
X1338 (vdd vss n1081 n1507 vdd vss) tx_mux_pdk110_64
X1339 (vss vss n1081 n1508 vdd vss) tx_mux_pdk110_64
X1340 (vss vss n1074 n1509 vdd vss) tx_mux_pdk110_64
X1341 (vdd vss n1074 n1510 vdd vss) tx_mux_pdk110_64
X1342 (vdd vss n1069 n1511 vdd vss) tx_mux_pdk110_64
X1343 (vss vss n1069 n1512 vdd vss) tx_mux_pdk110_64
X1344 (vss vdd n240 n1513 vdd vss) tx_mux_pdk110_64
X1345 (vss vdd n243 n1514 vdd vss) tx_mux_pdk110_64
X1346 (n1514 n1513 n351 n1515 vdd vss) tx_mux_pdk110_64
X1347 (n1515 vss n236 n1516 vdd vss) tx_mux_pdk110_64
X1348 (vdd n1516 n960 n1517 vdd vss) tx_mux_pdk110_64
X1349 (n1517 vss n234 n1518 vdd vss) tx_mux_pdk110_64
X1350 (vss vdd n232 n1519 vdd vss) tx_mux_pdk110_64
X1351 (n1518 n1519 n238 n194 vdd vss) tx_mux_pdk110_64
X1352 (n1269 vss n1102 n1520 vdd vss) tx_mux_pdk110_64
X1353 (vss vss n240 n1521 vdd vss) tx_mux_pdk110_64
X1354 (vss vss n243 n1522 vdd vss) tx_mux_pdk110_64
X1355 (n1522 n1521 n351 n1523 vdd vss) tx_mux_pdk110_64
X1356 (n1523 vss n236 n1524 vdd vss) tx_mux_pdk110_64
X1357 (vss n1524 n960 n1525 vdd vss) tx_mux_pdk110_64
X1358 (n1525 vss n234 n1526 vdd vss) tx_mux_pdk110_64
X1359 (vss vss n232 n1527 vdd vss) tx_mux_pdk110_64
X1360 (n1526 n1527 n238 n1528 vdd vss) tx_mux_pdk110_64
X1361 (vss n1528 n88 n1529 vdd vss) tx_mux_pdk110_64
X1362 (vss n1529 n117 n1530 vdd vss) tx_mux_pdk110_64
X1363 (vss n1530 n51 n1531 vdd vss) tx_mux_pdk110_64
X1364 (vss n336 n980 n1532 vdd vss) tx_mux_pdk110_64
X1365 (vss n338 n980 n1533 vdd vss) tx_mux_pdk110_64
X1366 (vss n340 n980 n1534 vdd vss) tx_mux_pdk110_64
X1367 (vss n342 n980 n1535 vdd vss) tx_mux_pdk110_64
X1368 (vss n344 n980 n1536 vdd vss) tx_mux_pdk110_64
X1369 (vdd n1320 n980 n1537 vdd vss) tx_mux_pdk110_64
X1370 (n364 vss n240 n1538 vdd vss) tx_mux_pdk110_64
X1371 (n367 vss n240 n1539 vdd vss) tx_mux_pdk110_64
X1372 (n370 vss n240 n1540 vdd vss) tx_mux_pdk110_64
X1373 (n373 vss n240 n1541 vdd vss) tx_mux_pdk110_64
X1374 (n376 vss n240 n1542 vdd vss) tx_mux_pdk110_64
X1375 (n379 vss n240 n1543 vdd vss) tx_mux_pdk110_64
X1376 (n391 vss n243 n1544 vdd vss) tx_mux_pdk110_64
X1377 (n393 vss n243 n1545 vdd vss) tx_mux_pdk110_64
X1378 (n395 vss n243 n1546 vdd vss) tx_mux_pdk110_64
X1379 (n397 vss n243 n1547 vdd vss) tx_mux_pdk110_64
X1380 (n399 vss n243 n1548 vdd vss) tx_mux_pdk110_64
X1381 (n401 vss n243 n1549 vdd vss) tx_mux_pdk110_64
X1382 (n1544 n1538 n351 n1550 vdd vss) tx_mux_pdk110_64
X1383 (n1545 n1539 n351 n1551 vdd vss) tx_mux_pdk110_64
X1384 (n1546 n1540 n351 n1552 vdd vss) tx_mux_pdk110_64
X1385 (n1547 n1541 n351 n1553 vdd vss) tx_mux_pdk110_64
X1386 (n1548 n1542 n351 n1554 vdd vss) tx_mux_pdk110_64
X1387 (n1549 n1543 n351 n1555 vdd vss) tx_mux_pdk110_64
X1388 (n1550 vss n236 n1556 vdd vss) tx_mux_pdk110_64
X1389 (n1551 vss n236 n1557 vdd vss) tx_mux_pdk110_64
X1390 (n1552 vss n236 n1558 vdd vss) tx_mux_pdk110_64
X1391 (n1553 vss n236 n1559 vdd vss) tx_mux_pdk110_64
X1392 (n1554 vss n236 n1560 vdd vss) tx_mux_pdk110_64
X1393 (n1555 vss n236 n1561 vdd vss) tx_mux_pdk110_64
X1394 (vss n1556 n960 n1562 vdd vss) tx_mux_pdk110_64
X1395 (vss n1557 n960 n1563 vdd vss) tx_mux_pdk110_64
X1396 (vss n1558 n960 n1564 vdd vss) tx_mux_pdk110_64
X1397 (vss n1559 n960 n1565 vdd vss) tx_mux_pdk110_64
X1398 (vss n1560 n960 n1566 vdd vss) tx_mux_pdk110_64
X1399 (vss n1561 n960 n1567 vdd vss) tx_mux_pdk110_64
X1400 (n1562 vss n234 n1568 vdd vss) tx_mux_pdk110_64
X1401 (n1563 vss n234 n1569 vdd vss) tx_mux_pdk110_64
X1402 (n1564 vss n234 n1570 vdd vss) tx_mux_pdk110_64
X1403 (n1565 vss n234 n1571 vdd vss) tx_mux_pdk110_64
X1404 (n1566 vss n234 n1572 vdd vss) tx_mux_pdk110_64
X1405 (n1567 vss n234 n1573 vdd vss) tx_mux_pdk110_64
X1406 (vss vss n232 n1368 vdd vss) tx_mux_pdk110_64
X1407 (n1568 n1368 n238 n1574 vdd vss) tx_mux_pdk110_64
X1408 (n1569 n1368 n238 n1575 vdd vss) tx_mux_pdk110_64
X1409 (n1570 n1368 n238 n1576 vdd vss) tx_mux_pdk110_64
X1410 (n1571 n1368 n238 n1577 vdd vss) tx_mux_pdk110_64
X1411 (n1572 n1368 n238 n1578 vdd vss) tx_mux_pdk110_64
X1412 (n1573 n1366 n238 n1579 vdd vss) tx_mux_pdk110_64
X1413 (n1532 n1574 n88 n1580 vdd vss) tx_mux_pdk110_64
X1414 (n1533 n1575 n88 n1581 vdd vss) tx_mux_pdk110_64
X1415 (n1534 n1576 n88 n1582 vdd vss) tx_mux_pdk110_64
X1416 (n1535 n1577 n88 n1583 vdd vss) tx_mux_pdk110_64
X1417 (n1536 n1578 n88 n1584 vdd vss) tx_mux_pdk110_64
X1418 (n1537 n1579 n88 n1585 vdd vss) tx_mux_pdk110_64
X1419 (vss vss n980 n1375 vdd vss) tx_mux_pdk110_64
X1420 (n1375 n1580 n117 n1586 vdd vss) tx_mux_pdk110_64
X1421 (n1375 n1581 n117 n1587 vdd vss) tx_mux_pdk110_64
X1422 (n1375 n1582 n117 n1588 vdd vss) tx_mux_pdk110_64
X1423 (n1375 n1583 n117 n1589 vdd vss) tx_mux_pdk110_64
X1424 (n1375 n1584 n117 n1590 vdd vss) tx_mux_pdk110_64
X1425 (n1374 n1585 n117 n1591 vdd vss) tx_mux_pdk110_64
X1426 (vss vss n978 n1592 vdd vss) tx_mux_pdk110_64
X1427 (vdd vss n978 n1459 vdd vss) tx_mux_pdk110_64
X1428 (n1592 n1586 n51 n163 vdd vss) tx_mux_pdk110_64
X1429 (n1592 n1587 n51 n162 vdd vss) tx_mux_pdk110_64
X1430 (n1592 n1588 n51 n161 vdd vss) tx_mux_pdk110_64
X1431 (n1592 n1589 n51 n160 vdd vss) tx_mux_pdk110_64
X1432 (n1592 n1590 n51 n158 vdd vss) tx_mux_pdk110_64
X1433 (n1459 n1591 n51 n182 vdd vss) tx_mux_pdk110_64
X1434 (n296 vss n232 n1593 vdd vss) tx_mux_pdk110_64
X1435 (n1329 vss n232 n1594 vdd vss) tx_mux_pdk110_64
X1436 (n1330 vss n232 n1595 vdd vss) tx_mux_pdk110_64
X1437 (n1331 vss n232 n1596 vdd vss) tx_mux_pdk110_64
X1438 (n1332 vss n232 n1597 vdd vss) tx_mux_pdk110_64
X1439 (n1333 vss n232 n1598 vdd vss) tx_mux_pdk110_64
X1440 (n1334 vss n232 n1599 vdd vss) tx_mux_pdk110_64
X1441 (n1335 vss n232 n1600 vdd vss) tx_mux_pdk110_64
X1442 (vss n1593 n238 n1601 vdd vss) tx_mux_pdk110_64
X1443 (vss n1594 n238 n1602 vdd vss) tx_mux_pdk110_64
X1444 (vss n1595 n238 n1603 vdd vss) tx_mux_pdk110_64
X1445 (vss n1596 n238 n1604 vdd vss) tx_mux_pdk110_64
X1446 (vss n1597 n238 n1605 vdd vss) tx_mux_pdk110_64
X1447 (vss n1598 n238 n1606 vdd vss) tx_mux_pdk110_64
X1448 (vss n1599 n238 n1607 vdd vss) tx_mux_pdk110_64
X1449 (vss n1600 n238 n1608 vdd vss) tx_mux_pdk110_64
X1450 (vss n1601 n88 n1609 vdd vss) tx_mux_pdk110_64
X1451 (vss n1602 n88 n1610 vdd vss) tx_mux_pdk110_64
X1452 (vss n1603 n88 n1611 vdd vss) tx_mux_pdk110_64
X1453 (vss n1604 n88 n1612 vdd vss) tx_mux_pdk110_64
X1454 (vss n1605 n88 n1613 vdd vss) tx_mux_pdk110_64
X1455 (vss n1606 n88 n1614 vdd vss) tx_mux_pdk110_64
X1456 (vss n1607 n88 n1615 vdd vss) tx_mux_pdk110_64
X1457 (vss n1608 n88 n1616 vdd vss) tx_mux_pdk110_64
X1458 (n1321 n323 n980 n1617 vdd vss) tx_mux_pdk110_64
X1459 (n1322 n324 n980 n1618 vdd vss) tx_mux_pdk110_64
X1460 (n1323 n326 n980 n1619 vdd vss) tx_mux_pdk110_64
X1461 (n1324 n328 n980 n1620 vdd vss) tx_mux_pdk110_64
X1462 (n1325 n330 n980 n1621 vdd vss) tx_mux_pdk110_64
X1463 (n1326 n332 n980 n1622 vdd vss) tx_mux_pdk110_64
X1464 (n1327 n334 n980 n1623 vdd vss) tx_mux_pdk110_64
X1465 (n1328 n522 n980 n1624 vdd vss) tx_mux_pdk110_64
X1466 (n1617 n1609 n117 n1625 vdd vss) tx_mux_pdk110_64
X1467 (n1618 n1610 n117 n1626 vdd vss) tx_mux_pdk110_64
X1468 (n1619 n1611 n117 n1627 vdd vss) tx_mux_pdk110_64
X1469 (n1620 n1612 n117 n1628 vdd vss) tx_mux_pdk110_64
X1470 (n1621 n1613 n117 n1629 vdd vss) tx_mux_pdk110_64
X1471 (n1622 n1614 n117 n1630 vdd vss) tx_mux_pdk110_64
X1472 (n1623 n1615 n117 n1631 vdd vss) tx_mux_pdk110_64
X1473 (n1624 n1616 n117 n1632 vdd vss) tx_mux_pdk110_64
X1474 (vss n1625 n51 n177 vdd vss) tx_mux_pdk110_64
X1475 (vss n1626 n51 n176 vdd vss) tx_mux_pdk110_64
X1476 (vss n1627 n51 n175 vdd vss) tx_mux_pdk110_64
X1477 (vss n1628 n51 n174 vdd vss) tx_mux_pdk110_64
X1478 (vss n1629 n51 n173 vdd vss) tx_mux_pdk110_64
X1479 (vss n1630 n51 n172 vdd vss) tx_mux_pdk110_64
X1480 (vss n1631 n51 n170 vdd vss) tx_mux_pdk110_64
X1481 (n978 n1632 n51 n180 vdd vss) tx_mux_pdk110_64
X1482 (n1484 n1055 n1180 vdd vss) tx_and_pdk110_47
X1483 (n1476 n1238 n1181 vdd vss) tx_and_pdk110_47
X1484 (n1468 n1053 n1183 vdd vss) tx_and_pdk110_47
X1485 (n1460 n1175 n1184 vdd vss) tx_and_pdk110_47
X1486 (n1485 n1055 n1187 vdd vss) tx_and_pdk110_47
X1487 (n1477 n1238 n1188 vdd vss) tx_and_pdk110_47
X1488 (n1469 n1053 n1190 vdd vss) tx_and_pdk110_47
X1489 (n1461 n1175 n1191 vdd vss) tx_and_pdk110_47
X1490 (n1486 n1055 n1194 vdd vss) tx_and_pdk110_47
X1491 (n1478 n1238 n1195 vdd vss) tx_and_pdk110_47
X1492 (n1470 n1053 n1197 vdd vss) tx_and_pdk110_47
X1493 (n1462 n1175 n1198 vdd vss) tx_and_pdk110_47
X1494 (n1487 n1055 n1201 vdd vss) tx_and_pdk110_47
X1495 (n1479 n1238 n1202 vdd vss) tx_and_pdk110_47
X1496 (n1471 n1053 n1204 vdd vss) tx_and_pdk110_47
X1497 (n1463 n1175 n1205 vdd vss) tx_and_pdk110_47
X1498 (n1488 n1055 n1208 vdd vss) tx_and_pdk110_47
X1499 (n1480 n1238 n1209 vdd vss) tx_and_pdk110_47
X1500 (n1472 n1053 n1211 vdd vss) tx_and_pdk110_47
X1501 (n1464 n1175 n1212 vdd vss) tx_and_pdk110_47
X1502 (n1489 n1055 n1215 vdd vss) tx_and_pdk110_47
X1503 (n1481 n1238 n1216 vdd vss) tx_and_pdk110_47
X1504 (n1473 n1053 n1218 vdd vss) tx_and_pdk110_47
X1505 (n1465 n1175 n1219 vdd vss) tx_and_pdk110_47
X1506 (n1490 n1055 n1222 vdd vss) tx_and_pdk110_47
X1507 (n1482 n1238 n1223 vdd vss) tx_and_pdk110_47
X1508 (n1474 n1053 n1225 vdd vss) tx_and_pdk110_47
X1509 (n1466 n1175 n1226 vdd vss) tx_and_pdk110_47
X1510 (n1491 n1055 n1229 vdd vss) tx_and_pdk110_47
X1511 (n1483 n1238 n1230 vdd vss) tx_and_pdk110_47
X1512 (n1475 n1053 n1232 vdd vss) tx_and_pdk110_47
X1513 (n1467 n1175 n1233 vdd vss) tx_and_pdk110_47
X1514 (n1505 n184 n1241 vdd vss) tx_and_pdk110_47
X1515 (n1511 n1055 n1245 vdd vss) tx_and_pdk110_47
X1516 (n1493 n1175 n1253 vdd vss) tx_and_pdk110_47
X1517 (n1507 n1053 n1242 vdd vss) tx_and_pdk110_47
X1518 (n1510 n1238 n1250 vdd vss) tx_and_pdk110_47
X1519 (n1492 n1175 n1247 vdd vss) tx_and_pdk110_47
X1520 (n1506 n184 n1256 vdd vss) tx_and_pdk110_47
X1521 (n1508 n1053 n1257 vdd vss) tx_and_pdk110_47
X1522 (n1509 n1238 n1244 vdd vss) tx_and_pdk110_47
X1523 (n1512 n1055 n1251 vdd vss) tx_and_pdk110_47
X1524 (n1520 n1175 n1262 vdd vss) tx_and_pdk110_47
X1525 (n1531 n184 n1263 vdd vss) tx_and_pdk110_47
X1526 (n1069 n1055 n1265 vdd vss) tx_and_pdk110_47
X1527 (n68 n306 vdd vss) pll_inv_pdk110_7
X1528 (n70 n308 vdd vss) pll_inv_pdk110_7
X1529 (n72 n310 vdd vss) pll_inv_pdk110_7
X1530 (n60 n298 vdd vss) pll_inv_pdk110_7
X1531 (n62 n300 vdd vss) pll_inv_pdk110_7
X1532 (n64 n302 vdd vss) pll_inv_pdk110_7
X1533 (n66 n304 vdd vss) pll_inv_pdk110_7
X1534 (n351 n1031 vdd vss) pll_inv_pdk110_7
X1535 (n346 n1126 vdd vss) pll_inv_pdk110_7
X1536 (n348 n1131 vdd vss) pll_inv_pdk110_7
X1537 (n824 n349 vdd vss) pll_inv_pdk110_7
X1538 (n908 n1141 vdd vss) pll_inv_pdk110_7
X1539 (n354 n1144 vdd vss) pll_inv_pdk110_7
X1540 (n943 n352 vdd vss) pll_inv_pdk110_7
X1541 (n127 n923 vdd vss) pll_inv_pdk110_7
X1542 (n129 n925 vdd vss) pll_inv_pdk110_7
X1543 (n131 n927 vdd vss) pll_inv_pdk110_7
X1544 (n135 n931 vdd vss) pll_inv_pdk110_7
X1545 (n137 n933 vdd vss) pll_inv_pdk110_7
X1546 (dac1 n500 vdd vss) pll_inv_pdk110_7
X1547 (dac5 n578 vdd vss) pll_inv_pdk110_7
X1548 (measured0 n403 vdd vss) pll_inv_pdk110_7
X1549 (measured1 n402 vdd vss) pll_inv_pdk110_7
X1550 (measured4 n641 vdd vss) pll_inv_pdk110_7
X1551 (measured5 n644 vdd vss) pll_inv_pdk110_7
X1552 (measured6 n647 vdd vss) pll_inv_pdk110_7
X1553 (measured7 n650 vdd vss) pll_inv_pdk110_7
X1554 (measured8 n653 vdd vss) pll_inv_pdk110_7
X1555 (measured9 n656 vdd vss) pll_inv_pdk110_7
X1556 (measured10 n659 vdd vss) pll_inv_pdk110_7
X1557 (measured11 n662 vdd vss) pll_inv_pdk110_7
X1558 (measured12 n665 vdd vss) pll_inv_pdk110_7
X1559 (measured13 n668 vdd vss) pll_inv_pdk110_7
X1560 (n646 n885 vdd vss) pll_inv_pdk110_7
X1561 (n649 n699 vdd vss) pll_inv_pdk110_7
X1562 (n652 n816 vdd vss) pll_inv_pdk110_7
X1563 (n655 n817 vdd vss) pll_inv_pdk110_7
X1564 (n658 n818 vdd vss) pll_inv_pdk110_7
X1565 (n664 n700 vdd vss) pll_inv_pdk110_7
X1566 (target_k3 n754 vdd vss) pll_inv_pdk110_7
X1567 (target_k4 n1123 vdd vss) pll_inv_pdk110_7
X1568 (target_k5 n747 vdd vss) pll_inv_pdk110_7
X1569 (target_k1 n1118 vdd vss) pll_inv_pdk110_7
X1570 (n643 n698 vdd vss) pll_inv_pdk110_7
X1571 (n322 n1128 vdd vss) pll_inv_pdk110_7
X1572 (coarse1 n538 vdd vss) pll_inv_pdk110_7
X1573 (coarse2 n540 vdd vss) pll_inv_pdk110_7
X1574 (coarse3 n543 vdd vss) pll_inv_pdk110_7
X1575 (coarse4 n546 vdd vss) pll_inv_pdk110_7
X1576 (coarse5 n549 vdd vss) pll_inv_pdk110_7
X1577 (coarse6 n552 vdd vss) pll_inv_pdk110_7
X1578 (n93 n1089 vdd vss) pll_inv_pdk110_7
X1579 (n95 n1090 vdd vss) pll_inv_pdk110_7
X1580 (n640 n696 vdd vss) pll_inv_pdk110_7
X1581 (n661 n702 vdd vss) pll_inv_pdk110_7
X1582 (n667 n886 vdd vss) pll_inv_pdk110_7
X1583 (n75 n888 vdd vss) pll_inv_pdk110_7
X1584 (n77 n890 vdd vss) pll_inv_pdk110_7
X1585 (n79 n892 vdd vss) pll_inv_pdk110_7
X1586 (n81 n894 vdd vss) pll_inv_pdk110_7
X1587 (n83 n896 vdd vss) pll_inv_pdk110_7
X1588 (n85 n898 vdd vss) pll_inv_pdk110_7
X1589 (n133 n929 vdd vss) pll_inv_pdk110_7
X1590 (dac2 n572 vdd vss) pll_inv_pdk110_7
X1591 (dac4 n575 vdd vss) pll_inv_pdk110_7
X1592 (n101 n1075 vdd vss) pll_inv_pdk110_7
X1593 (n103 n1062 vdd vss) pll_inv_pdk110_7
X1594 (n105 n1098 vdd vss) pll_inv_pdk110_7
X1595 (vss n1186 n1179 n209 vdd vss) tx_mux_pdk110_64
X1596 (vss n1193 n1179 n208 vdd vss) tx_mux_pdk110_64
X1597 (vss n1200 n1179 n207 vdd vss) tx_mux_pdk110_64
X1598 (vss n1207 n1179 n206 vdd vss) tx_mux_pdk110_64
X1599 (vss n1214 n1179 n205 vdd vss) tx_mux_pdk110_64
X1600 (vss n1221 n1179 n204 vdd vss) tx_mux_pdk110_64
X1601 (vss n1228 n1179 n202 vdd vss) tx_mux_pdk110_64
X1602 (vss n1235 n1179 n210 vdd vss) tx_mux_pdk110_64
X1603 (vss n1249 n1240 n143 vdd vss) tx_mux_pdk110_64
X1604 (vss n1255 n1240 n141 vdd vss) tx_mux_pdk110_64
X1605 (vss n1261 n1240 n198 vdd vss) tx_mux_pdk110_64
X1606 (vss n1264 n981 n191 vdd vss) tx_mux_pdk110_64
X1607 (vss n1266 n189 n188 vdd vss) tx_mux_pdk110_64
X1608 (vss n1238 n186 n185 vdd vss) tx_mux_pdk110_64
// @RNL(author="functional-compact127") {
// $CELL = @DEFINE-SYMBOL {
// @LINE {(-18, -46) (18, -46) (18, 46) (-18, 46) (-18, -46)};
// @LINE {(-6, 9.5) (6, 9.5) (6, 14.5) (-6, 14.5) (-6, 9.5)};
// (0, 12) @TEXT("COARSE", size=0.9, halign="middle");
// @LINE {(-6, 1.5) (6, 1.5) (6, 6.5) (-6, 6.5) (-6, 1.5)};
// (0, 4) @TEXT("FINE", size=0.9, halign="middle");
// @LINE {(-6, -6.5) (6, -6.5) (6, -1.5) (-6, -1.5) (-6, -6.5)};
// (0, -4) @TEXT("CHECK", size=0.9, halign="middle");
// @LINE {(-6, -14.5) (6, -14.5) (6, -9.5) (-6, -9.5) (-6, -14.5)};
// (0, -12) @TEXT("HANDOFF", size=0.9, halign="middle");
// @LINE {(0, 9.5) (0, 6.5)};
// @LINE {(0.575311, 7.5531) (0, 6.5) (-0.575311, 7.5531)};
// @LINE {(0, 1.5) (0, -1.5)};
// @LINE {(0.575311, -0.446901) (0, -1.5) (-0.575311, -0.446901)};
// @LINE {(0, -6.5) (0, -9.5)};
// @LINE {(0.575311, -8.4469) (0, -9.5) (-0.575311, -8.4469)};
// (0, 19) @TEXT("SAR / FLL", size=1.1, halign="middle");
// (0, -18) @TEXT("2x pass", size=0.9, halign="middle");
// (-20, 42) @PIN(terminal="refclk", direction="left");
// @LINE {(-20, 42) (-18, 42)};
// (-17.4, 42) @TEXT("refclk", size=0.7, halign="start");
// (-20, 38) @PIN(terminal="reset", direction="left");
// @LINE {(-20, 38) (-18, 38)};
// (-17.4, 38) @TEXT("reset", size=0.7, halign="start");
// (-20, 34) @PIN(terminal="target_k0", direction="left");
// @LINE {(-20, 34) (-18, 34)};
// (-17.4, 34) @TEXT("target_k0", size=0.7, halign="start");
// (-20, 30) @PIN(terminal="target_k1", direction="left");
// @LINE {(-20, 30) (-18, 30)};
// (-17.4, 30) @TEXT("target_k1", size=0.7, halign="start");
// (-20, 26) @PIN(terminal="target_k2", direction="left");
// @LINE {(-20, 26) (-18, 26)};
// (-17.4, 26) @TEXT("target_k2", size=0.7, halign="start");
// (-20, 22) @PIN(terminal="target_k3", direction="left");
// @LINE {(-20, 22) (-18, 22)};
// (-17.4, 22) @TEXT("target_k3", size=0.7, halign="start");
// (-20, 18) @PIN(terminal="target_k4", direction="left");
// @LINE {(-20, 18) (-18, 18)};
// (-17.4, 18) @TEXT("target_k4", size=0.7, halign="start");
// (-20, 14) @PIN(terminal="target_k5", direction="left");
// @LINE {(-20, 14) (-18, 14)};
// (-17.4, 14) @TEXT("target_k5", size=0.7, halign="start");
// (-20, 10) @PIN(terminal="measured0", direction="left");
// @LINE {(-20, 10) (-18, 10)};
// (-17.4, 10) @TEXT("measured0", size=0.7, halign="start");
// (-20, 6) @PIN(terminal="measured1", direction="left");
// @LINE {(-20, 6) (-18, 6)};
// (-17.4, 6) @TEXT("measured1", size=0.7, halign="start");
// (-20, 2) @PIN(terminal="measured2", direction="left");
// @LINE {(-20, 2) (-18, 2)};
// (-17.4, 2) @TEXT("measured2", size=0.7, halign="start");
// (-20, -2) @PIN(terminal="measured3", direction="left");
// @LINE {(-20, -2) (-18, -2)};
// (-17.4, -2) @TEXT("measured3", size=0.7, halign="start");
// (-20, -6) @PIN(terminal="measured4", direction="left");
// @LINE {(-20, -6) (-18, -6)};
// (-17.4, -6) @TEXT("measured4", size=0.7, halign="start");
// (-20, -10) @PIN(terminal="measured5", direction="left");
// @LINE {(-20, -10) (-18, -10)};
// (-17.4, -10) @TEXT("measured5", size=0.7, halign="start");
// (-20, -14) @PIN(terminal="measured6", direction="left");
// @LINE {(-20, -14) (-18, -14)};
// (-17.4, -14) @TEXT("measured6", size=0.7, halign="start");
// (-20, -18) @PIN(terminal="measured7", direction="left");
// @LINE {(-20, -18) (-18, -18)};
// (-17.4, -18) @TEXT("measured7", size=0.7, halign="start");
// (-20, -22) @PIN(terminal="measured8", direction="left");
// @LINE {(-20, -22) (-18, -22)};
// (-17.4, -22) @TEXT("measured8", size=0.7, halign="start");
// (-20, -26) @PIN(terminal="measured9", direction="left");
// @LINE {(-20, -26) (-18, -26)};
// (-17.4, -26) @TEXT("measured9", size=0.7, halign="start");
// (-20, -30) @PIN(terminal="measured10", direction="left");
// @LINE {(-20, -30) (-18, -30)};
// (-17.4, -30) @TEXT("measured10", size=0.7, halign="start");
// (-20, -34) @PIN(terminal="measured11", direction="left");
// @LINE {(-20, -34) (-18, -34)};
// (-17.4, -34) @TEXT("measured11", size=0.7, halign="start");
// (-20, -38) @PIN(terminal="measured12", direction="left");
// @LINE {(-20, -38) (-18, -38)};
// (-17.4, -38) @TEXT("measured12", size=0.7, halign="start");
// (-20, -42) @PIN(terminal="measured13", direction="left");
// @LINE {(-20, -42) (-18, -42)};
// (-17.4, -42) @TEXT("measured13", size=0.7, halign="start");
// (20, 40) @PIN(terminal="coarse0", direction="right");
// @LINE {(20, 40) (18, 40)};
// (17.4, 40) @TEXT("coarse0", size=0.7, halign="end");
// (20, 36) @PIN(terminal="coarse1", direction="right");
// @LINE {(20, 36) (18, 36)};
// (17.4, 36) @TEXT("coarse1", size=0.7, halign="end");
// (20, 32) @PIN(terminal="coarse2", direction="right");
// @LINE {(20, 32) (18, 32)};
// (17.4, 32) @TEXT("coarse2", size=0.7, halign="end");
// (20, 28) @PIN(terminal="coarse3", direction="right");
// @LINE {(20, 28) (18, 28)};
// (17.4, 28) @TEXT("coarse3", size=0.7, halign="end");
// (20, 24) @PIN(terminal="coarse4", direction="right");
// @LINE {(20, 24) (18, 24)};
// (17.4, 24) @TEXT("coarse4", size=0.7, halign="end");
// (20, 20) @PIN(terminal="coarse5", direction="right");
// @LINE {(20, 20) (18, 20)};
// (17.4, 20) @TEXT("coarse5", size=0.7, halign="end");
// (20, 16) @PIN(terminal="coarse6", direction="right");
// @LINE {(20, 16) (18, 16)};
// (17.4, 16) @TEXT("coarse6", size=0.7, halign="end");
// (20, 12) @PIN(terminal="coarse7", direction="right");
// @LINE {(20, 12) (18, 12)};
// (17.4, 12) @TEXT("coarse7", size=0.7, halign="end");
// (20, 8) @PIN(terminal="dac0", direction="right");
// @LINE {(20, 8) (18, 8)};
// (17.4, 8) @TEXT("dac0", size=0.7, halign="end");
// (20, 4) @PIN(terminal="dac1", direction="right");
// @LINE {(20, 4) (18, 4)};
// (17.4, 4) @TEXT("dac1", size=0.7, halign="end");
// (20, 0) @PIN(terminal="dac2", direction="right");
// @LINE {(20, 0) (18, 0)};
// (17.4, 0) @TEXT("dac2", size=0.7, halign="end");
// (20, -4) @PIN(terminal="dac3", direction="right");
// @LINE {(20, -4) (18, -4)};
// (17.4, -4) @TEXT("dac3", size=0.7, halign="end");
// (20, -8) @PIN(terminal="dac4", direction="right");
// @LINE {(20, -8) (18, -8)};
// (17.4, -8) @TEXT("dac4", size=0.7, halign="end");
// (20, -12) @PIN(terminal="dac5", direction="right");
// @LINE {(20, -12) (18, -12)};
// (17.4, -12) @TEXT("dac5", size=0.7, halign="end");
// (20, -16) @PIN(terminal="count_gate", direction="right");
// @LINE {(20, -16) (18, -16)};
// (17.4, -16) @TEXT("count_gate", size=0.7, halign="end");
// (20, -20) @PIN(terminal="count_reset", direction="right");
// @LINE {(20, -20) (18, -20)};
// (17.4, -20) @TEXT("count_reset", size=0.7, halign="end");
// (20, -24) @PIN(terminal="enable", direction="right");
// @LINE {(20, -24) (18, -24)};
// (17.4, -24) @TEXT("enable", size=0.7, halign="end");
// (20, -28) @PIN(terminal="range_error", direction="right");
// @LINE {(20, -28) (18, -28)};
// (17.4, -28) @TEXT("range_error", size=0.7, halign="end");
// (20, -32) @PIN(terminal="state_out0", direction="right");
// @LINE {(20, -32) (18, -32)};
// (17.4, -32) @TEXT("state_out0", size=0.7, halign="end");
// (20, -36) @PIN(terminal="state_out1", direction="right");
// @LINE {(20, -36) (18, -36)};
// (17.4, -36) @TEXT("state_out1", size=0.7, halign="end");
// (20, -40) @PIN(terminal="state_out2", direction="right");
// @LINE {(20, -40) (18, -40)};
// (17.4, -40) @TEXT("state_out2", size=0.7, halign="end");
// (0, 48) @PIN(terminal="vdd", direction="up");
// @LINE {(0, 48) (0, 46)};
// (0, -48) @PIN(terminal="vss", direction="down");
// @LINE {(0, -48) (0, -46)};
// ? @TEXT("${name}", key="name", size=1, halign="middle") => @PLACE(20, 49.5);
// (0, 45.1) @TEXT("FLL / recenter", size=0.85, halign="middle");
// };
// # @SET-SYMBOL $CELL;
// #X0 @PLACE(0, -518) => @ORIENT("R0");
// (-25, -504) @TEXT("Panel 01 | X0 - X23", size=1.1, halign="start");
// #X1 @PLACE(40, -518) => @ORIENT("R0");
// #X2 @PLACE(80, -518) => @ORIENT("R0");
// #X3 @PLACE(120, -518) => @ORIENT("R0");
// #X4 @PLACE(0, -553) => @ORIENT("R0");
// #X5 @PLACE(40, -553) => @ORIENT("R0");
// #X6 @PLACE(80, -553) => @ORIENT("R0");
// #X7 @PLACE(120, -553) => @ORIENT("R0");
// #X8 @PLACE(0, -588) => @ORIENT("R0");
// #X9 @PLACE(40, -588) => @ORIENT("R0");
// #X10 @PLACE(80, -588) => @ORIENT("R0");
// #X11 @PLACE(120, -588) => @ORIENT("R0");
// #X12 @PLACE(0, -623) => @ORIENT("R0");
// #X13 @PLACE(40, -623) => @ORIENT("R0");
// #X14 @PLACE(80, -623) => @ORIENT("R0");
// #X15 @PLACE(120, -623) => @ORIENT("R0");
// #X16 @PLACE(0, -658) => @ORIENT("R0");
// #X17 @PLACE(40, -658) => @ORIENT("R0");
// #X18 @PLACE(80, -658) => @ORIENT("R0");
// #X19 @PLACE(120, -658) => @ORIENT("R0");
// #X20 @PLACE(0, -693) => @ORIENT("R0");
// #X21 @PLACE(40, -693) => @ORIENT("R0");
// #X22 @PLACE(80, -693) => @ORIENT("R0");
// #X23 @PLACE(120, -693) => @ORIENT("R0");
// #X24 @PLACE(168, -518) => @ORIENT("R0");
// (152, -504) @TEXT("Panel 02 | X24 - X47", size=1.1, halign="start");
// #X25 @PLACE(208, -518) => @ORIENT("R0");
// #X26 @PLACE(248, -518) => @ORIENT("R0");
// #X27 @PLACE(288, -518) => @ORIENT("R0");
// #X28 @PLACE(168, -553) => @ORIENT("R0");
// #X29 @PLACE(208, -553) => @ORIENT("R0");
// #X30 @PLACE(248, -553) => @ORIENT("R0");
// #X31 @PLACE(288, -553) => @ORIENT("R0");
// #X32 @PLACE(168, -588) => @ORIENT("R0");
// #X33 @PLACE(208, -588) => @ORIENT("R0");
// #X34 @PLACE(248, -588) => @ORIENT("R0");
// #X35 @PLACE(288, -588) => @ORIENT("R0");
// #X36 @PLACE(168, -623) => @ORIENT("R0");
// #X37 @PLACE(208, -623) => @ORIENT("R0");
// #X38 @PLACE(248, -623) => @ORIENT("R0");
// #X39 @PLACE(288, -623) => @ORIENT("R0");
// #X40 @PLACE(168, -658) => @ORIENT("R0");
// #X41 @PLACE(208, -658) => @ORIENT("R0");
// #X42 @PLACE(248, -658) => @ORIENT("R0");
// #X43 @PLACE(288, -658) => @ORIENT("R0");
// #X44 @PLACE(168, -693) => @ORIENT("R0");
// #X45 @PLACE(208, -693) => @ORIENT("R0");
// #X46 @PLACE(248, -693) => @ORIENT("R0");
// #X47 @PLACE(288, -693) => @ORIENT("R0");
// #X48 @PLACE(336, -518) => @ORIENT("R0");
// (320, -504) @TEXT("Panel 03 | X48 - X71", size=1.1, halign="start");
// #X49 @PLACE(376, -518) => @ORIENT("R0");
// #X50 @PLACE(416, -518) => @ORIENT("R0");
// #X51 @PLACE(456, -518) => @ORIENT("R0");
// #X52 @PLACE(336, -553) => @ORIENT("R0");
// #X53 @PLACE(376, -553) => @ORIENT("R0");
// #X54 @PLACE(416, -553) => @ORIENT("R0");
// #X55 @PLACE(456, -553) => @ORIENT("R0");
// #X56 @PLACE(336, -588) => @ORIENT("R0");
// #X57 @PLACE(376, -588) => @ORIENT("R0");
// #X58 @PLACE(416, -588) => @ORIENT("R0");
// #X59 @PLACE(456, -588) => @ORIENT("R0");
// #X60 @PLACE(336, -623) => @ORIENT("R0");
// #X61 @PLACE(376, -623) => @ORIENT("R0");
// #X62 @PLACE(416, -623) => @ORIENT("R0");
// #X63 @PLACE(456, -623) => @ORIENT("R0");
// #X64 @PLACE(336, -658) => @ORIENT("R0");
// #X65 @PLACE(376, -658) => @ORIENT("R0");
// #X66 @PLACE(416, -658) => @ORIENT("R0");
// #X67 @PLACE(456, -658) => @ORIENT("R0");
// #X68 @PLACE(336, -693) => @ORIENT("R0");
// #X69 @PLACE(376, -693) => @ORIENT("R0");
// #X70 @PLACE(416, -693) => @ORIENT("R0");
// #X71 @PLACE(456, -693) => @ORIENT("R0");
// #X72 @PLACE(504, -518) => @ORIENT("R0");
// (488, -504) @TEXT("Panel 04 | X72 - X95", size=1.1, halign="start");
// #X73 @PLACE(544, -518) => @ORIENT("R0");
// #X74 @PLACE(584, -518) => @ORIENT("R0");
// #X75 @PLACE(624, -518) => @ORIENT("R0");
// #X76 @PLACE(504, -553) => @ORIENT("R0");
// #X77 @PLACE(544, -553) => @ORIENT("R0");
// #X78 @PLACE(584, -553) => @ORIENT("R0");
// #X79 @PLACE(624, -553) => @ORIENT("R0");
// #X80 @PLACE(504, -588) => @ORIENT("R0");
// #X81 @PLACE(544, -588) => @ORIENT("R0");
// #X82 @PLACE(584, -588) => @ORIENT("R0");
// #X83 @PLACE(624, -588) => @ORIENT("R0");
// #X84 @PLACE(504, -623) => @ORIENT("R0");
// #X85 @PLACE(544, -623) => @ORIENT("R0");
// #X86 @PLACE(584, -623) => @ORIENT("R0");
// #X87 @PLACE(624, -623) => @ORIENT("R0");
// #X88 @PLACE(504, -658) => @ORIENT("R0");
// #X89 @PLACE(544, -658) => @ORIENT("R0");
// #X90 @PLACE(584, -658) => @ORIENT("R0");
// #X91 @PLACE(624, -658) => @ORIENT("R0");
// #X92 @PLACE(504, -693) => @ORIENT("R0");
// #X93 @PLACE(544, -693) => @ORIENT("R0");
// #X94 @PLACE(584, -693) => @ORIENT("R0");
// #X95 @PLACE(624, -693) => @ORIENT("R0");
// #X96 @PLACE(0, -738) => @ORIENT("R0");
// (-25, -724) @TEXT("Panel 05 | X96 - X119", size=1.1, halign="start");
// #X97 @PLACE(40, -738) => @ORIENT("R0");
// #X98 @PLACE(80, -738) => @ORIENT("R0");
// #X99 @PLACE(120, -738) => @ORIENT("R0");
// #X100 @PLACE(0, -773) => @ORIENT("R0");
// #X101 @PLACE(40, -773) => @ORIENT("R0");
// #X102 @PLACE(80, -773) => @ORIENT("R0");
// #X103 @PLACE(120, -773) => @ORIENT("R0");
// #X104 @PLACE(0, -808) => @ORIENT("R0");
// #X105 @PLACE(40, -808) => @ORIENT("R0");
// #X106 @PLACE(80, -808) => @ORIENT("R0");
// #X107 @PLACE(120, -808) => @ORIENT("R0");
// #X108 @PLACE(0, -843) => @ORIENT("R0");
// #X109 @PLACE(40, -843) => @ORIENT("R0");
// #X110 @PLACE(80, -843) => @ORIENT("R0");
// #X111 @PLACE(120, -843) => @ORIENT("R0");
// #X112 @PLACE(0, -878) => @ORIENT("R0");
// #X113 @PLACE(40, -878) => @ORIENT("R0");
// #X114 @PLACE(80, -878) => @ORIENT("R0");
// #X115 @PLACE(120, -878) => @ORIENT("R0");
// #X116 @PLACE(0, -911) => @ORIENT("R0");
// #X117 @PLACE(40, -911) => @ORIENT("R0");
// #X118 @PLACE(80, -911) => @ORIENT("R0");
// #X119 @PLACE(120, -911) => @ORIENT("R0");
// #X120 @PLACE(168, -738) => @ORIENT("R0");
// (152, -724) @TEXT("Panel 06 | X120 - X143", size=1.1, halign="start");
// #X121 @PLACE(208, -738) => @ORIENT("R0");
// #X122 @PLACE(248, -738) => @ORIENT("R0");
// #X123 @PLACE(288, -738) => @ORIENT("R0");
// #X124 @PLACE(168, -773) => @ORIENT("R0");
// #X125 @PLACE(208, -773) => @ORIENT("R0");
// #X126 @PLACE(248, -773) => @ORIENT("R0");
// #X127 @PLACE(288, -773) => @ORIENT("R0");
// #X128 @PLACE(168, -808) => @ORIENT("R0");
// #X129 @PLACE(208, -808) => @ORIENT("R0");
// #X130 @PLACE(248, -808) => @ORIENT("R0");
// #X131 @PLACE(288, -808) => @ORIENT("R0");
// #X132 @PLACE(168, -843) => @ORIENT("R0");
// #X133 @PLACE(208, -843) => @ORIENT("R0");
// #X134 @PLACE(248, -843) => @ORIENT("R0");
// #X135 @PLACE(288, -843) => @ORIENT("R0");
// #X136 @PLACE(168, -878) => @ORIENT("R0");
// #X137 @PLACE(208, -878) => @ORIENT("R0");
// #X138 @PLACE(248, -878) => @ORIENT("R0");
// #X139 @PLACE(288, -878) => @ORIENT("R0");
// #X140 @PLACE(168, -911) => @ORIENT("R0");
// #X141 @PLACE(208, -911) => @ORIENT("R0");
// #X142 @PLACE(248, -911) => @ORIENT("R0");
// #X143 @PLACE(288, -911) => @ORIENT("R0");
// #X144 @PLACE(336, -738) => @ORIENT("R0");
// (320, -724) @TEXT("Panel 07 | X144 - X167", size=1.1, halign="start");
// #X145 @PLACE(376, -738) => @ORIENT("R0");
// #X146 @PLACE(416, -738) => @ORIENT("R0");
// #X147 @PLACE(456, -738) => @ORIENT("R0");
// #X148 @PLACE(336, -773) => @ORIENT("R0");
// #X149 @PLACE(376, -773) => @ORIENT("R0");
// #X150 @PLACE(416, -773) => @ORIENT("R0");
// #X151 @PLACE(456, -773) => @ORIENT("R0");
// #X152 @PLACE(336, -808) => @ORIENT("R0");
// #X153 @PLACE(376, -808) => @ORIENT("R0");
// #X154 @PLACE(416, -808) => @ORIENT("R0");
// #X155 @PLACE(456, -808) => @ORIENT("R0");
// #X156 @PLACE(336, -843) => @ORIENT("R0");
// #X157 @PLACE(376, -843) => @ORIENT("R0");
// #X158 @PLACE(416, -843) => @ORIENT("R0");
// #X159 @PLACE(456, -843) => @ORIENT("R0");
// #X160 @PLACE(336, -878) => @ORIENT("R0");
// #X161 @PLACE(376, -878) => @ORIENT("R0");
// #X162 @PLACE(416, -878) => @ORIENT("R0");
// #X163 @PLACE(456, -878) => @ORIENT("R0");
// #X164 @PLACE(336, -911) => @ORIENT("R0");
// #X165 @PLACE(376, -911) => @ORIENT("R0");
// #X166 @PLACE(416, -911) => @ORIENT("R0");
// #X167 @PLACE(456, -911) => @ORIENT("R0");
// #X168 @PLACE(504, -738) => @ORIENT("R0");
// (488, -724) @TEXT("Panel 08 | X168 - X191", size=1.1, halign="start");
// #X169 @PLACE(544, -738) => @ORIENT("R0");
// #X170 @PLACE(584, -738) => @ORIENT("R0");
// #X171 @PLACE(624, -738) => @ORIENT("R0");
// #X172 @PLACE(504, -773) => @ORIENT("R0");
// #X173 @PLACE(544, -773) => @ORIENT("R0");
// #X174 @PLACE(584, -773) => @ORIENT("R0");
// #X175 @PLACE(624, -773) => @ORIENT("R0");
// #X176 @PLACE(504, -808) => @ORIENT("R0");
// #X177 @PLACE(544, -808) => @ORIENT("R0");
// #X178 @PLACE(584, -808) => @ORIENT("R0");
// #X179 @PLACE(624, -808) => @ORIENT("R0");
// #X180 @PLACE(504, -843) => @ORIENT("R0");
// #X181 @PLACE(544, -843) => @ORIENT("R0");
// #X182 @PLACE(584, -843) => @ORIENT("R0");
// #X183 @PLACE(624, -843) => @ORIENT("R0");
// #X184 @PLACE(504, -878) => @ORIENT("R0");
// #X185 @PLACE(544, -878) => @ORIENT("R0");
// #X186 @PLACE(584, -878) => @ORIENT("R0");
// #X187 @PLACE(624, -878) => @ORIENT("R0");
// #X188 @PLACE(504, -911) => @ORIENT("R0");
// #X189 @PLACE(544, -911) => @ORIENT("R0");
// #X190 @PLACE(584, -911) => @ORIENT("R0");
// #X191 @PLACE(624, -911) => @ORIENT("R0");
// #X192 @PLACE(0, -954) => @ORIENT("R0");
// (-25, -940) @TEXT("Panel 09 | X192 - X215", size=1.1, halign="start");
// #X193 @PLACE(40, -954) => @ORIENT("R0");
// #X194 @PLACE(80, -954) => @ORIENT("R0");
// #X195 @PLACE(120, -954) => @ORIENT("R0");
// #X196 @PLACE(0, -985) => @ORIENT("R0");
// #X197 @PLACE(40, -985) => @ORIENT("R0");
// #X198 @PLACE(80, -985) => @ORIENT("R0");
// #X199 @PLACE(120, -985) => @ORIENT("R0");
// #X200 @PLACE(0, -1016) => @ORIENT("R0");
// #X201 @PLACE(40, -1016) => @ORIENT("R0");
// #X202 @PLACE(80, -1016) => @ORIENT("R0");
// #X203 @PLACE(120, -1016) => @ORIENT("R0");
// #X204 @PLACE(0, -1047) => @ORIENT("R0");
// #X205 @PLACE(40, -1047) => @ORIENT("R0");
// #X206 @PLACE(80, -1047) => @ORIENT("R0");
// #X207 @PLACE(120, -1047) => @ORIENT("R0");
// #X208 @PLACE(0, -1078) => @ORIENT("R0");
// #X209 @PLACE(40, -1078) => @ORIENT("R0");
// #X210 @PLACE(80, -1078) => @ORIENT("R0");
// #X211 @PLACE(120, -1078) => @ORIENT("R0");
// #X212 @PLACE(0, -1109) => @ORIENT("R0");
// #X213 @PLACE(40, -1109) => @ORIENT("R0");
// #X214 @PLACE(80, -1109) => @ORIENT("R0");
// #X215 @PLACE(120, -1109) => @ORIENT("R0");
// #X216 @PLACE(168, -954) => @ORIENT("R0");
// (152, -940) @TEXT("Panel 10 | X216 - X239", size=1.1, halign="start");
// #X217 @PLACE(208, -954) => @ORIENT("R0");
// #X218 @PLACE(248, -954) => @ORIENT("R0");
// #X219 @PLACE(288, -954) => @ORIENT("R0");
// #X220 @PLACE(168, -985) => @ORIENT("R0");
// #X221 @PLACE(208, -985) => @ORIENT("R0");
// #X222 @PLACE(248, -985) => @ORIENT("R0");
// #X223 @PLACE(288, -985) => @ORIENT("R0");
// #X224 @PLACE(168, -1016) => @ORIENT("R0");
// #X225 @PLACE(208, -1016) => @ORIENT("R0");
// #X226 @PLACE(248, -1016) => @ORIENT("R0");
// #X227 @PLACE(288, -1016) => @ORIENT("R0");
// #X228 @PLACE(168, -1047) => @ORIENT("R0");
// #X229 @PLACE(208, -1047) => @ORIENT("R0");
// #X230 @PLACE(248, -1047) => @ORIENT("R0");
// #X231 @PLACE(288, -1047) => @ORIENT("R0");
// #X232 @PLACE(168, -1078) => @ORIENT("R0");
// #X233 @PLACE(208, -1078) => @ORIENT("R0");
// #X234 @PLACE(248, -1078) => @ORIENT("R0");
// #X235 @PLACE(288, -1078) => @ORIENT("R0");
// #X236 @PLACE(168, -1109) => @ORIENT("R0");
// #X237 @PLACE(208, -1109) => @ORIENT("R0");
// #X238 @PLACE(248, -1109) => @ORIENT("R0");
// #X239 @PLACE(288, -1109) => @ORIENT("R0");
// #X240 @PLACE(336, -954) => @ORIENT("R0");
// (320, -940) @TEXT("Panel 11 | X240 - X263", size=1.1, halign="start");
// #X241 @PLACE(376, -954) => @ORIENT("R0");
// #X242 @PLACE(416, -954) => @ORIENT("R0");
// #X243 @PLACE(456, -954) => @ORIENT("R0");
// #X244 @PLACE(336, -985) => @ORIENT("R0");
// #X245 @PLACE(376, -985) => @ORIENT("R0");
// #X246 @PLACE(416, -985) => @ORIENT("R0");
// #X247 @PLACE(456, -985) => @ORIENT("R0");
// #X248 @PLACE(336, -1016) => @ORIENT("R0");
// #X249 @PLACE(376, -1016) => @ORIENT("R0");
// #X250 @PLACE(416, -1016) => @ORIENT("R0");
// #X251 @PLACE(456, -1016) => @ORIENT("R0");
// #X252 @PLACE(336, -1047) => @ORIENT("R0");
// #X253 @PLACE(376, -1047) => @ORIENT("R0");
// #X254 @PLACE(416, -1047) => @ORIENT("R0");
// #X255 @PLACE(456, -1047) => @ORIENT("R0");
// #X256 @PLACE(336, -1078) => @ORIENT("R0");
// #X257 @PLACE(376, -1078) => @ORIENT("R0");
// #X258 @PLACE(416, -1078) => @ORIENT("R0");
// #X259 @PLACE(456, -1078) => @ORIENT("R0");
// #X260 @PLACE(336, -1109) => @ORIENT("R0");
// #X261 @PLACE(376, -1109) => @ORIENT("R0");
// #X262 @PLACE(416, -1109) => @ORIENT("R0");
// #X263 @PLACE(456, -1109) => @ORIENT("R0");
// #X264 @PLACE(504, -954) => @ORIENT("R0");
// (488, -940) @TEXT("Panel 12 | X264 - X287", size=1.1, halign="start");
// #X265 @PLACE(544, -954) => @ORIENT("R0");
// #X266 @PLACE(584, -954) => @ORIENT("R0");
// #X267 @PLACE(624, -954) => @ORIENT("R0");
// #X268 @PLACE(504, -985) => @ORIENT("R0");
// #X269 @PLACE(544, -985) => @ORIENT("R0");
// #X270 @PLACE(584, -985) => @ORIENT("R0");
// #X271 @PLACE(624, -985) => @ORIENT("R0");
// #X272 @PLACE(504, -1016) => @ORIENT("R0");
// #X273 @PLACE(544, -1016) => @ORIENT("R0");
// #X274 @PLACE(584, -1016) => @ORIENT("R0");
// #X275 @PLACE(624, -1016) => @ORIENT("R0");
// #X276 @PLACE(504, -1047) => @ORIENT("R0");
// #X277 @PLACE(544, -1047) => @ORIENT("R0");
// #X278 @PLACE(584, -1047) => @ORIENT("R0");
// #X279 @PLACE(624, -1047) => @ORIENT("R0");
// #X280 @PLACE(504, -1078) => @ORIENT("R0");
// #X281 @PLACE(544, -1078) => @ORIENT("R0");
// #X282 @PLACE(584, -1078) => @ORIENT("R0");
// #X283 @PLACE(624, -1078) => @ORIENT("R0");
// #X284 @PLACE(504, -1109) => @ORIENT("R0");
// #X285 @PLACE(544, -1109) => @ORIENT("R0");
// #X286 @PLACE(584, -1109) => @ORIENT("R0");
// #X287 @PLACE(624, -1109) => @ORIENT("R0");
// #X288 @PLACE(0, -1152) => @ORIENT("R0");
// (-25, -1138) @TEXT("Panel 13 | X288 - X311", size=1.1, halign="start");
// #X289 @PLACE(40, -1152) => @ORIENT("R0");
// #X290 @PLACE(80, -1152) => @ORIENT("R0");
// #X291 @PLACE(120, -1152) => @ORIENT("R0");
// #X292 @PLACE(0, -1183) => @ORIENT("R0");
// #X293 @PLACE(40, -1183) => @ORIENT("R0");
// #X294 @PLACE(80, -1183) => @ORIENT("R0");
// #X295 @PLACE(120, -1183) => @ORIENT("R0");
// #X296 @PLACE(0, -1214) => @ORIENT("R0");
// #X297 @PLACE(40, -1214) => @ORIENT("R0");
// #X298 @PLACE(80, -1214) => @ORIENT("R0");
// #X299 @PLACE(120, -1214) => @ORIENT("R0");
// #X300 @PLACE(0, -1245) => @ORIENT("R0");
// #X301 @PLACE(40, -1245) => @ORIENT("R0");
// #X302 @PLACE(80, -1245) => @ORIENT("R0");
// #X303 @PLACE(120, -1245) => @ORIENT("R0");
// #X304 @PLACE(0, -1276) => @ORIENT("R0");
// #X305 @PLACE(40, -1276) => @ORIENT("R0");
// #X306 @PLACE(80, -1276) => @ORIENT("R0");
// #X307 @PLACE(120, -1276) => @ORIENT("R0");
// #X308 @PLACE(0, -1307) => @ORIENT("R0");
// #X309 @PLACE(40, -1307) => @ORIENT("R0");
// #X310 @PLACE(80, -1307) => @ORIENT("R0");
// #X311 @PLACE(120, -1307) => @ORIENT("R0");
// #X312 @PLACE(168, -1152) => @ORIENT("R0");
// (152, -1138) @TEXT("Panel 14 | X312 - X335", size=1.1, halign="start");
// #X313 @PLACE(208, -1152) => @ORIENT("R0");
// #X314 @PLACE(248, -1152) => @ORIENT("R0");
// #X315 @PLACE(288, -1152) => @ORIENT("R0");
// #X316 @PLACE(168, -1183) => @ORIENT("R0");
// #X317 @PLACE(208, -1183) => @ORIENT("R0");
// #X318 @PLACE(248, -1183) => @ORIENT("R0");
// #X319 @PLACE(288, -1183) => @ORIENT("R0");
// #X320 @PLACE(168, -1214) => @ORIENT("R0");
// #X321 @PLACE(208, -1214) => @ORIENT("R0");
// #X322 @PLACE(248, -1214) => @ORIENT("R0");
// #X323 @PLACE(288, -1214) => @ORIENT("R0");
// #X324 @PLACE(168, -1245) => @ORIENT("R0");
// #X325 @PLACE(208, -1245) => @ORIENT("R0");
// #X326 @PLACE(248, -1245) => @ORIENT("R0");
// #X327 @PLACE(288, -1245) => @ORIENT("R0");
// #X328 @PLACE(168, -1276) => @ORIENT("R0");
// #X329 @PLACE(208, -1276) => @ORIENT("R0");
// #X330 @PLACE(248, -1276) => @ORIENT("R0");
// #X331 @PLACE(288, -1276) => @ORIENT("R0");
// #X332 @PLACE(168, -1307) => @ORIENT("R0");
// #X333 @PLACE(208, -1307) => @ORIENT("R0");
// #X334 @PLACE(248, -1307) => @ORIENT("R0");
// #X335 @PLACE(288, -1307) => @ORIENT("R0");
// #X336 @PLACE(336, -1152) => @ORIENT("R0");
// (320, -1138) @TEXT("Panel 15 | X336 - X359", size=1.1, halign="start");
// #X337 @PLACE(376, -1152) => @ORIENT("R0");
// #X338 @PLACE(416, -1152) => @ORIENT("R0");
// #X339 @PLACE(456, -1152) => @ORIENT("R0");
// #X340 @PLACE(336, -1183) => @ORIENT("R0");
// #X341 @PLACE(376, -1183) => @ORIENT("R0");
// #X342 @PLACE(416, -1183) => @ORIENT("R0");
// #X343 @PLACE(456, -1183) => @ORIENT("R0");
// #X344 @PLACE(336, -1214) => @ORIENT("R0");
// #X345 @PLACE(376, -1214) => @ORIENT("R0");
// #X346 @PLACE(416, -1214) => @ORIENT("R0");
// #X347 @PLACE(456, -1214) => @ORIENT("R0");
// #X348 @PLACE(336, -1245) => @ORIENT("R0");
// #X349 @PLACE(376, -1245) => @ORIENT("R0");
// #X350 @PLACE(416, -1245) => @ORIENT("R0");
// #X351 @PLACE(456, -1245) => @ORIENT("R0");
// #X352 @PLACE(336, -1276) => @ORIENT("R0");
// #X353 @PLACE(376, -1276) => @ORIENT("R0");
// #X354 @PLACE(416, -1276) => @ORIENT("R0");
// #X355 @PLACE(456, -1276) => @ORIENT("R0");
// #X356 @PLACE(336, -1307) => @ORIENT("R0");
// #X357 @PLACE(376, -1307) => @ORIENT("R0");
// #X358 @PLACE(416, -1307) => @ORIENT("R0");
// #X359 @PLACE(456, -1307) => @ORIENT("R0");
// #X360 @PLACE(504, -1152) => @ORIENT("R0");
// (488, -1138) @TEXT("Panel 16 | X360 - X383", size=1.1, halign="start");
// #X361 @PLACE(544, -1152) => @ORIENT("R0");
// #X362 @PLACE(584, -1152) => @ORIENT("R0");
// #X363 @PLACE(624, -1152) => @ORIENT("R0");
// #X364 @PLACE(504, -1183) => @ORIENT("R0");
// #X365 @PLACE(544, -1183) => @ORIENT("R0");
// #X366 @PLACE(584, -1183) => @ORIENT("R0");
// #X367 @PLACE(624, -1183) => @ORIENT("R0");
// #X368 @PLACE(504, -1214) => @ORIENT("R0");
// #X369 @PLACE(544, -1214) => @ORIENT("R0");
// #X370 @PLACE(584, -1214) => @ORIENT("R0");
// #X371 @PLACE(624, -1214) => @ORIENT("R0");
// #X372 @PLACE(504, -1245) => @ORIENT("R0");
// #X373 @PLACE(544, -1245) => @ORIENT("R0");
// #X374 @PLACE(584, -1245) => @ORIENT("R0");
// #X375 @PLACE(624, -1245) => @ORIENT("R0");
// #X376 @PLACE(504, -1276) => @ORIENT("R0");
// #X377 @PLACE(544, -1276) => @ORIENT("R0");
// #X378 @PLACE(584, -1276) => @ORIENT("R0");
// #X379 @PLACE(624, -1276) => @ORIENT("R0");
// #X380 @PLACE(504, -1307) => @ORIENT("R0");
// #X381 @PLACE(544, -1307) => @ORIENT("R0");
// #X382 @PLACE(584, -1307) => @ORIENT("R0");
// #X383 @PLACE(624, -1307) => @ORIENT("R0");
// #X384 @PLACE(0, -1350) => @ORIENT("R0");
// (-25, -1336) @TEXT("Panel 17 | X384 - X407", size=1.1, halign="start");
// #X385 @PLACE(40, -1350) => @ORIENT("R0");
// #X386 @PLACE(80, -1350) => @ORIENT("R0");
// #X387 @PLACE(120, -1350) => @ORIENT("R0");
// #X388 @PLACE(0, -1381) => @ORIENT("R0");
// #X389 @PLACE(40, -1381) => @ORIENT("R0");
// #X390 @PLACE(80, -1381) => @ORIENT("R0");
// #X391 @PLACE(120, -1381) => @ORIENT("R0");
// #X392 @PLACE(0, -1412) => @ORIENT("R0");
// #X393 @PLACE(40, -1412) => @ORIENT("R0");
// #X394 @PLACE(80, -1412) => @ORIENT("R0");
// #X395 @PLACE(120, -1412) => @ORIENT("R0");
// #X396 @PLACE(0, -1443) => @ORIENT("R0");
// #X397 @PLACE(40, -1443) => @ORIENT("R0");
// #X398 @PLACE(80, -1443) => @ORIENT("R0");
// #X399 @PLACE(120, -1443) => @ORIENT("R0");
// #X400 @PLACE(0, -1474) => @ORIENT("R0");
// #X401 @PLACE(40, -1474) => @ORIENT("R0");
// #X402 @PLACE(80, -1474) => @ORIENT("R0");
// #X403 @PLACE(120, -1474) => @ORIENT("R0");
// #X404 @PLACE(0, -1505) => @ORIENT("R0");
// #X405 @PLACE(40, -1505) => @ORIENT("R0");
// #X406 @PLACE(80, -1505) => @ORIENT("R0");
// #X407 @PLACE(120, -1505) => @ORIENT("R0");
// #X408 @PLACE(168, -1350) => @ORIENT("R0");
// (152, -1336) @TEXT("Panel 18 | X408 - X431", size=1.1, halign="start");
// #X409 @PLACE(208, -1350) => @ORIENT("R0");
// #X410 @PLACE(248, -1350) => @ORIENT("R0");
// #X411 @PLACE(288, -1350) => @ORIENT("R0");
// #X412 @PLACE(168, -1381) => @ORIENT("R0");
// #X413 @PLACE(208, -1381) => @ORIENT("R0");
// #X414 @PLACE(248, -1381) => @ORIENT("R0");
// #X415 @PLACE(288, -1381) => @ORIENT("R0");
// #X416 @PLACE(168, -1412) => @ORIENT("R0");
// #X417 @PLACE(208, -1412) => @ORIENT("R0");
// #X418 @PLACE(248, -1412) => @ORIENT("R0");
// #X419 @PLACE(288, -1412) => @ORIENT("R0");
// #X420 @PLACE(168, -1443) => @ORIENT("R0");
// #X421 @PLACE(208, -1443) => @ORIENT("R0");
// #X422 @PLACE(248, -1443) => @ORIENT("R0");
// #X423 @PLACE(288, -1443) => @ORIENT("R0");
// #X424 @PLACE(168, -1474) => @ORIENT("R0");
// #X425 @PLACE(208, -1474) => @ORIENT("R0");
// #X426 @PLACE(248, -1474) => @ORIENT("R0");
// #X427 @PLACE(288, -1474) => @ORIENT("R0");
// #X428 @PLACE(168, -1505) => @ORIENT("R0");
// #X429 @PLACE(208, -1505) => @ORIENT("R0");
// #X430 @PLACE(248, -1505) => @ORIENT("R0");
// #X431 @PLACE(288, -1505) => @ORIENT("R0");
// #X432 @PLACE(336, -1350) => @ORIENT("R0");
// (320, -1336) @TEXT("Panel 19 | X432 - X455", size=1.1, halign="start");
// #X433 @PLACE(376, -1350) => @ORIENT("R0");
// #X434 @PLACE(416, -1350) => @ORIENT("R0");
// #X435 @PLACE(456, -1350) => @ORIENT("R0");
// #X436 @PLACE(336, -1381) => @ORIENT("R0");
// #X437 @PLACE(376, -1381) => @ORIENT("R0");
// #X438 @PLACE(416, -1381) => @ORIENT("R0");
// #X439 @PLACE(456, -1381) => @ORIENT("R0");
// #X440 @PLACE(336, -1412) => @ORIENT("R0");
// #X441 @PLACE(376, -1412) => @ORIENT("R0");
// #X442 @PLACE(416, -1412) => @ORIENT("R0");
// #X443 @PLACE(456, -1412) => @ORIENT("R0");
// #X444 @PLACE(336, -1443) => @ORIENT("R0");
// #X445 @PLACE(376, -1443) => @ORIENT("R0");
// #X446 @PLACE(416, -1443) => @ORIENT("R0");
// #X447 @PLACE(456, -1443) => @ORIENT("R0");
// #X448 @PLACE(336, -1474) => @ORIENT("R0");
// #X449 @PLACE(376, -1474) => @ORIENT("R0");
// #X450 @PLACE(416, -1474) => @ORIENT("R0");
// #X451 @PLACE(456, -1474) => @ORIENT("R0");
// #X452 @PLACE(336, -1505) => @ORIENT("R0");
// #X453 @PLACE(376, -1505) => @ORIENT("R0");
// #X454 @PLACE(416, -1505) => @ORIENT("R0");
// #X455 @PLACE(456, -1505) => @ORIENT("R0");
// #X456 @PLACE(504, -1350) => @ORIENT("R0");
// (488, -1336) @TEXT("Panel 20 | X456 - X479", size=1.1, halign="start");
// #X457 @PLACE(544, -1350) => @ORIENT("R0");
// #X458 @PLACE(584, -1350) => @ORIENT("R0");
// #X459 @PLACE(624, -1350) => @ORIENT("R0");
// #X460 @PLACE(504, -1381) => @ORIENT("R0");
// #X461 @PLACE(544, -1381) => @ORIENT("R0");
// #X462 @PLACE(584, -1381) => @ORIENT("R0");
// #X463 @PLACE(624, -1381) => @ORIENT("R0");
// #X464 @PLACE(504, -1412) => @ORIENT("R0");
// #X465 @PLACE(544, -1412) => @ORIENT("R0");
// #X466 @PLACE(584, -1412) => @ORIENT("R0");
// #X467 @PLACE(624, -1412) => @ORIENT("R0");
// #X468 @PLACE(504, -1443) => @ORIENT("R0");
// #X469 @PLACE(544, -1443) => @ORIENT("R0");
// #X470 @PLACE(584, -1443) => @ORIENT("R0");
// #X471 @PLACE(624, -1443) => @ORIENT("R0");
// #X472 @PLACE(504, -1474) => @ORIENT("R0");
// #X473 @PLACE(544, -1474) => @ORIENT("R0");
// #X474 @PLACE(584, -1474) => @ORIENT("R0");
// #X475 @PLACE(624, -1474) => @ORIENT("R0");
// #X476 @PLACE(504, -1505) => @ORIENT("R0");
// #X477 @PLACE(544, -1505) => @ORIENT("R0");
// #X478 @PLACE(584, -1505) => @ORIENT("R0");
// #X479 @PLACE(624, -1505) => @ORIENT("R0");
// #X480 @PLACE(0, -1548) => @ORIENT("R0");
// (-25, -1534) @TEXT("Panel 21 | X480 - X503", size=1.1, halign="start");
// #X481 @PLACE(40, -1548) => @ORIENT("R0");
// #X482 @PLACE(80, -1548) => @ORIENT("R0");
// #X483 @PLACE(120, -1548) => @ORIENT("R0");
// #X484 @PLACE(0, -1579) => @ORIENT("R0");
// #X485 @PLACE(40, -1579) => @ORIENT("R0");
// #X486 @PLACE(80, -1579) => @ORIENT("R0");
// #X487 @PLACE(120, -1579) => @ORIENT("R0");
// #X488 @PLACE(0, -1610) => @ORIENT("R0");
// #X489 @PLACE(40, -1610) => @ORIENT("R0");
// #X490 @PLACE(80, -1610) => @ORIENT("R0");
// #X491 @PLACE(120, -1610) => @ORIENT("R0");
// #X492 @PLACE(0, -1641) => @ORIENT("R0");
// #X493 @PLACE(40, -1641) => @ORIENT("R0");
// #X494 @PLACE(80, -1641) => @ORIENT("R0");
// #X495 @PLACE(120, -1641) => @ORIENT("R0");
// #X496 @PLACE(0, -1672) => @ORIENT("R0");
// #X497 @PLACE(40, -1672) => @ORIENT("R0");
// #X498 @PLACE(80, -1672) => @ORIENT("R0");
// #X499 @PLACE(120, -1672) => @ORIENT("R0");
// #X500 @PLACE(0, -1703) => @ORIENT("R0");
// #X501 @PLACE(40, -1703) => @ORIENT("R0");
// #X502 @PLACE(80, -1703) => @ORIENT("R0");
// #X503 @PLACE(120, -1703) => @ORIENT("R0");
// #X504 @PLACE(168, -1548) => @ORIENT("R0");
// (152, -1534) @TEXT("Panel 22 | X504 - X527", size=1.1, halign="start");
// #X505 @PLACE(208, -1548) => @ORIENT("R0");
// #X506 @PLACE(248, -1548) => @ORIENT("R0");
// #X507 @PLACE(288, -1548) => @ORIENT("R0");
// #X508 @PLACE(168, -1579) => @ORIENT("R0");
// #X509 @PLACE(208, -1579) => @ORIENT("R0");
// #X510 @PLACE(248, -1579) => @ORIENT("R0");
// #X511 @PLACE(288, -1579) => @ORIENT("R0");
// #X512 @PLACE(168, -1610) => @ORIENT("R0");
// #X513 @PLACE(208, -1610) => @ORIENT("R0");
// #X514 @PLACE(248, -1610) => @ORIENT("R0");
// #X515 @PLACE(288, -1610) => @ORIENT("R0");
// #X516 @PLACE(168, -1641) => @ORIENT("R0");
// #X517 @PLACE(208, -1641) => @ORIENT("R0");
// #X518 @PLACE(248, -1641) => @ORIENT("R0");
// #X519 @PLACE(288, -1641) => @ORIENT("R0");
// #X520 @PLACE(168, -1672) => @ORIENT("R0");
// #X521 @PLACE(208, -1672) => @ORIENT("R0");
// #X522 @PLACE(248, -1672) => @ORIENT("R0");
// #X523 @PLACE(288, -1672) => @ORIENT("R0");
// #X524 @PLACE(168, -1703) => @ORIENT("R0");
// #X525 @PLACE(208, -1703) => @ORIENT("R0");
// #X526 @PLACE(248, -1703) => @ORIENT("R0");
// #X527 @PLACE(288, -1703) => @ORIENT("R0");
// #X528 @PLACE(336, -1548) => @ORIENT("R0");
// (320, -1534) @TEXT("Panel 23 | X528 - X551", size=1.1, halign="start");
// #X529 @PLACE(376, -1548) => @ORIENT("R0");
// #X530 @PLACE(416, -1548) => @ORIENT("R0");
// #X531 @PLACE(456, -1548) => @ORIENT("R0");
// #X532 @PLACE(336, -1579) => @ORIENT("R0");
// #X533 @PLACE(376, -1579) => @ORIENT("R0");
// #X534 @PLACE(416, -1579) => @ORIENT("R0");
// #X535 @PLACE(456, -1579) => @ORIENT("R0");
// #X536 @PLACE(336, -1610) => @ORIENT("R0");
// #X537 @PLACE(376, -1610) => @ORIENT("R0");
// #X538 @PLACE(416, -1610) => @ORIENT("R0");
// #X539 @PLACE(456, -1610) => @ORIENT("R0");
// #X540 @PLACE(336, -1641) => @ORIENT("R0");
// #X541 @PLACE(376, -1641) => @ORIENT("R0");
// #X542 @PLACE(416, -1641) => @ORIENT("R0");
// #X543 @PLACE(456, -1641) => @ORIENT("R0");
// #X544 @PLACE(336, -1672) => @ORIENT("R0");
// #X545 @PLACE(376, -1672) => @ORIENT("R0");
// #X546 @PLACE(416, -1672) => @ORIENT("R0");
// #X547 @PLACE(456, -1672) => @ORIENT("R0");
// #X548 @PLACE(336, -1703) => @ORIENT("R0");
// #X549 @PLACE(376, -1703) => @ORIENT("R0");
// #X550 @PLACE(416, -1703) => @ORIENT("R0");
// #X551 @PLACE(456, -1703) => @ORIENT("R0");
// #X552 @PLACE(504, -1548) => @ORIENT("R0");
// (488, -1534) @TEXT("Panel 24 | X552 - X575", size=1.1, halign="start");
// #X553 @PLACE(544, -1548) => @ORIENT("R0");
// #X554 @PLACE(584, -1548) => @ORIENT("R0");
// #X555 @PLACE(624, -1548) => @ORIENT("R0");
// #X556 @PLACE(504, -1579) => @ORIENT("R0");
// #X557 @PLACE(544, -1579) => @ORIENT("R0");
// #X558 @PLACE(584, -1579) => @ORIENT("R0");
// #X559 @PLACE(624, -1579) => @ORIENT("R0");
// #X560 @PLACE(504, -1610) => @ORIENT("R0");
// #X561 @PLACE(544, -1610) => @ORIENT("R0");
// #X562 @PLACE(584, -1610) => @ORIENT("R0");
// #X563 @PLACE(624, -1610) => @ORIENT("R0");
// #X564 @PLACE(504, -1641) => @ORIENT("R0");
// #X565 @PLACE(544, -1641) => @ORIENT("R0");
// #X566 @PLACE(584, -1641) => @ORIENT("R0");
// #X567 @PLACE(624, -1641) => @ORIENT("R0");
// #X568 @PLACE(504, -1672) => @ORIENT("R0");
// #X569 @PLACE(544, -1672) => @ORIENT("R0");
// #X570 @PLACE(584, -1672) => @ORIENT("R0");
// #X571 @PLACE(624, -1672) => @ORIENT("R0");
// #X572 @PLACE(504, -1703) => @ORIENT("R0");
// #X573 @PLACE(544, -1703) => @ORIENT("R0");
// #X574 @PLACE(584, -1703) => @ORIENT("R0");
// #X575 @PLACE(624, -1703) => @ORIENT("R0");
// #X576 @PLACE(0, -1746) => @ORIENT("R0");
// (-25, -1732) @TEXT("Panel 25 | X576 - X599", size=1.1, halign="start");
// #X577 @PLACE(40, -1746) => @ORIENT("R0");
// #X578 @PLACE(80, -1746) => @ORIENT("R0");
// #X579 @PLACE(120, -1746) => @ORIENT("R0");
// #X580 @PLACE(0, -1777) => @ORIENT("R0");
// #X581 @PLACE(40, -1777) => @ORIENT("R0");
// #X582 @PLACE(80, -1777) => @ORIENT("R0");
// #X583 @PLACE(120, -1777) => @ORIENT("R0");
// #X584 @PLACE(0, -1808) => @ORIENT("R0");
// #X585 @PLACE(40, -1808) => @ORIENT("R0");
// #X586 @PLACE(80, -1808) => @ORIENT("R0");
// #X587 @PLACE(120, -1808) => @ORIENT("R0");
// #X588 @PLACE(0, -1839) => @ORIENT("R0");
// #X589 @PLACE(40, -1839) => @ORIENT("R0");
// #X590 @PLACE(80, -1839) => @ORIENT("R0");
// #X591 @PLACE(120, -1839) => @ORIENT("R0");
// #X592 @PLACE(0, -1870) => @ORIENT("R0");
// #X593 @PLACE(40, -1870) => @ORIENT("R0");
// #X594 @PLACE(80, -1870) => @ORIENT("R0");
// #X595 @PLACE(120, -1870) => @ORIENT("R0");
// #X596 @PLACE(0, -1901) => @ORIENT("R0");
// #X597 @PLACE(40, -1901) => @ORIENT("R0");
// #X598 @PLACE(80, -1901) => @ORIENT("R0");
// #X599 @PLACE(120, -1901) => @ORIENT("R0");
// #X600 @PLACE(168, -1746) => @ORIENT("R0");
// (152, -1732) @TEXT("Panel 26 | X600 - X623", size=1.1, halign="start");
// #X601 @PLACE(208, -1746) => @ORIENT("R0");
// #X602 @PLACE(248, -1746) => @ORIENT("R0");
// #X603 @PLACE(288, -1746) => @ORIENT("R0");
// #X604 @PLACE(168, -1777) => @ORIENT("R0");
// #X605 @PLACE(208, -1777) => @ORIENT("R0");
// #X606 @PLACE(248, -1777) => @ORIENT("R0");
// #X607 @PLACE(288, -1777) => @ORIENT("R0");
// #X608 @PLACE(168, -1808) => @ORIENT("R0");
// #X609 @PLACE(208, -1808) => @ORIENT("R0");
// #X610 @PLACE(248, -1808) => @ORIENT("R0");
// #X611 @PLACE(288, -1808) => @ORIENT("R0");
// #X612 @PLACE(168, -1839) => @ORIENT("R0");
// #X613 @PLACE(208, -1839) => @ORIENT("R0");
// #X614 @PLACE(248, -1839) => @ORIENT("R0");
// #X615 @PLACE(288, -1839) => @ORIENT("R0");
// #X616 @PLACE(168, -1870) => @ORIENT("R0");
// #X617 @PLACE(208, -1870) => @ORIENT("R0");
// #X618 @PLACE(248, -1870) => @ORIENT("R0");
// #X619 @PLACE(288, -1870) => @ORIENT("R0");
// #X620 @PLACE(168, -1901) => @ORIENT("R0");
// #X621 @PLACE(208, -1901) => @ORIENT("R0");
// #X622 @PLACE(248, -1901) => @ORIENT("R0");
// #X623 @PLACE(288, -1901) => @ORIENT("R0");
// #X624 @PLACE(336, -1746) => @ORIENT("R0");
// (320, -1732) @TEXT("Panel 27 | X624 - X647", size=1.1, halign="start");
// #X625 @PLACE(376, -1746) => @ORIENT("R0");
// #X626 @PLACE(416, -1746) => @ORIENT("R0");
// #X627 @PLACE(456, -1746) => @ORIENT("R0");
// #X628 @PLACE(336, -1777) => @ORIENT("R0");
// #X629 @PLACE(376, -1777) => @ORIENT("R0");
// #X630 @PLACE(416, -1777) => @ORIENT("R0");
// #X631 @PLACE(456, -1777) => @ORIENT("R0");
// #X632 @PLACE(336, -1808) => @ORIENT("R0");
// #X633 @PLACE(376, -1808) => @ORIENT("R0");
// #X634 @PLACE(416, -1808) => @ORIENT("R0");
// #X635 @PLACE(456, -1808) => @ORIENT("R0");
// #X636 @PLACE(336, -1839) => @ORIENT("R0");
// #X637 @PLACE(376, -1839) => @ORIENT("R0");
// #X638 @PLACE(416, -1839) => @ORIENT("R0");
// #X639 @PLACE(456, -1839) => @ORIENT("R0");
// #X640 @PLACE(336, -1870) => @ORIENT("R0");
// #X641 @PLACE(376, -1870) => @ORIENT("R0");
// #X642 @PLACE(416, -1870) => @ORIENT("R0");
// #X643 @PLACE(456, -1870) => @ORIENT("R0");
// #X644 @PLACE(336, -1901) => @ORIENT("R0");
// #X645 @PLACE(376, -1901) => @ORIENT("R0");
// #X646 @PLACE(416, -1901) => @ORIENT("R0");
// #X647 @PLACE(456, -1901) => @ORIENT("R0");
// #X648 @PLACE(504, -1746) => @ORIENT("R0");
// (488, -1732) @TEXT("Panel 28 | X648 - X671", size=1.1, halign="start");
// #X649 @PLACE(544, -1746) => @ORIENT("R0");
// #X650 @PLACE(584, -1746) => @ORIENT("R0");
// #X651 @PLACE(624, -1746) => @ORIENT("R0");
// #X652 @PLACE(504, -1777) => @ORIENT("R0");
// #X653 @PLACE(544, -1777) => @ORIENT("R0");
// #X654 @PLACE(584, -1777) => @ORIENT("R0");
// #X655 @PLACE(624, -1777) => @ORIENT("R0");
// #X656 @PLACE(504, -1808) => @ORIENT("R0");
// #X657 @PLACE(544, -1808) => @ORIENT("R0");
// #X658 @PLACE(584, -1808) => @ORIENT("R0");
// #X659 @PLACE(624, -1808) => @ORIENT("R0");
// #X660 @PLACE(504, -1839) => @ORIENT("R0");
// #X661 @PLACE(544, -1839) => @ORIENT("R0");
// #X662 @PLACE(584, -1839) => @ORIENT("R0");
// #X663 @PLACE(624, -1839) => @ORIENT("R0");
// #X664 @PLACE(504, -1870) => @ORIENT("R0");
// #X665 @PLACE(544, -1870) => @ORIENT("R0");
// #X666 @PLACE(584, -1870) => @ORIENT("R0");
// #X667 @PLACE(624, -1870) => @ORIENT("R0");
// #X668 @PLACE(504, -1901) => @ORIENT("R0");
// #X669 @PLACE(544, -1901) => @ORIENT("R0");
// #X670 @PLACE(584, -1901) => @ORIENT("R0");
// #X671 @PLACE(624, -1901) => @ORIENT("R0");
// #X672 @PLACE(0, -1944) => @ORIENT("R0");
// (-25, -1930) @TEXT("Panel 29 | X672 - X695", size=1.1, halign="start");
// #X673 @PLACE(40, -1944) => @ORIENT("R0");
// #X674 @PLACE(80, -1944) => @ORIENT("R0");
// #X675 @PLACE(120, -1944) => @ORIENT("R0");
// #X676 @PLACE(0, -1975) => @ORIENT("R0");
// #X677 @PLACE(40, -1975) => @ORIENT("R0");
// #X678 @PLACE(80, -1975) => @ORIENT("R0");
// #X679 @PLACE(120, -1975) => @ORIENT("R0");
// #X680 @PLACE(0, -2006) => @ORIENT("R0");
// #X681 @PLACE(40, -2006) => @ORIENT("R0");
// #X682 @PLACE(80, -2006) => @ORIENT("R0");
// #X683 @PLACE(120, -2006) => @ORIENT("R0");
// #X684 @PLACE(0, -2037) => @ORIENT("R0");
// #X685 @PLACE(40, -2037) => @ORIENT("R0");
// #X686 @PLACE(80, -2037) => @ORIENT("R0");
// #X687 @PLACE(120, -2037) => @ORIENT("R0");
// #X688 @PLACE(0, -2068) => @ORIENT("R0");
// #X689 @PLACE(40, -2068) => @ORIENT("R0");
// #X690 @PLACE(80, -2068) => @ORIENT("R0");
// #X691 @PLACE(120, -2068) => @ORIENT("R0");
// #X692 @PLACE(0, -2099) => @ORIENT("R0");
// #X693 @PLACE(40, -2099) => @ORIENT("R0");
// #X694 @PLACE(80, -2099) => @ORIENT("R0");
// #X695 @PLACE(120, -2099) => @ORIENT("R0");
// #X696 @PLACE(168, -1944) => @ORIENT("R0");
// (152, -1930) @TEXT("Panel 30 | X696 - X719", size=1.1, halign="start");
// #X697 @PLACE(208, -1944) => @ORIENT("R0");
// #X698 @PLACE(248, -1944) => @ORIENT("R0");
// #X699 @PLACE(288, -1944) => @ORIENT("R0");
// #X700 @PLACE(168, -1975) => @ORIENT("R0");
// #X701 @PLACE(208, -1975) => @ORIENT("R0");
// #X702 @PLACE(248, -1975) => @ORIENT("R0");
// #X703 @PLACE(288, -1975) => @ORIENT("R0");
// #X704 @PLACE(168, -2006) => @ORIENT("R0");
// #X705 @PLACE(208, -2006) => @ORIENT("R0");
// #X706 @PLACE(248, -2006) => @ORIENT("R0");
// #X707 @PLACE(288, -2006) => @ORIENT("R0");
// #X708 @PLACE(168, -2037) => @ORIENT("R0");
// #X709 @PLACE(208, -2037) => @ORIENT("R0");
// #X710 @PLACE(248, -2037) => @ORIENT("R0");
// #X711 @PLACE(288, -2037) => @ORIENT("R0");
// #X712 @PLACE(168, -2068) => @ORIENT("R0");
// #X713 @PLACE(208, -2068) => @ORIENT("R0");
// #X714 @PLACE(248, -2068) => @ORIENT("R0");
// #X715 @PLACE(288, -2068) => @ORIENT("R0");
// #X716 @PLACE(168, -2099) => @ORIENT("R0");
// #X717 @PLACE(208, -2099) => @ORIENT("R0");
// #X718 @PLACE(248, -2099) => @ORIENT("R0");
// #X719 @PLACE(288, -2099) => @ORIENT("R0");
// #X720 @PLACE(336, -1944) => @ORIENT("R0");
// (320, -1930) @TEXT("Panel 31 | X720 - X743", size=1.1, halign="start");
// #X721 @PLACE(376, -1944) => @ORIENT("R0");
// #X722 @PLACE(416, -1944) => @ORIENT("R0");
// #X723 @PLACE(456, -1944) => @ORIENT("R0");
// #X724 @PLACE(336, -1975) => @ORIENT("R0");
// #X725 @PLACE(376, -1975) => @ORIENT("R0");
// #X726 @PLACE(416, -1975) => @ORIENT("R0");
// #X727 @PLACE(456, -1975) => @ORIENT("R0");
// #X728 @PLACE(336, -2006) => @ORIENT("R0");
// #X729 @PLACE(376, -2006) => @ORIENT("R0");
// #X730 @PLACE(416, -2006) => @ORIENT("R0");
// #X731 @PLACE(456, -2006) => @ORIENT("R0");
// #X732 @PLACE(336, -2037) => @ORIENT("R0");
// #X733 @PLACE(376, -2037) => @ORIENT("R0");
// #X734 @PLACE(416, -2037) => @ORIENT("R0");
// #X735 @PLACE(456, -2037) => @ORIENT("R0");
// #X736 @PLACE(336, -2068) => @ORIENT("R0");
// #X737 @PLACE(376, -2068) => @ORIENT("R0");
// #X738 @PLACE(416, -2068) => @ORIENT("R0");
// #X739 @PLACE(456, -2068) => @ORIENT("R0");
// #X740 @PLACE(336, -2099) => @ORIENT("R0");
// #X741 @PLACE(376, -2099) => @ORIENT("R0");
// #X742 @PLACE(416, -2099) => @ORIENT("R0");
// #X743 @PLACE(456, -2099) => @ORIENT("R0");
// #X744 @PLACE(504, -1944) => @ORIENT("R0");
// (488, -1930) @TEXT("Panel 32 | X744 - X767", size=1.1, halign="start");
// #X745 @PLACE(544, -1944) => @ORIENT("R0");
// #X746 @PLACE(584, -1944) => @ORIENT("R0");
// #X747 @PLACE(624, -1944) => @ORIENT("R0");
// #X748 @PLACE(504, -1975) => @ORIENT("R0");
// #X749 @PLACE(544, -1975) => @ORIENT("R0");
// #X750 @PLACE(584, -1975) => @ORIENT("R0");
// #X751 @PLACE(624, -1975) => @ORIENT("R0");
// #X752 @PLACE(504, -2006) => @ORIENT("R0");
// #X753 @PLACE(544, -2006) => @ORIENT("R0");
// #X754 @PLACE(584, -2006) => @ORIENT("R0");
// #X755 @PLACE(624, -2006) => @ORIENT("R0");
// #X756 @PLACE(504, -2037) => @ORIENT("R0");
// #X757 @PLACE(544, -2037) => @ORIENT("R0");
// #X758 @PLACE(584, -2037) => @ORIENT("R0");
// #X759 @PLACE(624, -2037) => @ORIENT("R0");
// #X760 @PLACE(504, -2068) => @ORIENT("R0");
// #X761 @PLACE(544, -2068) => @ORIENT("R0");
// #X762 @PLACE(584, -2068) => @ORIENT("R0");
// #X763 @PLACE(624, -2068) => @ORIENT("R0");
// #X764 @PLACE(504, -2099) => @ORIENT("R0");
// #X765 @PLACE(544, -2099) => @ORIENT("R0");
// #X766 @PLACE(584, -2099) => @ORIENT("R0");
// #X767 @PLACE(624, -2099) => @ORIENT("R0");
// #X768 @PLACE(0, -2142) => @ORIENT("R0");
// (-25, -2128) @TEXT("Panel 33 | X768 - X791", size=1.1, halign="start");
// #X769 @PLACE(40, -2142) => @ORIENT("R0");
// #X770 @PLACE(80, -2142) => @ORIENT("R0");
// #X771 @PLACE(120, -2142) => @ORIENT("R0");
// #X772 @PLACE(0, -2173) => @ORIENT("R0");
// #X773 @PLACE(40, -2173) => @ORIENT("R0");
// #X774 @PLACE(80, -2173) => @ORIENT("R0");
// #X775 @PLACE(120, -2173) => @ORIENT("R0");
// #X776 @PLACE(0, -2204) => @ORIENT("R0");
// #X777 @PLACE(40, -2204) => @ORIENT("R0");
// #X778 @PLACE(80, -2204) => @ORIENT("R0");
// #X779 @PLACE(120, -2204) => @ORIENT("R0");
// #X780 @PLACE(0, -2235) => @ORIENT("R0");
// #X781 @PLACE(40, -2235) => @ORIENT("R0");
// #X782 @PLACE(80, -2235) => @ORIENT("R0");
// #X783 @PLACE(120, -2235) => @ORIENT("R0");
// #X784 @PLACE(0, -2266) => @ORIENT("R0");
// #X785 @PLACE(40, -2266) => @ORIENT("R0");
// #X786 @PLACE(80, -2266) => @ORIENT("R0");
// #X787 @PLACE(120, -2266) => @ORIENT("R0");
// #X788 @PLACE(0, -2297) => @ORIENT("R0");
// #X789 @PLACE(40, -2297) => @ORIENT("R0");
// #X790 @PLACE(80, -2297) => @ORIENT("R0");
// #X791 @PLACE(120, -2297) => @ORIENT("R0");
// #X792 @PLACE(168, -2142) => @ORIENT("R0");
// (152, -2128) @TEXT("Panel 34 | X792 - X815", size=1.1, halign="start");
// #X793 @PLACE(208, -2142) => @ORIENT("R0");
// #X794 @PLACE(248, -2142) => @ORIENT("R0");
// #X795 @PLACE(288, -2142) => @ORIENT("R0");
// #X796 @PLACE(168, -2173) => @ORIENT("R0");
// #X797 @PLACE(208, -2173) => @ORIENT("R0");
// #X798 @PLACE(248, -2173) => @ORIENT("R0");
// #X799 @PLACE(288, -2173) => @ORIENT("R0");
// #X800 @PLACE(168, -2204) => @ORIENT("R0");
// #X801 @PLACE(208, -2204) => @ORIENT("R0");
// #X802 @PLACE(248, -2204) => @ORIENT("R0");
// #X803 @PLACE(288, -2204) => @ORIENT("R0");
// #X804 @PLACE(168, -2235) => @ORIENT("R0");
// #X805 @PLACE(208, -2235) => @ORIENT("R0");
// #X806 @PLACE(248, -2235) => @ORIENT("R0");
// #X807 @PLACE(288, -2235) => @ORIENT("R0");
// #X808 @PLACE(168, -2266) => @ORIENT("R0");
// #X809 @PLACE(208, -2266) => @ORIENT("R0");
// #X810 @PLACE(248, -2266) => @ORIENT("R0");
// #X811 @PLACE(288, -2266) => @ORIENT("R0");
// #X812 @PLACE(168, -2297) => @ORIENT("R0");
// #X813 @PLACE(208, -2297) => @ORIENT("R0");
// #X814 @PLACE(248, -2297) => @ORIENT("R0");
// #X815 @PLACE(288, -2297) => @ORIENT("R0");
// #X816 @PLACE(336, -2142) => @ORIENT("R0");
// (320, -2128) @TEXT("Panel 35 | X816 - X839", size=1.1, halign="start");
// #X817 @PLACE(376, -2142) => @ORIENT("R0");
// #X818 @PLACE(416, -2142) => @ORIENT("R0");
// #X819 @PLACE(456, -2142) => @ORIENT("R0");
// #X820 @PLACE(336, -2173) => @ORIENT("R0");
// #X821 @PLACE(376, -2173) => @ORIENT("R0");
// #X822 @PLACE(416, -2173) => @ORIENT("R0");
// #X823 @PLACE(456, -2173) => @ORIENT("R0");
// #X824 @PLACE(336, -2204) => @ORIENT("R0");
// #X825 @PLACE(376, -2204) => @ORIENT("R0");
// #X826 @PLACE(416, -2204) => @ORIENT("R0");
// #X827 @PLACE(456, -2204) => @ORIENT("R0");
// #X828 @PLACE(336, -2235) => @ORIENT("R0");
// #X829 @PLACE(376, -2235) => @ORIENT("R0");
// #X830 @PLACE(416, -2235) => @ORIENT("R0");
// #X831 @PLACE(456, -2235) => @ORIENT("R0");
// #X832 @PLACE(336, -2266) => @ORIENT("R0");
// #X833 @PLACE(376, -2266) => @ORIENT("R0");
// #X834 @PLACE(416, -2266) => @ORIENT("R0");
// #X835 @PLACE(456, -2266) => @ORIENT("R0");
// #X836 @PLACE(336, -2297) => @ORIENT("R0");
// #X837 @PLACE(376, -2297) => @ORIENT("R0");
// #X838 @PLACE(416, -2297) => @ORIENT("R0");
// #X839 @PLACE(456, -2297) => @ORIENT("R0");
// #X840 @PLACE(504, -2142) => @ORIENT("R0");
// (488, -2128) @TEXT("Panel 36 | X840 - X863", size=1.1, halign="start");
// #X841 @PLACE(544, -2142) => @ORIENT("R0");
// #X842 @PLACE(584, -2142) => @ORIENT("R0");
// #X843 @PLACE(624, -2142) => @ORIENT("R0");
// #X844 @PLACE(504, -2173) => @ORIENT("R0");
// #X845 @PLACE(544, -2173) => @ORIENT("R0");
// #X846 @PLACE(584, -2173) => @ORIENT("R0");
// #X847 @PLACE(624, -2173) => @ORIENT("R0");
// #X848 @PLACE(504, -2204) => @ORIENT("R0");
// #X849 @PLACE(544, -2204) => @ORIENT("R0");
// #X850 @PLACE(584, -2204) => @ORIENT("R0");
// #X851 @PLACE(624, -2204) => @ORIENT("R0");
// #X852 @PLACE(504, -2235) => @ORIENT("R0");
// #X853 @PLACE(544, -2235) => @ORIENT("R0");
// #X854 @PLACE(584, -2235) => @ORIENT("R0");
// #X855 @PLACE(624, -2235) => @ORIENT("R0");
// #X856 @PLACE(504, -2266) => @ORIENT("R0");
// #X857 @PLACE(544, -2266) => @ORIENT("R0");
// #X858 @PLACE(584, -2266) => @ORIENT("R0");
// #X859 @PLACE(624, -2266) => @ORIENT("R0");
// #X860 @PLACE(504, -2297) => @ORIENT("R0");
// #X861 @PLACE(544, -2297) => @ORIENT("R0");
// #X862 @PLACE(584, -2297) => @ORIENT("R0");
// #X863 @PLACE(624, -2297) => @ORIENT("R0");
// #X864 @PLACE(0, -2340) => @ORIENT("R0");
// (-25, -2326) @TEXT("Panel 37 | X864 - X887", size=1.1, halign="start");
// #X865 @PLACE(40, -2340) => @ORIENT("R0");
// #X866 @PLACE(80, -2340) => @ORIENT("R0");
// #X867 @PLACE(120, -2340) => @ORIENT("R0");
// #X868 @PLACE(0, -2371) => @ORIENT("R0");
// #X869 @PLACE(40, -2371) => @ORIENT("R0");
// #X870 @PLACE(80, -2371) => @ORIENT("R0");
// #X871 @PLACE(120, -2371) => @ORIENT("R0");
// #X872 @PLACE(0, -2402) => @ORIENT("R0");
// #X873 @PLACE(40, -2402) => @ORIENT("R0");
// #X874 @PLACE(80, -2402) => @ORIENT("R0");
// #X875 @PLACE(120, -2402) => @ORIENT("R0");
// #X876 @PLACE(0, -2433) => @ORIENT("R0");
// #X877 @PLACE(40, -2433) => @ORIENT("R0");
// #X878 @PLACE(80, -2433) => @ORIENT("R0");
// #X879 @PLACE(120, -2433) => @ORIENT("R0");
// #X880 @PLACE(0, -2464) => @ORIENT("R0");
// #X881 @PLACE(40, -2464) => @ORIENT("R0");
// #X882 @PLACE(80, -2464) => @ORIENT("R0");
// #X883 @PLACE(120, -2464) => @ORIENT("R0");
// #X884 @PLACE(0, -2495) => @ORIENT("R0");
// #X885 @PLACE(40, -2495) => @ORIENT("R0");
// #X886 @PLACE(80, -2495) => @ORIENT("R0");
// #X887 @PLACE(120, -2495) => @ORIENT("R0");
// #X888 @PLACE(168, -2340) => @ORIENT("R0");
// (152, -2326) @TEXT("Panel 38 | X888 - X911", size=1.1, halign="start");
// #X889 @PLACE(208, -2340) => @ORIENT("R0");
// #X890 @PLACE(248, -2340) => @ORIENT("R0");
// #X891 @PLACE(288, -2340) => @ORIENT("R0");
// #X892 @PLACE(168, -2371) => @ORIENT("R0");
// #X893 @PLACE(208, -2371) => @ORIENT("R0");
// #X894 @PLACE(248, -2371) => @ORIENT("R0");
// #X895 @PLACE(288, -2371) => @ORIENT("R0");
// #X896 @PLACE(168, -2402) => @ORIENT("R0");
// #X897 @PLACE(208, -2402) => @ORIENT("R0");
// #X898 @PLACE(248, -2402) => @ORIENT("R0");
// #X899 @PLACE(288, -2402) => @ORIENT("R0");
// #X900 @PLACE(168, -2433) => @ORIENT("R0");
// #X901 @PLACE(208, -2433) => @ORIENT("R0");
// #X902 @PLACE(248, -2433) => @ORIENT("R0");
// #X903 @PLACE(288, -2433) => @ORIENT("R0");
// #X904 @PLACE(168, -2464) => @ORIENT("R0");
// #X905 @PLACE(208, -2464) => @ORIENT("R0");
// #X906 @PLACE(248, -2464) => @ORIENT("R0");
// #X907 @PLACE(288, -2464) => @ORIENT("R0");
// #X908 @PLACE(168, -2495) => @ORIENT("R0");
// #X909 @PLACE(208, -2495) => @ORIENT("R0");
// #X910 @PLACE(248, -2495) => @ORIENT("R0");
// #X911 @PLACE(288, -2495) => @ORIENT("R0");
// #X912 @PLACE(336, -2340) => @ORIENT("R0");
// (320, -2326) @TEXT("Panel 39 | X912 - X935", size=1.1, halign="start");
// #X913 @PLACE(376, -2340) => @ORIENT("R0");
// #X914 @PLACE(416, -2340) => @ORIENT("R0");
// #X915 @PLACE(456, -2340) => @ORIENT("R0");
// #X916 @PLACE(336, -2371) => @ORIENT("R0");
// #X917 @PLACE(376, -2371) => @ORIENT("R0");
// #X918 @PLACE(416, -2371) => @ORIENT("R0");
// #X919 @PLACE(456, -2371) => @ORIENT("R0");
// #X920 @PLACE(336, -2402) => @ORIENT("R0");
// #X921 @PLACE(376, -2402) => @ORIENT("R0");
// #X922 @PLACE(416, -2402) => @ORIENT("R0");
// #X923 @PLACE(456, -2402) => @ORIENT("R0");
// #X924 @PLACE(336, -2433) => @ORIENT("R0");
// #X925 @PLACE(376, -2433) => @ORIENT("R0");
// #X926 @PLACE(416, -2433) => @ORIENT("R0");
// #X927 @PLACE(456, -2433) => @ORIENT("R0");
// #X928 @PLACE(336, -2464) => @ORIENT("R0");
// #X929 @PLACE(376, -2464) => @ORIENT("R0");
// #X930 @PLACE(416, -2464) => @ORIENT("R0");
// #X931 @PLACE(456, -2464) => @ORIENT("R0");
// #X932 @PLACE(336, -2495) => @ORIENT("R0");
// #X933 @PLACE(376, -2495) => @ORIENT("R0");
// #X934 @PLACE(416, -2495) => @ORIENT("R0");
// #X935 @PLACE(456, -2495) => @ORIENT("R0");
// #X936 @PLACE(504, -2340) => @ORIENT("R0");
// (488, -2326) @TEXT("Panel 40 | X936 - X959", size=1.1, halign="start");
// #X937 @PLACE(544, -2340) => @ORIENT("R0");
// #X938 @PLACE(584, -2340) => @ORIENT("R0");
// #X939 @PLACE(624, -2340) => @ORIENT("R0");
// #X940 @PLACE(504, -2371) => @ORIENT("R0");
// #X941 @PLACE(544, -2371) => @ORIENT("R0");
// #X942 @PLACE(584, -2371) => @ORIENT("R0");
// #X943 @PLACE(624, -2371) => @ORIENT("R0");
// #X944 @PLACE(504, -2402) => @ORIENT("R0");
// #X945 @PLACE(544, -2402) => @ORIENT("R0");
// #X946 @PLACE(584, -2402) => @ORIENT("R0");
// #X947 @PLACE(624, -2402) => @ORIENT("R0");
// #X948 @PLACE(504, -2433) => @ORIENT("R0");
// #X949 @PLACE(544, -2433) => @ORIENT("R0");
// #X950 @PLACE(584, -2433) => @ORIENT("R0");
// #X951 @PLACE(624, -2433) => @ORIENT("R0");
// #X952 @PLACE(504, -2464) => @ORIENT("R0");
// #X953 @PLACE(544, -2464) => @ORIENT("R0");
// #X954 @PLACE(584, -2464) => @ORIENT("R0");
// #X955 @PLACE(624, -2464) => @ORIENT("R0");
// #X956 @PLACE(504, -2495) => @ORIENT("R0");
// #X957 @PLACE(544, -2495) => @ORIENT("R0");
// #X958 @PLACE(584, -2495) => @ORIENT("R0");
// #X959 @PLACE(624, -2495) => @ORIENT("R0");
// #X960 @PLACE(0, -2538) => @ORIENT("R0");
// (-25, -2524) @TEXT("Panel 41 | X960 - X983", size=1.1, halign="start");
// #X961 @PLACE(40, -2538) => @ORIENT("R0");
// #X962 @PLACE(80, -2538) => @ORIENT("R0");
// #X963 @PLACE(120, -2538) => @ORIENT("R0");
// #X964 @PLACE(0, -2569) => @ORIENT("R0");
// #X965 @PLACE(40, -2569) => @ORIENT("R0");
// #X966 @PLACE(80, -2569) => @ORIENT("R0");
// #X967 @PLACE(120, -2569) => @ORIENT("R0");
// #X968 @PLACE(0, -2600) => @ORIENT("R0");
// #X969 @PLACE(40, -2600) => @ORIENT("R0");
// #X970 @PLACE(80, -2600) => @ORIENT("R0");
// #X971 @PLACE(120, -2600) => @ORIENT("R0");
// #X972 @PLACE(0, -2633) => @ORIENT("R0");
// #X973 @PLACE(40, -2633) => @ORIENT("R0");
// #X974 @PLACE(80, -2633) => @ORIENT("R0");
// #X975 @PLACE(120, -2633) => @ORIENT("R0");
// #X976 @PLACE(0, -2668) => @ORIENT("R0");
// #X977 @PLACE(40, -2668) => @ORIENT("R0");
// #X978 @PLACE(80, -2668) => @ORIENT("R0");
// #X979 @PLACE(120, -2668) => @ORIENT("R0");
// #X980 @PLACE(0, -2703) => @ORIENT("R0");
// #X981 @PLACE(40, -2703) => @ORIENT("R0");
// #X982 @PLACE(80, -2703) => @ORIENT("R0");
// #X983 @PLACE(120, -2703) => @ORIENT("R0");
// #X984 @PLACE(168, -2538) => @ORIENT("R0");
// (152, -2524) @TEXT("Panel 42 | X984 - X1007", size=1.1, halign="start");
// #X985 @PLACE(208, -2538) => @ORIENT("R0");
// #X986 @PLACE(248, -2538) => @ORIENT("R0");
// #X987 @PLACE(288, -2538) => @ORIENT("R0");
// #X988 @PLACE(168, -2569) => @ORIENT("R0");
// #X989 @PLACE(208, -2569) => @ORIENT("R0");
// #X990 @PLACE(248, -2569) => @ORIENT("R0");
// #X991 @PLACE(288, -2569) => @ORIENT("R0");
// #X992 @PLACE(168, -2600) => @ORIENT("R0");
// #X993 @PLACE(208, -2600) => @ORIENT("R0");
// #X994 @PLACE(248, -2600) => @ORIENT("R0");
// #X995 @PLACE(288, -2600) => @ORIENT("R0");
// #X996 @PLACE(168, -2633) => @ORIENT("R0");
// #X997 @PLACE(208, -2633) => @ORIENT("R0");
// #X998 @PLACE(248, -2633) => @ORIENT("R0");
// #X999 @PLACE(288, -2633) => @ORIENT("R0");
// #X1000 @PLACE(168, -2668) => @ORIENT("R0");
// #X1001 @PLACE(208, -2668) => @ORIENT("R0");
// #X1002 @PLACE(248, -2668) => @ORIENT("R0");
// #X1003 @PLACE(288, -2668) => @ORIENT("R0");
// #X1004 @PLACE(168, -2703) => @ORIENT("R0");
// #X1005 @PLACE(208, -2703) => @ORIENT("R0");
// #X1006 @PLACE(248, -2703) => @ORIENT("R0");
// #X1007 @PLACE(288, -2703) => @ORIENT("R0");
// #X1008 @PLACE(336, -2538) => @ORIENT("R0");
// (320, -2524) @TEXT("Panel 43 | X1008 - X1031", size=1.1, halign="start");
// #X1009 @PLACE(376, -2538) => @ORIENT("R0");
// #X1010 @PLACE(416, -2538) => @ORIENT("R0");
// #X1011 @PLACE(456, -2538) => @ORIENT("R0");
// #X1012 @PLACE(336, -2569) => @ORIENT("R0");
// #X1013 @PLACE(376, -2569) => @ORIENT("R0");
// #X1014 @PLACE(416, -2569) => @ORIENT("R0");
// #X1015 @PLACE(456, -2569) => @ORIENT("R0");
// #X1016 @PLACE(336, -2600) => @ORIENT("R0");
// #X1017 @PLACE(376, -2600) => @ORIENT("R0");
// #X1018 @PLACE(416, -2600) => @ORIENT("R0");
// #X1019 @PLACE(456, -2600) => @ORIENT("R0");
// #X1020 @PLACE(336, -2633) => @ORIENT("R0");
// #X1021 @PLACE(376, -2633) => @ORIENT("R0");
// #X1022 @PLACE(416, -2633) => @ORIENT("R0");
// #X1023 @PLACE(456, -2633) => @ORIENT("R0");
// #X1024 @PLACE(336, -2668) => @ORIENT("R0");
// #X1025 @PLACE(376, -2668) => @ORIENT("R0");
// #X1026 @PLACE(416, -2668) => @ORIENT("R0");
// #X1027 @PLACE(456, -2668) => @ORIENT("R0");
// #X1028 @PLACE(336, -2703) => @ORIENT("R0");
// #X1029 @PLACE(376, -2703) => @ORIENT("R0");
// #X1030 @PLACE(416, -2703) => @ORIENT("R0");
// #X1031 @PLACE(456, -2703) => @ORIENT("R0");
// #X1032 @PLACE(504, -2538) => @ORIENT("R0");
// (488, -2524) @TEXT("Panel 44 | X1032 - X1055", size=1.1, halign="start");
// #X1033 @PLACE(544, -2538) => @ORIENT("R0");
// #X1034 @PLACE(584, -2538) => @ORIENT("R0");
// #X1035 @PLACE(624, -2538) => @ORIENT("R0");
// #X1036 @PLACE(504, -2569) => @ORIENT("R0");
// #X1037 @PLACE(544, -2569) => @ORIENT("R0");
// #X1038 @PLACE(584, -2569) => @ORIENT("R0");
// #X1039 @PLACE(624, -2569) => @ORIENT("R0");
// #X1040 @PLACE(504, -2600) => @ORIENT("R0");
// #X1041 @PLACE(544, -2600) => @ORIENT("R0");
// #X1042 @PLACE(584, -2600) => @ORIENT("R0");
// #X1043 @PLACE(624, -2600) => @ORIENT("R0");
// #X1044 @PLACE(504, -2633) => @ORIENT("R0");
// #X1045 @PLACE(544, -2633) => @ORIENT("R0");
// #X1046 @PLACE(584, -2633) => @ORIENT("R0");
// #X1047 @PLACE(624, -2633) => @ORIENT("R0");
// #X1048 @PLACE(504, -2668) => @ORIENT("R0");
// #X1049 @PLACE(544, -2668) => @ORIENT("R0");
// #X1050 @PLACE(584, -2668) => @ORIENT("R0");
// #X1051 @PLACE(624, -2668) => @ORIENT("R0");
// #X1052 @PLACE(504, -2703) => @ORIENT("R0");
// #X1053 @PLACE(544, -2703) => @ORIENT("R0");
// #X1054 @PLACE(584, -2703) => @ORIENT("R0");
// #X1055 @PLACE(624, -2703) => @ORIENT("R0");
// #X1056 @PLACE(0, -2748) => @ORIENT("R0");
// (-25, -2734) @TEXT("Panel 45 | X1056 - X1079", size=1.1, halign="start");
// #X1057 @PLACE(40, -2748) => @ORIENT("R0");
// #X1058 @PLACE(80, -2748) => @ORIENT("R0");
// #X1059 @PLACE(120, -2748) => @ORIENT("R0");
// #X1060 @PLACE(0, -2783) => @ORIENT("R0");
// #X1061 @PLACE(40, -2783) => @ORIENT("R0");
// #X1062 @PLACE(80, -2783) => @ORIENT("R0");
// #X1063 @PLACE(120, -2783) => @ORIENT("R0");
// #X1064 @PLACE(0, -2818) => @ORIENT("R0");
// #X1065 @PLACE(40, -2818) => @ORIENT("R0");
// #X1066 @PLACE(80, -2818) => @ORIENT("R0");
// #X1067 @PLACE(120, -2818) => @ORIENT("R0");
// #X1068 @PLACE(0, -2853) => @ORIENT("R0");
// #X1069 @PLACE(40, -2853) => @ORIENT("R0");
// #X1070 @PLACE(80, -2853) => @ORIENT("R0");
// #X1071 @PLACE(120, -2853) => @ORIENT("R0");
// #X1072 @PLACE(0, -2888) => @ORIENT("R0");
// #X1073 @PLACE(40, -2888) => @ORIENT("R0");
// #X1074 @PLACE(80, -2888) => @ORIENT("R0");
// #X1075 @PLACE(120, -2888) => @ORIENT("R0");
// #X1076 @PLACE(0, -2923) => @ORIENT("R0");
// #X1077 @PLACE(40, -2923) => @ORIENT("R0");
// #X1078 @PLACE(80, -2923) => @ORIENT("R0");
// #X1079 @PLACE(120, -2923) => @ORIENT("R0");
// #X1080 @PLACE(168, -2748) => @ORIENT("R0");
// (152, -2734) @TEXT("Panel 46 | X1080 - X1103", size=1.1, halign="start");
// #X1081 @PLACE(208, -2748) => @ORIENT("R0");
// #X1082 @PLACE(248, -2748) => @ORIENT("R0");
// #X1083 @PLACE(288, -2748) => @ORIENT("R0");
// #X1084 @PLACE(168, -2783) => @ORIENT("R0");
// #X1085 @PLACE(208, -2783) => @ORIENT("R0");
// #X1086 @PLACE(248, -2783) => @ORIENT("R0");
// #X1087 @PLACE(288, -2783) => @ORIENT("R0");
// #X1088 @PLACE(168, -2818) => @ORIENT("R0");
// #X1089 @PLACE(208, -2818) => @ORIENT("R0");
// #X1090 @PLACE(248, -2818) => @ORIENT("R0");
// #X1091 @PLACE(288, -2818) => @ORIENT("R0");
// #X1092 @PLACE(168, -2853) => @ORIENT("R0");
// #X1093 @PLACE(208, -2853) => @ORIENT("R0");
// #X1094 @PLACE(248, -2853) => @ORIENT("R0");
// #X1095 @PLACE(288, -2853) => @ORIENT("R0");
// #X1096 @PLACE(168, -2888) => @ORIENT("R0");
// #X1097 @PLACE(208, -2888) => @ORIENT("R0");
// #X1098 @PLACE(248, -2888) => @ORIENT("R0");
// #X1099 @PLACE(288, -2888) => @ORIENT("R0");
// #X1100 @PLACE(168, -2923) => @ORIENT("R0");
// #X1101 @PLACE(208, -2923) => @ORIENT("R0");
// #X1102 @PLACE(248, -2923) => @ORIENT("R0");
// #X1103 @PLACE(288, -2923) => @ORIENT("R0");
// #X1104 @PLACE(336, -2748) => @ORIENT("R0");
// (320, -2734) @TEXT("Panel 47 | X1104 - X1127", size=1.1, halign="start");
// #X1105 @PLACE(376, -2748) => @ORIENT("R0");
// #X1106 @PLACE(416, -2748) => @ORIENT("R0");
// #X1107 @PLACE(456, -2748) => @ORIENT("R0");
// #X1108 @PLACE(336, -2783) => @ORIENT("R0");
// #X1109 @PLACE(376, -2783) => @ORIENT("R0");
// #X1110 @PLACE(416, -2783) => @ORIENT("R0");
// #X1111 @PLACE(456, -2783) => @ORIENT("R0");
// #X1112 @PLACE(336, -2818) => @ORIENT("R0");
// #X1113 @PLACE(376, -2818) => @ORIENT("R0");
// #X1114 @PLACE(416, -2818) => @ORIENT("R0");
// #X1115 @PLACE(456, -2818) => @ORIENT("R0");
// #X1116 @PLACE(336, -2853) => @ORIENT("R0");
// #X1117 @PLACE(376, -2853) => @ORIENT("R0");
// #X1118 @PLACE(416, -2853) => @ORIENT("R0");
// #X1119 @PLACE(456, -2853) => @ORIENT("R0");
// #X1120 @PLACE(336, -2888) => @ORIENT("R0");
// #X1121 @PLACE(376, -2888) => @ORIENT("R0");
// #X1122 @PLACE(416, -2888) => @ORIENT("R0");
// #X1123 @PLACE(456, -2888) => @ORIENT("R0");
// #X1124 @PLACE(336, -2923) => @ORIENT("R0");
// #X1125 @PLACE(376, -2923) => @ORIENT("R0");
// #X1126 @PLACE(416, -2923) => @ORIENT("R0");
// #X1127 @PLACE(456, -2923) => @ORIENT("R0");
// #X1128 @PLACE(504, -2748) => @ORIENT("R0");
// (488, -2734) @TEXT("Panel 48 | X1128 - X1151", size=1.1, halign="start");
// #X1129 @PLACE(544, -2748) => @ORIENT("R0");
// #X1130 @PLACE(584, -2748) => @ORIENT("R0");
// #X1131 @PLACE(624, -2748) => @ORIENT("R0");
// #X1132 @PLACE(504, -2783) => @ORIENT("R0");
// #X1133 @PLACE(544, -2783) => @ORIENT("R0");
// #X1134 @PLACE(584, -2783) => @ORIENT("R0");
// #X1135 @PLACE(624, -2783) => @ORIENT("R0");
// #X1136 @PLACE(504, -2818) => @ORIENT("R0");
// #X1137 @PLACE(544, -2818) => @ORIENT("R0");
// #X1138 @PLACE(584, -2818) => @ORIENT("R0");
// #X1139 @PLACE(624, -2818) => @ORIENT("R0");
// #X1140 @PLACE(504, -2853) => @ORIENT("R0");
// #X1141 @PLACE(544, -2853) => @ORIENT("R0");
// #X1142 @PLACE(584, -2853) => @ORIENT("R0");
// #X1143 @PLACE(624, -2853) => @ORIENT("R0");
// #X1144 @PLACE(504, -2888) => @ORIENT("R0");
// #X1145 @PLACE(544, -2888) => @ORIENT("R0");
// #X1146 @PLACE(584, -2888) => @ORIENT("R0");
// #X1147 @PLACE(624, -2888) => @ORIENT("R0");
// #X1148 @PLACE(504, -2923) => @ORIENT("R0");
// #X1149 @PLACE(544, -2923) => @ORIENT("R0");
// #X1150 @PLACE(584, -2923) => @ORIENT("R0");
// #X1151 @PLACE(624, -2923) => @ORIENT("R0");
// #X1152 @PLACE(0, -2968) => @ORIENT("R0");
// (-25, -2954) @TEXT("Panel 49 | X1152 - X1175", size=1.1, halign="start");
// #X1153 @PLACE(40, -2968) => @ORIENT("R0");
// #X1154 @PLACE(80, -2968) => @ORIENT("R0");
// #X1155 @PLACE(120, -2968) => @ORIENT("R0");
// #X1156 @PLACE(0, -3003) => @ORIENT("R0");
// #X1157 @PLACE(40, -3003) => @ORIENT("R0");
// #X1158 @PLACE(80, -3003) => @ORIENT("R0");
// #X1159 @PLACE(120, -3003) => @ORIENT("R0");
// #X1160 @PLACE(0, -3038) => @ORIENT("R0");
// #X1161 @PLACE(40, -3038) => @ORIENT("R0");
// #X1162 @PLACE(80, -3038) => @ORIENT("R0");
// #X1163 @PLACE(120, -3038) => @ORIENT("R0");
// #X1164 @PLACE(0, -3073) => @ORIENT("R0");
// #X1165 @PLACE(40, -3073) => @ORIENT("R0");
// #X1166 @PLACE(80, -3073) => @ORIENT("R0");
// #X1167 @PLACE(120, -3073) => @ORIENT("R0");
// #X1168 @PLACE(0, -3108) => @ORIENT("R0");
// #X1169 @PLACE(40, -3108) => @ORIENT("R0");
// #X1170 @PLACE(80, -3108) => @ORIENT("R0");
// #X1171 @PLACE(120, -3108) => @ORIENT("R0");
// #X1172 @PLACE(0, -3143) => @ORIENT("R0");
// #X1173 @PLACE(40, -3143) => @ORIENT("R0");
// #X1174 @PLACE(80, -3143) => @ORIENT("R0");
// #X1175 @PLACE(120, -3143) => @ORIENT("R0");
// #X1176 @PLACE(168, -2968) => @ORIENT("R0");
// (152, -2954) @TEXT("Panel 50 | X1176 - X1199", size=1.1, halign="start");
// #X1177 @PLACE(208, -2968) => @ORIENT("R0");
// #X1178 @PLACE(248, -2968) => @ORIENT("R0");
// #X1179 @PLACE(288, -2968) => @ORIENT("R0");
// #X1180 @PLACE(168, -3003) => @ORIENT("R0");
// #X1181 @PLACE(208, -3003) => @ORIENT("R0");
// #X1182 @PLACE(248, -3003) => @ORIENT("R0");
// #X1183 @PLACE(288, -3003) => @ORIENT("R0");
// #X1184 @PLACE(168, -3038) => @ORIENT("R0");
// #X1185 @PLACE(208, -3038) => @ORIENT("R0");
// #X1186 @PLACE(248, -3038) => @ORIENT("R0");
// #X1187 @PLACE(288, -3038) => @ORIENT("R0");
// #X1188 @PLACE(168, -3073) => @ORIENT("R0");
// #X1189 @PLACE(208, -3073) => @ORIENT("R0");
// #X1190 @PLACE(248, -3073) => @ORIENT("R0");
// #X1191 @PLACE(288, -3073) => @ORIENT("R0");
// #X1192 @PLACE(168, -3108) => @ORIENT("R0");
// #X1193 @PLACE(208, -3108) => @ORIENT("R0");
// #X1194 @PLACE(248, -3108) => @ORIENT("R0");
// #X1195 @PLACE(288, -3108) => @ORIENT("R0");
// #X1196 @PLACE(168, -3143) => @ORIENT("R0");
// #X1197 @PLACE(208, -3143) => @ORIENT("R0");
// #X1198 @PLACE(248, -3143) => @ORIENT("R0");
// #X1199 @PLACE(288, -3143) => @ORIENT("R0");
// #X1200 @PLACE(336, -2968) => @ORIENT("R0");
// (320, -2954) @TEXT("Panel 51 | X1200 - X1223", size=1.1, halign="start");
// #X1201 @PLACE(376, -2968) => @ORIENT("R0");
// #X1202 @PLACE(416, -2968) => @ORIENT("R0");
// #X1203 @PLACE(456, -2968) => @ORIENT("R0");
// #X1204 @PLACE(336, -3003) => @ORIENT("R0");
// #X1205 @PLACE(376, -3003) => @ORIENT("R0");
// #X1206 @PLACE(416, -3003) => @ORIENT("R0");
// #X1207 @PLACE(456, -3003) => @ORIENT("R0");
// #X1208 @PLACE(336, -3038) => @ORIENT("R0");
// #X1209 @PLACE(376, -3038) => @ORIENT("R0");
// #X1210 @PLACE(416, -3038) => @ORIENT("R0");
// #X1211 @PLACE(456, -3038) => @ORIENT("R0");
// #X1212 @PLACE(336, -3073) => @ORIENT("R0");
// #X1213 @PLACE(376, -3073) => @ORIENT("R0");
// #X1214 @PLACE(416, -3073) => @ORIENT("R0");
// #X1215 @PLACE(456, -3073) => @ORIENT("R0");
// #X1216 @PLACE(336, -3108) => @ORIENT("R0");
// #X1217 @PLACE(376, -3108) => @ORIENT("R0");
// #X1218 @PLACE(416, -3108) => @ORIENT("R0");
// #X1219 @PLACE(456, -3108) => @ORIENT("R0");
// #X1220 @PLACE(336, -3143) => @ORIENT("R0");
// #X1221 @PLACE(376, -3143) => @ORIENT("R0");
// #X1222 @PLACE(416, -3143) => @ORIENT("R0");
// #X1223 @PLACE(456, -3143) => @ORIENT("R0");
// #X1224 @PLACE(504, -2968) => @ORIENT("R0");
// (488, -2954) @TEXT("Panel 52 | X1224 - X1247", size=1.1, halign="start");
// #X1225 @PLACE(544, -2968) => @ORIENT("R0");
// #X1226 @PLACE(584, -2968) => @ORIENT("R0");
// #X1227 @PLACE(624, -2968) => @ORIENT("R0");
// #X1228 @PLACE(504, -3003) => @ORIENT("R0");
// #X1229 @PLACE(544, -3003) => @ORIENT("R0");
// #X1230 @PLACE(584, -3003) => @ORIENT("R0");
// #X1231 @PLACE(624, -3003) => @ORIENT("R0");
// #X1232 @PLACE(504, -3038) => @ORIENT("R0");
// #X1233 @PLACE(544, -3038) => @ORIENT("R0");
// #X1234 @PLACE(584, -3038) => @ORIENT("R0");
// #X1235 @PLACE(624, -3038) => @ORIENT("R0");
// #X1236 @PLACE(504, -3073) => @ORIENT("R0");
// #X1237 @PLACE(544, -3073) => @ORIENT("R0");
// #X1238 @PLACE(584, -3073) => @ORIENT("R0");
// #X1239 @PLACE(624, -3073) => @ORIENT("R0");
// #X1240 @PLACE(504, -3108) => @ORIENT("R0");
// #X1241 @PLACE(544, -3108) => @ORIENT("R0");
// #X1242 @PLACE(584, -3108) => @ORIENT("R0");
// #X1243 @PLACE(624, -3108) => @ORIENT("R0");
// #X1244 @PLACE(504, -3143) => @ORIENT("R0");
// #X1245 @PLACE(544, -3143) => @ORIENT("R0");
// #X1246 @PLACE(584, -3143) => @ORIENT("R0");
// #X1247 @PLACE(624, -3143) => @ORIENT("R0");
// #X1248 @PLACE(0, -3188) => @ORIENT("R0");
// (-25, -3174) @TEXT("Panel 53 | X1248 - X1271", size=1.1, halign="start");
// #X1249 @PLACE(40, -3188) => @ORIENT("R0");
// #X1250 @PLACE(80, -3188) => @ORIENT("R0");
// #X1251 @PLACE(120, -3188) => @ORIENT("R0");
// #X1252 @PLACE(0, -3223) => @ORIENT("R0");
// #X1253 @PLACE(40, -3223) => @ORIENT("R0");
// #X1254 @PLACE(80, -3223) => @ORIENT("R0");
// #X1255 @PLACE(120, -3223) => @ORIENT("R0");
// #X1256 @PLACE(0, -3258) => @ORIENT("R0");
// #X1257 @PLACE(40, -3258) => @ORIENT("R0");
// #X1258 @PLACE(80, -3258) => @ORIENT("R0");
// #X1259 @PLACE(120, -3258) => @ORIENT("R0");
// #X1260 @PLACE(0, -3293) => @ORIENT("R0");
// #X1261 @PLACE(40, -3293) => @ORIENT("R0");
// #X1262 @PLACE(80, -3293) => @ORIENT("R0");
// #X1263 @PLACE(120, -3293) => @ORIENT("R0");
// #X1264 @PLACE(0, -3328) => @ORIENT("R0");
// #X1265 @PLACE(40, -3328) => @ORIENT("R0");
// #X1266 @PLACE(80, -3328) => @ORIENT("R0");
// #X1267 @PLACE(120, -3328) => @ORIENT("R0");
// #X1268 @PLACE(0, -3363) => @ORIENT("R0");
// #X1269 @PLACE(40, -3363) => @ORIENT("R0");
// #X1270 @PLACE(80, -3363) => @ORIENT("R0");
// #X1271 @PLACE(120, -3363) => @ORIENT("R0");
// #X1272 @PLACE(168, -3188) => @ORIENT("R0");
// (152, -3174) @TEXT("Panel 54 | X1272 - X1295", size=1.1, halign="start");
// #X1273 @PLACE(208, -3188) => @ORIENT("R0");
// #X1274 @PLACE(248, -3188) => @ORIENT("R0");
// #X1275 @PLACE(288, -3188) => @ORIENT("R0");
// #X1276 @PLACE(168, -3223) => @ORIENT("R0");
// #X1277 @PLACE(208, -3223) => @ORIENT("R0");
// #X1278 @PLACE(248, -3223) => @ORIENT("R0");
// #X1279 @PLACE(288, -3223) => @ORIENT("R0");
// #X1280 @PLACE(168, -3258) => @ORIENT("R0");
// #X1281 @PLACE(208, -3258) => @ORIENT("R0");
// #X1282 @PLACE(248, -3258) => @ORIENT("R0");
// #X1283 @PLACE(288, -3258) => @ORIENT("R0");
// #X1284 @PLACE(168, -3293) => @ORIENT("R0");
// #X1285 @PLACE(208, -3293) => @ORIENT("R0");
// #X1286 @PLACE(248, -3293) => @ORIENT("R0");
// #X1287 @PLACE(288, -3293) => @ORIENT("R0");
// #X1288 @PLACE(168, -3328) => @ORIENT("R0");
// #X1289 @PLACE(208, -3328) => @ORIENT("R0");
// #X1290 @PLACE(248, -3328) => @ORIENT("R0");
// #X1291 @PLACE(288, -3328) => @ORIENT("R0");
// #X1292 @PLACE(168, -3363) => @ORIENT("R0");
// #X1293 @PLACE(208, -3363) => @ORIENT("R0");
// #X1294 @PLACE(248, -3363) => @ORIENT("R0");
// #X1295 @PLACE(288, -3363) => @ORIENT("R0");
// #X1296 @PLACE(336, -3188) => @ORIENT("R0");
// (320, -3174) @TEXT("Panel 55 | X1296 - X1319", size=1.1, halign="start");
// #X1297 @PLACE(376, -3188) => @ORIENT("R0");
// #X1298 @PLACE(416, -3188) => @ORIENT("R0");
// #X1299 @PLACE(456, -3188) => @ORIENT("R0");
// #X1300 @PLACE(336, -3223) => @ORIENT("R0");
// #X1301 @PLACE(376, -3223) => @ORIENT("R0");
// #X1302 @PLACE(416, -3223) => @ORIENT("R0");
// #X1303 @PLACE(456, -3223) => @ORIENT("R0");
// #X1304 @PLACE(336, -3258) => @ORIENT("R0");
// #X1305 @PLACE(376, -3258) => @ORIENT("R0");
// #X1306 @PLACE(416, -3258) => @ORIENT("R0");
// #X1307 @PLACE(456, -3258) => @ORIENT("R0");
// #X1308 @PLACE(336, -3293) => @ORIENT("R0");
// #X1309 @PLACE(376, -3293) => @ORIENT("R0");
// #X1310 @PLACE(416, -3293) => @ORIENT("R0");
// #X1311 @PLACE(456, -3293) => @ORIENT("R0");
// #X1312 @PLACE(336, -3328) => @ORIENT("R0");
// #X1313 @PLACE(376, -3328) => @ORIENT("R0");
// #X1314 @PLACE(416, -3328) => @ORIENT("R0");
// #X1315 @PLACE(456, -3328) => @ORIENT("R0");
// #X1316 @PLACE(336, -3363) => @ORIENT("R0");
// #X1317 @PLACE(376, -3363) => @ORIENT("R0");
// #X1318 @PLACE(416, -3363) => @ORIENT("R0");
// #X1319 @PLACE(456, -3363) => @ORIENT("R0");
// #X1320 @PLACE(504, -3188) => @ORIENT("R0");
// (488, -3174) @TEXT("Panel 56 | X1320 - X1343", size=1.1, halign="start");
// #X1321 @PLACE(544, -3188) => @ORIENT("R0");
// #X1322 @PLACE(584, -3188) => @ORIENT("R0");
// #X1323 @PLACE(624, -3188) => @ORIENT("R0");
// #X1324 @PLACE(504, -3223) => @ORIENT("R0");
// #X1325 @PLACE(544, -3223) => @ORIENT("R0");
// #X1326 @PLACE(584, -3223) => @ORIENT("R0");
// #X1327 @PLACE(624, -3223) => @ORIENT("R0");
// #X1328 @PLACE(504, -3258) => @ORIENT("R0");
// #X1329 @PLACE(544, -3258) => @ORIENT("R0");
// #X1330 @PLACE(584, -3258) => @ORIENT("R0");
// #X1331 @PLACE(624, -3258) => @ORIENT("R0");
// #X1332 @PLACE(504, -3293) => @ORIENT("R0");
// #X1333 @PLACE(544, -3293) => @ORIENT("R0");
// #X1334 @PLACE(584, -3293) => @ORIENT("R0");
// #X1335 @PLACE(624, -3293) => @ORIENT("R0");
// #X1336 @PLACE(504, -3328) => @ORIENT("R0");
// #X1337 @PLACE(544, -3328) => @ORIENT("R0");
// #X1338 @PLACE(584, -3328) => @ORIENT("R0");
// #X1339 @PLACE(624, -3328) => @ORIENT("R0");
// #X1340 @PLACE(504, -3363) => @ORIENT("R0");
// #X1341 @PLACE(544, -3363) => @ORIENT("R0");
// #X1342 @PLACE(584, -3363) => @ORIENT("R0");
// #X1343 @PLACE(624, -3363) => @ORIENT("R0");
// #X1344 @PLACE(0, -3408) => @ORIENT("R0");
// (-25, -3394) @TEXT("Panel 57 | X1344 - X1367", size=1.1, halign="start");
// #X1345 @PLACE(40, -3408) => @ORIENT("R0");
// #X1346 @PLACE(80, -3408) => @ORIENT("R0");
// #X1347 @PLACE(120, -3408) => @ORIENT("R0");
// #X1348 @PLACE(0, -3443) => @ORIENT("R0");
// #X1349 @PLACE(40, -3443) => @ORIENT("R0");
// #X1350 @PLACE(80, -3443) => @ORIENT("R0");
// #X1351 @PLACE(120, -3443) => @ORIENT("R0");
// #X1352 @PLACE(0, -3478) => @ORIENT("R0");
// #X1353 @PLACE(40, -3478) => @ORIENT("R0");
// #X1354 @PLACE(80, -3478) => @ORIENT("R0");
// #X1355 @PLACE(120, -3478) => @ORIENT("R0");
// #X1356 @PLACE(0, -3513) => @ORIENT("R0");
// #X1357 @PLACE(40, -3513) => @ORIENT("R0");
// #X1358 @PLACE(80, -3513) => @ORIENT("R0");
// #X1359 @PLACE(120, -3513) => @ORIENT("R0");
// #X1360 @PLACE(0, -3548) => @ORIENT("R0");
// #X1361 @PLACE(40, -3548) => @ORIENT("R0");
// #X1362 @PLACE(80, -3548) => @ORIENT("R0");
// #X1363 @PLACE(120, -3548) => @ORIENT("R0");
// #X1364 @PLACE(0, -3583) => @ORIENT("R0");
// #X1365 @PLACE(40, -3583) => @ORIENT("R0");
// #X1366 @PLACE(80, -3583) => @ORIENT("R0");
// #X1367 @PLACE(120, -3583) => @ORIENT("R0");
// #X1368 @PLACE(168, -3408) => @ORIENT("R0");
// (152, -3394) @TEXT("Panel 58 | X1368 - X1391", size=1.1, halign="start");
// #X1369 @PLACE(208, -3408) => @ORIENT("R0");
// #X1370 @PLACE(248, -3408) => @ORIENT("R0");
// #X1371 @PLACE(288, -3408) => @ORIENT("R0");
// #X1372 @PLACE(168, -3443) => @ORIENT("R0");
// #X1373 @PLACE(208, -3443) => @ORIENT("R0");
// #X1374 @PLACE(248, -3443) => @ORIENT("R0");
// #X1375 @PLACE(288, -3443) => @ORIENT("R0");
// #X1376 @PLACE(168, -3478) => @ORIENT("R0");
// #X1377 @PLACE(208, -3478) => @ORIENT("R0");
// #X1378 @PLACE(248, -3478) => @ORIENT("R0");
// #X1379 @PLACE(288, -3478) => @ORIENT("R0");
// #X1380 @PLACE(168, -3513) => @ORIENT("R0");
// #X1381 @PLACE(208, -3513) => @ORIENT("R0");
// #X1382 @PLACE(248, -3513) => @ORIENT("R0");
// #X1383 @PLACE(288, -3513) => @ORIENT("R0");
// #X1384 @PLACE(168, -3548) => @ORIENT("R0");
// #X1385 @PLACE(208, -3548) => @ORIENT("R0");
// #X1386 @PLACE(248, -3548) => @ORIENT("R0");
// #X1387 @PLACE(288, -3548) => @ORIENT("R0");
// #X1388 @PLACE(168, -3583) => @ORIENT("R0");
// #X1389 @PLACE(208, -3583) => @ORIENT("R0");
// #X1390 @PLACE(248, -3583) => @ORIENT("R0");
// #X1391 @PLACE(288, -3583) => @ORIENT("R0");
// #X1392 @PLACE(336, -3408) => @ORIENT("R0");
// (320, -3394) @TEXT("Panel 59 | X1392 - X1415", size=1.1, halign="start");
// #X1393 @PLACE(376, -3408) => @ORIENT("R0");
// #X1394 @PLACE(416, -3408) => @ORIENT("R0");
// #X1395 @PLACE(456, -3408) => @ORIENT("R0");
// #X1396 @PLACE(336, -3443) => @ORIENT("R0");
// #X1397 @PLACE(376, -3443) => @ORIENT("R0");
// #X1398 @PLACE(416, -3443) => @ORIENT("R0");
// #X1399 @PLACE(456, -3443) => @ORIENT("R0");
// #X1400 @PLACE(336, -3478) => @ORIENT("R0");
// #X1401 @PLACE(376, -3478) => @ORIENT("R0");
// #X1402 @PLACE(416, -3478) => @ORIENT("R0");
// #X1403 @PLACE(456, -3478) => @ORIENT("R0");
// #X1404 @PLACE(336, -3513) => @ORIENT("R0");
// #X1405 @PLACE(376, -3513) => @ORIENT("R0");
// #X1406 @PLACE(416, -3513) => @ORIENT("R0");
// #X1407 @PLACE(456, -3513) => @ORIENT("R0");
// #X1408 @PLACE(336, -3548) => @ORIENT("R0");
// #X1409 @PLACE(376, -3548) => @ORIENT("R0");
// #X1410 @PLACE(416, -3548) => @ORIENT("R0");
// #X1411 @PLACE(456, -3548) => @ORIENT("R0");
// #X1412 @PLACE(336, -3583) => @ORIENT("R0");
// #X1413 @PLACE(376, -3583) => @ORIENT("R0");
// #X1414 @PLACE(416, -3583) => @ORIENT("R0");
// #X1415 @PLACE(456, -3583) => @ORIENT("R0");
// #X1416 @PLACE(504, -3408) => @ORIENT("R0");
// (488, -3394) @TEXT("Panel 60 | X1416 - X1439", size=1.1, halign="start");
// #X1417 @PLACE(544, -3408) => @ORIENT("R0");
// #X1418 @PLACE(584, -3408) => @ORIENT("R0");
// #X1419 @PLACE(624, -3408) => @ORIENT("R0");
// #X1420 @PLACE(504, -3443) => @ORIENT("R0");
// #X1421 @PLACE(544, -3443) => @ORIENT("R0");
// #X1422 @PLACE(584, -3443) => @ORIENT("R0");
// #X1423 @PLACE(624, -3443) => @ORIENT("R0");
// #X1424 @PLACE(504, -3478) => @ORIENT("R0");
// #X1425 @PLACE(544, -3478) => @ORIENT("R0");
// #X1426 @PLACE(584, -3478) => @ORIENT("R0");
// #X1427 @PLACE(624, -3478) => @ORIENT("R0");
// #X1428 @PLACE(504, -3513) => @ORIENT("R0");
// #X1429 @PLACE(544, -3513) => @ORIENT("R0");
// #X1430 @PLACE(584, -3513) => @ORIENT("R0");
// #X1431 @PLACE(624, -3513) => @ORIENT("R0");
// #X1432 @PLACE(504, -3548) => @ORIENT("R0");
// #X1433 @PLACE(544, -3548) => @ORIENT("R0");
// #X1434 @PLACE(584, -3548) => @ORIENT("R0");
// #X1435 @PLACE(624, -3548) => @ORIENT("R0");
// #X1436 @PLACE(504, -3583) => @ORIENT("R0");
// #X1437 @PLACE(544, -3583) => @ORIENT("R0");
// #X1438 @PLACE(584, -3583) => @ORIENT("R0");
// #X1439 @PLACE(624, -3583) => @ORIENT("R0");
// #X1440 @PLACE(0, -3628) => @ORIENT("R0");
// (-25, -3614) @TEXT("Panel 61 | X1440 - X1463", size=1.1, halign="start");
// #X1441 @PLACE(40, -3628) => @ORIENT("R0");
// #X1442 @PLACE(80, -3628) => @ORIENT("R0");
// #X1443 @PLACE(120, -3628) => @ORIENT("R0");
// #X1444 @PLACE(0, -3663) => @ORIENT("R0");
// #X1445 @PLACE(40, -3663) => @ORIENT("R0");
// #X1446 @PLACE(80, -3663) => @ORIENT("R0");
// #X1447 @PLACE(120, -3663) => @ORIENT("R0");
// #X1448 @PLACE(0, -3698) => @ORIENT("R0");
// #X1449 @PLACE(40, -3698) => @ORIENT("R0");
// #X1450 @PLACE(80, -3698) => @ORIENT("R0");
// #X1451 @PLACE(120, -3698) => @ORIENT("R0");
// #X1452 @PLACE(0, -3733) => @ORIENT("R0");
// #X1453 @PLACE(40, -3733) => @ORIENT("R0");
// #X1454 @PLACE(80, -3733) => @ORIENT("R0");
// #X1455 @PLACE(120, -3733) => @ORIENT("R0");
// #X1456 @PLACE(0, -3768) => @ORIENT("R0");
// #X1457 @PLACE(40, -3768) => @ORIENT("R0");
// #X1458 @PLACE(80, -3768) => @ORIENT("R0");
// #X1459 @PLACE(120, -3768) => @ORIENT("R0");
// #X1460 @PLACE(0, -3803) => @ORIENT("R0");
// #X1461 @PLACE(40, -3803) => @ORIENT("R0");
// #X1462 @PLACE(80, -3803) => @ORIENT("R0");
// #X1463 @PLACE(120, -3803) => @ORIENT("R0");
// #X1464 @PLACE(168, -3628) => @ORIENT("R0");
// (152, -3614) @TEXT("Panel 62 | X1464 - X1487", size=1.1, halign="start");
// #X1465 @PLACE(208, -3628) => @ORIENT("R0");
// #X1466 @PLACE(248, -3628) => @ORIENT("R0");
// #X1467 @PLACE(288, -3628) => @ORIENT("R0");
// #X1468 @PLACE(168, -3663) => @ORIENT("R0");
// #X1469 @PLACE(208, -3663) => @ORIENT("R0");
// #X1470 @PLACE(248, -3663) => @ORIENT("R0");
// #X1471 @PLACE(288, -3663) => @ORIENT("R0");
// #X1472 @PLACE(168, -3698) => @ORIENT("R0");
// #X1473 @PLACE(208, -3698) => @ORIENT("R0");
// #X1474 @PLACE(248, -3698) => @ORIENT("R0");
// #X1475 @PLACE(288, -3698) => @ORIENT("R0");
// #X1476 @PLACE(168, -3733) => @ORIENT("R0");
// #X1477 @PLACE(208, -3733) => @ORIENT("R0");
// #X1478 @PLACE(248, -3733) => @ORIENT("R0");
// #X1479 @PLACE(288, -3733) => @ORIENT("R0");
// #X1480 @PLACE(168, -3768) => @ORIENT("R0");
// #X1481 @PLACE(208, -3768) => @ORIENT("R0");
// #X1482 @PLACE(248, -3768) => @ORIENT("R0");
// #X1483 @PLACE(288, -3768) => @ORIENT("R0");
// #X1484 @PLACE(168, -3803) => @ORIENT("R0");
// #X1485 @PLACE(208, -3803) => @ORIENT("R0");
// #X1486 @PLACE(248, -3803) => @ORIENT("R0");
// #X1487 @PLACE(288, -3803) => @ORIENT("R0");
// #X1488 @PLACE(336, -3628) => @ORIENT("R0");
// (320, -3614) @TEXT("Panel 63 | X1488 - X1511", size=1.1, halign="start");
// #X1489 @PLACE(376, -3628) => @ORIENT("R0");
// #X1490 @PLACE(416, -3628) => @ORIENT("R0");
// #X1491 @PLACE(456, -3628) => @ORIENT("R0");
// #X1492 @PLACE(336, -3663) => @ORIENT("R0");
// #X1493 @PLACE(376, -3663) => @ORIENT("R0");
// #X1494 @PLACE(416, -3663) => @ORIENT("R0");
// #X1495 @PLACE(456, -3663) => @ORIENT("R0");
// #X1496 @PLACE(336, -3698) => @ORIENT("R0");
// #X1497 @PLACE(376, -3698) => @ORIENT("R0");
// #X1498 @PLACE(416, -3698) => @ORIENT("R0");
// #X1499 @PLACE(456, -3698) => @ORIENT("R0");
// #X1500 @PLACE(336, -3733) => @ORIENT("R0");
// #X1501 @PLACE(376, -3733) => @ORIENT("R0");
// #X1502 @PLACE(416, -3733) => @ORIENT("R0");
// #X1503 @PLACE(456, -3733) => @ORIENT("R0");
// #X1504 @PLACE(336, -3768) => @ORIENT("R0");
// #X1505 @PLACE(376, -3768) => @ORIENT("R0");
// #X1506 @PLACE(416, -3768) => @ORIENT("R0");
// #X1507 @PLACE(456, -3768) => @ORIENT("R0");
// #X1508 @PLACE(336, -3803) => @ORIENT("R0");
// #X1509 @PLACE(376, -3803) => @ORIENT("R0");
// #X1510 @PLACE(416, -3803) => @ORIENT("R0");
// #X1511 @PLACE(456, -3803) => @ORIENT("R0");
// #X1512 @PLACE(504, -3628) => @ORIENT("R0");
// (488, -3614) @TEXT("Panel 64 | X1512 - X1535", size=1.1, halign="start");
// #X1513 @PLACE(544, -3628) => @ORIENT("R0");
// #X1514 @PLACE(584, -3628) => @ORIENT("R0");
// #X1515 @PLACE(624, -3628) => @ORIENT("R0");
// #X1516 @PLACE(504, -3663) => @ORIENT("R0");
// #X1517 @PLACE(544, -3663) => @ORIENT("R0");
// #X1518 @PLACE(584, -3663) => @ORIENT("R0");
// #X1519 @PLACE(624, -3663) => @ORIENT("R0");
// #X1520 @PLACE(504, -3698) => @ORIENT("R0");
// #X1521 @PLACE(544, -3698) => @ORIENT("R0");
// #X1522 @PLACE(584, -3698) => @ORIENT("R0");
// #X1523 @PLACE(624, -3698) => @ORIENT("R0");
// #X1524 @PLACE(504, -3733) => @ORIENT("R0");
// #X1525 @PLACE(544, -3733) => @ORIENT("R0");
// #X1526 @PLACE(584, -3733) => @ORIENT("R0");
// #X1527 @PLACE(624, -3733) => @ORIENT("R0");
// #X1528 @PLACE(504, -3768) => @ORIENT("R0");
// #X1529 @PLACE(544, -3768) => @ORIENT("R0");
// #X1530 @PLACE(584, -3768) => @ORIENT("R0");
// #X1531 @PLACE(624, -3768) => @ORIENT("R0");
// #X1532 @PLACE(504, -3803) => @ORIENT("R0");
// #X1533 @PLACE(544, -3803) => @ORIENT("R0");
// #X1534 @PLACE(584, -3803) => @ORIENT("R0");
// #X1535 @PLACE(624, -3803) => @ORIENT("R0");
// #X1536 @PLACE(0, -3848) => @ORIENT("R0");
// (-25, -3834) @TEXT("Panel 65 | X1536 - X1559", size=1.1, halign="start");
// #X1537 @PLACE(40, -3848) => @ORIENT("R0");
// #X1538 @PLACE(80, -3848) => @ORIENT("R0");
// #X1539 @PLACE(120, -3848) => @ORIENT("R0");
// #X1540 @PLACE(0, -3879) => @ORIENT("R0");
// #X1541 @PLACE(40, -3879) => @ORIENT("R0");
// #X1542 @PLACE(80, -3879) => @ORIENT("R0");
// #X1543 @PLACE(120, -3879) => @ORIENT("R0");
// #X1544 @PLACE(0, -3910) => @ORIENT("R0");
// #X1545 @PLACE(40, -3910) => @ORIENT("R0");
// #X1546 @PLACE(80, -3910) => @ORIENT("R0");
// #X1547 @PLACE(120, -3910) => @ORIENT("R0");
// #X1548 @PLACE(0, -3945) => @ORIENT("R0");
// #X1549 @PLACE(40, -3945) => @ORIENT("R0");
// #X1550 @PLACE(80, -3945) => @ORIENT("R0");
// #X1551 @PLACE(120, -3945) => @ORIENT("R0");
// #X1552 @PLACE(0, -3980) => @ORIENT("R0");
// #X1553 @PLACE(40, -3980) => @ORIENT("R0");
// #X1554 @PLACE(80, -3980) => @ORIENT("R0");
// #X1555 @PLACE(120, -3980) => @ORIENT("R0");
// #X1556 @PLACE(0, -4015) => @ORIENT("R0");
// #X1557 @PLACE(40, -4015) => @ORIENT("R0");
// #X1558 @PLACE(80, -4015) => @ORIENT("R0");
// #X1559 @PLACE(120, -4015) => @ORIENT("R0");
// #X1560 @PLACE(168, -3848) => @ORIENT("R0");
// (152, -3834) @TEXT("Panel 66 | X1560 - X1583", size=1.1, halign="start");
// #X1561 @PLACE(208, -3848) => @ORIENT("R0");
// #X1562 @PLACE(248, -3848) => @ORIENT("R0");
// #X1563 @PLACE(288, -3848) => @ORIENT("R0");
// #X1564 @PLACE(168, -3879) => @ORIENT("R0");
// #X1565 @PLACE(208, -3879) => @ORIENT("R0");
// #X1566 @PLACE(248, -3879) => @ORIENT("R0");
// #X1567 @PLACE(288, -3879) => @ORIENT("R0");
// #X1568 @PLACE(168, -3910) => @ORIENT("R0");
// #X1569 @PLACE(208, -3910) => @ORIENT("R0");
// #X1570 @PLACE(248, -3910) => @ORIENT("R0");
// #X1571 @PLACE(288, -3910) => @ORIENT("R0");
// #X1572 @PLACE(168, -3945) => @ORIENT("R0");
// #X1573 @PLACE(208, -3945) => @ORIENT("R0");
// #X1574 @PLACE(248, -3945) => @ORIENT("R0");
// #X1575 @PLACE(288, -3945) => @ORIENT("R0");
// #X1576 @PLACE(168, -3980) => @ORIENT("R0");
// #X1577 @PLACE(208, -3980) => @ORIENT("R0");
// #X1578 @PLACE(248, -3980) => @ORIENT("R0");
// #X1579 @PLACE(288, -3980) => @ORIENT("R0");
// #X1580 @PLACE(168, -4015) => @ORIENT("R0");
// #X1581 @PLACE(208, -4015) => @ORIENT("R0");
// #X1582 @PLACE(248, -4015) => @ORIENT("R0");
// #X1583 @PLACE(288, -4015) => @ORIENT("R0");
// #X1584 @PLACE(336, -3848) => @ORIENT("R0");
// (320, -3834) @TEXT("Panel 67 | X1584 - X1607", size=1.1, halign="start");
// #X1585 @PLACE(376, -3848) => @ORIENT("R0");
// #X1586 @PLACE(416, -3848) => @ORIENT("R0");
// #X1587 @PLACE(456, -3848) => @ORIENT("R0");
// #X1588 @PLACE(336, -3879) => @ORIENT("R0");
// #X1589 @PLACE(376, -3879) => @ORIENT("R0");
// #X1590 @PLACE(416, -3879) => @ORIENT("R0");
// #X1591 @PLACE(456, -3879) => @ORIENT("R0");
// #X1592 @PLACE(336, -3910) => @ORIENT("R0");
// #X1593 @PLACE(376, -3910) => @ORIENT("R0");
// #X1594 @PLACE(416, -3910) => @ORIENT("R0");
// #X1595 @PLACE(456, -3910) => @ORIENT("R0");
// #X1596 @PLACE(336, -3945) => @ORIENT("R0");
// #X1597 @PLACE(376, -3945) => @ORIENT("R0");
// #X1598 @PLACE(416, -3945) => @ORIENT("R0");
// #X1599 @PLACE(456, -3945) => @ORIENT("R0");
// #X1600 @PLACE(336, -3980) => @ORIENT("R0");
// #X1601 @PLACE(376, -3980) => @ORIENT("R0");
// #X1602 @PLACE(416, -3980) => @ORIENT("R0");
// #X1603 @PLACE(456, -3980) => @ORIENT("R0");
// #X1604 @PLACE(336, -4015) => @ORIENT("R0");
// #X1605 @PLACE(376, -4015) => @ORIENT("R0");
// #X1606 @PLACE(416, -4015) => @ORIENT("R0");
// #X1607 @PLACE(456, -4015) => @ORIENT("R0");
// #X1608 @PLACE(504, -3848) => @ORIENT("R0");
// (488, -3834) @TEXT("Panel 68 | X1608 - X1608", size=1.1, halign="start");
// (-25, -455) @TEXT("Frozen controller: coarse SAR -> fine SAR -> <=8 fresh measurements -> 32-ref HANDOFF", size=1.2, halign="start");
// (-25, -460) @TEXT("Two consecutive same-code errors <=1; one adjacent coarse recenter at a fine-range edge.", size=1, halign="start");
// (-25, -465) @TEXT("Gate atlas: original instance order. Each panel has 24 cells; select a named net to trace all tags.", size=1, halign="start");
// %t1 = $IO_PORT @ATTACH &n45 => @PLACE(-11, -514) => @ORIENT("R0");
// %t1 @TEXT("n45", key="name", size=0.75);
// &n45 @WIRE(mode="straight") {#X0:1 %t1:p};
// %t2 = $IO_PORT @ATTACH &refclk => @PLACE(-11, -518) => @ORIENT("R0");
// %t2 @TEXT("refclk", key="name", size=0.75);
// &refclk @WIRE(mode="straight") {#X0:2 %t2:p};
// %t3 = $IO_PORT @ATTACH &reset => @PLACE(-11, -522) => @ORIENT("R0");
// %t3 @TEXT("reset", key="name", size=0.75);
// &reset @WIRE(mode="straight") {#X0:3 %t3:p};
// %t4 = $IO_PORT @ATTACH &dac0 => @PLACE(10, -518) => @ORIENT("MY");
// %t4 @TEXT("dac0", key="name", size=0.75);
// &dac0 @WIRE(mode="straight") {#X0:4 %t4:p};
// %t5 = $SUPPLY @ATTACH &vdd => @PLACE(0, -505);
// &vdd @WIRE(mode="straight") {#X0:5 %t5:p};
// %t6 = $GROUND @ATTACH &vss => @PLACE(0, -531);
// &vss @WIRE(mode="straight") {#X0:6 %t6:p};
// %t7 = $IO_PORT @ATTACH &n46 => @PLACE(30, -514) => @ORIENT("R0");
// %t7 @TEXT("n46", key="name", size=0.75);
// &n46 @WIRE(mode="straight") {#X1:1 %t7:p};
// %t8 = $IO_PORT @ATTACH &refclk => @PLACE(30, -518) => @ORIENT("R0");
// %t8 @TEXT("refclk", key="name", size=0.75);
// &refclk @WIRE(mode="straight") {#X1:2 %t8:p};
// %t9 = $IO_PORT @ATTACH &reset => @PLACE(30, -522) => @ORIENT("R0");
// %t9 @TEXT("reset", key="name", size=0.75);
// &reset @WIRE(mode="straight") {#X1:3 %t9:p};
// %t10 = $IO_PORT @ATTACH &dac1 => @PLACE(50, -518) => @ORIENT("MY");
// %t10 @TEXT("dac1", key="name", size=0.75);
// &dac1 @WIRE(mode="straight") {#X1:4 %t10:p};
// %t11 = $SUPPLY @ATTACH &vdd => @PLACE(40, -505);
// &vdd @WIRE(mode="straight") {#X1:5 %t11:p};
// %t12 = $GROUND @ATTACH &vss => @PLACE(40, -531);
// &vss @WIRE(mode="straight") {#X1:6 %t12:p};
// %t13 = $IO_PORT @ATTACH &n47 => @PLACE(70, -514) => @ORIENT("R0");
// %t13 @TEXT("n47", key="name", size=0.75);
// &n47 @WIRE(mode="straight") {#X2:1 %t13:p};
// %t14 = $IO_PORT @ATTACH &refclk => @PLACE(70, -518) => @ORIENT("R0");
// %t14 @TEXT("refclk", key="name", size=0.75);
// &refclk @WIRE(mode="straight") {#X2:2 %t14:p};
// %t15 = $IO_PORT @ATTACH &reset => @PLACE(70, -522) => @ORIENT("R0");
// %t15 @TEXT("reset", key="name", size=0.75);
// &reset @WIRE(mode="straight") {#X2:3 %t15:p};
// %t16 = $IO_PORT @ATTACH &dac2 => @PLACE(90, -518) => @ORIENT("MY");
// %t16 @TEXT("dac2", key="name", size=0.75);
// &dac2 @WIRE(mode="straight") {#X2:4 %t16:p};
// %t17 = $SUPPLY @ATTACH &vdd => @PLACE(80, -505);
// &vdd @WIRE(mode="straight") {#X2:5 %t17:p};
// %t18 = $GROUND @ATTACH &vss => @PLACE(80, -531);
// &vss @WIRE(mode="straight") {#X2:6 %t18:p};
// %t19 = $IO_PORT @ATTACH &n48 => @PLACE(110, -514) => @ORIENT("R0");
// %t19 @TEXT("n48", key="name", size=0.75);
// &n48 @WIRE(mode="straight") {#X3:1 %t19:p};
// %t20 = $IO_PORT @ATTACH &refclk => @PLACE(110, -518) => @ORIENT("R0");
// %t20 @TEXT("refclk", key="name", size=0.75);
// &refclk @WIRE(mode="straight") {#X3:2 %t20:p};
// %t21 = $IO_PORT @ATTACH &reset => @PLACE(110, -522) => @ORIENT("R0");
// %t21 @TEXT("reset", key="name", size=0.75);
// &reset @WIRE(mode="straight") {#X3:3 %t21:p};
// %t22 = $IO_PORT @ATTACH &dac3 => @PLACE(130, -518) => @ORIENT("MY");
// %t22 @TEXT("dac3", key="name", size=0.75);
// &dac3 @WIRE(mode="straight") {#X3:4 %t22:p};
// %t23 = $SUPPLY @ATTACH &vdd => @PLACE(120, -505);
// &vdd @WIRE(mode="straight") {#X3:5 %t23:p};
// %t24 = $GROUND @ATTACH &vss => @PLACE(120, -531);
// &vss @WIRE(mode="straight") {#X3:6 %t24:p};
// %t25 = $IO_PORT @ATTACH &n49 => @PLACE(-11, -549) => @ORIENT("R0");
// %t25 @TEXT("n49", key="name", size=0.75);
// &n49 @WIRE(mode="straight") {#X4:1 %t25:p};
// %t26 = $IO_PORT @ATTACH &refclk => @PLACE(-11, -553) => @ORIENT("R0");
// %t26 @TEXT("refclk", key="name", size=0.75);
// &refclk @WIRE(mode="straight") {#X4:2 %t26:p};
// %t27 = $IO_PORT @ATTACH &reset => @PLACE(-11, -557) => @ORIENT("R0");
// %t27 @TEXT("reset", key="name", size=0.75);
// &reset @WIRE(mode="straight") {#X4:3 %t27:p};
// %t28 = $IO_PORT @ATTACH &dac4 => @PLACE(10, -553) => @ORIENT("MY");
// %t28 @TEXT("dac4", key="name", size=0.75);
// &dac4 @WIRE(mode="straight") {#X4:4 %t28:p};
// %t29 = $SUPPLY @ATTACH &vdd => @PLACE(0, -540);
// &vdd @WIRE(mode="straight") {#X4:5 %t29:p};
// %t30 = $GROUND @ATTACH &vss => @PLACE(0, -566);
// &vss @WIRE(mode="straight") {#X4:6 %t30:p};
// %t31 = $IO_PORT @ATTACH &n50 => @PLACE(30, -549) => @ORIENT("R0");
// %t31 @TEXT("n50", key="name", size=0.75);
// &n50 @WIRE(mode="straight") {#X5:1 %t31:p};
// %t32 = $IO_PORT @ATTACH &refclk => @PLACE(30, -553) => @ORIENT("R0");
// %t32 @TEXT("refclk", key="name", size=0.75);
// &refclk @WIRE(mode="straight") {#X5:2 %t32:p};
// %t33 = $IO_PORT @ATTACH &reset => @PLACE(30, -557) => @ORIENT("R0");
// %t33 @TEXT("reset", key="name", size=0.75);
// &reset @WIRE(mode="straight") {#X5:3 %t33:p};
// %t34 = $IO_PORT @ATTACH &n51 => @PLACE(50, -553) => @ORIENT("MY");
// %t34 @TEXT("n51", key="name", size=0.75);
// &n51 @WIRE(mode="straight") {#X5:4 %t34:p};
// %t35 = $SUPPLY @ATTACH &vdd => @PLACE(40, -540);
// &vdd @WIRE(mode="straight") {#X5:5 %t35:p};
// %t36 = $GROUND @ATTACH &vss => @PLACE(40, -566);
// &vss @WIRE(mode="straight") {#X5:6 %t36:p};
// %t37 = $IO_PORT @ATTACH &n52 => @PLACE(70, -549) => @ORIENT("R0");
// %t37 @TEXT("n52", key="name", size=0.75);
// &n52 @WIRE(mode="straight") {#X6:1 %t37:p};
// %t38 = $IO_PORT @ATTACH &refclk => @PLACE(70, -553) => @ORIENT("R0");
// %t38 @TEXT("refclk", key="name", size=0.75);
// &refclk @WIRE(mode="straight") {#X6:2 %t38:p};
// %t39 = $IO_PORT @ATTACH &reset => @PLACE(70, -557) => @ORIENT("R0");
// %t39 @TEXT("reset", key="name", size=0.75);
// &reset @WIRE(mode="straight") {#X6:3 %t39:p};
// %t40 = $IO_PORT @ATTACH &count_gate => @PLACE(90, -553) => @ORIENT("MY");
// %t40 @TEXT("count_gate", key="name", size=0.75);
// &count_gate @WIRE(mode="straight") {#X6:4 %t40:p};
// %t41 = $SUPPLY @ATTACH &vdd => @PLACE(80, -540);
// &vdd @WIRE(mode="straight") {#X6:5 %t41:p};
// %t42 = $GROUND @ATTACH &vss => @PLACE(80, -566);
// &vss @WIRE(mode="straight") {#X6:6 %t42:p};
// %t43 = $IO_PORT @ATTACH &n53 => @PLACE(110, -549) => @ORIENT("R0");
// %t43 @TEXT("n53", key="name", size=0.75);
// &n53 @WIRE(mode="straight") {#X7:1 %t43:p};
// %t44 = $IO_PORT @ATTACH &refclk => @PLACE(110, -553) => @ORIENT("R0");
// %t44 @TEXT("refclk", key="name", size=0.75);
// &refclk @WIRE(mode="straight") {#X7:2 %t44:p};
// %t45 = $IO_PORT @ATTACH &reset => @PLACE(110, -557) => @ORIENT("R0");
// %t45 @TEXT("reset", key="name", size=0.75);
// &reset @WIRE(mode="straight") {#X7:3 %t45:p};
// %t46 = $IO_PORT @ATTACH &n54 => @PLACE(130, -553) => @ORIENT("MY");
// %t46 @TEXT("n54", key="name", size=0.75);
// &n54 @WIRE(mode="straight") {#X7:4 %t46:p};
// %t47 = $SUPPLY @ATTACH &vdd => @PLACE(120, -540);
// &vdd @WIRE(mode="straight") {#X7:5 %t47:p};
// %t48 = $GROUND @ATTACH &vss => @PLACE(120, -566);
// &vss @WIRE(mode="straight") {#X7:6 %t48:p};
// %t49 = $IO_PORT @ATTACH &n55 => @PLACE(-11, -584) => @ORIENT("R0");
// %t49 @TEXT("n55", key="name", size=0.75);
// &n55 @WIRE(mode="straight") {#X8:1 %t49:p};
// %t50 = $IO_PORT @ATTACH &refclk => @PLACE(-11, -588) => @ORIENT("R0");
// %t50 @TEXT("refclk", key="name", size=0.75);
// &refclk @WIRE(mode="straight") {#X8:2 %t50:p};
// %t51 = $IO_PORT @ATTACH &reset => @PLACE(-11, -592) => @ORIENT("R0");
// %t51 @TEXT("reset", key="name", size=0.75);
// &reset @WIRE(mode="straight") {#X8:3 %t51:p};
// %t52 = $IO_PORT @ATTACH &count_reset => @PLACE(10, -588) => @ORIENT("MY");
// %t52 @TEXT("count_reset", key="name", size=0.75);
// &count_reset @WIRE(mode="straight") {#X8:4 %t52:p};
// %t53 = $SUPPLY @ATTACH &vdd => @PLACE(0, -575);
// &vdd @WIRE(mode="straight") {#X8:5 %t53:p};
// %t54 = $GROUND @ATTACH &vss => @PLACE(0, -601);
// &vss @WIRE(mode="straight") {#X8:6 %t54:p};
// %t55 = $IO_PORT @ATTACH &n56 => @PLACE(30, -584) => @ORIENT("R0");
// %t55 @TEXT("n56", key="name", size=0.75);
// &n56 @WIRE(mode="straight") {#X9:1 %t55:p};
// %t56 = $IO_PORT @ATTACH &refclk => @PLACE(30, -588) => @ORIENT("R0");
// %t56 @TEXT("refclk", key="name", size=0.75);
// &refclk @WIRE(mode="straight") {#X9:2 %t56:p};
// %t57 = $IO_PORT @ATTACH &reset => @PLACE(30, -592) => @ORIENT("R0");
// %t57 @TEXT("reset", key="name", size=0.75);
// &reset @WIRE(mode="straight") {#X9:3 %t57:p};
// %t58 = $IO_PORT @ATTACH &dac5 => @PLACE(50, -588) => @ORIENT("MY");
// %t58 @TEXT("dac5", key="name", size=0.75);
// &dac5 @WIRE(mode="straight") {#X9:4 %t58:p};
// %t59 = $SUPPLY @ATTACH &vdd => @PLACE(40, -575);
// &vdd @WIRE(mode="straight") {#X9:5 %t59:p};
// %t60 = $GROUND @ATTACH &vss => @PLACE(40, -601);
// &vss @WIRE(mode="straight") {#X9:6 %t60:p};
// %t61 = $IO_PORT @ATTACH &n57 => @PLACE(70, -584) => @ORIENT("R0");
// %t61 @TEXT("n57", key="name", size=0.75);
// &n57 @WIRE(mode="straight") {#X10:1 %t61:p};
// %t62 = $IO_PORT @ATTACH &refclk => @PLACE(70, -588) => @ORIENT("R0");
// %t62 @TEXT("refclk", key="name", size=0.75);
// &refclk @WIRE(mode="straight") {#X10:2 %t62:p};
// %t63 = $IO_PORT @ATTACH &reset => @PLACE(70, -592) => @ORIENT("R0");
// %t63 @TEXT("reset", key="name", size=0.75);
// &reset @WIRE(mode="straight") {#X10:3 %t63:p};
// %t64 = $IO_PORT @ATTACH &n58 => @PLACE(90, -588) => @ORIENT("MY");
// %t64 @TEXT("n58", key="name", size=0.75);
// &n58 @WIRE(mode="straight") {#X10:4 %t64:p};
// %t65 = $SUPPLY @ATTACH &vdd => @PLACE(80, -575);
// &vdd @WIRE(mode="straight") {#X10:5 %t65:p};
// %t66 = $GROUND @ATTACH &vss => @PLACE(80, -601);
// &vss @WIRE(mode="straight") {#X10:6 %t66:p};
// %t67 = $IO_PORT @ATTACH &n59 => @PLACE(110, -584) => @ORIENT("R0");
// %t67 @TEXT("n59", key="name", size=0.75);
// &n59 @WIRE(mode="straight") {#X11:1 %t67:p};
// %t68 = $IO_PORT @ATTACH &refclk => @PLACE(110, -588) => @ORIENT("R0");
// %t68 @TEXT("refclk", key="name", size=0.75);
// &refclk @WIRE(mode="straight") {#X11:2 %t68:p};
// %t69 = $IO_PORT @ATTACH &reset => @PLACE(110, -592) => @ORIENT("R0");
// %t69 @TEXT("reset", key="name", size=0.75);
// &reset @WIRE(mode="straight") {#X11:3 %t69:p};
// %t70 = $IO_PORT @ATTACH &n60 => @PLACE(130, -588) => @ORIENT("MY");
// %t70 @TEXT("n60", key="name", size=0.75);
// &n60 @WIRE(mode="straight") {#X11:4 %t70:p};
// %t71 = $SUPPLY @ATTACH &vdd => @PLACE(120, -575);
// &vdd @WIRE(mode="straight") {#X11:5 %t71:p};
// %t72 = $GROUND @ATTACH &vss => @PLACE(120, -601);
// &vss @WIRE(mode="straight") {#X11:6 %t72:p};
// %t73 = $IO_PORT @ATTACH &n61 => @PLACE(-11, -619) => @ORIENT("R0");
// %t73 @TEXT("n61", key="name", size=0.75);
// &n61 @WIRE(mode="straight") {#X12:1 %t73:p};
// %t74 = $IO_PORT @ATTACH &refclk => @PLACE(-11, -623) => @ORIENT("R0");
// %t74 @TEXT("refclk", key="name", size=0.75);
// &refclk @WIRE(mode="straight") {#X12:2 %t74:p};
// %t75 = $IO_PORT @ATTACH &reset => @PLACE(-11, -627) => @ORIENT("R0");
// %t75 @TEXT("reset", key="name", size=0.75);
// &reset @WIRE(mode="straight") {#X12:3 %t75:p};
// %t76 = $IO_PORT @ATTACH &n62 => @PLACE(10, -623) => @ORIENT("MY");
// %t76 @TEXT("n62", key="name", size=0.75);
// &n62 @WIRE(mode="straight") {#X12:4 %t76:p};
// %t77 = $SUPPLY @ATTACH &vdd => @PLACE(0, -610);
// &vdd @WIRE(mode="straight") {#X12:5 %t77:p};
// %t78 = $GROUND @ATTACH &vss => @PLACE(0, -636);
// &vss @WIRE(mode="straight") {#X12:6 %t78:p};
// %t79 = $IO_PORT @ATTACH &n63 => @PLACE(30, -619) => @ORIENT("R0");
// %t79 @TEXT("n63", key="name", size=0.75);
// &n63 @WIRE(mode="straight") {#X13:1 %t79:p};
// %t80 = $IO_PORT @ATTACH &refclk => @PLACE(30, -623) => @ORIENT("R0");
// %t80 @TEXT("refclk", key="name", size=0.75);
// &refclk @WIRE(mode="straight") {#X13:2 %t80:p};
// %t81 = $IO_PORT @ATTACH &reset => @PLACE(30, -627) => @ORIENT("R0");
// %t81 @TEXT("reset", key="name", size=0.75);
// &reset @WIRE(mode="straight") {#X13:3 %t81:p};
// %t82 = $IO_PORT @ATTACH &n64 => @PLACE(50, -623) => @ORIENT("MY");
// %t82 @TEXT("n64", key="name", size=0.75);
// &n64 @WIRE(mode="straight") {#X13:4 %t82:p};
// %t83 = $SUPPLY @ATTACH &vdd => @PLACE(40, -610);
// &vdd @WIRE(mode="straight") {#X13:5 %t83:p};
// %t84 = $GROUND @ATTACH &vss => @PLACE(40, -636);
// &vss @WIRE(mode="straight") {#X13:6 %t84:p};
// %t85 = $IO_PORT @ATTACH &n65 => @PLACE(70, -619) => @ORIENT("R0");
// %t85 @TEXT("n65", key="name", size=0.75);
// &n65 @WIRE(mode="straight") {#X14:1 %t85:p};
// %t86 = $IO_PORT @ATTACH &refclk => @PLACE(70, -623) => @ORIENT("R0");
// %t86 @TEXT("refclk", key="name", size=0.75);
// &refclk @WIRE(mode="straight") {#X14:2 %t86:p};
// %t87 = $IO_PORT @ATTACH &reset => @PLACE(70, -627) => @ORIENT("R0");
// %t87 @TEXT("reset", key="name", size=0.75);
// &reset @WIRE(mode="straight") {#X14:3 %t87:p};
// %t88 = $IO_PORT @ATTACH &n66 => @PLACE(90, -623) => @ORIENT("MY");
// %t88 @TEXT("n66", key="name", size=0.75);
// &n66 @WIRE(mode="straight") {#X14:4 %t88:p};
// %t89 = $SUPPLY @ATTACH &vdd => @PLACE(80, -610);
// &vdd @WIRE(mode="straight") {#X14:5 %t89:p};
// %t90 = $GROUND @ATTACH &vss => @PLACE(80, -636);
// &vss @WIRE(mode="straight") {#X14:6 %t90:p};
// %t91 = $IO_PORT @ATTACH &n67 => @PLACE(110, -619) => @ORIENT("R0");
// %t91 @TEXT("n67", key="name", size=0.75);
// &n67 @WIRE(mode="straight") {#X15:1 %t91:p};
// %t92 = $IO_PORT @ATTACH &refclk => @PLACE(110, -623) => @ORIENT("R0");
// %t92 @TEXT("refclk", key="name", size=0.75);
// &refclk @WIRE(mode="straight") {#X15:2 %t92:p};
// %t93 = $IO_PORT @ATTACH &reset => @PLACE(110, -627) => @ORIENT("R0");
// %t93 @TEXT("reset", key="name", size=0.75);
// &reset @WIRE(mode="straight") {#X15:3 %t93:p};
// %t94 = $IO_PORT @ATTACH &n68 => @PLACE(130, -623) => @ORIENT("MY");
// %t94 @TEXT("n68", key="name", size=0.75);
// &n68 @WIRE(mode="straight") {#X15:4 %t94:p};
// %t95 = $SUPPLY @ATTACH &vdd => @PLACE(120, -610);
// &vdd @WIRE(mode="straight") {#X15:5 %t95:p};
// %t96 = $GROUND @ATTACH &vss => @PLACE(120, -636);
// &vss @WIRE(mode="straight") {#X15:6 %t96:p};
// %t97 = $IO_PORT @ATTACH &n69 => @PLACE(-11, -654) => @ORIENT("R0");
// %t97 @TEXT("n69", key="name", size=0.75);
// &n69 @WIRE(mode="straight") {#X16:1 %t97:p};
// %t98 = $IO_PORT @ATTACH &refclk => @PLACE(-11, -658) => @ORIENT("R0");
// %t98 @TEXT("refclk", key="name", size=0.75);
// &refclk @WIRE(mode="straight") {#X16:2 %t98:p};
// %t99 = $IO_PORT @ATTACH &reset => @PLACE(-11, -662) => @ORIENT("R0");
// %t99 @TEXT("reset", key="name", size=0.75);
// &reset @WIRE(mode="straight") {#X16:3 %t99:p};
// %t100 = $IO_PORT @ATTACH &n70 => @PLACE(10, -658) => @ORIENT("MY");
// %t100 @TEXT("n70", key="name", size=0.75);
// &n70 @WIRE(mode="straight") {#X16:4 %t100:p};
// %t101 = $SUPPLY @ATTACH &vdd => @PLACE(0, -645);
// &vdd @WIRE(mode="straight") {#X16:5 %t101:p};
// %t102 = $GROUND @ATTACH &vss => @PLACE(0, -671);
// &vss @WIRE(mode="straight") {#X16:6 %t102:p};
// %t103 = $IO_PORT @ATTACH &n71 => @PLACE(30, -654) => @ORIENT("R0");
// %t103 @TEXT("n71", key="name", size=0.75);
// &n71 @WIRE(mode="straight") {#X17:1 %t103:p};
// %t104 = $IO_PORT @ATTACH &refclk => @PLACE(30, -658) => @ORIENT("R0");
// %t104 @TEXT("refclk", key="name", size=0.75);
// &refclk @WIRE(mode="straight") {#X17:2 %t104:p};
// %t105 = $IO_PORT @ATTACH &reset => @PLACE(30, -662) => @ORIENT("R0");
// %t105 @TEXT("reset", key="name", size=0.75);
// &reset @WIRE(mode="straight") {#X17:3 %t105:p};
// %t106 = $IO_PORT @ATTACH &n72 => @PLACE(50, -658) => @ORIENT("MY");
// %t106 @TEXT("n72", key="name", size=0.75);
// &n72 @WIRE(mode="straight") {#X17:4 %t106:p};
// %t107 = $SUPPLY @ATTACH &vdd => @PLACE(40, -645);
// &vdd @WIRE(mode="straight") {#X17:5 %t107:p};
// %t108 = $GROUND @ATTACH &vss => @PLACE(40, -671);
// &vss @WIRE(mode="straight") {#X17:6 %t108:p};
// %t109 = $IO_PORT @ATTACH &n73 => @PLACE(70, -654) => @ORIENT("R0");
// %t109 @TEXT("n73", key="name", size=0.75);
// &n73 @WIRE(mode="straight") {#X18:1 %t109:p};
// %t110 = $IO_PORT @ATTACH &refclk => @PLACE(70, -658) => @ORIENT("R0");
// %t110 @TEXT("refclk", key="name", size=0.75);
// &refclk @WIRE(mode="straight") {#X18:2 %t110:p};
// %t111 = $IO_PORT @ATTACH &reset => @PLACE(70, -662) => @ORIENT("R0");
// %t111 @TEXT("reset", key="name", size=0.75);
// &reset @WIRE(mode="straight") {#X18:3 %t111:p};
// %t112 = $IO_PORT @ATTACH &enable => @PLACE(90, -658) => @ORIENT("MY");
// %t112 @TEXT("enable", key="name", size=0.75);
// &enable @WIRE(mode="straight") {#X18:4 %t112:p};
// %t113 = $SUPPLY @ATTACH &vdd => @PLACE(80, -645);
// &vdd @WIRE(mode="straight") {#X18:5 %t113:p};
// %t114 = $GROUND @ATTACH &vss => @PLACE(80, -671);
// &vss @WIRE(mode="straight") {#X18:6 %t114:p};
// %t115 = $IO_PORT @ATTACH &n74 => @PLACE(110, -654) => @ORIENT("R0");
// %t115 @TEXT("n74", key="name", size=0.75);
// &n74 @WIRE(mode="straight") {#X19:1 %t115:p};
// %t116 = $IO_PORT @ATTACH &refclk => @PLACE(110, -658) => @ORIENT("R0");
// %t116 @TEXT("refclk", key="name", size=0.75);
// &refclk @WIRE(mode="straight") {#X19:2 %t116:p};
// %t117 = $IO_PORT @ATTACH &reset => @PLACE(110, -662) => @ORIENT("R0");
// %t117 @TEXT("reset", key="name", size=0.75);
// &reset @WIRE(mode="straight") {#X19:3 %t117:p};
// %t118 = $IO_PORT @ATTACH &n75 => @PLACE(130, -658) => @ORIENT("MY");
// %t118 @TEXT("n75", key="name", size=0.75);
// &n75 @WIRE(mode="straight") {#X19:4 %t118:p};
// %t119 = $SUPPLY @ATTACH &vdd => @PLACE(120, -645);
// &vdd @WIRE(mode="straight") {#X19:5 %t119:p};
// %t120 = $GROUND @ATTACH &vss => @PLACE(120, -671);
// &vss @WIRE(mode="straight") {#X19:6 %t120:p};
// %t121 = $IO_PORT @ATTACH &n76 => @PLACE(-11, -689) => @ORIENT("R0");
// %t121 @TEXT("n76", key="name", size=0.75);
// &n76 @WIRE(mode="straight") {#X20:1 %t121:p};
// %t122 = $IO_PORT @ATTACH &refclk => @PLACE(-11, -693) => @ORIENT("R0");
// %t122 @TEXT("refclk", key="name", size=0.75);
// &refclk @WIRE(mode="straight") {#X20:2 %t122:p};
// %t123 = $IO_PORT @ATTACH &reset => @PLACE(-11, -697) => @ORIENT("R0");
// %t123 @TEXT("reset", key="name", size=0.75);
// &reset @WIRE(mode="straight") {#X20:3 %t123:p};
// %t124 = $IO_PORT @ATTACH &n77 => @PLACE(10, -693) => @ORIENT("MY");
// %t124 @TEXT("n77", key="name", size=0.75);
// &n77 @WIRE(mode="straight") {#X20:4 %t124:p};
// %t125 = $SUPPLY @ATTACH &vdd => @PLACE(0, -680);
// &vdd @WIRE(mode="straight") {#X20:5 %t125:p};
// %t126 = $GROUND @ATTACH &vss => @PLACE(0, -706);
// &vss @WIRE(mode="straight") {#X20:6 %t126:p};
// %t127 = $IO_PORT @ATTACH &n78 => @PLACE(30, -689) => @ORIENT("R0");
// %t127 @TEXT("n78", key="name", size=0.75);
// &n78 @WIRE(mode="straight") {#X21:1 %t127:p};
// %t128 = $IO_PORT @ATTACH &refclk => @PLACE(30, -693) => @ORIENT("R0");
// %t128 @TEXT("refclk", key="name", size=0.75);
// &refclk @WIRE(mode="straight") {#X21:2 %t128:p};
// %t129 = $IO_PORT @ATTACH &reset => @PLACE(30, -697) => @ORIENT("R0");
// %t129 @TEXT("reset", key="name", size=0.75);
// &reset @WIRE(mode="straight") {#X21:3 %t129:p};
// %t130 = $IO_PORT @ATTACH &n79 => @PLACE(50, -693) => @ORIENT("MY");
// %t130 @TEXT("n79", key="name", size=0.75);
// &n79 @WIRE(mode="straight") {#X21:4 %t130:p};
// %t131 = $SUPPLY @ATTACH &vdd => @PLACE(40, -680);
// &vdd @WIRE(mode="straight") {#X21:5 %t131:p};
// %t132 = $GROUND @ATTACH &vss => @PLACE(40, -706);
// &vss @WIRE(mode="straight") {#X21:6 %t132:p};
// %t133 = $IO_PORT @ATTACH &n80 => @PLACE(70, -689) => @ORIENT("R0");
// %t133 @TEXT("n80", key="name", size=0.75);
// &n80 @WIRE(mode="straight") {#X22:1 %t133:p};
// %t134 = $IO_PORT @ATTACH &refclk => @PLACE(70, -693) => @ORIENT("R0");
// %t134 @TEXT("refclk", key="name", size=0.75);
// &refclk @WIRE(mode="straight") {#X22:2 %t134:p};
// %t135 = $IO_PORT @ATTACH &reset => @PLACE(70, -697) => @ORIENT("R0");
// %t135 @TEXT("reset", key="name", size=0.75);
// &reset @WIRE(mode="straight") {#X22:3 %t135:p};
// %t136 = $IO_PORT @ATTACH &n81 => @PLACE(90, -693) => @ORIENT("MY");
// %t136 @TEXT("n81", key="name", size=0.75);
// &n81 @WIRE(mode="straight") {#X22:4 %t136:p};
// %t137 = $SUPPLY @ATTACH &vdd => @PLACE(80, -680);
// &vdd @WIRE(mode="straight") {#X22:5 %t137:p};
// %t138 = $GROUND @ATTACH &vss => @PLACE(80, -706);
// &vss @WIRE(mode="straight") {#X22:6 %t138:p};
// %t139 = $IO_PORT @ATTACH &n82 => @PLACE(110, -689) => @ORIENT("R0");
// %t139 @TEXT("n82", key="name", size=0.75);
// &n82 @WIRE(mode="straight") {#X23:1 %t139:p};
// %t140 = $IO_PORT @ATTACH &refclk => @PLACE(110, -693) => @ORIENT("R0");
// %t140 @TEXT("refclk", key="name", size=0.75);
// &refclk @WIRE(mode="straight") {#X23:2 %t140:p};
// %t141 = $IO_PORT @ATTACH &reset => @PLACE(110, -697) => @ORIENT("R0");
// %t141 @TEXT("reset", key="name", size=0.75);
// &reset @WIRE(mode="straight") {#X23:3 %t141:p};
// %t142 = $IO_PORT @ATTACH &n83 => @PLACE(130, -693) => @ORIENT("MY");
// %t142 @TEXT("n83", key="name", size=0.75);
// &n83 @WIRE(mode="straight") {#X23:4 %t142:p};
// %t143 = $SUPPLY @ATTACH &vdd => @PLACE(120, -680);
// &vdd @WIRE(mode="straight") {#X23:5 %t143:p};
// %t144 = $GROUND @ATTACH &vss => @PLACE(120, -706);
// &vss @WIRE(mode="straight") {#X23:6 %t144:p};
// %t145 = $IO_PORT @ATTACH &n84 => @PLACE(158, -514) => @ORIENT("R0");
// %t145 @TEXT("n84", key="name", size=0.75);
// &n84 @WIRE(mode="straight") {#X24:1 %t145:p};
// %t146 = $IO_PORT @ATTACH &refclk => @PLACE(158, -518) => @ORIENT("R0");
// %t146 @TEXT("refclk", key="name", size=0.75);
// &refclk @WIRE(mode="straight") {#X24:2 %t146:p};
// %t147 = $IO_PORT @ATTACH &reset => @PLACE(158, -522) => @ORIENT("R0");
// %t147 @TEXT("reset", key="name", size=0.75);
// &reset @WIRE(mode="straight") {#X24:3 %t147:p};
// %t148 = $IO_PORT @ATTACH &n85 => @PLACE(178, -518) => @ORIENT("MY");
// %t148 @TEXT("n85", key="name", size=0.75);
// &n85 @WIRE(mode="straight") {#X24:4 %t148:p};
// %t149 = $SUPPLY @ATTACH &vdd => @PLACE(168, -505);
// &vdd @WIRE(mode="straight") {#X24:5 %t149:p};
// %t150 = $GROUND @ATTACH &vss => @PLACE(168, -531);
// &vss @WIRE(mode="straight") {#X24:6 %t150:p};
// %t151 = $IO_PORT @ATTACH &n86 => @PLACE(198, -514) => @ORIENT("R0");
// %t151 @TEXT("n86", key="name", size=0.75);
// &n86 @WIRE(mode="straight") {#X25:1 %t151:p};
// %t152 = $IO_PORT @ATTACH &refclk => @PLACE(198, -518) => @ORIENT("R0");
// %t152 @TEXT("refclk", key="name", size=0.75);
// &refclk @WIRE(mode="straight") {#X25:2 %t152:p};
// %t153 = $IO_PORT @ATTACH &reset => @PLACE(198, -522) => @ORIENT("R0");
// %t153 @TEXT("reset", key="name", size=0.75);
// &reset @WIRE(mode="straight") {#X25:3 %t153:p};
// %t154 = $IO_PORT @ATTACH &range_error => @PLACE(218, -518) => @ORIENT("MY");
// %t154 @TEXT("range_error", key="name", size=0.75);
// &range_error @WIRE(mode="straight") {#X25:4 %t154:p};
// %t155 = $SUPPLY @ATTACH &vdd => @PLACE(208, -505);
// &vdd @WIRE(mode="straight") {#X25:5 %t155:p};
// %t156 = $GROUND @ATTACH &vss => @PLACE(208, -531);
// &vss @WIRE(mode="straight") {#X25:6 %t156:p};
// %t157 = $IO_PORT @ATTACH &n87 => @PLACE(238, -514) => @ORIENT("R0");
// %t157 @TEXT("n87", key="name", size=0.75);
// &n87 @WIRE(mode="straight") {#X26:1 %t157:p};
// %t158 = $IO_PORT @ATTACH &refclk => @PLACE(238, -518) => @ORIENT("R0");
// %t158 @TEXT("refclk", key="name", size=0.75);
// &refclk @WIRE(mode="straight") {#X26:2 %t158:p};
// %t159 = $IO_PORT @ATTACH &reset => @PLACE(238, -522) => @ORIENT("R0");
// %t159 @TEXT("reset", key="name", size=0.75);
// &reset @WIRE(mode="straight") {#X26:3 %t159:p};
// %t160 = $IO_PORT @ATTACH &n88 => @PLACE(258, -518) => @ORIENT("MY");
// %t160 @TEXT("n88", key="name", size=0.75);
// &n88 @WIRE(mode="straight") {#X26:4 %t160:p};
// %t161 = $SUPPLY @ATTACH &vdd => @PLACE(248, -505);
// &vdd @WIRE(mode="straight") {#X26:5 %t161:p};
// %t162 = $GROUND @ATTACH &vss => @PLACE(248, -531);
// &vss @WIRE(mode="straight") {#X26:6 %t162:p};
// %t163 = $IO_PORT @ATTACH &n89 => @PLACE(278, -514) => @ORIENT("R0");
// %t163 @TEXT("n89", key="name", size=0.75);
// &n89 @WIRE(mode="straight") {#X27:1 %t163:p};
// %t164 = $IO_PORT @ATTACH &refclk => @PLACE(278, -518) => @ORIENT("R0");
// %t164 @TEXT("refclk", key="name", size=0.75);
// &refclk @WIRE(mode="straight") {#X27:2 %t164:p};
// %t165 = $IO_PORT @ATTACH &reset => @PLACE(278, -522) => @ORIENT("R0");
// %t165 @TEXT("reset", key="name", size=0.75);
// &reset @WIRE(mode="straight") {#X27:3 %t165:p};
// %t166 = $IO_PORT @ATTACH &state_out0 => @PLACE(298, -518) => @ORIENT("MY");
// %t166 @TEXT("state_out0", key="name", size=0.75);
// &state_out0 @WIRE(mode="straight") {#X27:4 %t166:p};
// %t167 = $SUPPLY @ATTACH &vdd => @PLACE(288, -505);
// &vdd @WIRE(mode="straight") {#X27:5 %t167:p};
// %t168 = $GROUND @ATTACH &vss => @PLACE(288, -531);
// &vss @WIRE(mode="straight") {#X27:6 %t168:p};
// %t169 = $IO_PORT @ATTACH &n90 => @PLACE(158, -549) => @ORIENT("R0");
// %t169 @TEXT("n90", key="name", size=0.75);
// &n90 @WIRE(mode="straight") {#X28:1 %t169:p};
// %t170 = $IO_PORT @ATTACH &refclk => @PLACE(158, -553) => @ORIENT("R0");
// %t170 @TEXT("refclk", key="name", size=0.75);
// &refclk @WIRE(mode="straight") {#X28:2 %t170:p};
// %t171 = $IO_PORT @ATTACH &reset => @PLACE(158, -557) => @ORIENT("R0");
// %t171 @TEXT("reset", key="name", size=0.75);
// &reset @WIRE(mode="straight") {#X28:3 %t171:p};
// %t172 = $IO_PORT @ATTACH &state_out1 => @PLACE(178, -553) => @ORIENT("MY");
// %t172 @TEXT("state_out1", key="name", size=0.75);
// &state_out1 @WIRE(mode="straight") {#X28:4 %t172:p};
// %t173 = $SUPPLY @ATTACH &vdd => @PLACE(168, -540);
// &vdd @WIRE(mode="straight") {#X28:5 %t173:p};
// %t174 = $GROUND @ATTACH &vss => @PLACE(168, -566);
// &vss @WIRE(mode="straight") {#X28:6 %t174:p};
// %t175 = $IO_PORT @ATTACH &n91 => @PLACE(198, -549) => @ORIENT("R0");
// %t175 @TEXT("n91", key="name", size=0.75);
// &n91 @WIRE(mode="straight") {#X29:1 %t175:p};
// %t176 = $IO_PORT @ATTACH &refclk => @PLACE(198, -553) => @ORIENT("R0");
// %t176 @TEXT("refclk", key="name", size=0.75);
// &refclk @WIRE(mode="straight") {#X29:2 %t176:p};
// %t177 = $IO_PORT @ATTACH &reset => @PLACE(198, -557) => @ORIENT("R0");
// %t177 @TEXT("reset", key="name", size=0.75);
// &reset @WIRE(mode="straight") {#X29:3 %t177:p};
// %t178 = $IO_PORT @ATTACH &state_out2 => @PLACE(218, -553) => @ORIENT("MY");
// %t178 @TEXT("state_out2", key="name", size=0.75);
// &state_out2 @WIRE(mode="straight") {#X29:4 %t178:p};
// %t179 = $SUPPLY @ATTACH &vdd => @PLACE(208, -540);
// &vdd @WIRE(mode="straight") {#X29:5 %t179:p};
// %t180 = $GROUND @ATTACH &vss => @PLACE(208, -566);
// &vss @WIRE(mode="straight") {#X29:6 %t180:p};
// %t181 = $IO_PORT @ATTACH &n92 => @PLACE(238, -549) => @ORIENT("R0");
// %t181 @TEXT("n92", key="name", size=0.75);
// &n92 @WIRE(mode="straight") {#X30:1 %t181:p};
// %t182 = $IO_PORT @ATTACH &refclk => @PLACE(238, -553) => @ORIENT("R0");
// %t182 @TEXT("refclk", key="name", size=0.75);
// &refclk @WIRE(mode="straight") {#X30:2 %t182:p};
// %t183 = $IO_PORT @ATTACH &reset => @PLACE(238, -557) => @ORIENT("R0");
// %t183 @TEXT("reset", key="name", size=0.75);
// &reset @WIRE(mode="straight") {#X30:3 %t183:p};
// %t184 = $IO_PORT @ATTACH &n93 => @PLACE(258, -553) => @ORIENT("MY");
// %t184 @TEXT("n93", key="name", size=0.75);
// &n93 @WIRE(mode="straight") {#X30:4 %t184:p};
// %t185 = $SUPPLY @ATTACH &vdd => @PLACE(248, -540);
// &vdd @WIRE(mode="straight") {#X30:5 %t185:p};
// %t186 = $GROUND @ATTACH &vss => @PLACE(248, -566);
// &vss @WIRE(mode="straight") {#X30:6 %t186:p};
// %t187 = $IO_PORT @ATTACH &n94 => @PLACE(278, -549) => @ORIENT("R0");
// %t187 @TEXT("n94", key="name", size=0.75);
// &n94 @WIRE(mode="straight") {#X31:1 %t187:p};
// %t188 = $IO_PORT @ATTACH &refclk => @PLACE(278, -553) => @ORIENT("R0");
// %t188 @TEXT("refclk", key="name", size=0.75);
// &refclk @WIRE(mode="straight") {#X31:2 %t188:p};
// %t189 = $IO_PORT @ATTACH &reset => @PLACE(278, -557) => @ORIENT("R0");
// %t189 @TEXT("reset", key="name", size=0.75);
// &reset @WIRE(mode="straight") {#X31:3 %t189:p};
// %t190 = $IO_PORT @ATTACH &n95 => @PLACE(298, -553) => @ORIENT("MY");
// %t190 @TEXT("n95", key="name", size=0.75);
// &n95 @WIRE(mode="straight") {#X31:4 %t190:p};
// %t191 = $SUPPLY @ATTACH &vdd => @PLACE(288, -540);
// &vdd @WIRE(mode="straight") {#X31:5 %t191:p};
// %t192 = $GROUND @ATTACH &vss => @PLACE(288, -566);
// &vss @WIRE(mode="straight") {#X31:6 %t192:p};
// %t193 = $IO_PORT @ATTACH &n96 => @PLACE(158, -584) => @ORIENT("R0");
// %t193 @TEXT("n96", key="name", size=0.75);
// &n96 @WIRE(mode="straight") {#X32:1 %t193:p};
// %t194 = $IO_PORT @ATTACH &refclk => @PLACE(158, -588) => @ORIENT("R0");
// %t194 @TEXT("refclk", key="name", size=0.75);
// &refclk @WIRE(mode="straight") {#X32:2 %t194:p};
// %t195 = $IO_PORT @ATTACH &reset => @PLACE(158, -592) => @ORIENT("R0");
// %t195 @TEXT("reset", key="name", size=0.75);
// &reset @WIRE(mode="straight") {#X32:3 %t195:p};
// %t196 = $IO_PORT @ATTACH &n97 => @PLACE(178, -588) => @ORIENT("MY");
// %t196 @TEXT("n97", key="name", size=0.75);
// &n97 @WIRE(mode="straight") {#X32:4 %t196:p};
// %t197 = $SUPPLY @ATTACH &vdd => @PLACE(168, -575);
// &vdd @WIRE(mode="straight") {#X32:5 %t197:p};
// %t198 = $GROUND @ATTACH &vss => @PLACE(168, -601);
// &vss @WIRE(mode="straight") {#X32:6 %t198:p};
// %t199 = $IO_PORT @ATTACH &n98 => @PLACE(198, -584) => @ORIENT("R0");
// %t199 @TEXT("n98", key="name", size=0.75);
// &n98 @WIRE(mode="straight") {#X33:1 %t199:p};
// %t200 = $IO_PORT @ATTACH &refclk => @PLACE(198, -588) => @ORIENT("R0");
// %t200 @TEXT("refclk", key="name", size=0.75);
// &refclk @WIRE(mode="straight") {#X33:2 %t200:p};
// %t201 = $IO_PORT @ATTACH &reset => @PLACE(198, -592) => @ORIENT("R0");
// %t201 @TEXT("reset", key="name", size=0.75);
// &reset @WIRE(mode="straight") {#X33:3 %t201:p};
// %t202 = $IO_PORT @ATTACH &n99 => @PLACE(218, -588) => @ORIENT("MY");
// %t202 @TEXT("n99", key="name", size=0.75);
// &n99 @WIRE(mode="straight") {#X33:4 %t202:p};
// %t203 = $SUPPLY @ATTACH &vdd => @PLACE(208, -575);
// &vdd @WIRE(mode="straight") {#X33:5 %t203:p};
// %t204 = $GROUND @ATTACH &vss => @PLACE(208, -601);
// &vss @WIRE(mode="straight") {#X33:6 %t204:p};
// %t205 = $IO_PORT @ATTACH &n100 => @PLACE(238, -584) => @ORIENT("R0");
// %t205 @TEXT("n100", key="name", size=0.75);
// &n100 @WIRE(mode="straight") {#X34:1 %t205:p};
// %t206 = $IO_PORT @ATTACH &refclk => @PLACE(238, -588) => @ORIENT("R0");
// %t206 @TEXT("refclk", key="name", size=0.75);
// &refclk @WIRE(mode="straight") {#X34:2 %t206:p};
// %t207 = $IO_PORT @ATTACH &reset => @PLACE(238, -592) => @ORIENT("R0");
// %t207 @TEXT("reset", key="name", size=0.75);
// &reset @WIRE(mode="straight") {#X34:3 %t207:p};
// %t208 = $IO_PORT @ATTACH &n101 => @PLACE(258, -588) => @ORIENT("MY");
// %t208 @TEXT("n101", key="name", size=0.75);
// &n101 @WIRE(mode="straight") {#X34:4 %t208:p};
// %t209 = $SUPPLY @ATTACH &vdd => @PLACE(248, -575);
// &vdd @WIRE(mode="straight") {#X34:5 %t209:p};
// %t210 = $GROUND @ATTACH &vss => @PLACE(248, -601);
// &vss @WIRE(mode="straight") {#X34:6 %t210:p};
// %t211 = $IO_PORT @ATTACH &n102 => @PLACE(278, -584) => @ORIENT("R0");
// %t211 @TEXT("n102", key="name", size=0.75);
// &n102 @WIRE(mode="straight") {#X35:1 %t211:p};
// %t212 = $IO_PORT @ATTACH &refclk => @PLACE(278, -588) => @ORIENT("R0");
// %t212 @TEXT("refclk", key="name", size=0.75);
// &refclk @WIRE(mode="straight") {#X35:2 %t212:p};
// %t213 = $IO_PORT @ATTACH &reset => @PLACE(278, -592) => @ORIENT("R0");
// %t213 @TEXT("reset", key="name", size=0.75);
// &reset @WIRE(mode="straight") {#X35:3 %t213:p};
// %t214 = $IO_PORT @ATTACH &n103 => @PLACE(298, -588) => @ORIENT("MY");
// %t214 @TEXT("n103", key="name", size=0.75);
// &n103 @WIRE(mode="straight") {#X35:4 %t214:p};
// %t215 = $SUPPLY @ATTACH &vdd => @PLACE(288, -575);
// &vdd @WIRE(mode="straight") {#X35:5 %t215:p};
// %t216 = $GROUND @ATTACH &vss => @PLACE(288, -601);
// &vss @WIRE(mode="straight") {#X35:6 %t216:p};
// %t217 = $IO_PORT @ATTACH &n104 => @PLACE(158, -619) => @ORIENT("R0");
// %t217 @TEXT("n104", key="name", size=0.75);
// &n104 @WIRE(mode="straight") {#X36:1 %t217:p};
// %t218 = $IO_PORT @ATTACH &refclk => @PLACE(158, -623) => @ORIENT("R0");
// %t218 @TEXT("refclk", key="name", size=0.75);
// &refclk @WIRE(mode="straight") {#X36:2 %t218:p};
// %t219 = $IO_PORT @ATTACH &reset => @PLACE(158, -627) => @ORIENT("R0");
// %t219 @TEXT("reset", key="name", size=0.75);
// &reset @WIRE(mode="straight") {#X36:3 %t219:p};
// %t220 = $IO_PORT @ATTACH &n105 => @PLACE(178, -623) => @ORIENT("MY");
// %t220 @TEXT("n105", key="name", size=0.75);
// &n105 @WIRE(mode="straight") {#X36:4 %t220:p};
// %t221 = $SUPPLY @ATTACH &vdd => @PLACE(168, -610);
// &vdd @WIRE(mode="straight") {#X36:5 %t221:p};
// %t222 = $GROUND @ATTACH &vss => @PLACE(168, -636);
// &vss @WIRE(mode="straight") {#X36:6 %t222:p};
// %t223 = $IO_PORT @ATTACH &n106 => @PLACE(198, -619) => @ORIENT("R0");
// %t223 @TEXT("n106", key="name", size=0.75);
// &n106 @WIRE(mode="straight") {#X37:1 %t223:p};
// %t224 = $IO_PORT @ATTACH &refclk => @PLACE(198, -623) => @ORIENT("R0");
// %t224 @TEXT("refclk", key="name", size=0.75);
// &refclk @WIRE(mode="straight") {#X37:2 %t224:p};
// %t225 = $IO_PORT @ATTACH &reset => @PLACE(198, -627) => @ORIENT("R0");
// %t225 @TEXT("reset", key="name", size=0.75);
// &reset @WIRE(mode="straight") {#X37:3 %t225:p};
// %t226 = $IO_PORT @ATTACH &n107 => @PLACE(218, -623) => @ORIENT("MY");
// %t226 @TEXT("n107", key="name", size=0.75);
// &n107 @WIRE(mode="straight") {#X37:4 %t226:p};
// %t227 = $SUPPLY @ATTACH &vdd => @PLACE(208, -610);
// &vdd @WIRE(mode="straight") {#X37:5 %t227:p};
// %t228 = $GROUND @ATTACH &vss => @PLACE(208, -636);
// &vss @WIRE(mode="straight") {#X37:6 %t228:p};
// %t229 = $IO_PORT @ATTACH &n108 => @PLACE(238, -619) => @ORIENT("R0");
// %t229 @TEXT("n108", key="name", size=0.75);
// &n108 @WIRE(mode="straight") {#X38:1 %t229:p};
// %t230 = $IO_PORT @ATTACH &refclk => @PLACE(238, -623) => @ORIENT("R0");
// %t230 @TEXT("refclk", key="name", size=0.75);
// &refclk @WIRE(mode="straight") {#X38:2 %t230:p};
// %t231 = $IO_PORT @ATTACH &reset => @PLACE(238, -627) => @ORIENT("R0");
// %t231 @TEXT("reset", key="name", size=0.75);
// &reset @WIRE(mode="straight") {#X38:3 %t231:p};
// %t232 = $IO_PORT @ATTACH &n109 => @PLACE(258, -623) => @ORIENT("MY");
// %t232 @TEXT("n109", key="name", size=0.75);
// &n109 @WIRE(mode="straight") {#X38:4 %t232:p};
// %t233 = $SUPPLY @ATTACH &vdd => @PLACE(248, -610);
// &vdd @WIRE(mode="straight") {#X38:5 %t233:p};
// %t234 = $GROUND @ATTACH &vss => @PLACE(248, -636);
// &vss @WIRE(mode="straight") {#X38:6 %t234:p};
// %t235 = $IO_PORT @ATTACH &n110 => @PLACE(278, -619) => @ORIENT("R0");
// %t235 @TEXT("n110", key="name", size=0.75);
// &n110 @WIRE(mode="straight") {#X39:1 %t235:p};
// %t236 = $IO_PORT @ATTACH &refclk => @PLACE(278, -623) => @ORIENT("R0");
// %t236 @TEXT("refclk", key="name", size=0.75);
// &refclk @WIRE(mode="straight") {#X39:2 %t236:p};
// %t237 = $IO_PORT @ATTACH &reset => @PLACE(278, -627) => @ORIENT("R0");
// %t237 @TEXT("reset", key="name", size=0.75);
// &reset @WIRE(mode="straight") {#X39:3 %t237:p};
// %t238 = $IO_PORT @ATTACH &n111 => @PLACE(298, -623) => @ORIENT("MY");
// %t238 @TEXT("n111", key="name", size=0.75);
// &n111 @WIRE(mode="straight") {#X39:4 %t238:p};
// %t239 = $SUPPLY @ATTACH &vdd => @PLACE(288, -610);
// &vdd @WIRE(mode="straight") {#X39:5 %t239:p};
// %t240 = $GROUND @ATTACH &vss => @PLACE(288, -636);
// &vss @WIRE(mode="straight") {#X39:6 %t240:p};
// %t241 = $IO_PORT @ATTACH &n112 => @PLACE(158, -654) => @ORIENT("R0");
// %t241 @TEXT("n112", key="name", size=0.75);
// &n112 @WIRE(mode="straight") {#X40:1 %t241:p};
// %t242 = $IO_PORT @ATTACH &refclk => @PLACE(158, -658) => @ORIENT("R0");
// %t242 @TEXT("refclk", key="name", size=0.75);
// &refclk @WIRE(mode="straight") {#X40:2 %t242:p};
// %t243 = $IO_PORT @ATTACH &reset => @PLACE(158, -662) => @ORIENT("R0");
// %t243 @TEXT("reset", key="name", size=0.75);
// &reset @WIRE(mode="straight") {#X40:3 %t243:p};
// %t244 = $IO_PORT @ATTACH &n113 => @PLACE(178, -658) => @ORIENT("MY");
// %t244 @TEXT("n113", key="name", size=0.75);
// &n113 @WIRE(mode="straight") {#X40:4 %t244:p};
// %t245 = $SUPPLY @ATTACH &vdd => @PLACE(168, -645);
// &vdd @WIRE(mode="straight") {#X40:5 %t245:p};
// %t246 = $GROUND @ATTACH &vss => @PLACE(168, -671);
// &vss @WIRE(mode="straight") {#X40:6 %t246:p};
// %t247 = $IO_PORT @ATTACH &n114 => @PLACE(198, -654) => @ORIENT("R0");
// %t247 @TEXT("n114", key="name", size=0.75);
// &n114 @WIRE(mode="straight") {#X41:1 %t247:p};
// %t248 = $IO_PORT @ATTACH &refclk => @PLACE(198, -658) => @ORIENT("R0");
// %t248 @TEXT("refclk", key="name", size=0.75);
// &refclk @WIRE(mode="straight") {#X41:2 %t248:p};
// %t249 = $IO_PORT @ATTACH &reset => @PLACE(198, -662) => @ORIENT("R0");
// %t249 @TEXT("reset", key="name", size=0.75);
// &reset @WIRE(mode="straight") {#X41:3 %t249:p};
// %t250 = $IO_PORT @ATTACH &n115 => @PLACE(218, -658) => @ORIENT("MY");
// %t250 @TEXT("n115", key="name", size=0.75);
// &n115 @WIRE(mode="straight") {#X41:4 %t250:p};
// %t251 = $SUPPLY @ATTACH &vdd => @PLACE(208, -645);
// &vdd @WIRE(mode="straight") {#X41:5 %t251:p};
// %t252 = $GROUND @ATTACH &vss => @PLACE(208, -671);
// &vss @WIRE(mode="straight") {#X41:6 %t252:p};
// %t253 = $IO_PORT @ATTACH &n116 => @PLACE(238, -654) => @ORIENT("R0");
// %t253 @TEXT("n116", key="name", size=0.75);
// &n116 @WIRE(mode="straight") {#X42:1 %t253:p};
// %t254 = $IO_PORT @ATTACH &refclk => @PLACE(238, -658) => @ORIENT("R0");
// %t254 @TEXT("refclk", key="name", size=0.75);
// &refclk @WIRE(mode="straight") {#X42:2 %t254:p};
// %t255 = $IO_PORT @ATTACH &reset => @PLACE(238, -662) => @ORIENT("R0");
// %t255 @TEXT("reset", key="name", size=0.75);
// &reset @WIRE(mode="straight") {#X42:3 %t255:p};
// %t256 = $IO_PORT @ATTACH &n117 => @PLACE(258, -658) => @ORIENT("MY");
// %t256 @TEXT("n117", key="name", size=0.75);
// &n117 @WIRE(mode="straight") {#X42:4 %t256:p};
// %t257 = $SUPPLY @ATTACH &vdd => @PLACE(248, -645);
// &vdd @WIRE(mode="straight") {#X42:5 %t257:p};
// %t258 = $GROUND @ATTACH &vss => @PLACE(248, -671);
// &vss @WIRE(mode="straight") {#X42:6 %t258:p};
// %t259 = $IO_PORT @ATTACH &n118 => @PLACE(278, -654) => @ORIENT("R0");
// %t259 @TEXT("n118", key="name", size=0.75);
// &n118 @WIRE(mode="straight") {#X43:1 %t259:p};
// %t260 = $IO_PORT @ATTACH &refclk => @PLACE(278, -658) => @ORIENT("R0");
// %t260 @TEXT("refclk", key="name", size=0.75);
// &refclk @WIRE(mode="straight") {#X43:2 %t260:p};
// %t261 = $IO_PORT @ATTACH &reset => @PLACE(278, -662) => @ORIENT("R0");
// %t261 @TEXT("reset", key="name", size=0.75);
// &reset @WIRE(mode="straight") {#X43:3 %t261:p};
// %t262 = $IO_PORT @ATTACH &coarse0 => @PLACE(298, -658) => @ORIENT("MY");
// %t262 @TEXT("coarse0", key="name", size=0.75);
// &coarse0 @WIRE(mode="straight") {#X43:4 %t262:p};
// %t263 = $SUPPLY @ATTACH &vdd => @PLACE(288, -645);
// &vdd @WIRE(mode="straight") {#X43:5 %t263:p};
// %t264 = $GROUND @ATTACH &vss => @PLACE(288, -671);
// &vss @WIRE(mode="straight") {#X43:6 %t264:p};
// %t265 = $IO_PORT @ATTACH &n119 => @PLACE(158, -689) => @ORIENT("R0");
// %t265 @TEXT("n119", key="name", size=0.75);
// &n119 @WIRE(mode="straight") {#X44:1 %t265:p};
// %t266 = $IO_PORT @ATTACH &refclk => @PLACE(158, -693) => @ORIENT("R0");
// %t266 @TEXT("refclk", key="name", size=0.75);
// &refclk @WIRE(mode="straight") {#X44:2 %t266:p};
// %t267 = $IO_PORT @ATTACH &reset => @PLACE(158, -697) => @ORIENT("R0");
// %t267 @TEXT("reset", key="name", size=0.75);
// &reset @WIRE(mode="straight") {#X44:3 %t267:p};
// %t268 = $IO_PORT @ATTACH &coarse1 => @PLACE(178, -693) => @ORIENT("MY");
// %t268 @TEXT("coarse1", key="name", size=0.75);
// &coarse1 @WIRE(mode="straight") {#X44:4 %t268:p};
// %t269 = $SUPPLY @ATTACH &vdd => @PLACE(168, -680);
// &vdd @WIRE(mode="straight") {#X44:5 %t269:p};
// %t270 = $GROUND @ATTACH &vss => @PLACE(168, -706);
// &vss @WIRE(mode="straight") {#X44:6 %t270:p};
// %t271 = $IO_PORT @ATTACH &n120 => @PLACE(198, -689) => @ORIENT("R0");
// %t271 @TEXT("n120", key="name", size=0.75);
// &n120 @WIRE(mode="straight") {#X45:1 %t271:p};
// %t272 = $IO_PORT @ATTACH &refclk => @PLACE(198, -693) => @ORIENT("R0");
// %t272 @TEXT("refclk", key="name", size=0.75);
// &refclk @WIRE(mode="straight") {#X45:2 %t272:p};
// %t273 = $IO_PORT @ATTACH &reset => @PLACE(198, -697) => @ORIENT("R0");
// %t273 @TEXT("reset", key="name", size=0.75);
// &reset @WIRE(mode="straight") {#X45:3 %t273:p};
// %t274 = $IO_PORT @ATTACH &coarse2 => @PLACE(218, -693) => @ORIENT("MY");
// %t274 @TEXT("coarse2", key="name", size=0.75);
// &coarse2 @WIRE(mode="straight") {#X45:4 %t274:p};
// %t275 = $SUPPLY @ATTACH &vdd => @PLACE(208, -680);
// &vdd @WIRE(mode="straight") {#X45:5 %t275:p};
// %t276 = $GROUND @ATTACH &vss => @PLACE(208, -706);
// &vss @WIRE(mode="straight") {#X45:6 %t276:p};
// %t277 = $IO_PORT @ATTACH &n121 => @PLACE(238, -689) => @ORIENT("R0");
// %t277 @TEXT("n121", key="name", size=0.75);
// &n121 @WIRE(mode="straight") {#X46:1 %t277:p};
// %t278 = $IO_PORT @ATTACH &refclk => @PLACE(238, -693) => @ORIENT("R0");
// %t278 @TEXT("refclk", key="name", size=0.75);
// &refclk @WIRE(mode="straight") {#X46:2 %t278:p};
// %t279 = $IO_PORT @ATTACH &reset => @PLACE(238, -697) => @ORIENT("R0");
// %t279 @TEXT("reset", key="name", size=0.75);
// &reset @WIRE(mode="straight") {#X46:3 %t279:p};
// %t280 = $IO_PORT @ATTACH &coarse3 => @PLACE(258, -693) => @ORIENT("MY");
// %t280 @TEXT("coarse3", key="name", size=0.75);
// &coarse3 @WIRE(mode="straight") {#X46:4 %t280:p};
// %t281 = $SUPPLY @ATTACH &vdd => @PLACE(248, -680);
// &vdd @WIRE(mode="straight") {#X46:5 %t281:p};
// %t282 = $GROUND @ATTACH &vss => @PLACE(248, -706);
// &vss @WIRE(mode="straight") {#X46:6 %t282:p};
// %t283 = $IO_PORT @ATTACH &n122 => @PLACE(278, -689) => @ORIENT("R0");
// %t283 @TEXT("n122", key="name", size=0.75);
// &n122 @WIRE(mode="straight") {#X47:1 %t283:p};
// %t284 = $IO_PORT @ATTACH &refclk => @PLACE(278, -693) => @ORIENT("R0");
// %t284 @TEXT("refclk", key="name", size=0.75);
// &refclk @WIRE(mode="straight") {#X47:2 %t284:p};
// %t285 = $IO_PORT @ATTACH &reset => @PLACE(278, -697) => @ORIENT("R0");
// %t285 @TEXT("reset", key="name", size=0.75);
// &reset @WIRE(mode="straight") {#X47:3 %t285:p};
// %t286 = $IO_PORT @ATTACH &coarse4 => @PLACE(298, -693) => @ORIENT("MY");
// %t286 @TEXT("coarse4", key="name", size=0.75);
// &coarse4 @WIRE(mode="straight") {#X47:4 %t286:p};
// %t287 = $SUPPLY @ATTACH &vdd => @PLACE(288, -680);
// &vdd @WIRE(mode="straight") {#X47:5 %t287:p};
// %t288 = $GROUND @ATTACH &vss => @PLACE(288, -706);
// &vss @WIRE(mode="straight") {#X47:6 %t288:p};
// %t289 = $IO_PORT @ATTACH &n123 => @PLACE(326, -514) => @ORIENT("R0");
// %t289 @TEXT("n123", key="name", size=0.75);
// &n123 @WIRE(mode="straight") {#X48:1 %t289:p};
// %t290 = $IO_PORT @ATTACH &refclk => @PLACE(326, -518) => @ORIENT("R0");
// %t290 @TEXT("refclk", key="name", size=0.75);
// &refclk @WIRE(mode="straight") {#X48:2 %t290:p};
// %t291 = $IO_PORT @ATTACH &reset => @PLACE(326, -522) => @ORIENT("R0");
// %t291 @TEXT("reset", key="name", size=0.75);
// &reset @WIRE(mode="straight") {#X48:3 %t291:p};
// %t292 = $IO_PORT @ATTACH &coarse5 => @PLACE(346, -518) => @ORIENT("MY");
// %t292 @TEXT("coarse5", key="name", size=0.75);
// &coarse5 @WIRE(mode="straight") {#X48:4 %t292:p};
// %t293 = $SUPPLY @ATTACH &vdd => @PLACE(336, -505);
// &vdd @WIRE(mode="straight") {#X48:5 %t293:p};
// %t294 = $GROUND @ATTACH &vss => @PLACE(336, -531);
// &vss @WIRE(mode="straight") {#X48:6 %t294:p};
// %t295 = $IO_PORT @ATTACH &n124 => @PLACE(366, -514) => @ORIENT("R0");
// %t295 @TEXT("n124", key="name", size=0.75);
// &n124 @WIRE(mode="straight") {#X49:1 %t295:p};
// %t296 = $IO_PORT @ATTACH &refclk => @PLACE(366, -518) => @ORIENT("R0");
// %t296 @TEXT("refclk", key="name", size=0.75);
// &refclk @WIRE(mode="straight") {#X49:2 %t296:p};
// %t297 = $IO_PORT @ATTACH &reset => @PLACE(366, -522) => @ORIENT("R0");
// %t297 @TEXT("reset", key="name", size=0.75);
// &reset @WIRE(mode="straight") {#X49:3 %t297:p};
// %t298 = $IO_PORT @ATTACH &coarse6 => @PLACE(386, -518) => @ORIENT("MY");
// %t298 @TEXT("coarse6", key="name", size=0.75);
// &coarse6 @WIRE(mode="straight") {#X49:4 %t298:p};
// %t299 = $SUPPLY @ATTACH &vdd => @PLACE(376, -505);
// &vdd @WIRE(mode="straight") {#X49:5 %t299:p};
// %t300 = $GROUND @ATTACH &vss => @PLACE(376, -531);
// &vss @WIRE(mode="straight") {#X49:6 %t300:p};
// %t301 = $IO_PORT @ATTACH &n125 => @PLACE(406, -514) => @ORIENT("R0");
// %t301 @TEXT("n125", key="name", size=0.75);
// &n125 @WIRE(mode="straight") {#X50:1 %t301:p};
// %t302 = $IO_PORT @ATTACH &refclk => @PLACE(406, -518) => @ORIENT("R0");
// %t302 @TEXT("refclk", key="name", size=0.75);
// &refclk @WIRE(mode="straight") {#X50:2 %t302:p};
// %t303 = $IO_PORT @ATTACH &reset => @PLACE(406, -522) => @ORIENT("R0");
// %t303 @TEXT("reset", key="name", size=0.75);
// &reset @WIRE(mode="straight") {#X50:3 %t303:p};
// %t304 = $IO_PORT @ATTACH &coarse7 => @PLACE(426, -518) => @ORIENT("MY");
// %t304 @TEXT("coarse7", key="name", size=0.75);
// &coarse7 @WIRE(mode="straight") {#X50:4 %t304:p};
// %t305 = $SUPPLY @ATTACH &vdd => @PLACE(416, -505);
// &vdd @WIRE(mode="straight") {#X50:5 %t305:p};
// %t306 = $GROUND @ATTACH &vss => @PLACE(416, -531);
// &vss @WIRE(mode="straight") {#X50:6 %t306:p};
// %t307 = $IO_PORT @ATTACH &n126 => @PLACE(446, -514) => @ORIENT("R0");
// %t307 @TEXT("n126", key="name", size=0.75);
// &n126 @WIRE(mode="straight") {#X51:1 %t307:p};
// %t308 = $IO_PORT @ATTACH &refclk => @PLACE(446, -518) => @ORIENT("R0");
// %t308 @TEXT("refclk", key="name", size=0.75);
// &refclk @WIRE(mode="straight") {#X51:2 %t308:p};
// %t309 = $IO_PORT @ATTACH &reset => @PLACE(446, -522) => @ORIENT("R0");
// %t309 @TEXT("reset", key="name", size=0.75);
// &reset @WIRE(mode="straight") {#X51:3 %t309:p};
// %t310 = $IO_PORT @ATTACH &n127 => @PLACE(466, -518) => @ORIENT("MY");
// %t310 @TEXT("n127", key="name", size=0.75);
// &n127 @WIRE(mode="straight") {#X51:4 %t310:p};
// %t311 = $SUPPLY @ATTACH &vdd => @PLACE(456, -505);
// &vdd @WIRE(mode="straight") {#X51:5 %t311:p};
// %t312 = $GROUND @ATTACH &vss => @PLACE(456, -531);
// &vss @WIRE(mode="straight") {#X51:6 %t312:p};
// %t313 = $IO_PORT @ATTACH &n128 => @PLACE(326, -549) => @ORIENT("R0");
// %t313 @TEXT("n128", key="name", size=0.75);
// &n128 @WIRE(mode="straight") {#X52:1 %t313:p};
// %t314 = $IO_PORT @ATTACH &refclk => @PLACE(326, -553) => @ORIENT("R0");
// %t314 @TEXT("refclk", key="name", size=0.75);
// &refclk @WIRE(mode="straight") {#X52:2 %t314:p};
// %t315 = $IO_PORT @ATTACH &reset => @PLACE(326, -557) => @ORIENT("R0");
// %t315 @TEXT("reset", key="name", size=0.75);
// &reset @WIRE(mode="straight") {#X52:3 %t315:p};
// %t316 = $IO_PORT @ATTACH &n129 => @PLACE(346, -553) => @ORIENT("MY");
// %t316 @TEXT("n129", key="name", size=0.75);
// &n129 @WIRE(mode="straight") {#X52:4 %t316:p};
// %t317 = $SUPPLY @ATTACH &vdd => @PLACE(336, -540);
// &vdd @WIRE(mode="straight") {#X52:5 %t317:p};
// %t318 = $GROUND @ATTACH &vss => @PLACE(336, -566);
// &vss @WIRE(mode="straight") {#X52:6 %t318:p};
// %t319 = $IO_PORT @ATTACH &n130 => @PLACE(366, -549) => @ORIENT("R0");
// %t319 @TEXT("n130", key="name", size=0.75);
// &n130 @WIRE(mode="straight") {#X53:1 %t319:p};
// %t320 = $IO_PORT @ATTACH &refclk => @PLACE(366, -553) => @ORIENT("R0");
// %t320 @TEXT("refclk", key="name", size=0.75);
// &refclk @WIRE(mode="straight") {#X53:2 %t320:p};
// %t321 = $IO_PORT @ATTACH &reset => @PLACE(366, -557) => @ORIENT("R0");
// %t321 @TEXT("reset", key="name", size=0.75);
// &reset @WIRE(mode="straight") {#X53:3 %t321:p};
// %t322 = $IO_PORT @ATTACH &n131 => @PLACE(386, -553) => @ORIENT("MY");
// %t322 @TEXT("n131", key="name", size=0.75);
// &n131 @WIRE(mode="straight") {#X53:4 %t322:p};
// %t323 = $SUPPLY @ATTACH &vdd => @PLACE(376, -540);
// &vdd @WIRE(mode="straight") {#X53:5 %t323:p};
// %t324 = $GROUND @ATTACH &vss => @PLACE(376, -566);
// &vss @WIRE(mode="straight") {#X53:6 %t324:p};
// %t325 = $IO_PORT @ATTACH &n132 => @PLACE(406, -549) => @ORIENT("R0");
// %t325 @TEXT("n132", key="name", size=0.75);
// &n132 @WIRE(mode="straight") {#X54:1 %t325:p};
// %t326 = $IO_PORT @ATTACH &refclk => @PLACE(406, -553) => @ORIENT("R0");
// %t326 @TEXT("refclk", key="name", size=0.75);
// &refclk @WIRE(mode="straight") {#X54:2 %t326:p};
// %t327 = $IO_PORT @ATTACH &reset => @PLACE(406, -557) => @ORIENT("R0");
// %t327 @TEXT("reset", key="name", size=0.75);
// &reset @WIRE(mode="straight") {#X54:3 %t327:p};
// %t328 = $IO_PORT @ATTACH &n133 => @PLACE(426, -553) => @ORIENT("MY");
// %t328 @TEXT("n133", key="name", size=0.75);
// &n133 @WIRE(mode="straight") {#X54:4 %t328:p};
// %t329 = $SUPPLY @ATTACH &vdd => @PLACE(416, -540);
// &vdd @WIRE(mode="straight") {#X54:5 %t329:p};
// %t330 = $GROUND @ATTACH &vss => @PLACE(416, -566);
// &vss @WIRE(mode="straight") {#X54:6 %t330:p};
// %t331 = $IO_PORT @ATTACH &n134 => @PLACE(446, -549) => @ORIENT("R0");
// %t331 @TEXT("n134", key="name", size=0.75);
// &n134 @WIRE(mode="straight") {#X55:1 %t331:p};
// %t332 = $IO_PORT @ATTACH &refclk => @PLACE(446, -553) => @ORIENT("R0");
// %t332 @TEXT("refclk", key="name", size=0.75);
// &refclk @WIRE(mode="straight") {#X55:2 %t332:p};
// %t333 = $IO_PORT @ATTACH &reset => @PLACE(446, -557) => @ORIENT("R0");
// %t333 @TEXT("reset", key="name", size=0.75);
// &reset @WIRE(mode="straight") {#X55:3 %t333:p};
// %t334 = $IO_PORT @ATTACH &n135 => @PLACE(466, -553) => @ORIENT("MY");
// %t334 @TEXT("n135", key="name", size=0.75);
// &n135 @WIRE(mode="straight") {#X55:4 %t334:p};
// %t335 = $SUPPLY @ATTACH &vdd => @PLACE(456, -540);
// &vdd @WIRE(mode="straight") {#X55:5 %t335:p};
// %t336 = $GROUND @ATTACH &vss => @PLACE(456, -566);
// &vss @WIRE(mode="straight") {#X55:6 %t336:p};
// %t337 = $IO_PORT @ATTACH &n136 => @PLACE(326, -584) => @ORIENT("R0");
// %t337 @TEXT("n136", key="name", size=0.75);
// &n136 @WIRE(mode="straight") {#X56:1 %t337:p};
// %t338 = $IO_PORT @ATTACH &refclk => @PLACE(326, -588) => @ORIENT("R0");
// %t338 @TEXT("refclk", key="name", size=0.75);
// &refclk @WIRE(mode="straight") {#X56:2 %t338:p};
// %t339 = $IO_PORT @ATTACH &reset => @PLACE(326, -592) => @ORIENT("R0");
// %t339 @TEXT("reset", key="name", size=0.75);
// &reset @WIRE(mode="straight") {#X56:3 %t339:p};
// %t340 = $IO_PORT @ATTACH &n137 => @PLACE(346, -588) => @ORIENT("MY");
// %t340 @TEXT("n137", key="name", size=0.75);
// &n137 @WIRE(mode="straight") {#X56:4 %t340:p};
// %t341 = $SUPPLY @ATTACH &vdd => @PLACE(336, -575);
// &vdd @WIRE(mode="straight") {#X56:5 %t341:p};
// %t342 = $GROUND @ATTACH &vss => @PLACE(336, -601);
// &vss @WIRE(mode="straight") {#X56:6 %t342:p};
// %t343 = $IO_PORT @ATTACH &n95 => @PLACE(366, -584) => @ORIENT("R0");
// %t343 @TEXT("n95", key="name", size=0.75);
// &n95 @WIRE(mode="straight") {#X57:1 %t343:p};
// %t344 = $IO_PORT @ATTACH &n138 => @PLACE(366, -588) => @ORIENT("R0");
// %t344 @TEXT("n138", key="name", size=0.75);
// &n138 @WIRE(mode="straight") {#X57:2 %t344:p};
// %t345 = $IO_PORT @ATTACH &n139 => @PLACE(366, -592) => @ORIENT("R0");
// %t345 @TEXT("n139", key="name", size=0.75);
// &n139 @WIRE(mode="straight") {#X57:3 %t345:p};
// %t346 = $IO_PORT @ATTACH &n94 => @PLACE(386, -588) => @ORIENT("MY");
// %t346 @TEXT("n94", key="name", size=0.75);
// &n94 @WIRE(mode="straight") {#X57:4 %t346:p};
// %t347 = $SUPPLY @ATTACH &vdd => @PLACE(376, -575);
// &vdd @WIRE(mode="straight") {#X57:5 %t347:p};
// %t348 = $GROUND @ATTACH &vss => @PLACE(376, -601);
// &vss @WIRE(mode="straight") {#X57:6 %t348:p};
// %t349 = $IO_PORT @ATTACH &n93 => @PLACE(406, -584) => @ORIENT("R0");
// %t349 @TEXT("n93", key="name", size=0.75);
// &n93 @WIRE(mode="straight") {#X58:1 %t349:p};
// %t350 = $IO_PORT @ATTACH &n140 => @PLACE(406, -588) => @ORIENT("R0");
// %t350 @TEXT("n140", key="name", size=0.75);
// &n140 @WIRE(mode="straight") {#X58:2 %t350:p};
// %t351 = $IO_PORT @ATTACH &n139 => @PLACE(406, -592) => @ORIENT("R0");
// %t351 @TEXT("n139", key="name", size=0.75);
// &n139 @WIRE(mode="straight") {#X58:3 %t351:p};
// %t352 = $IO_PORT @ATTACH &n92 => @PLACE(426, -588) => @ORIENT("MY");
// %t352 @TEXT("n92", key="name", size=0.75);
// &n92 @WIRE(mode="straight") {#X58:4 %t352:p};
// %t353 = $SUPPLY @ATTACH &vdd => @PLACE(416, -575);
// &vdd @WIRE(mode="straight") {#X58:5 %t353:p};
// %t354 = $GROUND @ATTACH &vss => @PLACE(416, -601);
// &vss @WIRE(mode="straight") {#X58:6 %t354:p};
// %t355 = $IO_PORT @ATTACH &state_out1 => @PLACE(446, -584) => @ORIENT("R0");
// %t355 @TEXT("state_out1", key="name", size=0.75);
// &state_out1 @WIRE(mode="straight") {#X59:1 %t355:p};
// %t356 = $IO_PORT @ATTACH &n141 => @PLACE(446, -588) => @ORIENT("R0");
// %t356 @TEXT("n141", key="name", size=0.75);
// &n141 @WIRE(mode="straight") {#X59:2 %t356:p};
// %t357 = $IO_PORT @ATTACH &n142 => @PLACE(446, -592) => @ORIENT("R0");
// %t357 @TEXT("n142", key="name", size=0.75);
// &n142 @WIRE(mode="straight") {#X59:3 %t357:p};
// %t358 = $IO_PORT @ATTACH &n90 => @PLACE(466, -588) => @ORIENT("MY");
// %t358 @TEXT("n90", key="name", size=0.75);
// &n90 @WIRE(mode="straight") {#X59:4 %t358:p};
// %t359 = $SUPPLY @ATTACH &vdd => @PLACE(456, -575);
// &vdd @WIRE(mode="straight") {#X59:5 %t359:p};
// %t360 = $GROUND @ATTACH &vss => @PLACE(456, -601);
// &vss @WIRE(mode="straight") {#X59:6 %t360:p};
// %t361 = $IO_PORT @ATTACH &state_out0 => @PLACE(326, -619) => @ORIENT("R0");
// %t361 @TEXT("state_out0", key="name", size=0.75);
// &state_out0 @WIRE(mode="straight") {#X60:1 %t361:p};
// %t362 = $IO_PORT @ATTACH &n143 => @PLACE(326, -623) => @ORIENT("R0");
// %t362 @TEXT("n143", key="name", size=0.75);
// &n143 @WIRE(mode="straight") {#X60:2 %t362:p};
// %t363 = $IO_PORT @ATTACH &n142 => @PLACE(326, -627) => @ORIENT("R0");
// %t363 @TEXT("n142", key="name", size=0.75);
// &n142 @WIRE(mode="straight") {#X60:3 %t363:p};
// %t364 = $IO_PORT @ATTACH &n89 => @PLACE(346, -623) => @ORIENT("MY");
// %t364 @TEXT("n89", key="name", size=0.75);
// &n89 @WIRE(mode="straight") {#X60:4 %t364:p};
// %t365 = $SUPPLY @ATTACH &vdd => @PLACE(336, -610);
// &vdd @WIRE(mode="straight") {#X60:5 %t365:p};
// %t366 = $GROUND @ATTACH &vss => @PLACE(336, -636);
// &vss @WIRE(mode="straight") {#X60:6 %t366:p};
// %t367 = $IO_PORT @ATTACH &n83 => @PLACE(366, -619) => @ORIENT("R0");
// %t367 @TEXT("n83", key="name", size=0.75);
// &n83 @WIRE(mode="straight") {#X61:1 %t367:p};
// %t368 = $IO_PORT @ATTACH &n144 => @PLACE(366, -623) => @ORIENT("R0");
// %t368 @TEXT("n144", key="name", size=0.75);
// &n144 @WIRE(mode="straight") {#X61:2 %t368:p};
// %t369 = $IO_PORT @ATTACH &n145 => @PLACE(366, -627) => @ORIENT("R0");
// %t369 @TEXT("n145", key="name", size=0.75);
// &n145 @WIRE(mode="straight") {#X61:3 %t369:p};
// %t370 = $IO_PORT @ATTACH &n82 => @PLACE(386, -623) => @ORIENT("MY");
// %t370 @TEXT("n82", key="name", size=0.75);
// &n82 @WIRE(mode="straight") {#X61:4 %t370:p};
// %t371 = $SUPPLY @ATTACH &vdd => @PLACE(376, -610);
// &vdd @WIRE(mode="straight") {#X61:5 %t371:p};
// %t372 = $GROUND @ATTACH &vss => @PLACE(376, -636);
// &vss @WIRE(mode="straight") {#X61:6 %t372:p};
// %t373 = $IO_PORT @ATTACH &n81 => @PLACE(406, -619) => @ORIENT("R0");
// %t373 @TEXT("n81", key="name", size=0.75);
// &n81 @WIRE(mode="straight") {#X62:1 %t373:p};
// %t374 = $IO_PORT @ATTACH &n146 => @PLACE(406, -623) => @ORIENT("R0");
// %t374 @TEXT("n146", key="name", size=0.75);
// &n146 @WIRE(mode="straight") {#X62:2 %t374:p};
// %t375 = $IO_PORT @ATTACH &n145 => @PLACE(406, -627) => @ORIENT("R0");
// %t375 @TEXT("n145", key="name", size=0.75);
// &n145 @WIRE(mode="straight") {#X62:3 %t375:p};
// %t376 = $IO_PORT @ATTACH &n80 => @PLACE(426, -623) => @ORIENT("MY");
// %t376 @TEXT("n80", key="name", size=0.75);
// &n80 @WIRE(mode="straight") {#X62:4 %t376:p};
// %t377 = $SUPPLY @ATTACH &vdd => @PLACE(416, -610);
// &vdd @WIRE(mode="straight") {#X62:5 %t377:p};
// %t378 = $GROUND @ATTACH &vss => @PLACE(416, -636);
// &vss @WIRE(mode="straight") {#X62:6 %t378:p};
// %t379 = $IO_PORT @ATTACH &n79 => @PLACE(446, -619) => @ORIENT("R0");
// %t379 @TEXT("n79", key="name", size=0.75);
// &n79 @WIRE(mode="straight") {#X63:1 %t379:p};
// %t380 = $IO_PORT @ATTACH &n147 => @PLACE(446, -623) => @ORIENT("R0");
// %t380 @TEXT("n147", key="name", size=0.75);
// &n147 @WIRE(mode="straight") {#X63:2 %t380:p};
// %t381 = $IO_PORT @ATTACH &n145 => @PLACE(446, -627) => @ORIENT("R0");
// %t381 @TEXT("n145", key="name", size=0.75);
// &n145 @WIRE(mode="straight") {#X63:3 %t381:p};
// %t382 = $IO_PORT @ATTACH &n78 => @PLACE(466, -623) => @ORIENT("MY");
// %t382 @TEXT("n78", key="name", size=0.75);
// &n78 @WIRE(mode="straight") {#X63:4 %t382:p};
// %t383 = $SUPPLY @ATTACH &vdd => @PLACE(456, -610);
// &vdd @WIRE(mode="straight") {#X63:5 %t383:p};
// %t384 = $GROUND @ATTACH &vss => @PLACE(456, -636);
// &vss @WIRE(mode="straight") {#X63:6 %t384:p};
// %t385 = $IO_PORT @ATTACH &n77 => @PLACE(326, -654) => @ORIENT("R0");
// %t385 @TEXT("n77", key="name", size=0.75);
// &n77 @WIRE(mode="straight") {#X64:1 %t385:p};
// %t386 = $IO_PORT @ATTACH &n148 => @PLACE(326, -658) => @ORIENT("R0");
// %t386 @TEXT("n148", key="name", size=0.75);
// &n148 @WIRE(mode="straight") {#X64:2 %t386:p};
// %t387 = $IO_PORT @ATTACH &n145 => @PLACE(326, -662) => @ORIENT("R0");
// %t387 @TEXT("n145", key="name", size=0.75);
// &n145 @WIRE(mode="straight") {#X64:3 %t387:p};
// %t388 = $IO_PORT @ATTACH &n76 => @PLACE(346, -658) => @ORIENT("MY");
// %t388 @TEXT("n76", key="name", size=0.75);
// &n76 @WIRE(mode="straight") {#X64:4 %t388:p};
// %t389 = $SUPPLY @ATTACH &vdd => @PLACE(336, -645);
// &vdd @WIRE(mode="straight") {#X64:5 %t389:p};
// %t390 = $GROUND @ATTACH &vss => @PLACE(336, -671);
// &vss @WIRE(mode="straight") {#X64:6 %t390:p};
// %t391 = $IO_PORT @ATTACH &n75 => @PLACE(366, -654) => @ORIENT("R0");
// %t391 @TEXT("n75", key="name", size=0.75);
// &n75 @WIRE(mode="straight") {#X65:1 %t391:p};
// %t392 = $IO_PORT @ATTACH &n149 => @PLACE(366, -658) => @ORIENT("R0");
// %t392 @TEXT("n149", key="name", size=0.75);
// &n149 @WIRE(mode="straight") {#X65:2 %t392:p};
// %t393 = $IO_PORT @ATTACH &n145 => @PLACE(366, -662) => @ORIENT("R0");
// %t393 @TEXT("n145", key="name", size=0.75);
// &n145 @WIRE(mode="straight") {#X65:3 %t393:p};
// %t394 = $IO_PORT @ATTACH &n74 => @PLACE(386, -658) => @ORIENT("MY");
// %t394 @TEXT("n74", key="name", size=0.75);
// &n74 @WIRE(mode="straight") {#X65:4 %t394:p};
// %t395 = $SUPPLY @ATTACH &vdd => @PLACE(376, -645);
// &vdd @WIRE(mode="straight") {#X65:5 %t395:p};
// %t396 = $GROUND @ATTACH &vss => @PLACE(376, -671);
// &vss @WIRE(mode="straight") {#X65:6 %t396:p};
// %t397 = $IO_PORT @ATTACH &n70 => @PLACE(406, -654) => @ORIENT("R0");
// %t397 @TEXT("n70", key="name", size=0.75);
// &n70 @WIRE(mode="straight") {#X66:1 %t397:p};
// %t398 = $IO_PORT @ATTACH &n150 => @PLACE(406, -658) => @ORIENT("R0");
// %t398 @TEXT("n150", key="name", size=0.75);
// &n150 @WIRE(mode="straight") {#X66:2 %t398:p};
// %t399 = $IO_PORT @ATTACH &n151 => @PLACE(406, -662) => @ORIENT("R0");
// %t399 @TEXT("n151", key="name", size=0.75);
// &n151 @WIRE(mode="straight") {#X66:3 %t399:p};
// %t400 = $IO_PORT @ATTACH &n69 => @PLACE(426, -658) => @ORIENT("MY");
// %t400 @TEXT("n69", key="name", size=0.75);
// &n69 @WIRE(mode="straight") {#X66:4 %t400:p};
// %t401 = $SUPPLY @ATTACH &vdd => @PLACE(416, -645);
// &vdd @WIRE(mode="straight") {#X66:5 %t401:p};
// %t402 = $GROUND @ATTACH &vss => @PLACE(416, -671);
// &vss @WIRE(mode="straight") {#X66:6 %t402:p};
// %t403 = $IO_PORT @ATTACH &n68 => @PLACE(446, -654) => @ORIENT("R0");
// %t403 @TEXT("n68", key="name", size=0.75);
// &n68 @WIRE(mode="straight") {#X67:1 %t403:p};
// %t404 = $IO_PORT @ATTACH &n152 => @PLACE(446, -658) => @ORIENT("R0");
// %t404 @TEXT("n152", key="name", size=0.75);
// &n152 @WIRE(mode="straight") {#X67:2 %t404:p};
// %t405 = $IO_PORT @ATTACH &n151 => @PLACE(446, -662) => @ORIENT("R0");
// %t405 @TEXT("n151", key="name", size=0.75);
// &n151 @WIRE(mode="straight") {#X67:3 %t405:p};
// %t406 = $IO_PORT @ATTACH &n67 => @PLACE(466, -658) => @ORIENT("MY");
// %t406 @TEXT("n67", key="name", size=0.75);
// &n67 @WIRE(mode="straight") {#X67:4 %t406:p};
// %t407 = $SUPPLY @ATTACH &vdd => @PLACE(456, -645);
// &vdd @WIRE(mode="straight") {#X67:5 %t407:p};
// %t408 = $GROUND @ATTACH &vss => @PLACE(456, -671);
// &vss @WIRE(mode="straight") {#X67:6 %t408:p};
// %t409 = $IO_PORT @ATTACH &n66 => @PLACE(326, -689) => @ORIENT("R0");
// %t409 @TEXT("n66", key="name", size=0.75);
// &n66 @WIRE(mode="straight") {#X68:1 %t409:p};
// %t410 = $IO_PORT @ATTACH &n153 => @PLACE(326, -693) => @ORIENT("R0");
// %t410 @TEXT("n153", key="name", size=0.75);
// &n153 @WIRE(mode="straight") {#X68:2 %t410:p};
// %t411 = $IO_PORT @ATTACH &n151 => @PLACE(326, -697) => @ORIENT("R0");
// %t411 @TEXT("n151", key="name", size=0.75);
// &n151 @WIRE(mode="straight") {#X68:3 %t411:p};
// %t412 = $IO_PORT @ATTACH &n65 => @PLACE(346, -693) => @ORIENT("MY");
// %t412 @TEXT("n65", key="name", size=0.75);
// &n65 @WIRE(mode="straight") {#X68:4 %t412:p};
// %t413 = $SUPPLY @ATTACH &vdd => @PLACE(336, -680);
// &vdd @WIRE(mode="straight") {#X68:5 %t413:p};
// %t414 = $GROUND @ATTACH &vss => @PLACE(336, -706);
// &vss @WIRE(mode="straight") {#X68:6 %t414:p};
// %t415 = $IO_PORT @ATTACH &n64 => @PLACE(366, -689) => @ORIENT("R0");
// %t415 @TEXT("n64", key="name", size=0.75);
// &n64 @WIRE(mode="straight") {#X69:1 %t415:p};
// %t416 = $IO_PORT @ATTACH &n154 => @PLACE(366, -693) => @ORIENT("R0");
// %t416 @TEXT("n154", key="name", size=0.75);
// &n154 @WIRE(mode="straight") {#X69:2 %t416:p};
// %t417 = $IO_PORT @ATTACH &n151 => @PLACE(366, -697) => @ORIENT("R0");
// %t417 @TEXT("n151", key="name", size=0.75);
// &n151 @WIRE(mode="straight") {#X69:3 %t417:p};
// %t418 = $IO_PORT @ATTACH &n63 => @PLACE(386, -693) => @ORIENT("MY");
// %t418 @TEXT("n63", key="name", size=0.75);
// &n63 @WIRE(mode="straight") {#X69:4 %t418:p};
// %t419 = $SUPPLY @ATTACH &vdd => @PLACE(376, -680);
// &vdd @WIRE(mode="straight") {#X69:5 %t419:p};
// %t420 = $GROUND @ATTACH &vss => @PLACE(376, -706);
// &vss @WIRE(mode="straight") {#X69:6 %t420:p};
// %t421 = $IO_PORT @ATTACH &n62 => @PLACE(406, -689) => @ORIENT("R0");
// %t421 @TEXT("n62", key="name", size=0.75);
// &n62 @WIRE(mode="straight") {#X70:1 %t421:p};
// %t422 = $IO_PORT @ATTACH &n155 => @PLACE(406, -693) => @ORIENT("R0");
// %t422 @TEXT("n155", key="name", size=0.75);
// &n155 @WIRE(mode="straight") {#X70:2 %t422:p};
// %t423 = $IO_PORT @ATTACH &n151 => @PLACE(406, -697) => @ORIENT("R0");
// %t423 @TEXT("n151", key="name", size=0.75);
// &n151 @WIRE(mode="straight") {#X70:3 %t423:p};
// %t424 = $IO_PORT @ATTACH &n61 => @PLACE(426, -693) => @ORIENT("MY");
// %t424 @TEXT("n61", key="name", size=0.75);
// &n61 @WIRE(mode="straight") {#X70:4 %t424:p};
// %t425 = $SUPPLY @ATTACH &vdd => @PLACE(416, -680);
// &vdd @WIRE(mode="straight") {#X70:5 %t425:p};
// %t426 = $GROUND @ATTACH &vss => @PLACE(416, -706);
// &vss @WIRE(mode="straight") {#X70:6 %t426:p};
// %t427 = $IO_PORT @ATTACH &n60 => @PLACE(446, -689) => @ORIENT("R0");
// %t427 @TEXT("n60", key="name", size=0.75);
// &n60 @WIRE(mode="straight") {#X71:1 %t427:p};
// %t428 = $IO_PORT @ATTACH &n156 => @PLACE(446, -693) => @ORIENT("R0");
// %t428 @TEXT("n156", key="name", size=0.75);
// &n156 @WIRE(mode="straight") {#X71:2 %t428:p};
// %t429 = $IO_PORT @ATTACH &n151 => @PLACE(446, -697) => @ORIENT("R0");
// %t429 @TEXT("n151", key="name", size=0.75);
// &n151 @WIRE(mode="straight") {#X71:3 %t429:p};
// %t430 = $IO_PORT @ATTACH &n59 => @PLACE(466, -693) => @ORIENT("MY");
// %t430 @TEXT("n59", key="name", size=0.75);
// &n59 @WIRE(mode="straight") {#X71:4 %t430:p};
// %t431 = $SUPPLY @ATTACH &vdd => @PLACE(456, -680);
// &vdd @WIRE(mode="straight") {#X71:5 %t431:p};
// %t432 = $GROUND @ATTACH &vss => @PLACE(456, -706);
// &vss @WIRE(mode="straight") {#X71:6 %t432:p};
// %t433 = $IO_PORT @ATTACH &n58 => @PLACE(494, -514) => @ORIENT("R0");
// %t433 @TEXT("n58", key="name", size=0.75);
// &n58 @WIRE(mode="straight") {#X72:1 %t433:p};
// %t434 = $IO_PORT @ATTACH &n157 => @PLACE(494, -518) => @ORIENT("R0");
// %t434 @TEXT("n157", key="name", size=0.75);
// &n157 @WIRE(mode="straight") {#X72:2 %t434:p};
// %t435 = $IO_PORT @ATTACH &n151 => @PLACE(494, -522) => @ORIENT("R0");
// %t435 @TEXT("n151", key="name", size=0.75);
// &n151 @WIRE(mode="straight") {#X72:3 %t435:p};
// %t436 = $IO_PORT @ATTACH &n57 => @PLACE(514, -518) => @ORIENT("MY");
// %t436 @TEXT("n57", key="name", size=0.75);
// &n57 @WIRE(mode="straight") {#X72:4 %t436:p};
// %t437 = $SUPPLY @ATTACH &vdd => @PLACE(504, -505);
// &vdd @WIRE(mode="straight") {#X72:5 %t437:p};
// %t438 = $GROUND @ATTACH &vss => @PLACE(504, -531);
// &vss @WIRE(mode="straight") {#X72:6 %t438:p};
// %t439 = $IO_PORT @ATTACH &dac4 => @PLACE(534, -514) => @ORIENT("R0");
// %t439 @TEXT("dac4", key="name", size=0.75);
// &dac4 @WIRE(mode="straight") {#X73:1 %t439:p};
// %t440 = $IO_PORT @ATTACH &n158 => @PLACE(534, -518) => @ORIENT("R0");
// %t440 @TEXT("n158", key="name", size=0.75);
// &n158 @WIRE(mode="straight") {#X73:2 %t440:p};
// %t441 = $IO_PORT @ATTACH &n159 => @PLACE(534, -522) => @ORIENT("R0");
// %t441 @TEXT("n159", key="name", size=0.75);
// &n159 @WIRE(mode="straight") {#X73:3 %t441:p};
// %t442 = $IO_PORT @ATTACH &n49 => @PLACE(554, -518) => @ORIENT("MY");
// %t442 @TEXT("n49", key="name", size=0.75);
// &n49 @WIRE(mode="straight") {#X73:4 %t442:p};
// %t443 = $SUPPLY @ATTACH &vdd => @PLACE(544, -505);
// &vdd @WIRE(mode="straight") {#X73:5 %t443:p};
// %t444 = $GROUND @ATTACH &vss => @PLACE(544, -531);
// &vss @WIRE(mode="straight") {#X73:6 %t444:p};
// %t445 = $IO_PORT @ATTACH &dac3 => @PLACE(574, -514) => @ORIENT("R0");
// %t445 @TEXT("dac3", key="name", size=0.75);
// &dac3 @WIRE(mode="straight") {#X74:1 %t445:p};
// %t446 = $IO_PORT @ATTACH &n160 => @PLACE(574, -518) => @ORIENT("R0");
// %t446 @TEXT("n160", key="name", size=0.75);
// &n160 @WIRE(mode="straight") {#X74:2 %t446:p};
// %t447 = $IO_PORT @ATTACH &n159 => @PLACE(574, -522) => @ORIENT("R0");
// %t447 @TEXT("n159", key="name", size=0.75);
// &n159 @WIRE(mode="straight") {#X74:3 %t447:p};
// %t448 = $IO_PORT @ATTACH &n48 => @PLACE(594, -518) => @ORIENT("MY");
// %t448 @TEXT("n48", key="name", size=0.75);
// &n48 @WIRE(mode="straight") {#X74:4 %t448:p};
// %t449 = $SUPPLY @ATTACH &vdd => @PLACE(584, -505);
// &vdd @WIRE(mode="straight") {#X74:5 %t449:p};
// %t450 = $GROUND @ATTACH &vss => @PLACE(584, -531);
// &vss @WIRE(mode="straight") {#X74:6 %t450:p};
// %t451 = $IO_PORT @ATTACH &dac2 => @PLACE(614, -514) => @ORIENT("R0");
// %t451 @TEXT("dac2", key="name", size=0.75);
// &dac2 @WIRE(mode="straight") {#X75:1 %t451:p};
// %t452 = $IO_PORT @ATTACH &n161 => @PLACE(614, -518) => @ORIENT("R0");
// %t452 @TEXT("n161", key="name", size=0.75);
// &n161 @WIRE(mode="straight") {#X75:2 %t452:p};
// %t453 = $IO_PORT @ATTACH &n159 => @PLACE(614, -522) => @ORIENT("R0");
// %t453 @TEXT("n159", key="name", size=0.75);
// &n159 @WIRE(mode="straight") {#X75:3 %t453:p};
// %t454 = $IO_PORT @ATTACH &n47 => @PLACE(635, -518) => @ORIENT("MY");
// %t454 @TEXT("n47", key="name", size=0.75);
// &n47 @WIRE(mode="straight") {#X75:4 %t454:p};
// %t455 = $SUPPLY @ATTACH &vdd => @PLACE(624, -505);
// &vdd @WIRE(mode="straight") {#X75:5 %t455:p};
// %t456 = $GROUND @ATTACH &vss => @PLACE(624, -531);
// &vss @WIRE(mode="straight") {#X75:6 %t456:p};
// %t457 = $IO_PORT @ATTACH &dac1 => @PLACE(494, -549) => @ORIENT("R0");
// %t457 @TEXT("dac1", key="name", size=0.75);
// &dac1 @WIRE(mode="straight") {#X76:1 %t457:p};
// %t458 = $IO_PORT @ATTACH &n162 => @PLACE(494, -553) => @ORIENT("R0");
// %t458 @TEXT("n162", key="name", size=0.75);
// &n162 @WIRE(mode="straight") {#X76:2 %t458:p};
// %t459 = $IO_PORT @ATTACH &n159 => @PLACE(494, -557) => @ORIENT("R0");
// %t459 @TEXT("n159", key="name", size=0.75);
// &n159 @WIRE(mode="straight") {#X76:3 %t459:p};
// %t460 = $IO_PORT @ATTACH &n46 => @PLACE(514, -553) => @ORIENT("MY");
// %t460 @TEXT("n46", key="name", size=0.75);
// &n46 @WIRE(mode="straight") {#X76:4 %t460:p};
// %t461 = $SUPPLY @ATTACH &vdd => @PLACE(504, -540);
// &vdd @WIRE(mode="straight") {#X76:5 %t461:p};
// %t462 = $GROUND @ATTACH &vss => @PLACE(504, -566);
// &vss @WIRE(mode="straight") {#X76:6 %t462:p};
// %t463 = $IO_PORT @ATTACH &dac0 => @PLACE(534, -549) => @ORIENT("R0");
// %t463 @TEXT("dac0", key="name", size=0.75);
// &dac0 @WIRE(mode="straight") {#X77:1 %t463:p};
// %t464 = $IO_PORT @ATTACH &n163 => @PLACE(534, -553) => @ORIENT("R0");
// %t464 @TEXT("n163", key="name", size=0.75);
// &n163 @WIRE(mode="straight") {#X77:2 %t464:p};
// %t465 = $IO_PORT @ATTACH &n159 => @PLACE(534, -557) => @ORIENT("R0");
// %t465 @TEXT("n159", key="name", size=0.75);
// &n159 @WIRE(mode="straight") {#X77:3 %t465:p};
// %t466 = $IO_PORT @ATTACH &n45 => @PLACE(554, -553) => @ORIENT("MY");
// %t466 @TEXT("n45", key="name", size=0.75);
// &n45 @WIRE(mode="straight") {#X77:4 %t466:p};
// %t467 = $SUPPLY @ATTACH &vdd => @PLACE(544, -540);
// &vdd @WIRE(mode="straight") {#X77:5 %t467:p};
// %t468 = $GROUND @ATTACH &vss => @PLACE(544, -566);
// &vss @WIRE(mode="straight") {#X77:6 %t468:p};
// %t469 = $IO_PORT @ATTACH &n135 => @PLACE(574, -549) => @ORIENT("R0");
// %t469 @TEXT("n135", key="name", size=0.75);
// &n135 @WIRE(mode="straight") {#X78:1 %t469:p};
// %t470 = $IO_PORT @ATTACH &n164 => @PLACE(574, -553) => @ORIENT("R0");
// %t470 @TEXT("n164", key="name", size=0.75);
// &n164 @WIRE(mode="straight") {#X78:2 %t470:p};
// %t471 = $IO_PORT @ATTACH &n165 => @PLACE(574, -557) => @ORIENT("R0");
// %t471 @TEXT("n165", key="name", size=0.75);
// &n165 @WIRE(mode="straight") {#X78:3 %t471:p};
// %t472 = $IO_PORT @ATTACH &n134 => @PLACE(594, -553) => @ORIENT("MY");
// %t472 @TEXT("n134", key="name", size=0.75);
// &n134 @WIRE(mode="straight") {#X78:4 %t472:p};
// %t473 = $SUPPLY @ATTACH &vdd => @PLACE(584, -540);
// &vdd @WIRE(mode="straight") {#X78:5 %t473:p};
// %t474 = $GROUND @ATTACH &vss => @PLACE(584, -566);
// &vss @WIRE(mode="straight") {#X78:6 %t474:p};
// %t475 = $IO_PORT @ATTACH &n133 => @PLACE(614, -549) => @ORIENT("R0");
// %t475 @TEXT("n133", key="name", size=0.75);
// &n133 @WIRE(mode="straight") {#X79:1 %t475:p};
// %t476 = $IO_PORT @ATTACH &n166 => @PLACE(614, -553) => @ORIENT("R0");
// %t476 @TEXT("n166", key="name", size=0.75);
// &n166 @WIRE(mode="straight") {#X79:2 %t476:p};
// %t477 = $IO_PORT @ATTACH &n165 => @PLACE(614, -557) => @ORIENT("R0");
// %t477 @TEXT("n165", key="name", size=0.75);
// &n165 @WIRE(mode="straight") {#X79:3 %t477:p};
// %t478 = $IO_PORT @ATTACH &n132 => @PLACE(635, -553) => @ORIENT("MY");
// %t478 @TEXT("n132", key="name", size=0.75);
// &n132 @WIRE(mode="straight") {#X79:4 %t478:p};
// %t479 = $SUPPLY @ATTACH &vdd => @PLACE(624, -540);
// &vdd @WIRE(mode="straight") {#X79:5 %t479:p};
// %t480 = $GROUND @ATTACH &vss => @PLACE(624, -566);
// &vss @WIRE(mode="straight") {#X79:6 %t480:p};
// %t481 = $IO_PORT @ATTACH &n131 => @PLACE(494, -584) => @ORIENT("R0");
// %t481 @TEXT("n131", key="name", size=0.75);
// &n131 @WIRE(mode="straight") {#X80:1 %t481:p};
// %t482 = $IO_PORT @ATTACH &n167 => @PLACE(494, -588) => @ORIENT("R0");
// %t482 @TEXT("n167", key="name", size=0.75);
// &n167 @WIRE(mode="straight") {#X80:2 %t482:p};
// %t483 = $IO_PORT @ATTACH &n165 => @PLACE(494, -592) => @ORIENT("R0");
// %t483 @TEXT("n165", key="name", size=0.75);
// &n165 @WIRE(mode="straight") {#X80:3 %t483:p};
// %t484 = $IO_PORT @ATTACH &n130 => @PLACE(514, -588) => @ORIENT("MY");
// %t484 @TEXT("n130", key="name", size=0.75);
// &n130 @WIRE(mode="straight") {#X80:4 %t484:p};
// %t485 = $SUPPLY @ATTACH &vdd => @PLACE(504, -575);
// &vdd @WIRE(mode="straight") {#X80:5 %t485:p};
// %t486 = $GROUND @ATTACH &vss => @PLACE(504, -601);
// &vss @WIRE(mode="straight") {#X80:6 %t486:p};
// %t487 = $IO_PORT @ATTACH &n129 => @PLACE(534, -584) => @ORIENT("R0");
// %t487 @TEXT("n129", key="name", size=0.75);
// &n129 @WIRE(mode="straight") {#X81:1 %t487:p};
// %t488 = $IO_PORT @ATTACH &n168 => @PLACE(534, -588) => @ORIENT("R0");
// %t488 @TEXT("n168", key="name", size=0.75);
// &n168 @WIRE(mode="straight") {#X81:2 %t488:p};
// %t489 = $IO_PORT @ATTACH &n165 => @PLACE(534, -592) => @ORIENT("R0");
// %t489 @TEXT("n165", key="name", size=0.75);
// &n165 @WIRE(mode="straight") {#X81:3 %t489:p};
// %t490 = $IO_PORT @ATTACH &n128 => @PLACE(554, -588) => @ORIENT("MY");
// %t490 @TEXT("n128", key="name", size=0.75);
// &n128 @WIRE(mode="straight") {#X81:4 %t490:p};
// %t491 = $SUPPLY @ATTACH &vdd => @PLACE(544, -575);
// &vdd @WIRE(mode="straight") {#X81:5 %t491:p};
// %t492 = $GROUND @ATTACH &vss => @PLACE(544, -601);
// &vss @WIRE(mode="straight") {#X81:6 %t492:p};
// %t493 = $IO_PORT @ATTACH &n127 => @PLACE(574, -584) => @ORIENT("R0");
// %t493 @TEXT("n127", key="name", size=0.75);
// &n127 @WIRE(mode="straight") {#X82:1 %t493:p};
// %t494 = $IO_PORT @ATTACH &n169 => @PLACE(574, -588) => @ORIENT("R0");
// %t494 @TEXT("n169", key="name", size=0.75);
// &n169 @WIRE(mode="straight") {#X82:2 %t494:p};
// %t495 = $IO_PORT @ATTACH &n165 => @PLACE(574, -592) => @ORIENT("R0");
// %t495 @TEXT("n165", key="name", size=0.75);
// &n165 @WIRE(mode="straight") {#X82:3 %t495:p};
// %t496 = $IO_PORT @ATTACH &n126 => @PLACE(594, -588) => @ORIENT("MY");
// %t496 @TEXT("n126", key="name", size=0.75);
// &n126 @WIRE(mode="straight") {#X82:4 %t496:p};
// %t497 = $SUPPLY @ATTACH &vdd => @PLACE(584, -575);
// &vdd @WIRE(mode="straight") {#X82:5 %t497:p};
// %t498 = $GROUND @ATTACH &vss => @PLACE(584, -601);
// &vss @WIRE(mode="straight") {#X82:6 %t498:p};
// %t499 = $IO_PORT @ATTACH &coarse6 => @PLACE(614, -584) => @ORIENT("R0");
// %t499 @TEXT("coarse6", key="name", size=0.75);
// &coarse6 @WIRE(mode="straight") {#X83:1 %t499:p};
// %t500 = $IO_PORT @ATTACH &n170 => @PLACE(614, -588) => @ORIENT("R0");
// %t500 @TEXT("n170", key="name", size=0.75);
// &n170 @WIRE(mode="straight") {#X83:2 %t500:p};
// %t501 = $IO_PORT @ATTACH &n171 => @PLACE(614, -592) => @ORIENT("R0");
// %t501 @TEXT("n171", key="name", size=0.75);
// &n171 @WIRE(mode="straight") {#X83:3 %t501:p};
// %t502 = $IO_PORT @ATTACH &n124 => @PLACE(635, -588) => @ORIENT("MY");
// %t502 @TEXT("n124", key="name", size=0.75);
// &n124 @WIRE(mode="straight") {#X83:4 %t502:p};
// %t503 = $SUPPLY @ATTACH &vdd => @PLACE(624, -575);
// &vdd @WIRE(mode="straight") {#X83:5 %t503:p};
// %t504 = $GROUND @ATTACH &vss => @PLACE(624, -601);
// &vss @WIRE(mode="straight") {#X83:6 %t504:p};
// %t505 = $IO_PORT @ATTACH &coarse5 => @PLACE(494, -619) => @ORIENT("R0");
// %t505 @TEXT("coarse5", key="name", size=0.75);
// &coarse5 @WIRE(mode="straight") {#X84:1 %t505:p};
// %t506 = $IO_PORT @ATTACH &n172 => @PLACE(494, -623) => @ORIENT("R0");
// %t506 @TEXT("n172", key="name", size=0.75);
// &n172 @WIRE(mode="straight") {#X84:2 %t506:p};
// %t507 = $IO_PORT @ATTACH &n171 => @PLACE(494, -627) => @ORIENT("R0");
// %t507 @TEXT("n171", key="name", size=0.75);
// &n171 @WIRE(mode="straight") {#X84:3 %t507:p};
// %t508 = $IO_PORT @ATTACH &n123 => @PLACE(514, -623) => @ORIENT("MY");
// %t508 @TEXT("n123", key="name", size=0.75);
// &n123 @WIRE(mode="straight") {#X84:4 %t508:p};
// %t509 = $SUPPLY @ATTACH &vdd => @PLACE(504, -610);
// &vdd @WIRE(mode="straight") {#X84:5 %t509:p};
// %t510 = $GROUND @ATTACH &vss => @PLACE(504, -636);
// &vss @WIRE(mode="straight") {#X84:6 %t510:p};
// %t511 = $IO_PORT @ATTACH &coarse4 => @PLACE(534, -619) => @ORIENT("R0");
// %t511 @TEXT("coarse4", key="name", size=0.75);
// &coarse4 @WIRE(mode="straight") {#X85:1 %t511:p};
// %t512 = $IO_PORT @ATTACH &n173 => @PLACE(534, -623) => @ORIENT("R0");
// %t512 @TEXT("n173", key="name", size=0.75);
// &n173 @WIRE(mode="straight") {#X85:2 %t512:p};
// %t513 = $IO_PORT @ATTACH &n171 => @PLACE(534, -627) => @ORIENT("R0");
// %t513 @TEXT("n171", key="name", size=0.75);
// &n171 @WIRE(mode="straight") {#X85:3 %t513:p};
// %t514 = $IO_PORT @ATTACH &n122 => @PLACE(554, -623) => @ORIENT("MY");
// %t514 @TEXT("n122", key="name", size=0.75);
// &n122 @WIRE(mode="straight") {#X85:4 %t514:p};
// %t515 = $SUPPLY @ATTACH &vdd => @PLACE(544, -610);
// &vdd @WIRE(mode="straight") {#X85:5 %t515:p};
// %t516 = $GROUND @ATTACH &vss => @PLACE(544, -636);
// &vss @WIRE(mode="straight") {#X85:6 %t516:p};
// %t517 = $IO_PORT @ATTACH &coarse3 => @PLACE(574, -619) => @ORIENT("R0");
// %t517 @TEXT("coarse3", key="name", size=0.75);
// &coarse3 @WIRE(mode="straight") {#X86:1 %t517:p};
// %t518 = $IO_PORT @ATTACH &n174 => @PLACE(574, -623) => @ORIENT("R0");
// %t518 @TEXT("n174", key="name", size=0.75);
// &n174 @WIRE(mode="straight") {#X86:2 %t518:p};
// %t519 = $IO_PORT @ATTACH &n171 => @PLACE(574, -627) => @ORIENT("R0");
// %t519 @TEXT("n171", key="name", size=0.75);
// &n171 @WIRE(mode="straight") {#X86:3 %t519:p};
// %t520 = $IO_PORT @ATTACH &n121 => @PLACE(594, -623) => @ORIENT("MY");
// %t520 @TEXT("n121", key="name", size=0.75);
// &n121 @WIRE(mode="straight") {#X86:4 %t520:p};
// %t521 = $SUPPLY @ATTACH &vdd => @PLACE(584, -610);
// &vdd @WIRE(mode="straight") {#X86:5 %t521:p};
// %t522 = $GROUND @ATTACH &vss => @PLACE(584, -636);
// &vss @WIRE(mode="straight") {#X86:6 %t522:p};
// %t523 = $IO_PORT @ATTACH &coarse2 => @PLACE(614, -619) => @ORIENT("R0");
// %t523 @TEXT("coarse2", key="name", size=0.75);
// &coarse2 @WIRE(mode="straight") {#X87:1 %t523:p};
// %t524 = $IO_PORT @ATTACH &n175 => @PLACE(614, -623) => @ORIENT("R0");
// %t524 @TEXT("n175", key="name", size=0.75);
// &n175 @WIRE(mode="straight") {#X87:2 %t524:p};
// %t525 = $IO_PORT @ATTACH &n171 => @PLACE(614, -627) => @ORIENT("R0");
// %t525 @TEXT("n171", key="name", size=0.75);
// &n171 @WIRE(mode="straight") {#X87:3 %t525:p};
// %t526 = $IO_PORT @ATTACH &n120 => @PLACE(635, -623) => @ORIENT("MY");
// %t526 @TEXT("n120", key="name", size=0.75);
// &n120 @WIRE(mode="straight") {#X87:4 %t526:p};
// %t527 = $SUPPLY @ATTACH &vdd => @PLACE(624, -610);
// &vdd @WIRE(mode="straight") {#X87:5 %t527:p};
// %t528 = $GROUND @ATTACH &vss => @PLACE(624, -636);
// &vss @WIRE(mode="straight") {#X87:6 %t528:p};
// %t529 = $IO_PORT @ATTACH &coarse1 => @PLACE(494, -654) => @ORIENT("R0");
// %t529 @TEXT("coarse1", key="name", size=0.75);
// &coarse1 @WIRE(mode="straight") {#X88:1 %t529:p};
// %t530 = $IO_PORT @ATTACH &n176 => @PLACE(494, -658) => @ORIENT("R0");
// %t530 @TEXT("n176", key="name", size=0.75);
// &n176 @WIRE(mode="straight") {#X88:2 %t530:p};
// %t531 = $IO_PORT @ATTACH &n171 => @PLACE(494, -662) => @ORIENT("R0");
// %t531 @TEXT("n171", key="name", size=0.75);
// &n171 @WIRE(mode="straight") {#X88:3 %t531:p};
// %t532 = $IO_PORT @ATTACH &n119 => @PLACE(514, -658) => @ORIENT("MY");
// %t532 @TEXT("n119", key="name", size=0.75);
// &n119 @WIRE(mode="straight") {#X88:4 %t532:p};
// %t533 = $SUPPLY @ATTACH &vdd => @PLACE(504, -645);
// &vdd @WIRE(mode="straight") {#X88:5 %t533:p};
// %t534 = $GROUND @ATTACH &vss => @PLACE(504, -671);
// &vss @WIRE(mode="straight") {#X88:6 %t534:p};
// %t535 = $IO_PORT @ATTACH &coarse0 => @PLACE(534, -654) => @ORIENT("R0");
// %t535 @TEXT("coarse0", key="name", size=0.75);
// &coarse0 @WIRE(mode="straight") {#X89:1 %t535:p};
// %t536 = $IO_PORT @ATTACH &n177 => @PLACE(534, -658) => @ORIENT("R0");
// %t536 @TEXT("n177", key="name", size=0.75);
// &n177 @WIRE(mode="straight") {#X89:2 %t536:p};
// %t537 = $IO_PORT @ATTACH &n171 => @PLACE(534, -662) => @ORIENT("R0");
// %t537 @TEXT("n171", key="name", size=0.75);
// &n171 @WIRE(mode="straight") {#X89:3 %t537:p};
// %t538 = $IO_PORT @ATTACH &n118 => @PLACE(554, -658) => @ORIENT("MY");
// %t538 @TEXT("n118", key="name", size=0.75);
// &n118 @WIRE(mode="straight") {#X89:4 %t538:p};
// %t539 = $SUPPLY @ATTACH &vdd => @PLACE(544, -645);
// &vdd @WIRE(mode="straight") {#X89:5 %t539:p};
// %t540 = $GROUND @ATTACH &vss => @PLACE(544, -671);
// &vss @WIRE(mode="straight") {#X89:6 %t540:p};
// %t541 = $IO_PORT @ATTACH &n117 => @PLACE(574, -654) => @ORIENT("R0");
// %t541 @TEXT("n117", key="name", size=0.75);
// &n117 @WIRE(mode="straight") {#X90:1 %t541:p};
// %t542 = $IO_PORT @ATTACH &n178 => @PLACE(574, -658) => @ORIENT("R0");
// %t542 @TEXT("n178", key="name", size=0.75);
// &n178 @WIRE(mode="straight") {#X90:2 %t542:p};
// %t543 = $IO_PORT @ATTACH &n179 => @PLACE(574, -662) => @ORIENT("R0");
// %t543 @TEXT("n179", key="name", size=0.75);
// &n179 @WIRE(mode="straight") {#X90:3 %t543:p};
// %t544 = $IO_PORT @ATTACH &n116 => @PLACE(594, -658) => @ORIENT("MY");
// %t544 @TEXT("n116", key="name", size=0.75);
// &n116 @WIRE(mode="straight") {#X90:4 %t544:p};
// %t545 = $SUPPLY @ATTACH &vdd => @PLACE(584, -645);
// &vdd @WIRE(mode="straight") {#X90:5 %t545:p};
// %t546 = $GROUND @ATTACH &vss => @PLACE(584, -671);
// &vss @WIRE(mode="straight") {#X90:6 %t546:p};
// %t547 = $IO_PORT @ATTACH &coarse7 => @PLACE(614, -654) => @ORIENT("R0");
// %t547 @TEXT("coarse7", key="name", size=0.75);
// &coarse7 @WIRE(mode="straight") {#X91:1 %t547:p};
// %t548 = $IO_PORT @ATTACH &n180 => @PLACE(614, -658) => @ORIENT("R0");
// %t548 @TEXT("n180", key="name", size=0.75);
// &n180 @WIRE(mode="straight") {#X91:2 %t548:p};
// %t549 = $IO_PORT @ATTACH &n171 => @PLACE(614, -662) => @ORIENT("R0");
// %t549 @TEXT("n171", key="name", size=0.75);
// &n171 @WIRE(mode="straight") {#X91:3 %t549:p};
// %t550 = $IO_PORT @ATTACH &n125 => @PLACE(635, -658) => @ORIENT("MY");
// %t550 @TEXT("n125", key="name", size=0.75);
// &n125 @WIRE(mode="straight") {#X91:4 %t550:p};
// %t551 = $SUPPLY @ATTACH &vdd => @PLACE(624, -645);
// &vdd @WIRE(mode="straight") {#X91:5 %t551:p};
// %t552 = $GROUND @ATTACH &vss => @PLACE(624, -671);
// &vss @WIRE(mode="straight") {#X91:6 %t552:p};
// %t553 = $IO_PORT @ATTACH &n137 => @PLACE(494, -689) => @ORIENT("R0");
// %t553 @TEXT("n137", key="name", size=0.75);
// &n137 @WIRE(mode="straight") {#X92:1 %t553:p};
// %t554 = $IO_PORT @ATTACH &n181 => @PLACE(494, -693) => @ORIENT("R0");
// %t554 @TEXT("n181", key="name", size=0.75);
// &n181 @WIRE(mode="straight") {#X92:2 %t554:p};
// %t555 = $IO_PORT @ATTACH &n165 => @PLACE(494, -697) => @ORIENT("R0");
// %t555 @TEXT("n165", key="name", size=0.75);
// &n165 @WIRE(mode="straight") {#X92:3 %t555:p};
// %t556 = $IO_PORT @ATTACH &n136 => @PLACE(514, -693) => @ORIENT("MY");
// %t556 @TEXT("n136", key="name", size=0.75);
// &n136 @WIRE(mode="straight") {#X92:4 %t556:p};
// %t557 = $SUPPLY @ATTACH &vdd => @PLACE(504, -680);
// &vdd @WIRE(mode="straight") {#X92:5 %t557:p};
// %t558 = $GROUND @ATTACH &vss => @PLACE(504, -706);
// &vss @WIRE(mode="straight") {#X92:6 %t558:p};
// %t559 = $IO_PORT @ATTACH &dac5 => @PLACE(534, -689) => @ORIENT("R0");
// %t559 @TEXT("dac5", key="name", size=0.75);
// &dac5 @WIRE(mode="straight") {#X93:1 %t559:p};
// %t560 = $IO_PORT @ATTACH &n182 => @PLACE(534, -693) => @ORIENT("R0");
// %t560 @TEXT("n182", key="name", size=0.75);
// &n182 @WIRE(mode="straight") {#X93:2 %t560:p};
// %t561 = $IO_PORT @ATTACH &n183 => @PLACE(534, -697) => @ORIENT("R0");
// %t561 @TEXT("n183", key="name", size=0.75);
// &n183 @WIRE(mode="straight") {#X93:3 %t561:p};
// %t562 = $IO_PORT @ATTACH &n56 => @PLACE(554, -693) => @ORIENT("MY");
// %t562 @TEXT("n56", key="name", size=0.75);
// &n56 @WIRE(mode="straight") {#X93:4 %t562:p};
// %t563 = $SUPPLY @ATTACH &vdd => @PLACE(544, -680);
// &vdd @WIRE(mode="straight") {#X93:5 %t563:p};
// %t564 = $GROUND @ATTACH &vss => @PLACE(544, -706);
// &vss @WIRE(mode="straight") {#X93:6 %t564:p};
// %t565 = $IO_PORT @ATTACH &n51 => @PLACE(574, -689) => @ORIENT("R0");
// %t565 @TEXT("n51", key="name", size=0.75);
// &n51 @WIRE(mode="straight") {#X94:1 %t565:p};
// %t566 = $IO_PORT @ATTACH &vdd => @PLACE(574, -693) => @ORIENT("R0");
// %t566 @TEXT("vdd", key="name", size=0.75);
// &vdd @WIRE(mode="straight") {#X94:2 %t566:p};
// %t567 = $IO_PORT @ATTACH &n184 => @PLACE(574, -697) => @ORIENT("R0");
// %t567 @TEXT("n184", key="name", size=0.75);
// &n184 @WIRE(mode="straight") {#X94:3 %t567:p};
// %t568 = $IO_PORT @ATTACH &n50 => @PLACE(594, -693) => @ORIENT("MY");
// %t568 @TEXT("n50", key="name", size=0.75);
// &n50 @WIRE(mode="straight") {#X94:4 %t568:p};
// %t569 = $SUPPLY @ATTACH &vdd => @PLACE(584, -680);
// &vdd @WIRE(mode="straight") {#X94:5 %t569:p};
// %t570 = $GROUND @ATTACH &vss => @PLACE(584, -706);
// &vss @WIRE(mode="straight") {#X94:6 %t570:p};
// %t571 = $IO_PORT @ATTACH &count_gate => @PLACE(614, -689) => @ORIENT("R0");
// %t571 @TEXT("count_gate", key="name", size=0.75);
// &count_gate @WIRE(mode="straight") {#X95:1 %t571:p};
// %t572 = $IO_PORT @ATTACH &n185 => @PLACE(614, -693) => @ORIENT("R0");
// %t572 @TEXT("n185", key="name", size=0.75);
// &n185 @WIRE(mode="straight") {#X95:2 %t572:p};
// %t573 = $IO_PORT @ATTACH &n186 => @PLACE(614, -697) => @ORIENT("R0");
// %t573 @TEXT("n186", key="name", size=0.75);
// &n186 @WIRE(mode="straight") {#X95:3 %t573:p};
// %t574 = $IO_PORT @ATTACH &n52 => @PLACE(635, -693) => @ORIENT("MY");
// %t574 @TEXT("n52", key="name", size=0.75);
// &n52 @WIRE(mode="straight") {#X95:4 %t574:p};
// %t575 = $SUPPLY @ATTACH &vdd => @PLACE(624, -680);
// &vdd @WIRE(mode="straight") {#X95:5 %t575:p};
// %t576 = $GROUND @ATTACH &vss => @PLACE(624, -706);
// &vss @WIRE(mode="straight") {#X95:6 %t576:p};
// %t577 = $IO_PORT @ATTACH &n54 => @PLACE(-11, -734) => @ORIENT("R0");
// %t577 @TEXT("n54", key="name", size=0.75);
// &n54 @WIRE(mode="straight") {#X96:1 %t577:p};
// %t578 = $IO_PORT @ATTACH &vdd => @PLACE(-11, -738) => @ORIENT("R0");
// %t578 @TEXT("vdd", key="name", size=0.75);
// &vdd @WIRE(mode="straight") {#X96:2 %t578:p};
// %t579 = $IO_PORT @ATTACH &n187 => @PLACE(-11, -742) => @ORIENT("R0");
// %t579 @TEXT("n187", key="name", size=0.75);
// &n187 @WIRE(mode="straight") {#X96:3 %t579:p};
// %t580 = $IO_PORT @ATTACH &n53 => @PLACE(10, -738) => @ORIENT("MY");
// %t580 @TEXT("n53", key="name", size=0.75);
// &n53 @WIRE(mode="straight") {#X96:4 %t580:p};
// %t581 = $SUPPLY @ATTACH &vdd => @PLACE(0, -725);
// &vdd @WIRE(mode="straight") {#X96:5 %t581:p};
// %t582 = $GROUND @ATTACH &vss => @PLACE(0, -751);
// &vss @WIRE(mode="straight") {#X96:6 %t582:p};
// %t583 = $IO_PORT @ATTACH &count_reset => @PLACE(30, -734) => @ORIENT("R0");
// %t583 @TEXT("count_reset", key="name", size=0.75);
// &count_reset @WIRE(mode="straight") {#X97:1 %t583:p};
// %t584 = $IO_PORT @ATTACH &n188 => @PLACE(30, -738) => @ORIENT("R0");
// %t584 @TEXT("n188", key="name", size=0.75);
// &n188 @WIRE(mode="straight") {#X97:2 %t584:p};
// %t585 = $IO_PORT @ATTACH &n189 => @PLACE(30, -742) => @ORIENT("R0");
// %t585 @TEXT("n189", key="name", size=0.75);
// &n189 @WIRE(mode="straight") {#X97:3 %t585:p};
// %t586 = $IO_PORT @ATTACH &n55 => @PLACE(50, -738) => @ORIENT("MY");
// %t586 @TEXT("n55", key="name", size=0.75);
// &n55 @WIRE(mode="straight") {#X97:4 %t586:p};
// %t587 = $SUPPLY @ATTACH &vdd => @PLACE(40, -725);
// &vdd @WIRE(mode="straight") {#X97:5 %t587:p};
// %t588 = $GROUND @ATTACH &vss => @PLACE(40, -751);
// &vss @WIRE(mode="straight") {#X97:6 %t588:p};
// %t589 = $IO_PORT @ATTACH &n72 => @PLACE(70, -734) => @ORIENT("R0");
// %t589 @TEXT("n72", key="name", size=0.75);
// &n72 @WIRE(mode="straight") {#X98:1 %t589:p};
// %t590 = $IO_PORT @ATTACH &n190 => @PLACE(70, -738) => @ORIENT("R0");
// %t590 @TEXT("n190", key="name", size=0.75);
// &n190 @WIRE(mode="straight") {#X98:2 %t590:p};
// %t591 = $IO_PORT @ATTACH &n151 => @PLACE(70, -742) => @ORIENT("R0");
// %t591 @TEXT("n151", key="name", size=0.75);
// &n151 @WIRE(mode="straight") {#X98:3 %t591:p};
// %t592 = $IO_PORT @ATTACH &n71 => @PLACE(90, -738) => @ORIENT("MY");
// %t592 @TEXT("n71", key="name", size=0.75);
// &n71 @WIRE(mode="straight") {#X98:4 %t592:p};
// %t593 = $SUPPLY @ATTACH &vdd => @PLACE(80, -725);
// &vdd @WIRE(mode="straight") {#X98:5 %t593:p};
// %t594 = $GROUND @ATTACH &vss => @PLACE(80, -751);
// &vss @WIRE(mode="straight") {#X98:6 %t594:p};
// %t595 = $IO_PORT @ATTACH &enable => @PLACE(110, -734) => @ORIENT("R0");
// %t595 @TEXT("enable", key="name", size=0.75);
// &enable @WIRE(mode="straight") {#X99:1 %t595:p};
// %t596 = $IO_PORT @ATTACH &n191 => @PLACE(110, -738) => @ORIENT("R0");
// %t596 @TEXT("n191", key="name", size=0.75);
// &n191 @WIRE(mode="straight") {#X99:2 %t596:p};
// %t597 = $IO_PORT @ATTACH &n192 => @PLACE(110, -742) => @ORIENT("R0");
// %t597 @TEXT("n192", key="name", size=0.75);
// &n192 @WIRE(mode="straight") {#X99:3 %t597:p};
// %t598 = $IO_PORT @ATTACH &n73 => @PLACE(130, -738) => @ORIENT("MY");
// %t598 @TEXT("n73", key="name", size=0.75);
// &n73 @WIRE(mode="straight") {#X99:4 %t598:p};
// %t599 = $SUPPLY @ATTACH &vdd => @PLACE(120, -725);
// &vdd @WIRE(mode="straight") {#X99:5 %t599:p};
// %t600 = $GROUND @ATTACH &vss => @PLACE(120, -751);
// &vss @WIRE(mode="straight") {#X99:6 %t600:p};
// %t601 = $IO_PORT @ATTACH &n85 => @PLACE(-11, -769) => @ORIENT("R0");
// %t601 @TEXT("n85", key="name", size=0.75);
// &n85 @WIRE(mode="straight") {#X100:1 %t601:p};
// %t602 = $IO_PORT @ATTACH &n193 => @PLACE(-11, -773) => @ORIENT("R0");
// %t602 @TEXT("n193", key="name", size=0.75);
// &n193 @WIRE(mode="straight") {#X100:2 %t602:p};
// %t603 = $IO_PORT @ATTACH &n145 => @PLACE(-11, -777) => @ORIENT("R0");
// %t603 @TEXT("n145", key="name", size=0.75);
// &n145 @WIRE(mode="straight") {#X100:3 %t603:p};
// %t604 = $IO_PORT @ATTACH &n84 => @PLACE(10, -773) => @ORIENT("MY");
// %t604 @TEXT("n84", key="name", size=0.75);
// &n84 @WIRE(mode="straight") {#X100:4 %t604:p};
// %t605 = $SUPPLY @ATTACH &vdd => @PLACE(0, -760);
// &vdd @WIRE(mode="straight") {#X100:5 %t605:p};
// %t606 = $GROUND @ATTACH &vss => @PLACE(0, -786);
// &vss @WIRE(mode="straight") {#X100:6 %t606:p};
// %t607 = $IO_PORT @ATTACH &range_error => @PLACE(30, -769) => @ORIENT("R0");
// %t607 @TEXT("range_error", key="name", size=0.75);
// &range_error @WIRE(mode="straight") {#X101:1 %t607:p};
// %t608 = $IO_PORT @ATTACH &n194 => @PLACE(30, -773) => @ORIENT("R0");
// %t608 @TEXT("n194", key="name", size=0.75);
// &n194 @WIRE(mode="straight") {#X101:2 %t608:p};
// %t609 = $IO_PORT @ATTACH &n195 => @PLACE(30, -777) => @ORIENT("R0");
// %t609 @TEXT("n195", key="name", size=0.75);
// &n195 @WIRE(mode="straight") {#X101:3 %t609:p};
// %t610 = $IO_PORT @ATTACH &n86 => @PLACE(50, -773) => @ORIENT("MY");
// %t610 @TEXT("n86", key="name", size=0.75);
// &n86 @WIRE(mode="straight") {#X101:4 %t610:p};
// %t611 = $SUPPLY @ATTACH &vdd => @PLACE(40, -760);
// &vdd @WIRE(mode="straight") {#X101:5 %t611:p};
// %t612 = $GROUND @ATTACH &vss => @PLACE(40, -786);
// &vss @WIRE(mode="straight") {#X101:6 %t612:p};
// %t613 = $IO_PORT @ATTACH &n88 => @PLACE(70, -769) => @ORIENT("R0");
// %t613 @TEXT("n88", key="name", size=0.75);
// &n88 @WIRE(mode="straight") {#X102:1 %t613:p};
// %t614 = $IO_PORT @ATTACH &n196 => @PLACE(70, -773) => @ORIENT("R0");
// %t614 @TEXT("n196", key="name", size=0.75);
// &n196 @WIRE(mode="straight") {#X102:2 %t614:p};
// %t615 = $IO_PORT @ATTACH &n197 => @PLACE(70, -777) => @ORIENT("R0");
// %t615 @TEXT("n197", key="name", size=0.75);
// &n197 @WIRE(mode="straight") {#X102:3 %t615:p};
// %t616 = $IO_PORT @ATTACH &n87 => @PLACE(90, -773) => @ORIENT("MY");
// %t616 @TEXT("n87", key="name", size=0.75);
// &n87 @WIRE(mode="straight") {#X102:4 %t616:p};
// %t617 = $SUPPLY @ATTACH &vdd => @PLACE(80, -760);
// &vdd @WIRE(mode="straight") {#X102:5 %t617:p};
// %t618 = $GROUND @ATTACH &vss => @PLACE(80, -786);
// &vss @WIRE(mode="straight") {#X102:6 %t618:p};
// %t619 = $IO_PORT @ATTACH &state_out2 => @PLACE(110, -769) => @ORIENT("R0");
// %t619 @TEXT("state_out2", key="name", size=0.75);
// &state_out2 @WIRE(mode="straight") {#X103:1 %t619:p};
// %t620 = $IO_PORT @ATTACH &n198 => @PLACE(110, -773) => @ORIENT("R0");
// %t620 @TEXT("n198", key="name", size=0.75);
// &n198 @WIRE(mode="straight") {#X103:2 %t620:p};
// %t621 = $IO_PORT @ATTACH &n142 => @PLACE(110, -777) => @ORIENT("R0");
// %t621 @TEXT("n142", key="name", size=0.75);
// &n142 @WIRE(mode="straight") {#X103:3 %t621:p};
// %t622 = $IO_PORT @ATTACH &n91 => @PLACE(130, -773) => @ORIENT("MY");
// %t622 @TEXT("n91", key="name", size=0.75);
// &n91 @WIRE(mode="straight") {#X103:4 %t622:p};
// %t623 = $SUPPLY @ATTACH &vdd => @PLACE(120, -760);
// &vdd @WIRE(mode="straight") {#X103:5 %t623:p};
// %t624 = $GROUND @ATTACH &vss => @PLACE(120, -786);
// &vss @WIRE(mode="straight") {#X103:6 %t624:p};
// %t625 = $IO_PORT @ATTACH &n97 => @PLACE(-11, -804) => @ORIENT("R0");
// %t625 @TEXT("n97", key="name", size=0.75);
// &n97 @WIRE(mode="straight") {#X104:1 %t625:p};
// %t626 = $IO_PORT @ATTACH &n199 => @PLACE(-11, -808) => @ORIENT("R0");
// %t626 @TEXT("n199", key="name", size=0.75);
// &n199 @WIRE(mode="straight") {#X104:2 %t626:p};
// %t627 = $IO_PORT @ATTACH &n139 => @PLACE(-11, -812) => @ORIENT("R0");
// %t627 @TEXT("n139", key="name", size=0.75);
// &n139 @WIRE(mode="straight") {#X104:3 %t627:p};
// %t628 = $IO_PORT @ATTACH &n96 => @PLACE(10, -808) => @ORIENT("MY");
// %t628 @TEXT("n96", key="name", size=0.75);
// &n96 @WIRE(mode="straight") {#X104:4 %t628:p};
// %t629 = $SUPPLY @ATTACH &vdd => @PLACE(0, -795);
// &vdd @WIRE(mode="straight") {#X104:5 %t629:p};
// %t630 = $GROUND @ATTACH &vss => @PLACE(0, -821);
// &vss @WIRE(mode="straight") {#X104:6 %t630:p};
// %t631 = $IO_PORT @ATTACH &n115 => @PLACE(30, -804) => @ORIENT("R0");
// %t631 @TEXT("n115", key="name", size=0.75);
// &n115 @WIRE(mode="straight") {#X105:1 %t631:p};
// %t632 = $IO_PORT @ATTACH &n200 => @PLACE(30, -808) => @ORIENT("R0");
// %t632 @TEXT("n200", key="name", size=0.75);
// &n200 @WIRE(mode="straight") {#X105:2 %t632:p};
// %t633 = $IO_PORT @ATTACH &n201 => @PLACE(30, -812) => @ORIENT("R0");
// %t633 @TEXT("n201", key="name", size=0.75);
// &n201 @WIRE(mode="straight") {#X105:3 %t633:p};
// %t634 = $IO_PORT @ATTACH &n114 => @PLACE(50, -808) => @ORIENT("MY");
// %t634 @TEXT("n114", key="name", size=0.75);
// &n114 @WIRE(mode="straight") {#X105:4 %t634:p};
// %t635 = $SUPPLY @ATTACH &vdd => @PLACE(40, -795);
// &vdd @WIRE(mode="straight") {#X105:5 %t635:p};
// %t636 = $GROUND @ATTACH &vss => @PLACE(40, -821);
// &vss @WIRE(mode="straight") {#X105:6 %t636:p};
// %t637 = $IO_PORT @ATTACH &n202 => @PLACE(70, -804) => @ORIENT("R0");
// %t637 @TEXT("n202", key="name", size=0.75);
// &n202 @WIRE(mode="straight") {#X106:1 %t637:p};
// %t638 = $IO_PORT @ATTACH &n111 => @PLACE(70, -808) => @ORIENT("R0");
// %t638 @TEXT("n111", key="name", size=0.75);
// &n111 @WIRE(mode="straight") {#X106:2 %t638:p};
// %t639 = $IO_PORT @ATTACH &n203 => @PLACE(70, -812) => @ORIENT("R0");
// %t639 @TEXT("n203", key="name", size=0.75);
// &n203 @WIRE(mode="straight") {#X106:3 %t639:p};
// %t640 = $IO_PORT @ATTACH &n110 => @PLACE(90, -808) => @ORIENT("MY");
// %t640 @TEXT("n110", key="name", size=0.75);
// &n110 @WIRE(mode="straight") {#X106:4 %t640:p};
// %t641 = $SUPPLY @ATTACH &vdd => @PLACE(80, -795);
// &vdd @WIRE(mode="straight") {#X106:5 %t641:p};
// %t642 = $GROUND @ATTACH &vss => @PLACE(80, -821);
// &vss @WIRE(mode="straight") {#X106:6 %t642:p};
// %t643 = $IO_PORT @ATTACH &n204 => @PLACE(110, -804) => @ORIENT("R0");
// %t643 @TEXT("n204", key="name", size=0.75);
// &n204 @WIRE(mode="straight") {#X107:1 %t643:p};
// %t644 = $IO_PORT @ATTACH &n109 => @PLACE(110, -808) => @ORIENT("R0");
// %t644 @TEXT("n109", key="name", size=0.75);
// &n109 @WIRE(mode="straight") {#X107:2 %t644:p};
// %t645 = $IO_PORT @ATTACH &n203 => @PLACE(110, -812) => @ORIENT("R0");
// %t645 @TEXT("n203", key="name", size=0.75);
// &n203 @WIRE(mode="straight") {#X107:3 %t645:p};
// %t646 = $IO_PORT @ATTACH &n108 => @PLACE(130, -808) => @ORIENT("MY");
// %t646 @TEXT("n108", key="name", size=0.75);
// &n108 @WIRE(mode="straight") {#X107:4 %t646:p};
// %t647 = $SUPPLY @ATTACH &vdd => @PLACE(120, -795);
// &vdd @WIRE(mode="straight") {#X107:5 %t647:p};
// %t648 = $GROUND @ATTACH &vss => @PLACE(120, -821);
// &vss @WIRE(mode="straight") {#X107:6 %t648:p};
// %t649 = $IO_PORT @ATTACH &n205 => @PLACE(-11, -839) => @ORIENT("R0");
// %t649 @TEXT("n205", key="name", size=0.75);
// &n205 @WIRE(mode="straight") {#X108:1 %t649:p};
// %t650 = $IO_PORT @ATTACH &n107 => @PLACE(-11, -843) => @ORIENT("R0");
// %t650 @TEXT("n107", key="name", size=0.75);
// &n107 @WIRE(mode="straight") {#X108:2 %t650:p};
// %t651 = $IO_PORT @ATTACH &n203 => @PLACE(-11, -847) => @ORIENT("R0");
// %t651 @TEXT("n203", key="name", size=0.75);
// &n203 @WIRE(mode="straight") {#X108:3 %t651:p};
// %t652 = $IO_PORT @ATTACH &n106 => @PLACE(10, -843) => @ORIENT("MY");
// %t652 @TEXT("n106", key="name", size=0.75);
// &n106 @WIRE(mode="straight") {#X108:4 %t652:p};
// %t653 = $SUPPLY @ATTACH &vdd => @PLACE(0, -830);
// &vdd @WIRE(mode="straight") {#X108:5 %t653:p};
// %t654 = $GROUND @ATTACH &vss => @PLACE(0, -856);
// &vss @WIRE(mode="straight") {#X108:6 %t654:p};
// %t655 = $IO_PORT @ATTACH &n206 => @PLACE(30, -839) => @ORIENT("R0");
// %t655 @TEXT("n206", key="name", size=0.75);
// &n206 @WIRE(mode="straight") {#X109:1 %t655:p};
// %t656 = $IO_PORT @ATTACH &n105 => @PLACE(30, -843) => @ORIENT("R0");
// %t656 @TEXT("n105", key="name", size=0.75);
// &n105 @WIRE(mode="straight") {#X109:2 %t656:p};
// %t657 = $IO_PORT @ATTACH &n203 => @PLACE(30, -847) => @ORIENT("R0");
// %t657 @TEXT("n203", key="name", size=0.75);
// &n203 @WIRE(mode="straight") {#X109:3 %t657:p};
// %t658 = $IO_PORT @ATTACH &n104 => @PLACE(50, -843) => @ORIENT("MY");
// %t658 @TEXT("n104", key="name", size=0.75);
// &n104 @WIRE(mode="straight") {#X109:4 %t658:p};
// %t659 = $SUPPLY @ATTACH &vdd => @PLACE(40, -830);
// &vdd @WIRE(mode="straight") {#X109:5 %t659:p};
// %t660 = $GROUND @ATTACH &vss => @PLACE(40, -856);
// &vss @WIRE(mode="straight") {#X109:6 %t660:p};
// %t661 = $IO_PORT @ATTACH &n207 => @PLACE(70, -839) => @ORIENT("R0");
// %t661 @TEXT("n207", key="name", size=0.75);
// &n207 @WIRE(mode="straight") {#X110:1 %t661:p};
// %t662 = $IO_PORT @ATTACH &n103 => @PLACE(70, -843) => @ORIENT("R0");
// %t662 @TEXT("n103", key="name", size=0.75);
// &n103 @WIRE(mode="straight") {#X110:2 %t662:p};
// %t663 = $IO_PORT @ATTACH &n203 => @PLACE(70, -847) => @ORIENT("R0");
// %t663 @TEXT("n203", key="name", size=0.75);
// &n203 @WIRE(mode="straight") {#X110:3 %t663:p};
// %t664 = $IO_PORT @ATTACH &n102 => @PLACE(90, -843) => @ORIENT("MY");
// %t664 @TEXT("n102", key="name", size=0.75);
// &n102 @WIRE(mode="straight") {#X110:4 %t664:p};
// %t665 = $SUPPLY @ATTACH &vdd => @PLACE(80, -830);
// &vdd @WIRE(mode="straight") {#X110:5 %t665:p};
// %t666 = $GROUND @ATTACH &vss => @PLACE(80, -856);
// &vss @WIRE(mode="straight") {#X110:6 %t666:p};
// %t667 = $IO_PORT @ATTACH &n208 => @PLACE(110, -839) => @ORIENT("R0");
// %t667 @TEXT("n208", key="name", size=0.75);
// &n208 @WIRE(mode="straight") {#X111:1 %t667:p};
// %t668 = $IO_PORT @ATTACH &n101 => @PLACE(110, -843) => @ORIENT("R0");
// %t668 @TEXT("n101", key="name", size=0.75);
// &n101 @WIRE(mode="straight") {#X111:2 %t668:p};
// %t669 = $IO_PORT @ATTACH &n203 => @PLACE(110, -847) => @ORIENT("R0");
// %t669 @TEXT("n203", key="name", size=0.75);
// &n203 @WIRE(mode="straight") {#X111:3 %t669:p};
// %t670 = $IO_PORT @ATTACH &n100 => @PLACE(130, -843) => @ORIENT("MY");
// %t670 @TEXT("n100", key="name", size=0.75);
// &n100 @WIRE(mode="straight") {#X111:4 %t670:p};
// %t671 = $SUPPLY @ATTACH &vdd => @PLACE(120, -830);
// &vdd @WIRE(mode="straight") {#X111:5 %t671:p};
// %t672 = $GROUND @ATTACH &vss => @PLACE(120, -856);
// &vss @WIRE(mode="straight") {#X111:6 %t672:p};
// %t673 = $IO_PORT @ATTACH &n209 => @PLACE(-11, -874) => @ORIENT("R0");
// %t673 @TEXT("n209", key="name", size=0.75);
// &n209 @WIRE(mode="straight") {#X112:1 %t673:p};
// %t674 = $IO_PORT @ATTACH &n99 => @PLACE(-11, -878) => @ORIENT("R0");
// %t674 @TEXT("n99", key="name", size=0.75);
// &n99 @WIRE(mode="straight") {#X112:2 %t674:p};
// %t675 = $IO_PORT @ATTACH &n203 => @PLACE(-11, -882) => @ORIENT("R0");
// %t675 @TEXT("n203", key="name", size=0.75);
// &n203 @WIRE(mode="straight") {#X112:3 %t675:p};
// %t676 = $IO_PORT @ATTACH &n98 => @PLACE(10, -878) => @ORIENT("MY");
// %t676 @TEXT("n98", key="name", size=0.75);
// &n98 @WIRE(mode="straight") {#X112:4 %t676:p};
// %t677 = $SUPPLY @ATTACH &vdd => @PLACE(0, -865);
// &vdd @WIRE(mode="straight") {#X112:5 %t677:p};
// %t678 = $GROUND @ATTACH &vss => @PLACE(0, -891);
// &vss @WIRE(mode="straight") {#X112:6 %t678:p};
// %t679 = $IO_PORT @ATTACH &n210 => @PLACE(30, -874) => @ORIENT("R0");
// %t679 @TEXT("n210", key="name", size=0.75);
// &n210 @WIRE(mode="straight") {#X113:1 %t679:p};
// %t680 = $IO_PORT @ATTACH &n113 => @PLACE(30, -878) => @ORIENT("R0");
// %t680 @TEXT("n113", key="name", size=0.75);
// &n113 @WIRE(mode="straight") {#X113:2 %t680:p};
// %t681 = $IO_PORT @ATTACH &n203 => @PLACE(30, -882) => @ORIENT("R0");
// %t681 @TEXT("n203", key="name", size=0.75);
// &n203 @WIRE(mode="straight") {#X113:3 %t681:p};
// %t682 = $IO_PORT @ATTACH &n112 => @PLACE(50, -878) => @ORIENT("MY");
// %t682 @TEXT("n112", key="name", size=0.75);
// &n112 @WIRE(mode="straight") {#X113:4 %t682:p};
// %t683 = $SUPPLY @ATTACH &vdd => @PLACE(40, -865);
// &vdd @WIRE(mode="straight") {#X113:5 %t683:p};
// %t684 = $GROUND @ATTACH &vss => @PLACE(40, -891);
// &vss @WIRE(mode="straight") {#X113:6 %t684:p};
// %t685 = $IO_PORT @ATTACH &dac3 => @PLACE(70, -878) => @ORIENT("R0");
// %t685 @TEXT("dac3", key="name", size=0.75);
// &dac3 @WIRE(mode="straight") {#X114:1 %t685:p};
// %t686 = $IO_PORT @ATTACH &n211 => @PLACE(90, -878) => @ORIENT("MY");
// %t686 @TEXT("n211", key="name", size=0.75);
// &n211 @WIRE(mode="straight") {#X114:2 %t686:p};
// %t687 = $SUPPLY @ATTACH &vdd => @PLACE(80, -869);
// &vdd @WIRE(mode="straight") {#X114:3 %t687:p};
// %t688 = $GROUND @ATTACH &vss => @PLACE(80, -887);
// &vss @WIRE(mode="straight") {#X114:4 %t688:p};
// %t689 = $IO_PORT @ATTACH &n212 => @PLACE(110, -878) => @ORIENT("R0");
// %t689 @TEXT("n212", key="name", size=0.75);
// &n212 @WIRE(mode="straight") {#X115:1 %t689:p};
// %t690 = $IO_PORT @ATTACH &n213 => @PLACE(130, -878) => @ORIENT("MY");
// %t690 @TEXT("n213", key="name", size=0.75);
// &n213 @WIRE(mode="straight") {#X115:2 %t690:p};
// %t691 = $SUPPLY @ATTACH &vdd => @PLACE(120, -869);
// &vdd @WIRE(mode="straight") {#X115:3 %t691:p};
// %t692 = $GROUND @ATTACH &vss => @PLACE(120, -887);
// &vss @WIRE(mode="straight") {#X115:4 %t692:p};
// %t693 = $IO_PORT @ATTACH &n214 => @PLACE(-11, -911) => @ORIENT("R0");
// %t693 @TEXT("n214", key="name", size=0.75);
// &n214 @WIRE(mode="straight") {#X116:1 %t693:p};
// %t694 = $IO_PORT @ATTACH &n215 => @PLACE(10, -911) => @ORIENT("MY");
// %t694 @TEXT("n215", key="name", size=0.75);
// &n215 @WIRE(mode="straight") {#X116:2 %t694:p};
// %t695 = $SUPPLY @ATTACH &vdd => @PLACE(0, -902);
// &vdd @WIRE(mode="straight") {#X116:3 %t695:p};
// %t696 = $GROUND @ATTACH &vss => @PLACE(0, -920);
// &vss @WIRE(mode="straight") {#X116:4 %t696:p};
// %t697 = $IO_PORT @ATTACH &n216 => @PLACE(30, -911) => @ORIENT("R0");
// %t697 @TEXT("n216", key="name", size=0.75);
// &n216 @WIRE(mode="straight") {#X117:1 %t697:p};
// %t698 = $IO_PORT @ATTACH &n217 => @PLACE(50, -911) => @ORIENT("MY");
// %t698 @TEXT("n217", key="name", size=0.75);
// &n217 @WIRE(mode="straight") {#X117:2 %t698:p};
// %t699 = $SUPPLY @ATTACH &vdd => @PLACE(40, -902);
// &vdd @WIRE(mode="straight") {#X117:3 %t699:p};
// %t700 = $GROUND @ATTACH &vss => @PLACE(40, -920);
// &vss @WIRE(mode="straight") {#X117:4 %t700:p};
// %t701 = $IO_PORT @ATTACH &n218 => @PLACE(70, -911) => @ORIENT("R0");
// %t701 @TEXT("n218", key="name", size=0.75);
// &n218 @WIRE(mode="straight") {#X118:1 %t701:p};
// %t702 = $IO_PORT @ATTACH &n219 => @PLACE(90, -911) => @ORIENT("MY");
// %t702 @TEXT("n219", key="name", size=0.75);
// &n219 @WIRE(mode="straight") {#X118:2 %t702:p};
// %t703 = $SUPPLY @ATTACH &vdd => @PLACE(80, -902);
// &vdd @WIRE(mode="straight") {#X118:3 %t703:p};
// %t704 = $GROUND @ATTACH &vss => @PLACE(80, -920);
// &vss @WIRE(mode="straight") {#X118:4 %t704:p};
// %t705 = $IO_PORT @ATTACH &n220 => @PLACE(110, -911) => @ORIENT("R0");
// %t705 @TEXT("n220", key="name", size=0.75);
// &n220 @WIRE(mode="straight") {#X119:1 %t705:p};
// %t706 = $IO_PORT @ATTACH &n221 => @PLACE(130, -911) => @ORIENT("MY");
// %t706 @TEXT("n221", key="name", size=0.75);
// &n221 @WIRE(mode="straight") {#X119:2 %t706:p};
// %t707 = $SUPPLY @ATTACH &vdd => @PLACE(120, -902);
// &vdd @WIRE(mode="straight") {#X119:3 %t707:p};
// %t708 = $GROUND @ATTACH &vss => @PLACE(120, -920);
// &vss @WIRE(mode="straight") {#X119:4 %t708:p};
// %t709 = $IO_PORT @ATTACH &n222 => @PLACE(158, -738) => @ORIENT("R0");
// %t709 @TEXT("n222", key="name", size=0.75);
// &n222 @WIRE(mode="straight") {#X120:1 %t709:p};
// %t710 = $IO_PORT @ATTACH &n223 => @PLACE(178, -738) => @ORIENT("MY");
// %t710 @TEXT("n223", key="name", size=0.75);
// &n223 @WIRE(mode="straight") {#X120:2 %t710:p};
// %t711 = $SUPPLY @ATTACH &vdd => @PLACE(168, -729);
// &vdd @WIRE(mode="straight") {#X120:3 %t711:p};
// %t712 = $GROUND @ATTACH &vss => @PLACE(168, -747);
// &vss @WIRE(mode="straight") {#X120:4 %t712:p};
// %t713 = $IO_PORT @ATTACH &target_k0 => @PLACE(198, -738) => @ORIENT("R0");
// %t713 @TEXT("target_k0", key="name", size=0.75);
// &target_k0 @WIRE(mode="straight") {#X121:1 %t713:p};
// %t714 = $IO_PORT @ATTACH &n224 => @PLACE(218, -738) => @ORIENT("MY");
// %t714 @TEXT("n224", key="name", size=0.75);
// &n224 @WIRE(mode="straight") {#X121:2 %t714:p};
// %t715 = $SUPPLY @ATTACH &vdd => @PLACE(208, -729);
// &vdd @WIRE(mode="straight") {#X121:3 %t715:p};
// %t716 = $GROUND @ATTACH &vss => @PLACE(208, -747);
// &vss @WIRE(mode="straight") {#X121:4 %t716:p};
// %t717 = $IO_PORT @ATTACH &state_out1 => @PLACE(238, -738) => @ORIENT("R0");
// %t717 @TEXT("state_out1", key="name", size=0.75);
// &state_out1 @WIRE(mode="straight") {#X122:1 %t717:p};
// %t718 = $IO_PORT @ATTACH &n225 => @PLACE(258, -738) => @ORIENT("MY");
// %t718 @TEXT("n225", key="name", size=0.75);
// &n225 @WIRE(mode="straight") {#X122:2 %t718:p};
// %t719 = $SUPPLY @ATTACH &vdd => @PLACE(248, -729);
// &vdd @WIRE(mode="straight") {#X122:3 %t719:p};
// %t720 = $GROUND @ATTACH &vss => @PLACE(248, -747);
// &vss @WIRE(mode="straight") {#X122:4 %t720:p};
// %t721 = $IO_PORT @ATTACH &state_out0 => @PLACE(278, -738) => @ORIENT("R0");
// %t721 @TEXT("state_out0", key="name", size=0.75);
// &state_out0 @WIRE(mode="straight") {#X123:1 %t721:p};
// %t722 = $IO_PORT @ATTACH &n226 => @PLACE(298, -738) => @ORIENT("MY");
// %t722 @TEXT("n226", key="name", size=0.75);
// &n226 @WIRE(mode="straight") {#X123:2 %t722:p};
// %t723 = $SUPPLY @ATTACH &vdd => @PLACE(288, -729);
// &vdd @WIRE(mode="straight") {#X123:3 %t723:p};
// %t724 = $GROUND @ATTACH &vss => @PLACE(288, -747);
// &vss @WIRE(mode="straight") {#X123:4 %t724:p};
// %t725 = $IO_PORT @ATTACH &n58 => @PLACE(158, -773) => @ORIENT("R0");
// %t725 @TEXT("n58", key="name", size=0.75);
// &n58 @WIRE(mode="straight") {#X124:1 %t725:p};
// %t726 = $IO_PORT @ATTACH &n227 => @PLACE(178, -773) => @ORIENT("MY");
// %t726 @TEXT("n227", key="name", size=0.75);
// &n227 @WIRE(mode="straight") {#X124:2 %t726:p};
// %t727 = $SUPPLY @ATTACH &vdd => @PLACE(168, -764);
// &vdd @WIRE(mode="straight") {#X124:3 %t727:p};
// %t728 = $GROUND @ATTACH &vss => @PLACE(168, -782);
// &vss @WIRE(mode="straight") {#X124:4 %t728:p};
// %t729 = $IO_PORT @ATTACH &n97 => @PLACE(198, -773) => @ORIENT("R0");
// %t729 @TEXT("n97", key="name", size=0.75);
// &n97 @WIRE(mode="straight") {#X125:1 %t729:p};
// %t730 = $IO_PORT @ATTACH &n228 => @PLACE(218, -773) => @ORIENT("MY");
// %t730 @TEXT("n228", key="name", size=0.75);
// &n228 @WIRE(mode="straight") {#X125:2 %t730:p};
// %t731 = $SUPPLY @ATTACH &vdd => @PLACE(208, -764);
// &vdd @WIRE(mode="straight") {#X125:3 %t731:p};
// %t732 = $GROUND @ATTACH &vss => @PLACE(208, -782);
// &vss @WIRE(mode="straight") {#X125:4 %t732:p};
// %t733 = $IO_PORT @ATTACH &state_out2 => @PLACE(238, -773) => @ORIENT("R0");
// %t733 @TEXT("state_out2", key="name", size=0.75);
// &state_out2 @WIRE(mode="straight") {#X126:1 %t733:p};
// %t734 = $IO_PORT @ATTACH &n229 => @PLACE(258, -773) => @ORIENT("MY");
// %t734 @TEXT("n229", key="name", size=0.75);
// &n229 @WIRE(mode="straight") {#X126:2 %t734:p};
// %t735 = $SUPPLY @ATTACH &vdd => @PLACE(248, -764);
// &vdd @WIRE(mode="straight") {#X126:3 %t735:p};
// %t736 = $GROUND @ATTACH &vss => @PLACE(248, -782);
// &vss @WIRE(mode="straight") {#X126:4 %t736:p};
// %t737 = $IO_PORT @ATTACH &n107 => @PLACE(278, -773) => @ORIENT("R0");
// %t737 @TEXT("n107", key="name", size=0.75);
// &n107 @WIRE(mode="straight") {#X127:1 %t737:p};
// %t738 = $IO_PORT @ATTACH &n230 => @PLACE(298, -773) => @ORIENT("MY");
// %t738 @TEXT("n230", key="name", size=0.75);
// &n230 @WIRE(mode="straight") {#X127:2 %t738:p};
// %t739 = $SUPPLY @ATTACH &vdd => @PLACE(288, -764);
// &vdd @WIRE(mode="straight") {#X127:3 %t739:p};
// %t740 = $GROUND @ATTACH &vss => @PLACE(288, -782);
// &vss @WIRE(mode="straight") {#X127:4 %t740:p};
// %t741 = $IO_PORT @ATTACH &n88 => @PLACE(158, -808) => @ORIENT("R0");
// %t741 @TEXT("n88", key="name", size=0.75);
// &n88 @WIRE(mode="straight") {#X128:1 %t741:p};
// %t742 = $IO_PORT @ATTACH &n231 => @PLACE(178, -808) => @ORIENT("MY");
// %t742 @TEXT("n231", key="name", size=0.75);
// &n231 @WIRE(mode="straight") {#X128:2 %t742:p};
// %t743 = $SUPPLY @ATTACH &vdd => @PLACE(168, -799);
// &vdd @WIRE(mode="straight") {#X128:3 %t743:p};
// %t744 = $GROUND @ATTACH &vss => @PLACE(168, -817);
// &vss @WIRE(mode="straight") {#X128:4 %t744:p};
// %t745 = $IO_PORT @ATTACH &n232 => @PLACE(198, -808) => @ORIENT("R0");
// %t745 @TEXT("n232", key="name", size=0.75);
// &n232 @WIRE(mode="straight") {#X129:1 %t745:p};
// %t746 = $IO_PORT @ATTACH &n233 => @PLACE(218, -808) => @ORIENT("MY");
// %t746 @TEXT("n233", key="name", size=0.75);
// &n233 @WIRE(mode="straight") {#X129:2 %t746:p};
// %t747 = $SUPPLY @ATTACH &vdd => @PLACE(208, -799);
// &vdd @WIRE(mode="straight") {#X129:3 %t747:p};
// %t748 = $GROUND @ATTACH &vss => @PLACE(208, -817);
// &vss @WIRE(mode="straight") {#X129:4 %t748:p};
// %t749 = $IO_PORT @ATTACH &n234 => @PLACE(238, -808) => @ORIENT("R0");
// %t749 @TEXT("n234", key="name", size=0.75);
// &n234 @WIRE(mode="straight") {#X130:1 %t749:p};
// %t750 = $IO_PORT @ATTACH &n235 => @PLACE(258, -808) => @ORIENT("MY");
// %t750 @TEXT("n235", key="name", size=0.75);
// &n235 @WIRE(mode="straight") {#X130:2 %t750:p};
// %t751 = $SUPPLY @ATTACH &vdd => @PLACE(248, -799);
// &vdd @WIRE(mode="straight") {#X130:3 %t751:p};
// %t752 = $GROUND @ATTACH &vss => @PLACE(248, -817);
// &vss @WIRE(mode="straight") {#X130:4 %t752:p};
// %t753 = $IO_PORT @ATTACH &n236 => @PLACE(278, -808) => @ORIENT("R0");
// %t753 @TEXT("n236", key="name", size=0.75);
// &n236 @WIRE(mode="straight") {#X131:1 %t753:p};
// %t754 = $IO_PORT @ATTACH &n237 => @PLACE(298, -808) => @ORIENT("MY");
// %t754 @TEXT("n237", key="name", size=0.75);
// &n237 @WIRE(mode="straight") {#X131:2 %t754:p};
// %t755 = $SUPPLY @ATTACH &vdd => @PLACE(288, -799);
// &vdd @WIRE(mode="straight") {#X131:3 %t755:p};
// %t756 = $GROUND @ATTACH &vss => @PLACE(288, -817);
// &vss @WIRE(mode="straight") {#X131:4 %t756:p};
// %t757 = $IO_PORT @ATTACH &n238 => @PLACE(158, -843) => @ORIENT("R0");
// %t757 @TEXT("n238", key="name", size=0.75);
// &n238 @WIRE(mode="straight") {#X132:1 %t757:p};
// %t758 = $IO_PORT @ATTACH &n239 => @PLACE(178, -843) => @ORIENT("MY");
// %t758 @TEXT("n239", key="name", size=0.75);
// &n239 @WIRE(mode="straight") {#X132:2 %t758:p};
// %t759 = $SUPPLY @ATTACH &vdd => @PLACE(168, -834);
// &vdd @WIRE(mode="straight") {#X132:3 %t759:p};
// %t760 = $GROUND @ATTACH &vss => @PLACE(168, -852);
// &vss @WIRE(mode="straight") {#X132:4 %t760:p};
// %t761 = $IO_PORT @ATTACH &n240 => @PLACE(198, -843) => @ORIENT("R0");
// %t761 @TEXT("n240", key="name", size=0.75);
// &n240 @WIRE(mode="straight") {#X133:1 %t761:p};
// %t762 = $IO_PORT @ATTACH &n241 => @PLACE(218, -843) => @ORIENT("MY");
// %t762 @TEXT("n241", key="name", size=0.75);
// &n241 @WIRE(mode="straight") {#X133:2 %t762:p};
// %t763 = $SUPPLY @ATTACH &vdd => @PLACE(208, -834);
// &vdd @WIRE(mode="straight") {#X133:3 %t763:p};
// %t764 = $GROUND @ATTACH &vss => @PLACE(208, -852);
// &vss @WIRE(mode="straight") {#X133:4 %t764:p};
// %t765 = $IO_PORT @ATTACH &n117 => @PLACE(238, -843) => @ORIENT("R0");
// %t765 @TEXT("n117", key="name", size=0.75);
// &n117 @WIRE(mode="straight") {#X134:1 %t765:p};
// %t766 = $IO_PORT @ATTACH &n242 => @PLACE(258, -843) => @ORIENT("MY");
// %t766 @TEXT("n242", key="name", size=0.75);
// &n242 @WIRE(mode="straight") {#X134:2 %t766:p};
// %t767 = $SUPPLY @ATTACH &vdd => @PLACE(248, -834);
// &vdd @WIRE(mode="straight") {#X134:3 %t767:p};
// %t768 = $GROUND @ATTACH &vss => @PLACE(248, -852);
// &vss @WIRE(mode="straight") {#X134:4 %t768:p};
// %t769 = $IO_PORT @ATTACH &n243 => @PLACE(278, -843) => @ORIENT("R0");
// %t769 @TEXT("n243", key="name", size=0.75);
// &n243 @WIRE(mode="straight") {#X135:1 %t769:p};
// %t770 = $IO_PORT @ATTACH &n244 => @PLACE(298, -843) => @ORIENT("MY");
// %t770 @TEXT("n244", key="name", size=0.75);
// &n244 @WIRE(mode="straight") {#X135:2 %t770:p};
// %t771 = $SUPPLY @ATTACH &vdd => @PLACE(288, -834);
// &vdd @WIRE(mode="straight") {#X135:3 %t771:p};
// %t772 = $GROUND @ATTACH &vss => @PLACE(288, -852);
// &vss @WIRE(mode="straight") {#X135:4 %t772:p};
// %t773 = $IO_PORT @ATTACH &measured3 => @PLACE(158, -878) => @ORIENT("R0");
// %t773 @TEXT("measured3", key="name", size=0.75);
// &measured3 @WIRE(mode="straight") {#X136:1 %t773:p};
// %t774 = $IO_PORT @ATTACH &n245 => @PLACE(178, -878) => @ORIENT("MY");
// %t774 @TEXT("n245", key="name", size=0.75);
// &n245 @WIRE(mode="straight") {#X136:2 %t774:p};
// %t775 = $SUPPLY @ATTACH &vdd => @PLACE(168, -869);
// &vdd @WIRE(mode="straight") {#X136:3 %t775:p};
// %t776 = $GROUND @ATTACH &vss => @PLACE(168, -887);
// &vss @WIRE(mode="straight") {#X136:4 %t776:p};
// %t777 = $IO_PORT @ATTACH &measured2 => @PLACE(198, -878) => @ORIENT("R0");
// %t777 @TEXT("measured2", key="name", size=0.75);
// &measured2 @WIRE(mode="straight") {#X137:1 %t777:p};
// %t778 = $IO_PORT @ATTACH &n246 => @PLACE(218, -878) => @ORIENT("MY");
// %t778 @TEXT("n246", key="name", size=0.75);
// &n246 @WIRE(mode="straight") {#X137:2 %t778:p};
// %t779 = $SUPPLY @ATTACH &vdd => @PLACE(208, -869);
// &vdd @WIRE(mode="straight") {#X137:3 %t779:p};
// %t780 = $GROUND @ATTACH &vss => @PLACE(208, -887);
// &vss @WIRE(mode="straight") {#X137:4 %t780:p};
// %t781 = $IO_PORT @ATTACH &n247 => @PLACE(238, -878) => @ORIENT("R0");
// %t781 @TEXT("n247", key="name", size=0.75);
// &n247 @WIRE(mode="straight") {#X138:1 %t781:p};
// %t782 = $IO_PORT @ATTACH &n248 => @PLACE(258, -878) => @ORIENT("MY");
// %t782 @TEXT("n248", key="name", size=0.75);
// &n248 @WIRE(mode="straight") {#X138:2 %t782:p};
// %t783 = $SUPPLY @ATTACH &vdd => @PLACE(248, -869);
// &vdd @WIRE(mode="straight") {#X138:3 %t783:p};
// %t784 = $GROUND @ATTACH &vss => @PLACE(248, -887);
// &vss @WIRE(mode="straight") {#X138:4 %t784:p};
// %t785 = $IO_PORT @ATTACH &n249 => @PLACE(278, -878) => @ORIENT("R0");
// %t785 @TEXT("n249", key="name", size=0.75);
// &n249 @WIRE(mode="straight") {#X139:1 %t785:p};
// %t786 = $IO_PORT @ATTACH &n250 => @PLACE(298, -878) => @ORIENT("MY");
// %t786 @TEXT("n250", key="name", size=0.75);
// &n250 @WIRE(mode="straight") {#X139:2 %t786:p};
// %t787 = $SUPPLY @ATTACH &vdd => @PLACE(288, -869);
// &vdd @WIRE(mode="straight") {#X139:3 %t787:p};
// %t788 = $GROUND @ATTACH &vss => @PLACE(288, -887);
// &vss @WIRE(mode="straight") {#X139:4 %t788:p};
// %t789 = $IO_PORT @ATTACH &n251 => @PLACE(158, -911) => @ORIENT("R0");
// %t789 @TEXT("n251", key="name", size=0.75);
// &n251 @WIRE(mode="straight") {#X140:1 %t789:p};
// %t790 = $IO_PORT @ATTACH &n252 => @PLACE(178, -911) => @ORIENT("MY");
// %t790 @TEXT("n252", key="name", size=0.75);
// &n252 @WIRE(mode="straight") {#X140:2 %t790:p};
// %t791 = $SUPPLY @ATTACH &vdd => @PLACE(168, -902);
// &vdd @WIRE(mode="straight") {#X140:3 %t791:p};
// %t792 = $GROUND @ATTACH &vss => @PLACE(168, -920);
// &vss @WIRE(mode="straight") {#X140:4 %t792:p};
// %t793 = $IO_PORT @ATTACH &n253 => @PLACE(198, -911) => @ORIENT("R0");
// %t793 @TEXT("n253", key="name", size=0.75);
// &n253 @WIRE(mode="straight") {#X141:1 %t793:p};
// %t794 = $IO_PORT @ATTACH &n254 => @PLACE(218, -911) => @ORIENT("MY");
// %t794 @TEXT("n254", key="name", size=0.75);
// &n254 @WIRE(mode="straight") {#X141:2 %t794:p};
// %t795 = $SUPPLY @ATTACH &vdd => @PLACE(208, -902);
// &vdd @WIRE(mode="straight") {#X141:3 %t795:p};
// %t796 = $GROUND @ATTACH &vss => @PLACE(208, -920);
// &vss @WIRE(mode="straight") {#X141:4 %t796:p};
// %t797 = $IO_PORT @ATTACH &n255 => @PLACE(238, -911) => @ORIENT("R0");
// %t797 @TEXT("n255", key="name", size=0.75);
// &n255 @WIRE(mode="straight") {#X142:1 %t797:p};
// %t798 = $IO_PORT @ATTACH &n256 => @PLACE(258, -911) => @ORIENT("MY");
// %t798 @TEXT("n256", key="name", size=0.75);
// &n256 @WIRE(mode="straight") {#X142:2 %t798:p};
// %t799 = $SUPPLY @ATTACH &vdd => @PLACE(248, -902);
// &vdd @WIRE(mode="straight") {#X142:3 %t799:p};
// %t800 = $GROUND @ATTACH &vss => @PLACE(248, -920);
// &vss @WIRE(mode="straight") {#X142:4 %t800:p};
// %t801 = $IO_PORT @ATTACH &n257 => @PLACE(278, -911) => @ORIENT("R0");
// %t801 @TEXT("n257", key="name", size=0.75);
// &n257 @WIRE(mode="straight") {#X143:1 %t801:p};
// %t802 = $IO_PORT @ATTACH &n258 => @PLACE(298, -911) => @ORIENT("MY");
// %t802 @TEXT("n258", key="name", size=0.75);
// &n258 @WIRE(mode="straight") {#X143:2 %t802:p};
// %t803 = $SUPPLY @ATTACH &vdd => @PLACE(288, -902);
// &vdd @WIRE(mode="straight") {#X143:3 %t803:p};
// %t804 = $GROUND @ATTACH &vss => @PLACE(288, -920);
// &vss @WIRE(mode="straight") {#X143:4 %t804:p};
// %t805 = $IO_PORT @ATTACH &n259 => @PLACE(326, -738) => @ORIENT("R0");
// %t805 @TEXT("n259", key="name", size=0.75);
// &n259 @WIRE(mode="straight") {#X144:1 %t805:p};
// %t806 = $IO_PORT @ATTACH &n260 => @PLACE(346, -738) => @ORIENT("MY");
// %t806 @TEXT("n260", key="name", size=0.75);
// &n260 @WIRE(mode="straight") {#X144:2 %t806:p};
// %t807 = $SUPPLY @ATTACH &vdd => @PLACE(336, -729);
// &vdd @WIRE(mode="straight") {#X144:3 %t807:p};
// %t808 = $GROUND @ATTACH &vss => @PLACE(336, -747);
// &vss @WIRE(mode="straight") {#X144:4 %t808:p};
// %t809 = $IO_PORT @ATTACH &n261 => @PLACE(366, -738) => @ORIENT("R0");
// %t809 @TEXT("n261", key="name", size=0.75);
// &n261 @WIRE(mode="straight") {#X145:1 %t809:p};
// %t810 = $IO_PORT @ATTACH &n262 => @PLACE(386, -738) => @ORIENT("MY");
// %t810 @TEXT("n262", key="name", size=0.75);
// &n262 @WIRE(mode="straight") {#X145:2 %t810:p};
// %t811 = $SUPPLY @ATTACH &vdd => @PLACE(376, -729);
// &vdd @WIRE(mode="straight") {#X145:3 %t811:p};
// %t812 = $GROUND @ATTACH &vss => @PLACE(376, -747);
// &vss @WIRE(mode="straight") {#X145:4 %t812:p};
// %t813 = $IO_PORT @ATTACH &n263 => @PLACE(406, -738) => @ORIENT("R0");
// %t813 @TEXT("n263", key="name", size=0.75);
// &n263 @WIRE(mode="straight") {#X146:1 %t813:p};
// %t814 = $IO_PORT @ATTACH &n264 => @PLACE(426, -738) => @ORIENT("MY");
// %t814 @TEXT("n264", key="name", size=0.75);
// &n264 @WIRE(mode="straight") {#X146:2 %t814:p};
// %t815 = $SUPPLY @ATTACH &vdd => @PLACE(416, -729);
// &vdd @WIRE(mode="straight") {#X146:3 %t815:p};
// %t816 = $GROUND @ATTACH &vss => @PLACE(416, -747);
// &vss @WIRE(mode="straight") {#X146:4 %t816:p};
// %t817 = $IO_PORT @ATTACH &n51 => @PLACE(446, -738) => @ORIENT("R0");
// %t817 @TEXT("n51", key="name", size=0.75);
// &n51 @WIRE(mode="straight") {#X147:1 %t817:p};
// %t818 = $IO_PORT @ATTACH &n265 => @PLACE(466, -738) => @ORIENT("MY");
// %t818 @TEXT("n265", key="name", size=0.75);
// &n265 @WIRE(mode="straight") {#X147:2 %t818:p};
// %t819 = $SUPPLY @ATTACH &vdd => @PLACE(456, -729);
// &vdd @WIRE(mode="straight") {#X147:3 %t819:p};
// %t820 = $GROUND @ATTACH &vss => @PLACE(456, -747);
// &vss @WIRE(mode="straight") {#X147:4 %t820:p};
// %t821 = $IO_PORT @ATTACH &n99 => @PLACE(326, -773) => @ORIENT("R0");
// %t821 @TEXT("n99", key="name", size=0.75);
// &n99 @WIRE(mode="straight") {#X148:1 %t821:p};
// %t822 = $IO_PORT @ATTACH &n266 => @PLACE(346, -773) => @ORIENT("MY");
// %t822 @TEXT("n266", key="name", size=0.75);
// &n266 @WIRE(mode="straight") {#X148:2 %t822:p};
// %t823 = $SUPPLY @ATTACH &vdd => @PLACE(336, -764);
// &vdd @WIRE(mode="straight") {#X148:3 %t823:p};
// %t824 = $GROUND @ATTACH &vss => @PLACE(336, -782);
// &vss @WIRE(mode="straight") {#X148:4 %t824:p};
// %t825 = $IO_PORT @ATTACH &dac0 => @PLACE(366, -773) => @ORIENT("R0");
// %t825 @TEXT("dac0", key="name", size=0.75);
// &dac0 @WIRE(mode="straight") {#X149:1 %t825:p};
// %t826 = $IO_PORT @ATTACH &n267 => @PLACE(386, -773) => @ORIENT("MY");
// %t826 @TEXT("n267", key="name", size=0.75);
// &n267 @WIRE(mode="straight") {#X149:2 %t826:p};
// %t827 = $SUPPLY @ATTACH &vdd => @PLACE(376, -764);
// &vdd @WIRE(mode="straight") {#X149:3 %t827:p};
// %t828 = $GROUND @ATTACH &vss => @PLACE(376, -782);
// &vss @WIRE(mode="straight") {#X149:4 %t828:p};
// %t829 = $IO_PORT @ATTACH &target_k2 => @PLACE(406, -773) => @ORIENT("R0");
// %t829 @TEXT("target_k2", key="name", size=0.75);
// &target_k2 @WIRE(mode="straight") {#X150:1 %t829:p};
// %t830 = $IO_PORT @ATTACH &n268 => @PLACE(426, -773) => @ORIENT("MY");
// %t830 @TEXT("n268", key="name", size=0.75);
// &n268 @WIRE(mode="straight") {#X150:2 %t830:p};
// %t831 = $SUPPLY @ATTACH &vdd => @PLACE(416, -764);
// &vdd @WIRE(mode="straight") {#X150:3 %t831:p};
// %t832 = $GROUND @ATTACH &vss => @PLACE(416, -782);
// &vss @WIRE(mode="straight") {#X150:4 %t832:p};
// %t833 = $IO_PORT @ATTACH &n269 => @PLACE(446, -773) => @ORIENT("R0");
// %t833 @TEXT("n269", key="name", size=0.75);
// &n269 @WIRE(mode="straight") {#X151:1 %t833:p};
// %t834 = $IO_PORT @ATTACH &n270 => @PLACE(466, -773) => @ORIENT("MY");
// %t834 @TEXT("n270", key="name", size=0.75);
// &n270 @WIRE(mode="straight") {#X151:2 %t834:p};
// %t835 = $SUPPLY @ATTACH &vdd => @PLACE(456, -764);
// &vdd @WIRE(mode="straight") {#X151:3 %t835:p};
// %t836 = $GROUND @ATTACH &vss => @PLACE(456, -782);
// &vss @WIRE(mode="straight") {#X151:4 %t836:p};
// %t837 = $IO_PORT @ATTACH &n271 => @PLACE(326, -808) => @ORIENT("R0");
// %t837 @TEXT("n271", key="name", size=0.75);
// &n271 @WIRE(mode="straight") {#X152:1 %t837:p};
// %t838 = $IO_PORT @ATTACH &n272 => @PLACE(346, -808) => @ORIENT("MY");
// %t838 @TEXT("n272", key="name", size=0.75);
// &n272 @WIRE(mode="straight") {#X152:2 %t838:p};
// %t839 = $SUPPLY @ATTACH &vdd => @PLACE(336, -799);
// &vdd @WIRE(mode="straight") {#X152:3 %t839:p};
// %t840 = $GROUND @ATTACH &vss => @PLACE(336, -817);
// &vss @WIRE(mode="straight") {#X152:4 %t840:p};
// %t841 = $IO_PORT @ATTACH &n273 => @PLACE(366, -808) => @ORIENT("R0");
// %t841 @TEXT("n273", key="name", size=0.75);
// &n273 @WIRE(mode="straight") {#X153:1 %t841:p};
// %t842 = $IO_PORT @ATTACH &n274 => @PLACE(386, -808) => @ORIENT("MY");
// %t842 @TEXT("n274", key="name", size=0.75);
// &n274 @WIRE(mode="straight") {#X153:2 %t842:p};
// %t843 = $SUPPLY @ATTACH &vdd => @PLACE(376, -799);
// &vdd @WIRE(mode="straight") {#X153:3 %t843:p};
// %t844 = $GROUND @ATTACH &vss => @PLACE(376, -817);
// &vss @WIRE(mode="straight") {#X153:4 %t844:p};
// %t845 = $IO_PORT @ATTACH &n275 => @PLACE(406, -808) => @ORIENT("R0");
// %t845 @TEXT("n275", key="name", size=0.75);
// &n275 @WIRE(mode="straight") {#X154:1 %t845:p};
// %t846 = $IO_PORT @ATTACH &n276 => @PLACE(426, -808) => @ORIENT("MY");
// %t846 @TEXT("n276", key="name", size=0.75);
// &n276 @WIRE(mode="straight") {#X154:2 %t846:p};
// %t847 = $SUPPLY @ATTACH &vdd => @PLACE(416, -799);
// &vdd @WIRE(mode="straight") {#X154:3 %t847:p};
// %t848 = $GROUND @ATTACH &vss => @PLACE(416, -817);
// &vss @WIRE(mode="straight") {#X154:4 %t848:p};
// %t849 = $IO_PORT @ATTACH &n277 => @PLACE(446, -808) => @ORIENT("R0");
// %t849 @TEXT("n277", key="name", size=0.75);
// &n277 @WIRE(mode="straight") {#X155:1 %t849:p};
// %t850 = $IO_PORT @ATTACH &n278 => @PLACE(466, -808) => @ORIENT("MY");
// %t850 @TEXT("n278", key="name", size=0.75);
// &n278 @WIRE(mode="straight") {#X155:2 %t850:p};
// %t851 = $SUPPLY @ATTACH &vdd => @PLACE(456, -799);
// &vdd @WIRE(mode="straight") {#X155:3 %t851:p};
// %t852 = $GROUND @ATTACH &vss => @PLACE(456, -817);
// &vss @WIRE(mode="straight") {#X155:4 %t852:p};
// %t853 = $IO_PORT @ATTACH &n279 => @PLACE(326, -843) => @ORIENT("R0");
// %t853 @TEXT("n279", key="name", size=0.75);
// &n279 @WIRE(mode="straight") {#X156:1 %t853:p};
// %t854 = $IO_PORT @ATTACH &n280 => @PLACE(346, -843) => @ORIENT("MY");
// %t854 @TEXT("n280", key="name", size=0.75);
// &n280 @WIRE(mode="straight") {#X156:2 %t854:p};
// %t855 = $SUPPLY @ATTACH &vdd => @PLACE(336, -834);
// &vdd @WIRE(mode="straight") {#X156:3 %t855:p};
// %t856 = $GROUND @ATTACH &vss => @PLACE(336, -852);
// &vss @WIRE(mode="straight") {#X156:4 %t856:p};
// %t857 = $IO_PORT @ATTACH &n281 => @PLACE(366, -843) => @ORIENT("R0");
// %t857 @TEXT("n281", key="name", size=0.75);
// &n281 @WIRE(mode="straight") {#X157:1 %t857:p};
// %t858 = $IO_PORT @ATTACH &n282 => @PLACE(386, -843) => @ORIENT("MY");
// %t858 @TEXT("n282", key="name", size=0.75);
// &n282 @WIRE(mode="straight") {#X157:2 %t858:p};
// %t859 = $SUPPLY @ATTACH &vdd => @PLACE(376, -834);
// &vdd @WIRE(mode="straight") {#X157:3 %t859:p};
// %t860 = $GROUND @ATTACH &vss => @PLACE(376, -852);
// &vss @WIRE(mode="straight") {#X157:4 %t860:p};
// %t861 = $IO_PORT @ATTACH &n283 => @PLACE(406, -843) => @ORIENT("R0");
// %t861 @TEXT("n283", key="name", size=0.75);
// &n283 @WIRE(mode="straight") {#X158:1 %t861:p};
// %t862 = $IO_PORT @ATTACH &n284 => @PLACE(426, -843) => @ORIENT("MY");
// %t862 @TEXT("n284", key="name", size=0.75);
// &n284 @WIRE(mode="straight") {#X158:2 %t862:p};
// %t863 = $SUPPLY @ATTACH &vdd => @PLACE(416, -834);
// &vdd @WIRE(mode="straight") {#X158:3 %t863:p};
// %t864 = $GROUND @ATTACH &vss => @PLACE(416, -852);
// &vss @WIRE(mode="straight") {#X158:4 %t864:p};
// %t865 = $IO_PORT @ATTACH &n285 => @PLACE(446, -843) => @ORIENT("R0");
// %t865 @TEXT("n285", key="name", size=0.75);
// &n285 @WIRE(mode="straight") {#X159:1 %t865:p};
// %t866 = $IO_PORT @ATTACH &n286 => @PLACE(466, -843) => @ORIENT("MY");
// %t866 @TEXT("n286", key="name", size=0.75);
// &n286 @WIRE(mode="straight") {#X159:2 %t866:p};
// %t867 = $SUPPLY @ATTACH &vdd => @PLACE(456, -834);
// &vdd @WIRE(mode="straight") {#X159:3 %t867:p};
// %t868 = $GROUND @ATTACH &vss => @PLACE(456, -852);
// &vss @WIRE(mode="straight") {#X159:4 %t868:p};
// %t869 = $IO_PORT @ATTACH &n287 => @PLACE(326, -878) => @ORIENT("R0");
// %t869 @TEXT("n287", key="name", size=0.75);
// &n287 @WIRE(mode="straight") {#X160:1 %t869:p};
// %t870 = $IO_PORT @ATTACH &n288 => @PLACE(346, -878) => @ORIENT("MY");
// %t870 @TEXT("n288", key="name", size=0.75);
// &n288 @WIRE(mode="straight") {#X160:2 %t870:p};
// %t871 = $SUPPLY @ATTACH &vdd => @PLACE(336, -869);
// &vdd @WIRE(mode="straight") {#X160:3 %t871:p};
// %t872 = $GROUND @ATTACH &vss => @PLACE(336, -887);
// &vss @WIRE(mode="straight") {#X160:4 %t872:p};
// %t873 = $IO_PORT @ATTACH &n289 => @PLACE(366, -878) => @ORIENT("R0");
// %t873 @TEXT("n289", key="name", size=0.75);
// &n289 @WIRE(mode="straight") {#X161:1 %t873:p};
// %t874 = $IO_PORT @ATTACH &n290 => @PLACE(386, -878) => @ORIENT("MY");
// %t874 @TEXT("n290", key="name", size=0.75);
// &n290 @WIRE(mode="straight") {#X161:2 %t874:p};
// %t875 = $SUPPLY @ATTACH &vdd => @PLACE(376, -869);
// &vdd @WIRE(mode="straight") {#X161:3 %t875:p};
// %t876 = $GROUND @ATTACH &vss => @PLACE(376, -887);
// &vss @WIRE(mode="straight") {#X161:4 %t876:p};
// %t877 = $IO_PORT @ATTACH &n291 => @PLACE(406, -878) => @ORIENT("R0");
// %t877 @TEXT("n291", key="name", size=0.75);
// &n291 @WIRE(mode="straight") {#X162:1 %t877:p};
// %t878 = $IO_PORT @ATTACH &n292 => @PLACE(426, -878) => @ORIENT("MY");
// %t878 @TEXT("n292", key="name", size=0.75);
// &n292 @WIRE(mode="straight") {#X162:2 %t878:p};
// %t879 = $SUPPLY @ATTACH &vdd => @PLACE(416, -869);
// &vdd @WIRE(mode="straight") {#X162:3 %t879:p};
// %t880 = $GROUND @ATTACH &vss => @PLACE(416, -887);
// &vss @WIRE(mode="straight") {#X162:4 %t880:p};
// %t881 = $IO_PORT @ATTACH &n293 => @PLACE(446, -878) => @ORIENT("R0");
// %t881 @TEXT("n293", key="name", size=0.75);
// &n293 @WIRE(mode="straight") {#X163:1 %t881:p};
// %t882 = $IO_PORT @ATTACH &n294 => @PLACE(466, -878) => @ORIENT("MY");
// %t882 @TEXT("n294", key="name", size=0.75);
// &n294 @WIRE(mode="straight") {#X163:2 %t882:p};
// %t883 = $SUPPLY @ATTACH &vdd => @PLACE(456, -869);
// &vdd @WIRE(mode="straight") {#X163:3 %t883:p};
// %t884 = $GROUND @ATTACH &vss => @PLACE(456, -887);
// &vss @WIRE(mode="straight") {#X163:4 %t884:p};
// %t885 = $IO_PORT @ATTACH &coarse7 => @PLACE(326, -911) => @ORIENT("R0");
// %t885 @TEXT("coarse7", key="name", size=0.75);
// &coarse7 @WIRE(mode="straight") {#X164:1 %t885:p};
// %t886 = $IO_PORT @ATTACH &n295 => @PLACE(346, -911) => @ORIENT("MY");
// %t886 @TEXT("n295", key="name", size=0.75);
// &n295 @WIRE(mode="straight") {#X164:2 %t886:p};
// %t887 = $SUPPLY @ATTACH &vdd => @PLACE(336, -902);
// &vdd @WIRE(mode="straight") {#X164:3 %t887:p};
// %t888 = $GROUND @ATTACH &vss => @PLACE(336, -920);
// &vss @WIRE(mode="straight") {#X164:4 %t888:p};
// %t889 = $IO_PORT @ATTACH &coarse0 => @PLACE(366, -911) => @ORIENT("R0");
// %t889 @TEXT("coarse0", key="name", size=0.75);
// &coarse0 @WIRE(mode="straight") {#X165:1 %t889:p};
// %t890 = $IO_PORT @ATTACH &n296 => @PLACE(386, -911) => @ORIENT("MY");
// %t890 @TEXT("n296", key="name", size=0.75);
// &n296 @WIRE(mode="straight") {#X165:2 %t890:p};
// %t891 = $SUPPLY @ATTACH &vdd => @PLACE(376, -902);
// &vdd @WIRE(mode="straight") {#X165:3 %t891:p};
// %t892 = $GROUND @ATTACH &vss => @PLACE(376, -920);
// &vss @WIRE(mode="straight") {#X165:4 %t892:p};
// %t893 = $IO_PORT @ATTACH &coarse0 => @PLACE(406, -909) => @ORIENT("R0");
// %t893 @TEXT("coarse0", key="name", size=0.75);
// &coarse0 @WIRE(mode="straight") {#X166:1 %t893:p};
// %t894 = $IO_PORT @ATTACH &n227 => @PLACE(406, -913) => @ORIENT("R0");
// %t894 @TEXT("n227", key="name", size=0.75);
// &n227 @WIRE(mode="straight") {#X166:2 %t894:p};
// %t895 = $IO_PORT @ATTACH &n297 => @PLACE(426, -911) => @ORIENT("MY");
// %t895 @TEXT("n297", key="name", size=0.75);
// &n297 @WIRE(mode="straight") {#X166:3 %t895:p};
// %t896 = $SUPPLY @ATTACH &vdd => @PLACE(416, -900);
// &vdd @WIRE(mode="straight") {#X166:4 %t896:p};
// %t897 = $GROUND @ATTACH &vss => @PLACE(416, -922);
// &vss @WIRE(mode="straight") {#X166:5 %t897:p};
// %t898 = $IO_PORT @ATTACH &coarse1 => @PLACE(446, -909) => @ORIENT("R0");
// %t898 @TEXT("coarse1", key="name", size=0.75);
// &coarse1 @WIRE(mode="straight") {#X167:1 %t898:p};
// %t899 = $IO_PORT @ATTACH &n298 => @PLACE(446, -913) => @ORIENT("R0");
// %t899 @TEXT("n298", key="name", size=0.75);
// &n298 @WIRE(mode="straight") {#X167:2 %t899:p};
// %t900 = $IO_PORT @ATTACH &n299 => @PLACE(466, -911) => @ORIENT("MY");
// %t900 @TEXT("n299", key="name", size=0.75);
// &n299 @WIRE(mode="straight") {#X167:3 %t900:p};
// %t901 = $SUPPLY @ATTACH &vdd => @PLACE(456, -900);
// &vdd @WIRE(mode="straight") {#X167:4 %t901:p};
// %t902 = $GROUND @ATTACH &vss => @PLACE(456, -922);
// &vss @WIRE(mode="straight") {#X167:5 %t902:p};
// %t903 = $IO_PORT @ATTACH &coarse2 => @PLACE(494, -736) => @ORIENT("R0");
// %t903 @TEXT("coarse2", key="name", size=0.75);
// &coarse2 @WIRE(mode="straight") {#X168:1 %t903:p};
// %t904 = $IO_PORT @ATTACH &n300 => @PLACE(494, -740) => @ORIENT("R0");
// %t904 @TEXT("n300", key="name", size=0.75);
// &n300 @WIRE(mode="straight") {#X168:2 %t904:p};
// %t905 = $IO_PORT @ATTACH &n301 => @PLACE(514, -738) => @ORIENT("MY");
// %t905 @TEXT("n301", key="name", size=0.75);
// &n301 @WIRE(mode="straight") {#X168:3 %t905:p};
// %t906 = $SUPPLY @ATTACH &vdd => @PLACE(504, -727);
// &vdd @WIRE(mode="straight") {#X168:4 %t906:p};
// %t907 = $GROUND @ATTACH &vss => @PLACE(504, -749);
// &vss @WIRE(mode="straight") {#X168:5 %t907:p};
// %t908 = $IO_PORT @ATTACH &coarse3 => @PLACE(534, -736) => @ORIENT("R0");
// %t908 @TEXT("coarse3", key="name", size=0.75);
// &coarse3 @WIRE(mode="straight") {#X169:1 %t908:p};
// %t909 = $IO_PORT @ATTACH &n302 => @PLACE(534, -740) => @ORIENT("R0");
// %t909 @TEXT("n302", key="name", size=0.75);
// &n302 @WIRE(mode="straight") {#X169:2 %t909:p};
// %t910 = $IO_PORT @ATTACH &n303 => @PLACE(554, -738) => @ORIENT("MY");
// %t910 @TEXT("n303", key="name", size=0.75);
// &n303 @WIRE(mode="straight") {#X169:3 %t910:p};
// %t911 = $SUPPLY @ATTACH &vdd => @PLACE(544, -727);
// &vdd @WIRE(mode="straight") {#X169:4 %t911:p};
// %t912 = $GROUND @ATTACH &vss => @PLACE(544, -749);
// &vss @WIRE(mode="straight") {#X169:5 %t912:p};
// %t913 = $IO_PORT @ATTACH &coarse4 => @PLACE(574, -736) => @ORIENT("R0");
// %t913 @TEXT("coarse4", key="name", size=0.75);
// &coarse4 @WIRE(mode="straight") {#X170:1 %t913:p};
// %t914 = $IO_PORT @ATTACH &n304 => @PLACE(574, -740) => @ORIENT("R0");
// %t914 @TEXT("n304", key="name", size=0.75);
// &n304 @WIRE(mode="straight") {#X170:2 %t914:p};
// %t915 = $IO_PORT @ATTACH &n305 => @PLACE(594, -738) => @ORIENT("MY");
// %t915 @TEXT("n305", key="name", size=0.75);
// &n305 @WIRE(mode="straight") {#X170:3 %t915:p};
// %t916 = $SUPPLY @ATTACH &vdd => @PLACE(584, -727);
// &vdd @WIRE(mode="straight") {#X170:4 %t916:p};
// %t917 = $GROUND @ATTACH &vss => @PLACE(584, -749);
// &vss @WIRE(mode="straight") {#X170:5 %t917:p};
// %t918 = $IO_PORT @ATTACH &coarse5 => @PLACE(614, -736) => @ORIENT("R0");
// %t918 @TEXT("coarse5", key="name", size=0.75);
// &coarse5 @WIRE(mode="straight") {#X171:1 %t918:p};
// %t919 = $IO_PORT @ATTACH &n306 => @PLACE(614, -740) => @ORIENT("R0");
// %t919 @TEXT("n306", key="name", size=0.75);
// &n306 @WIRE(mode="straight") {#X171:2 %t919:p};
// %t920 = $IO_PORT @ATTACH &n307 => @PLACE(635, -738) => @ORIENT("MY");
// %t920 @TEXT("n307", key="name", size=0.75);
// &n307 @WIRE(mode="straight") {#X171:3 %t920:p};
// %t921 = $SUPPLY @ATTACH &vdd => @PLACE(624, -727);
// &vdd @WIRE(mode="straight") {#X171:4 %t921:p};
// %t922 = $GROUND @ATTACH &vss => @PLACE(624, -749);
// &vss @WIRE(mode="straight") {#X171:5 %t922:p};
// %t923 = $IO_PORT @ATTACH &coarse6 => @PLACE(494, -771) => @ORIENT("R0");
// %t923 @TEXT("coarse6", key="name", size=0.75);
// &coarse6 @WIRE(mode="straight") {#X172:1 %t923:p};
// %t924 = $IO_PORT @ATTACH &n308 => @PLACE(494, -775) => @ORIENT("R0");
// %t924 @TEXT("n308", key="name", size=0.75);
// &n308 @WIRE(mode="straight") {#X172:2 %t924:p};
// %t925 = $IO_PORT @ATTACH &n309 => @PLACE(514, -773) => @ORIENT("MY");
// %t925 @TEXT("n309", key="name", size=0.75);
// &n309 @WIRE(mode="straight") {#X172:3 %t925:p};
// %t926 = $SUPPLY @ATTACH &vdd => @PLACE(504, -762);
// &vdd @WIRE(mode="straight") {#X172:4 %t926:p};
// %t927 = $GROUND @ATTACH &vss => @PLACE(504, -784);
// &vss @WIRE(mode="straight") {#X172:5 %t927:p};
// %t928 = $IO_PORT @ATTACH &coarse7 => @PLACE(534, -771) => @ORIENT("R0");
// %t928 @TEXT("coarse7", key="name", size=0.75);
// &coarse7 @WIRE(mode="straight") {#X173:1 %t928:p};
// %t929 = $IO_PORT @ATTACH &n310 => @PLACE(534, -775) => @ORIENT("R0");
// %t929 @TEXT("n310", key="name", size=0.75);
// &n310 @WIRE(mode="straight") {#X173:2 %t929:p};
// %t930 = $IO_PORT @ATTACH &n311 => @PLACE(554, -773) => @ORIENT("MY");
// %t930 @TEXT("n311", key="name", size=0.75);
// &n311 @WIRE(mode="straight") {#X173:3 %t930:p};
// %t931 = $SUPPLY @ATTACH &vdd => @PLACE(544, -762);
// &vdd @WIRE(mode="straight") {#X173:4 %t931:p};
// %t932 = $GROUND @ATTACH &vss => @PLACE(544, -784);
// &vss @WIRE(mode="straight") {#X173:5 %t932:p};
// %t933 = $IO_PORT @ATTACH &dac0 => @PLACE(574, -771) => @ORIENT("R0");
// %t933 @TEXT("dac0", key="name", size=0.75);
// &dac0 @WIRE(mode="straight") {#X174:1 %t933:p};
// %t934 = $IO_PORT @ATTACH &n227 => @PLACE(574, -775) => @ORIENT("R0");
// %t934 @TEXT("n227", key="name", size=0.75);
// &n227 @WIRE(mode="straight") {#X174:2 %t934:p};
// %t935 = $IO_PORT @ATTACH &n312 => @PLACE(594, -773) => @ORIENT("MY");
// %t935 @TEXT("n312", key="name", size=0.75);
// &n312 @WIRE(mode="straight") {#X174:3 %t935:p};
// %t936 = $SUPPLY @ATTACH &vdd => @PLACE(584, -762);
// &vdd @WIRE(mode="straight") {#X174:4 %t936:p};
// %t937 = $GROUND @ATTACH &vss => @PLACE(584, -784);
// &vss @WIRE(mode="straight") {#X174:5 %t937:p};
// %t938 = $IO_PORT @ATTACH &dac1 => @PLACE(614, -771) => @ORIENT("R0");
// %t938 @TEXT("dac1", key="name", size=0.75);
// &dac1 @WIRE(mode="straight") {#X175:1 %t938:p};
// %t939 = $IO_PORT @ATTACH &n298 => @PLACE(614, -775) => @ORIENT("R0");
// %t939 @TEXT("n298", key="name", size=0.75);
// &n298 @WIRE(mode="straight") {#X175:2 %t939:p};
// %t940 = $IO_PORT @ATTACH &n313 => @PLACE(635, -773) => @ORIENT("MY");
// %t940 @TEXT("n313", key="name", size=0.75);
// &n313 @WIRE(mode="straight") {#X175:3 %t940:p};
// %t941 = $SUPPLY @ATTACH &vdd => @PLACE(624, -762);
// &vdd @WIRE(mode="straight") {#X175:4 %t941:p};
// %t942 = $GROUND @ATTACH &vss => @PLACE(624, -784);
// &vss @WIRE(mode="straight") {#X175:5 %t942:p};
// %t943 = $IO_PORT @ATTACH &dac2 => @PLACE(494, -806) => @ORIENT("R0");
// %t943 @TEXT("dac2", key="name", size=0.75);
// &dac2 @WIRE(mode="straight") {#X176:1 %t943:p};
// %t944 = $IO_PORT @ATTACH &n300 => @PLACE(494, -810) => @ORIENT("R0");
// %t944 @TEXT("n300", key="name", size=0.75);
// &n300 @WIRE(mode="straight") {#X176:2 %t944:p};
// %t945 = $IO_PORT @ATTACH &n314 => @PLACE(514, -808) => @ORIENT("MY");
// %t945 @TEXT("n314", key="name", size=0.75);
// &n314 @WIRE(mode="straight") {#X176:3 %t945:p};
// %t946 = $SUPPLY @ATTACH &vdd => @PLACE(504, -797);
// &vdd @WIRE(mode="straight") {#X176:4 %t946:p};
// %t947 = $GROUND @ATTACH &vss => @PLACE(504, -819);
// &vss @WIRE(mode="straight") {#X176:5 %t947:p};
// %t948 = $IO_PORT @ATTACH &dac3 => @PLACE(534, -806) => @ORIENT("R0");
// %t948 @TEXT("dac3", key="name", size=0.75);
// &dac3 @WIRE(mode="straight") {#X177:1 %t948:p};
// %t949 = $IO_PORT @ATTACH &n302 => @PLACE(534, -810) => @ORIENT("R0");
// %t949 @TEXT("n302", key="name", size=0.75);
// &n302 @WIRE(mode="straight") {#X177:2 %t949:p};
// %t950 = $IO_PORT @ATTACH &n315 => @PLACE(554, -808) => @ORIENT("MY");
// %t950 @TEXT("n315", key="name", size=0.75);
// &n315 @WIRE(mode="straight") {#X177:3 %t950:p};
// %t951 = $SUPPLY @ATTACH &vdd => @PLACE(544, -797);
// &vdd @WIRE(mode="straight") {#X177:4 %t951:p};
// %t952 = $GROUND @ATTACH &vss => @PLACE(544, -819);
// &vss @WIRE(mode="straight") {#X177:5 %t952:p};
// %t953 = $IO_PORT @ATTACH &dac4 => @PLACE(574, -806) => @ORIENT("R0");
// %t953 @TEXT("dac4", key="name", size=0.75);
// &dac4 @WIRE(mode="straight") {#X178:1 %t953:p};
// %t954 = $IO_PORT @ATTACH &n304 => @PLACE(574, -810) => @ORIENT("R0");
// %t954 @TEXT("n304", key="name", size=0.75);
// &n304 @WIRE(mode="straight") {#X178:2 %t954:p};
// %t955 = $IO_PORT @ATTACH &n316 => @PLACE(594, -808) => @ORIENT("MY");
// %t955 @TEXT("n316", key="name", size=0.75);
// &n316 @WIRE(mode="straight") {#X178:3 %t955:p};
// %t956 = $SUPPLY @ATTACH &vdd => @PLACE(584, -797);
// &vdd @WIRE(mode="straight") {#X178:4 %t956:p};
// %t957 = $GROUND @ATTACH &vss => @PLACE(584, -819);
// &vss @WIRE(mode="straight") {#X178:5 %t957:p};
// %t958 = $IO_PORT @ATTACH &dac5 => @PLACE(614, -806) => @ORIENT("R0");
// %t958 @TEXT("dac5", key="name", size=0.75);
// &dac5 @WIRE(mode="straight") {#X179:1 %t958:p};
// %t959 = $IO_PORT @ATTACH &n306 => @PLACE(614, -810) => @ORIENT("R0");
// %t959 @TEXT("n306", key="name", size=0.75);
// &n306 @WIRE(mode="straight") {#X179:2 %t959:p};
// %t960 = $IO_PORT @ATTACH &n317 => @PLACE(635, -808) => @ORIENT("MY");
// %t960 @TEXT("n317", key="name", size=0.75);
// &n317 @WIRE(mode="straight") {#X179:3 %t960:p};
// %t961 = $SUPPLY @ATTACH &vdd => @PLACE(624, -797);
// &vdd @WIRE(mode="straight") {#X179:4 %t961:p};
// %t962 = $GROUND @ATTACH &vss => @PLACE(624, -819);
// &vss @WIRE(mode="straight") {#X179:5 %t962:p};
// %t963 = $IO_PORT @ATTACH &n105 => @PLACE(494, -841) => @ORIENT("R0");
// %t963 @TEXT("n105", key="name", size=0.75);
// &n105 @WIRE(mode="straight") {#X180:1 %t963:p};
// %t964 = $IO_PORT @ATTACH &n88 => @PLACE(494, -845) => @ORIENT("R0");
// %t964 @TEXT("n88", key="name", size=0.75);
// &n88 @WIRE(mode="straight") {#X180:2 %t964:p};
// %t965 = $IO_PORT @ATTACH &n318 => @PLACE(514, -843) => @ORIENT("MY");
// %t965 @TEXT("n318", key="name", size=0.75);
// &n318 @WIRE(mode="straight") {#X180:3 %t965:p};
// %t966 = $SUPPLY @ATTACH &vdd => @PLACE(504, -832);
// &vdd @WIRE(mode="straight") {#X180:4 %t966:p};
// %t967 = $GROUND @ATTACH &vss => @PLACE(504, -854);
// &vss @WIRE(mode="straight") {#X180:5 %t967:p};
// %t968 = $IO_PORT @ATTACH &n107 => @PLACE(534, -841) => @ORIENT("R0");
// %t968 @TEXT("n107", key="name", size=0.75);
// &n107 @WIRE(mode="straight") {#X181:1 %t968:p};
// %t969 = $IO_PORT @ATTACH &n88 => @PLACE(534, -845) => @ORIENT("R0");
// %t969 @TEXT("n88", key="name", size=0.75);
// &n88 @WIRE(mode="straight") {#X181:2 %t969:p};
// %t970 = $IO_PORT @ATTACH &n319 => @PLACE(554, -843) => @ORIENT("MY");
// %t970 @TEXT("n319", key="name", size=0.75);
// &n319 @WIRE(mode="straight") {#X181:3 %t970:p};
// %t971 = $SUPPLY @ATTACH &vdd => @PLACE(544, -832);
// &vdd @WIRE(mode="straight") {#X181:4 %t971:p};
// %t972 = $GROUND @ATTACH &vss => @PLACE(544, -854);
// &vss @WIRE(mode="straight") {#X181:5 %t972:p};
// %t973 = $IO_PORT @ATTACH &n109 => @PLACE(574, -841) => @ORIENT("R0");
// %t973 @TEXT("n109", key="name", size=0.75);
// &n109 @WIRE(mode="straight") {#X182:1 %t973:p};
// %t974 = $IO_PORT @ATTACH &n117 => @PLACE(574, -845) => @ORIENT("R0");
// %t974 @TEXT("n117", key="name", size=0.75);
// &n117 @WIRE(mode="straight") {#X182:2 %t974:p};
// %t975 = $IO_PORT @ATTACH &n320 => @PLACE(594, -843) => @ORIENT("MY");
// %t975 @TEXT("n320", key="name", size=0.75);
// &n320 @WIRE(mode="straight") {#X182:3 %t975:p};
// %t976 = $SUPPLY @ATTACH &vdd => @PLACE(584, -832);
// &vdd @WIRE(mode="straight") {#X182:4 %t976:p};
// %t977 = $GROUND @ATTACH &vss => @PLACE(584, -854);
// &vss @WIRE(mode="straight") {#X182:5 %t977:p};
// %t978 = $IO_PORT @ATTACH &n111 => @PLACE(614, -841) => @ORIENT("R0");
// %t978 @TEXT("n111", key="name", size=0.75);
// &n111 @WIRE(mode="straight") {#X183:1 %t978:p};
// %t979 = $IO_PORT @ATTACH &n117 => @PLACE(614, -845) => @ORIENT("R0");
// %t979 @TEXT("n117", key="name", size=0.75);
// &n117 @WIRE(mode="straight") {#X183:2 %t979:p};
// %t980 = $IO_PORT @ATTACH &n321 => @PLACE(635, -843) => @ORIENT("MY");
// %t980 @TEXT("n321", key="name", size=0.75);
// &n321 @WIRE(mode="straight") {#X183:3 %t980:p};
// %t981 = $SUPPLY @ATTACH &vdd => @PLACE(624, -832);
// &vdd @WIRE(mode="straight") {#X183:4 %t981:p};
// %t982 = $GROUND @ATTACH &vss => @PLACE(624, -854);
// &vss @WIRE(mode="straight") {#X183:5 %t982:p};
// %t983 = $IO_PORT @ATTACH &n322 => @PLACE(494, -876) => @ORIENT("R0");
// %t983 @TEXT("n322", key="name", size=0.75);
// &n322 @WIRE(mode="straight") {#X184:1 %t983:p};
// %t984 = $IO_PORT @ATTACH &n60 => @PLACE(494, -880) => @ORIENT("R0");
// %t984 @TEXT("n60", key="name", size=0.75);
// &n60 @WIRE(mode="straight") {#X184:2 %t984:p};
// %t985 = $IO_PORT @ATTACH &n323 => @PLACE(514, -878) => @ORIENT("MY");
// %t985 @TEXT("n323", key="name", size=0.75);
// &n323 @WIRE(mode="straight") {#X184:3 %t985:p};
// %t986 = $SUPPLY @ATTACH &vdd => @PLACE(504, -867);
// &vdd @WIRE(mode="straight") {#X184:4 %t986:p};
// %t987 = $GROUND @ATTACH &vss => @PLACE(504, -889);
// &vss @WIRE(mode="straight") {#X184:5 %t987:p};
// %t988 = $IO_PORT @ATTACH &n251 => @PLACE(534, -876) => @ORIENT("R0");
// %t988 @TEXT("n251", key="name", size=0.75);
// &n251 @WIRE(mode="straight") {#X185:1 %t988:p};
// %t989 = $IO_PORT @ATTACH &n62 => @PLACE(534, -880) => @ORIENT("R0");
// %t989 @TEXT("n62", key="name", size=0.75);
// &n62 @WIRE(mode="straight") {#X185:2 %t989:p};
// %t990 = $IO_PORT @ATTACH &n324 => @PLACE(554, -878) => @ORIENT("MY");
// %t990 @TEXT("n324", key="name", size=0.75);
// &n324 @WIRE(mode="straight") {#X185:3 %t990:p};
// %t991 = $SUPPLY @ATTACH &vdd => @PLACE(544, -867);
// &vdd @WIRE(mode="straight") {#X185:4 %t991:p};
// %t992 = $GROUND @ATTACH &vss => @PLACE(544, -889);
// &vss @WIRE(mode="straight") {#X185:5 %t992:p};
// %t993 = $IO_PORT @ATTACH &n325 => @PLACE(574, -876) => @ORIENT("R0");
// %t993 @TEXT("n325", key="name", size=0.75);
// &n325 @WIRE(mode="straight") {#X186:1 %t993:p};
// %t994 = $IO_PORT @ATTACH &n64 => @PLACE(574, -880) => @ORIENT("R0");
// %t994 @TEXT("n64", key="name", size=0.75);
// &n64 @WIRE(mode="straight") {#X186:2 %t994:p};
// %t995 = $IO_PORT @ATTACH &n326 => @PLACE(594, -878) => @ORIENT("MY");
// %t995 @TEXT("n326", key="name", size=0.75);
// &n326 @WIRE(mode="straight") {#X186:3 %t995:p};
// %t996 = $SUPPLY @ATTACH &vdd => @PLACE(584, -867);
// &vdd @WIRE(mode="straight") {#X186:4 %t996:p};
// %t997 = $GROUND @ATTACH &vss => @PLACE(584, -889);
// &vss @WIRE(mode="straight") {#X186:5 %t997:p};
// %t998 = $IO_PORT @ATTACH &n327 => @PLACE(614, -876) => @ORIENT("R0");
// %t998 @TEXT("n327", key="name", size=0.75);
// &n327 @WIRE(mode="straight") {#X187:1 %t998:p};
// %t999 = $IO_PORT @ATTACH &n66 => @PLACE(614, -880) => @ORIENT("R0");
// %t999 @TEXT("n66", key="name", size=0.75);
// &n66 @WIRE(mode="straight") {#X187:2 %t999:p};
// %t1000 = $IO_PORT @ATTACH &n328 => @PLACE(635, -878) => @ORIENT("MY");
// %t1000 @TEXT("n328", key="name", size=0.75);
// &n328 @WIRE(mode="straight") {#X187:3 %t1000:p};
// %t1001 = $SUPPLY @ATTACH &vdd => @PLACE(624, -867);
// &vdd @WIRE(mode="straight") {#X187:4 %t1001:p};
// %t1002 = $GROUND @ATTACH &vss => @PLACE(624, -889);
// &vss @WIRE(mode="straight") {#X187:5 %t1002:p};
// %t1003 = $IO_PORT @ATTACH &n329 => @PLACE(494, -909) => @ORIENT("R0");
// %t1003 @TEXT("n329", key="name", size=0.75);
// &n329 @WIRE(mode="straight") {#X188:1 %t1003:p};
// %t1004 = $IO_PORT @ATTACH &n68 => @PLACE(494, -913) => @ORIENT("R0");
// %t1004 @TEXT("n68", key="name", size=0.75);
// &n68 @WIRE(mode="straight") {#X188:2 %t1004:p};
// %t1005 = $IO_PORT @ATTACH &n330 => @PLACE(514, -911) => @ORIENT("MY");
// %t1005 @TEXT("n330", key="name", size=0.75);
// &n330 @WIRE(mode="straight") {#X188:3 %t1005:p};
// %t1006 = $SUPPLY @ATTACH &vdd => @PLACE(504, -900);
// &vdd @WIRE(mode="straight") {#X188:4 %t1006:p};
// %t1007 = $GROUND @ATTACH &vss => @PLACE(504, -922);
// &vss @WIRE(mode="straight") {#X188:5 %t1007:p};
// %t1008 = $IO_PORT @ATTACH &n331 => @PLACE(534, -909) => @ORIENT("R0");
// %t1008 @TEXT("n331", key="name", size=0.75);
// &n331 @WIRE(mode="straight") {#X189:1 %t1008:p};
// %t1009 = $IO_PORT @ATTACH &n70 => @PLACE(534, -913) => @ORIENT("R0");
// %t1009 @TEXT("n70", key="name", size=0.75);
// &n70 @WIRE(mode="straight") {#X189:2 %t1009:p};
// %t1010 = $IO_PORT @ATTACH &n332 => @PLACE(554, -911) => @ORIENT("MY");
// %t1010 @TEXT("n332", key="name", size=0.75);
// &n332 @WIRE(mode="straight") {#X189:3 %t1010:p};
// %t1011 = $SUPPLY @ATTACH &vdd => @PLACE(544, -900);
// &vdd @WIRE(mode="straight") {#X189:4 %t1011:p};
// %t1012 = $GROUND @ATTACH &vss => @PLACE(544, -922);
// &vss @WIRE(mode="straight") {#X189:5 %t1012:p};
// %t1013 = $IO_PORT @ATTACH &n333 => @PLACE(574, -909) => @ORIENT("R0");
// %t1013 @TEXT("n333", key="name", size=0.75);
// &n333 @WIRE(mode="straight") {#X190:1 %t1013:p};
// %t1014 = $IO_PORT @ATTACH &n72 => @PLACE(574, -913) => @ORIENT("R0");
// %t1014 @TEXT("n72", key="name", size=0.75);
// &n72 @WIRE(mode="straight") {#X190:2 %t1014:p};
// %t1015 = $IO_PORT @ATTACH &n334 => @PLACE(594, -911) => @ORIENT("MY");
// %t1015 @TEXT("n334", key="name", size=0.75);
// &n334 @WIRE(mode="straight") {#X190:3 %t1015:p};
// %t1016 = $SUPPLY @ATTACH &vdd => @PLACE(584, -900);
// &vdd @WIRE(mode="straight") {#X190:4 %t1016:p};
// %t1017 = $GROUND @ATTACH &vss => @PLACE(584, -922);
// &vss @WIRE(mode="straight") {#X190:5 %t1017:p};
// %t1018 = $IO_PORT @ATTACH &n335 => @PLACE(614, -909) => @ORIENT("R0");
// %t1018 @TEXT("n335", key="name", size=0.75);
// &n335 @WIRE(mode="straight") {#X191:1 %t1018:p};
// %t1019 = $IO_PORT @ATTACH &n60 => @PLACE(614, -913) => @ORIENT("R0");
// %t1019 @TEXT("n60", key="name", size=0.75);
// &n60 @WIRE(mode="straight") {#X191:2 %t1019:p};
// %t1020 = $IO_PORT @ATTACH &n336 => @PLACE(635, -911) => @ORIENT("MY");
// %t1020 @TEXT("n336", key="name", size=0.75);
// &n336 @WIRE(mode="straight") {#X191:3 %t1020:p};
// %t1021 = $SUPPLY @ATTACH &vdd => @PLACE(624, -900);
// &vdd @WIRE(mode="straight") {#X191:4 %t1021:p};
// %t1022 = $GROUND @ATTACH &vss => @PLACE(624, -922);
// &vss @WIRE(mode="straight") {#X191:5 %t1022:p};
// %t1023 = $IO_PORT @ATTACH &n337 => @PLACE(-11, -952) => @ORIENT("R0");
// %t1023 @TEXT("n337", key="name", size=0.75);
// &n337 @WIRE(mode="straight") {#X192:1 %t1023:p};
// %t1024 = $IO_PORT @ATTACH &n62 => @PLACE(-11, -956) => @ORIENT("R0");
// %t1024 @TEXT("n62", key="name", size=0.75);
// &n62 @WIRE(mode="straight") {#X192:2 %t1024:p};
// %t1025 = $IO_PORT @ATTACH &n338 => @PLACE(10, -954) => @ORIENT("MY");
// %t1025 @TEXT("n338", key="name", size=0.75);
// &n338 @WIRE(mode="straight") {#X192:3 %t1025:p};
// %t1026 = $SUPPLY @ATTACH &vdd => @PLACE(0, -943);
// &vdd @WIRE(mode="straight") {#X192:4 %t1026:p};
// %t1027 = $GROUND @ATTACH &vss => @PLACE(0, -965);
// &vss @WIRE(mode="straight") {#X192:5 %t1027:p};
// %t1028 = $IO_PORT @ATTACH &n339 => @PLACE(30, -952) => @ORIENT("R0");
// %t1028 @TEXT("n339", key="name", size=0.75);
// &n339 @WIRE(mode="straight") {#X193:1 %t1028:p};
// %t1029 = $IO_PORT @ATTACH &n64 => @PLACE(30, -956) => @ORIENT("R0");
// %t1029 @TEXT("n64", key="name", size=0.75);
// &n64 @WIRE(mode="straight") {#X193:2 %t1029:p};
// %t1030 = $IO_PORT @ATTACH &n340 => @PLACE(50, -954) => @ORIENT("MY");
// %t1030 @TEXT("n340", key="name", size=0.75);
// &n340 @WIRE(mode="straight") {#X193:3 %t1030:p};
// %t1031 = $SUPPLY @ATTACH &vdd => @PLACE(40, -943);
// &vdd @WIRE(mode="straight") {#X193:4 %t1031:p};
// %t1032 = $GROUND @ATTACH &vss => @PLACE(40, -965);
// &vss @WIRE(mode="straight") {#X193:5 %t1032:p};
// %t1033 = $IO_PORT @ATTACH &n341 => @PLACE(70, -952) => @ORIENT("R0");
// %t1033 @TEXT("n341", key="name", size=0.75);
// &n341 @WIRE(mode="straight") {#X194:1 %t1033:p};
// %t1034 = $IO_PORT @ATTACH &n66 => @PLACE(70, -956) => @ORIENT("R0");
// %t1034 @TEXT("n66", key="name", size=0.75);
// &n66 @WIRE(mode="straight") {#X194:2 %t1034:p};
// %t1035 = $IO_PORT @ATTACH &n342 => @PLACE(90, -954) => @ORIENT("MY");
// %t1035 @TEXT("n342", key="name", size=0.75);
// &n342 @WIRE(mode="straight") {#X194:3 %t1035:p};
// %t1036 = $SUPPLY @ATTACH &vdd => @PLACE(80, -943);
// &vdd @WIRE(mode="straight") {#X194:4 %t1036:p};
// %t1037 = $GROUND @ATTACH &vss => @PLACE(80, -965);
// &vss @WIRE(mode="straight") {#X194:5 %t1037:p};
// %t1038 = $IO_PORT @ATTACH &n343 => @PLACE(110, -952) => @ORIENT("R0");
// %t1038 @TEXT("n343", key="name", size=0.75);
// &n343 @WIRE(mode="straight") {#X195:1 %t1038:p};
// %t1039 = $IO_PORT @ATTACH &n68 => @PLACE(110, -956) => @ORIENT("R0");
// %t1039 @TEXT("n68", key="name", size=0.75);
// &n68 @WIRE(mode="straight") {#X195:2 %t1039:p};
// %t1040 = $IO_PORT @ATTACH &n344 => @PLACE(130, -954) => @ORIENT("MY");
// %t1040 @TEXT("n344", key="name", size=0.75);
// &n344 @WIRE(mode="straight") {#X195:3 %t1040:p};
// %t1041 = $SUPPLY @ATTACH &vdd => @PLACE(120, -943);
// &vdd @WIRE(mode="straight") {#X195:4 %t1041:p};
// %t1042 = $GROUND @ATTACH &vss => @PLACE(120, -965);
// &vss @WIRE(mode="straight") {#X195:5 %t1042:p};
// %t1043 = $IO_PORT @ATTACH &n254 => @PLACE(-11, -983) => @ORIENT("R0");
// %t1043 @TEXT("n254", key="name", size=0.75);
// &n254 @WIRE(mode="straight") {#X196:1 %t1043:p};
// %t1044 = $IO_PORT @ATTACH &n345 => @PLACE(-11, -987) => @ORIENT("R0");
// %t1044 @TEXT("n345", key="name", size=0.75);
// &n345 @WIRE(mode="straight") {#X196:2 %t1044:p};
// %t1045 = $IO_PORT @ATTACH &n346 => @PLACE(10, -985) => @ORIENT("MY");
// %t1045 @TEXT("n346", key="name", size=0.75);
// &n346 @WIRE(mode="straight") {#X196:3 %t1045:p};
// %t1046 = $SUPPLY @ATTACH &vdd => @PLACE(0, -974);
// &vdd @WIRE(mode="straight") {#X196:4 %t1046:p};
// %t1047 = $GROUND @ATTACH &vss => @PLACE(0, -996);
// &vss @WIRE(mode="straight") {#X196:5 %t1047:p};
// %t1048 = $IO_PORT @ATTACH &n250 => @PLACE(30, -983) => @ORIENT("R0");
// %t1048 @TEXT("n250", key="name", size=0.75);
// &n250 @WIRE(mode="straight") {#X197:1 %t1048:p};
// %t1049 = $IO_PORT @ATTACH &n347 => @PLACE(30, -987) => @ORIENT("R0");
// %t1049 @TEXT("n347", key="name", size=0.75);
// &n347 @WIRE(mode="straight") {#X197:2 %t1049:p};
// %t1050 = $IO_PORT @ATTACH &n348 => @PLACE(50, -985) => @ORIENT("MY");
// %t1050 @TEXT("n348", key="name", size=0.75);
// &n348 @WIRE(mode="straight") {#X197:3 %t1050:p};
// %t1051 = $SUPPLY @ATTACH &vdd => @PLACE(40, -974);
// &vdd @WIRE(mode="straight") {#X197:4 %t1051:p};
// %t1052 = $GROUND @ATTACH &vss => @PLACE(40, -996);
// &vss @WIRE(mode="straight") {#X197:5 %t1052:p};
// %t1053 = $IO_PORT @ATTACH &n349 => @PLACE(70, -983) => @ORIENT("R0");
// %t1053 @TEXT("n349", key="name", size=0.75);
// &n349 @WIRE(mode="straight") {#X198:1 %t1053:p};
// %t1054 = $IO_PORT @ATTACH &n350 => @PLACE(70, -987) => @ORIENT("R0");
// %t1054 @TEXT("n350", key="name", size=0.75);
// &n350 @WIRE(mode="straight") {#X198:2 %t1054:p};
// %t1055 = $IO_PORT @ATTACH &n351 => @PLACE(90, -985) => @ORIENT("MY");
// %t1055 @TEXT("n351", key="name", size=0.75);
// &n351 @WIRE(mode="straight") {#X198:3 %t1055:p};
// %t1056 = $SUPPLY @ATTACH &vdd => @PLACE(80, -974);
// &vdd @WIRE(mode="straight") {#X198:4 %t1056:p};
// %t1057 = $GROUND @ATTACH &vss => @PLACE(80, -996);
// &vss @WIRE(mode="straight") {#X198:5 %t1057:p};
// %t1058 = $IO_PORT @ATTACH &n352 => @PLACE(110, -983) => @ORIENT("R0");
// %t1058 @TEXT("n352", key="name", size=0.75);
// &n352 @WIRE(mode="straight") {#X199:1 %t1058:p};
// %t1059 = $IO_PORT @ATTACH &n353 => @PLACE(110, -987) => @ORIENT("R0");
// %t1059 @TEXT("n353", key="name", size=0.75);
// &n353 @WIRE(mode="straight") {#X199:2 %t1059:p};
// %t1060 = $IO_PORT @ATTACH &n354 => @PLACE(130, -985) => @ORIENT("MY");
// %t1060 @TEXT("n354", key="name", size=0.75);
// &n354 @WIRE(mode="straight") {#X199:3 %t1060:p};
// %t1061 = $SUPPLY @ATTACH &vdd => @PLACE(120, -974);
// &vdd @WIRE(mode="straight") {#X199:4 %t1061:p};
// %t1062 = $GROUND @ATTACH &vss => @PLACE(120, -996);
// &vss @WIRE(mode="straight") {#X199:5 %t1062:p};
// %t1063 = $IO_PORT @ATTACH &dac1 => @PLACE(-11, -1014) => @ORIENT("R0");
// %t1063 @TEXT("dac1", key="name", size=0.75);
// &dac1 @WIRE(mode="straight") {#X200:1 %t1063:p};
// %t1064 = $IO_PORT @ATTACH &dac0 => @PLACE(-11, -1018) => @ORIENT("R0");
// %t1064 @TEXT("dac0", key="name", size=0.75);
// &dac0 @WIRE(mode="straight") {#X200:2 %t1064:p};
// %t1065 = $IO_PORT @ATTACH &n355 => @PLACE(10, -1016) => @ORIENT("MY");
// %t1065 @TEXT("n355", key="name", size=0.75);
// &n355 @WIRE(mode="straight") {#X200:3 %t1065:p};
// %t1066 = $SUPPLY @ATTACH &vdd => @PLACE(0, -1005);
// &vdd @WIRE(mode="straight") {#X200:4 %t1066:p};
// %t1067 = $GROUND @ATTACH &vss => @PLACE(0, -1027);
// &vss @WIRE(mode="straight") {#X200:5 %t1067:p};
// %t1068 = $IO_PORT @ATTACH &dac2 => @PLACE(30, -1014) => @ORIENT("R0");
// %t1068 @TEXT("dac2", key="name", size=0.75);
// &dac2 @WIRE(mode="straight") {#X201:1 %t1068:p};
// %t1069 = $IO_PORT @ATTACH &n356 => @PLACE(30, -1018) => @ORIENT("R0");
// %t1069 @TEXT("n356", key="name", size=0.75);
// &n356 @WIRE(mode="straight") {#X201:2 %t1069:p};
// %t1070 = $IO_PORT @ATTACH &n357 => @PLACE(50, -1016) => @ORIENT("MY");
// %t1070 @TEXT("n357", key="name", size=0.75);
// &n357 @WIRE(mode="straight") {#X201:3 %t1070:p};
// %t1071 = $SUPPLY @ATTACH &vdd => @PLACE(40, -1005);
// &vdd @WIRE(mode="straight") {#X201:4 %t1071:p};
// %t1072 = $GROUND @ATTACH &vss => @PLACE(40, -1027);
// &vss @WIRE(mode="straight") {#X201:5 %t1072:p};
// %t1073 = $IO_PORT @ATTACH &dac4 => @PLACE(70, -1014) => @ORIENT("R0");
// %t1073 @TEXT("dac4", key="name", size=0.75);
// &dac4 @WIRE(mode="straight") {#X202:1 %t1073:p};
// %t1074 = $IO_PORT @ATTACH &n358 => @PLACE(70, -1018) => @ORIENT("R0");
// %t1074 @TEXT("n358", key="name", size=0.75);
// &n358 @WIRE(mode="straight") {#X202:2 %t1074:p};
// %t1075 = $IO_PORT @ATTACH &n359 => @PLACE(90, -1016) => @ORIENT("MY");
// %t1075 @TEXT("n359", key="name", size=0.75);
// &n359 @WIRE(mode="straight") {#X202:3 %t1075:p};
// %t1076 = $SUPPLY @ATTACH &vdd => @PLACE(80, -1005);
// &vdd @WIRE(mode="straight") {#X202:4 %t1076:p};
// %t1077 = $GROUND @ATTACH &vss => @PLACE(80, -1027);
// &vss @WIRE(mode="straight") {#X202:5 %t1077:p};
// %t1078 = $IO_PORT @ATTACH &dac5 => @PLACE(110, -1014) => @ORIENT("R0");
// %t1078 @TEXT("dac5", key="name", size=0.75);
// &dac5 @WIRE(mode="straight") {#X203:1 %t1078:p};
// %t1079 = $IO_PORT @ATTACH &n360 => @PLACE(110, -1018) => @ORIENT("R0");
// %t1079 @TEXT("n360", key="name", size=0.75);
// &n360 @WIRE(mode="straight") {#X203:2 %t1079:p};
// %t1080 = $IO_PORT @ATTACH &n361 => @PLACE(130, -1016) => @ORIENT("MY");
// %t1080 @TEXT("n361", key="name", size=0.75);
// &n361 @WIRE(mode="straight") {#X203:3 %t1080:p};
// %t1081 = $SUPPLY @ATTACH &vdd => @PLACE(120, -1005);
// &vdd @WIRE(mode="straight") {#X203:4 %t1081:p};
// %t1082 = $GROUND @ATTACH &vss => @PLACE(120, -1027);
// &vss @WIRE(mode="straight") {#X203:5 %t1082:p};
// %t1083 = $IO_PORT @ATTACH &n362 => @PLACE(-11, -1045) => @ORIENT("R0");
// %t1083 @TEXT("n362", key="name", size=0.75);
// &n362 @WIRE(mode="straight") {#X204:1 %t1083:p};
// %t1084 = $IO_PORT @ATTACH &n363 => @PLACE(-11, -1049) => @ORIENT("R0");
// %t1084 @TEXT("n363", key="name", size=0.75);
// &n363 @WIRE(mode="straight") {#X204:2 %t1084:p};
// %t1085 = $IO_PORT @ATTACH &n364 => @PLACE(10, -1047) => @ORIENT("MY");
// %t1085 @TEXT("n364", key="name", size=0.75);
// &n364 @WIRE(mode="straight") {#X204:3 %t1085:p};
// %t1086 = $SUPPLY @ATTACH &vdd => @PLACE(0, -1036);
// &vdd @WIRE(mode="straight") {#X204:4 %t1086:p};
// %t1087 = $GROUND @ATTACH &vss => @PLACE(0, -1058);
// &vss @WIRE(mode="straight") {#X204:5 %t1087:p};
// %t1088 = $IO_PORT @ATTACH &n365 => @PLACE(30, -1045) => @ORIENT("R0");
// %t1088 @TEXT("n365", key="name", size=0.75);
// &n365 @WIRE(mode="straight") {#X205:1 %t1088:p};
// %t1089 = $IO_PORT @ATTACH &n366 => @PLACE(30, -1049) => @ORIENT("R0");
// %t1089 @TEXT("n366", key="name", size=0.75);
// &n366 @WIRE(mode="straight") {#X205:2 %t1089:p};
// %t1090 = $IO_PORT @ATTACH &n367 => @PLACE(50, -1047) => @ORIENT("MY");
// %t1090 @TEXT("n367", key="name", size=0.75);
// &n367 @WIRE(mode="straight") {#X205:3 %t1090:p};
// %t1091 = $SUPPLY @ATTACH &vdd => @PLACE(40, -1036);
// &vdd @WIRE(mode="straight") {#X205:4 %t1091:p};
// %t1092 = $GROUND @ATTACH &vss => @PLACE(40, -1058);
// &vss @WIRE(mode="straight") {#X205:5 %t1092:p};
// %t1093 = $IO_PORT @ATTACH &n368 => @PLACE(70, -1045) => @ORIENT("R0");
// %t1093 @TEXT("n368", key="name", size=0.75);
// &n368 @WIRE(mode="straight") {#X206:1 %t1093:p};
// %t1094 = $IO_PORT @ATTACH &n369 => @PLACE(70, -1049) => @ORIENT("R0");
// %t1094 @TEXT("n369", key="name", size=0.75);
// &n369 @WIRE(mode="straight") {#X206:2 %t1094:p};
// %t1095 = $IO_PORT @ATTACH &n370 => @PLACE(90, -1047) => @ORIENT("MY");
// %t1095 @TEXT("n370", key="name", size=0.75);
// &n370 @WIRE(mode="straight") {#X206:3 %t1095:p};
// %t1096 = $SUPPLY @ATTACH &vdd => @PLACE(80, -1036);
// &vdd @WIRE(mode="straight") {#X206:4 %t1096:p};
// %t1097 = $GROUND @ATTACH &vss => @PLACE(80, -1058);
// &vss @WIRE(mode="straight") {#X206:5 %t1097:p};
// %t1098 = $IO_PORT @ATTACH &n371 => @PLACE(110, -1045) => @ORIENT("R0");
// %t1098 @TEXT("n371", key="name", size=0.75);
// &n371 @WIRE(mode="straight") {#X207:1 %t1098:p};
// %t1099 = $IO_PORT @ATTACH &n372 => @PLACE(110, -1049) => @ORIENT("R0");
// %t1099 @TEXT("n372", key="name", size=0.75);
// &n372 @WIRE(mode="straight") {#X207:2 %t1099:p};
// %t1100 = $IO_PORT @ATTACH &n373 => @PLACE(130, -1047) => @ORIENT("MY");
// %t1100 @TEXT("n373", key="name", size=0.75);
// &n373 @WIRE(mode="straight") {#X207:3 %t1100:p};
// %t1101 = $SUPPLY @ATTACH &vdd => @PLACE(120, -1036);
// &vdd @WIRE(mode="straight") {#X207:4 %t1101:p};
// %t1102 = $GROUND @ATTACH &vss => @PLACE(120, -1058);
// &vss @WIRE(mode="straight") {#X207:5 %t1102:p};
// %t1103 = $IO_PORT @ATTACH &n374 => @PLACE(-11, -1076) => @ORIENT("R0");
// %t1103 @TEXT("n374", key="name", size=0.75);
// &n374 @WIRE(mode="straight") {#X208:1 %t1103:p};
// %t1104 = $IO_PORT @ATTACH &n375 => @PLACE(-11, -1080) => @ORIENT("R0");
// %t1104 @TEXT("n375", key="name", size=0.75);
// &n375 @WIRE(mode="straight") {#X208:2 %t1104:p};
// %t1105 = $IO_PORT @ATTACH &n376 => @PLACE(10, -1078) => @ORIENT("MY");
// %t1105 @TEXT("n376", key="name", size=0.75);
// &n376 @WIRE(mode="straight") {#X208:3 %t1105:p};
// %t1106 = $SUPPLY @ATTACH &vdd => @PLACE(0, -1067);
// &vdd @WIRE(mode="straight") {#X208:4 %t1106:p};
// %t1107 = $GROUND @ATTACH &vss => @PLACE(0, -1089);
// &vss @WIRE(mode="straight") {#X208:5 %t1107:p};
// %t1108 = $IO_PORT @ATTACH &n377 => @PLACE(30, -1076) => @ORIENT("R0");
// %t1108 @TEXT("n377", key="name", size=0.75);
// &n377 @WIRE(mode="straight") {#X209:1 %t1108:p};
// %t1109 = $IO_PORT @ATTACH &n378 => @PLACE(30, -1080) => @ORIENT("R0");
// %t1109 @TEXT("n378", key="name", size=0.75);
// &n378 @WIRE(mode="straight") {#X209:2 %t1109:p};
// %t1110 = $IO_PORT @ATTACH &n379 => @PLACE(50, -1078) => @ORIENT("MY");
// %t1110 @TEXT("n379", key="name", size=0.75);
// &n379 @WIRE(mode="straight") {#X209:3 %t1110:p};
// %t1111 = $SUPPLY @ATTACH &vdd => @PLACE(40, -1067);
// &vdd @WIRE(mode="straight") {#X209:4 %t1111:p};
// %t1112 = $GROUND @ATTACH &vss => @PLACE(40, -1089);
// &vss @WIRE(mode="straight") {#X209:5 %t1112:p};
// %t1113 = $IO_PORT @ATTACH &n380 => @PLACE(70, -1076) => @ORIENT("R0");
// %t1113 @TEXT("n380", key="name", size=0.75);
// &n380 @WIRE(mode="straight") {#X210:1 %t1113:p};
// %t1114 = $IO_PORT @ATTACH &n381 => @PLACE(70, -1080) => @ORIENT("R0");
// %t1114 @TEXT("n381", key="name", size=0.75);
// &n381 @WIRE(mode="straight") {#X210:2 %t1114:p};
// %t1115 = $IO_PORT @ATTACH &n212 => @PLACE(90, -1078) => @ORIENT("MY");
// %t1115 @TEXT("n212", key="name", size=0.75);
// &n212 @WIRE(mode="straight") {#X210:3 %t1115:p};
// %t1116 = $SUPPLY @ATTACH &vdd => @PLACE(80, -1067);
// &vdd @WIRE(mode="straight") {#X210:4 %t1116:p};
// %t1117 = $GROUND @ATTACH &vss => @PLACE(80, -1089);
// &vss @WIRE(mode="straight") {#X210:5 %t1117:p};
// %t1118 = $IO_PORT @ATTACH &n382 => @PLACE(110, -1076) => @ORIENT("R0");
// %t1118 @TEXT("n382", key="name", size=0.75);
// &n382 @WIRE(mode="straight") {#X211:1 %t1118:p};
// %t1119 = $IO_PORT @ATTACH &n383 => @PLACE(110, -1080) => @ORIENT("R0");
// %t1119 @TEXT("n383", key="name", size=0.75);
// &n383 @WIRE(mode="straight") {#X211:2 %t1119:p};
// %t1120 = $IO_PORT @ATTACH &n216 => @PLACE(130, -1078) => @ORIENT("MY");
// %t1120 @TEXT("n216", key="name", size=0.75);
// &n216 @WIRE(mode="straight") {#X211:3 %t1120:p};
// %t1121 = $SUPPLY @ATTACH &vdd => @PLACE(120, -1067);
// &vdd @WIRE(mode="straight") {#X211:4 %t1121:p};
// %t1122 = $GROUND @ATTACH &vss => @PLACE(120, -1089);
// &vss @WIRE(mode="straight") {#X211:5 %t1122:p};
// %t1123 = $IO_PORT @ATTACH &n384 => @PLACE(-11, -1107) => @ORIENT("R0");
// %t1123 @TEXT("n384", key="name", size=0.75);
// &n384 @WIRE(mode="straight") {#X212:1 %t1123:p};
// %t1124 = $IO_PORT @ATTACH &n385 => @PLACE(-11, -1111) => @ORIENT("R0");
// %t1124 @TEXT("n385", key="name", size=0.75);
// &n385 @WIRE(mode="straight") {#X212:2 %t1124:p};
// %t1125 = $IO_PORT @ATTACH &n214 => @PLACE(10, -1109) => @ORIENT("MY");
// %t1125 @TEXT("n214", key="name", size=0.75);
// &n214 @WIRE(mode="straight") {#X212:3 %t1125:p};
// %t1126 = $SUPPLY @ATTACH &vdd => @PLACE(0, -1098);
// &vdd @WIRE(mode="straight") {#X212:4 %t1126:p};
// %t1127 = $GROUND @ATTACH &vss => @PLACE(0, -1120);
// &vss @WIRE(mode="straight") {#X212:5 %t1127:p};
// %t1128 = $IO_PORT @ATTACH &n386 => @PLACE(30, -1107) => @ORIENT("R0");
// %t1128 @TEXT("n386", key="name", size=0.75);
// &n386 @WIRE(mode="straight") {#X213:1 %t1128:p};
// %t1129 = $IO_PORT @ATTACH &n387 => @PLACE(30, -1111) => @ORIENT("R0");
// %t1129 @TEXT("n387", key="name", size=0.75);
// &n387 @WIRE(mode="straight") {#X213:2 %t1129:p};
// %t1130 = $IO_PORT @ATTACH &n218 => @PLACE(50, -1109) => @ORIENT("MY");
// %t1130 @TEXT("n218", key="name", size=0.75);
// &n218 @WIRE(mode="straight") {#X213:3 %t1130:p};
// %t1131 = $SUPPLY @ATTACH &vdd => @PLACE(40, -1098);
// &vdd @WIRE(mode="straight") {#X213:4 %t1131:p};
// %t1132 = $GROUND @ATTACH &vss => @PLACE(40, -1120);
// &vss @WIRE(mode="straight") {#X213:5 %t1132:p};
// %t1133 = $IO_PORT @ATTACH &n388 => @PLACE(70, -1107) => @ORIENT("R0");
// %t1133 @TEXT("n388", key="name", size=0.75);
// &n388 @WIRE(mode="straight") {#X214:1 %t1133:p};
// %t1134 = $IO_PORT @ATTACH &n389 => @PLACE(70, -1111) => @ORIENT("R0");
// %t1134 @TEXT("n389", key="name", size=0.75);
// &n389 @WIRE(mode="straight") {#X214:2 %t1134:p};
// %t1135 = $IO_PORT @ATTACH &n220 => @PLACE(90, -1109) => @ORIENT("MY");
// %t1135 @TEXT("n220", key="name", size=0.75);
// &n220 @WIRE(mode="straight") {#X214:3 %t1135:p};
// %t1136 = $SUPPLY @ATTACH &vdd => @PLACE(80, -1098);
// &vdd @WIRE(mode="straight") {#X214:4 %t1136:p};
// %t1137 = $GROUND @ATTACH &vss => @PLACE(80, -1120);
// &vss @WIRE(mode="straight") {#X214:5 %t1137:p};
// %t1138 = $IO_PORT @ATTACH &n213 => @PLACE(110, -1107) => @ORIENT("R0");
// %t1138 @TEXT("n213", key="name", size=0.75);
// &n213 @WIRE(mode="straight") {#X215:1 %t1138:p};
// %t1139 = $IO_PORT @ATTACH &n390 => @PLACE(110, -1111) => @ORIENT("R0");
// %t1139 @TEXT("n390", key="name", size=0.75);
// &n390 @WIRE(mode="straight") {#X215:2 %t1139:p};
// %t1140 = $IO_PORT @ATTACH &n391 => @PLACE(130, -1109) => @ORIENT("MY");
// %t1140 @TEXT("n391", key="name", size=0.75);
// &n391 @WIRE(mode="straight") {#X215:3 %t1140:p};
// %t1141 = $SUPPLY @ATTACH &vdd => @PLACE(120, -1098);
// &vdd @WIRE(mode="straight") {#X215:4 %t1141:p};
// %t1142 = $GROUND @ATTACH &vss => @PLACE(120, -1120);
// &vss @WIRE(mode="straight") {#X215:5 %t1142:p};
// %t1143 = $IO_PORT @ATTACH &n217 => @PLACE(158, -952) => @ORIENT("R0");
// %t1143 @TEXT("n217", key="name", size=0.75);
// &n217 @WIRE(mode="straight") {#X216:1 %t1143:p};
// %t1144 = $IO_PORT @ATTACH &n392 => @PLACE(158, -956) => @ORIENT("R0");
// %t1144 @TEXT("n392", key="name", size=0.75);
// &n392 @WIRE(mode="straight") {#X216:2 %t1144:p};
// %t1145 = $IO_PORT @ATTACH &n393 => @PLACE(178, -954) => @ORIENT("MY");
// %t1145 @TEXT("n393", key="name", size=0.75);
// &n393 @WIRE(mode="straight") {#X216:3 %t1145:p};
// %t1146 = $SUPPLY @ATTACH &vdd => @PLACE(168, -943);
// &vdd @WIRE(mode="straight") {#X216:4 %t1146:p};
// %t1147 = $GROUND @ATTACH &vss => @PLACE(168, -965);
// &vss @WIRE(mode="straight") {#X216:5 %t1147:p};
// %t1148 = $IO_PORT @ATTACH &n215 => @PLACE(198, -952) => @ORIENT("R0");
// %t1148 @TEXT("n215", key="name", size=0.75);
// &n215 @WIRE(mode="straight") {#X217:1 %t1148:p};
// %t1149 = $IO_PORT @ATTACH &n394 => @PLACE(198, -956) => @ORIENT("R0");
// %t1149 @TEXT("n394", key="name", size=0.75);
// &n394 @WIRE(mode="straight") {#X217:2 %t1149:p};
// %t1150 = $IO_PORT @ATTACH &n395 => @PLACE(218, -954) => @ORIENT("MY");
// %t1150 @TEXT("n395", key="name", size=0.75);
// &n395 @WIRE(mode="straight") {#X217:3 %t1150:p};
// %t1151 = $SUPPLY @ATTACH &vdd => @PLACE(208, -943);
// &vdd @WIRE(mode="straight") {#X217:4 %t1151:p};
// %t1152 = $GROUND @ATTACH &vss => @PLACE(208, -965);
// &vss @WIRE(mode="straight") {#X217:5 %t1152:p};
// %t1153 = $IO_PORT @ATTACH &n219 => @PLACE(238, -952) => @ORIENT("R0");
// %t1153 @TEXT("n219", key="name", size=0.75);
// &n219 @WIRE(mode="straight") {#X218:1 %t1153:p};
// %t1154 = $IO_PORT @ATTACH &n396 => @PLACE(238, -956) => @ORIENT("R0");
// %t1154 @TEXT("n396", key="name", size=0.75);
// &n396 @WIRE(mode="straight") {#X218:2 %t1154:p};
// %t1155 = $IO_PORT @ATTACH &n397 => @PLACE(258, -954) => @ORIENT("MY");
// %t1155 @TEXT("n397", key="name", size=0.75);
// &n397 @WIRE(mode="straight") {#X218:3 %t1155:p};
// %t1156 = $SUPPLY @ATTACH &vdd => @PLACE(248, -943);
// &vdd @WIRE(mode="straight") {#X218:4 %t1156:p};
// %t1157 = $GROUND @ATTACH &vss => @PLACE(248, -965);
// &vss @WIRE(mode="straight") {#X218:5 %t1157:p};
// %t1158 = $IO_PORT @ATTACH &n221 => @PLACE(278, -952) => @ORIENT("R0");
// %t1158 @TEXT("n221", key="name", size=0.75);
// &n221 @WIRE(mode="straight") {#X219:1 %t1158:p};
// %t1159 = $IO_PORT @ATTACH &n398 => @PLACE(278, -956) => @ORIENT("R0");
// %t1159 @TEXT("n398", key="name", size=0.75);
// &n398 @WIRE(mode="straight") {#X219:2 %t1159:p};
// %t1160 = $IO_PORT @ATTACH &n399 => @PLACE(298, -954) => @ORIENT("MY");
// %t1160 @TEXT("n399", key="name", size=0.75);
// &n399 @WIRE(mode="straight") {#X219:3 %t1160:p};
// %t1161 = $SUPPLY @ATTACH &vdd => @PLACE(288, -943);
// &vdd @WIRE(mode="straight") {#X219:4 %t1161:p};
// %t1162 = $GROUND @ATTACH &vss => @PLACE(288, -965);
// &vss @WIRE(mode="straight") {#X219:5 %t1162:p};
// %t1163 = $IO_PORT @ATTACH &n223 => @PLACE(158, -983) => @ORIENT("R0");
// %t1163 @TEXT("n223", key="name", size=0.75);
// &n223 @WIRE(mode="straight") {#X220:1 %t1163:p};
// %t1164 = $IO_PORT @ATTACH &n400 => @PLACE(158, -987) => @ORIENT("R0");
// %t1164 @TEXT("n400", key="name", size=0.75);
// &n400 @WIRE(mode="straight") {#X220:2 %t1164:p};
// %t1165 = $IO_PORT @ATTACH &n401 => @PLACE(178, -985) => @ORIENT("MY");
// %t1165 @TEXT("n401", key="name", size=0.75);
// &n401 @WIRE(mode="straight") {#X220:3 %t1165:p};
// %t1166 = $SUPPLY @ATTACH &vdd => @PLACE(168, -974);
// &vdd @WIRE(mode="straight") {#X220:4 %t1166:p};
// %t1167 = $GROUND @ATTACH &vss => @PLACE(168, -996);
// &vss @WIRE(mode="straight") {#X220:5 %t1167:p};
// %t1168 = $IO_PORT @ATTACH &n402 => @PLACE(198, -983) => @ORIENT("R0");
// %t1168 @TEXT("n402", key="name", size=0.75);
// &n402 @WIRE(mode="straight") {#X221:1 %t1168:p};
// %t1169 = $IO_PORT @ATTACH &n403 => @PLACE(198, -987) => @ORIENT("R0");
// %t1169 @TEXT("n403", key="name", size=0.75);
// &n403 @WIRE(mode="straight") {#X221:2 %t1169:p};
// %t1170 = $IO_PORT @ATTACH &n404 => @PLACE(218, -985) => @ORIENT("MY");
// %t1170 @TEXT("n404", key="name", size=0.75);
// &n404 @WIRE(mode="straight") {#X221:3 %t1170:p};
// %t1171 = $SUPPLY @ATTACH &vdd => @PLACE(208, -974);
// &vdd @WIRE(mode="straight") {#X221:4 %t1171:p};
// %t1172 = $GROUND @ATTACH &vss => @PLACE(208, -996);
// &vss @WIRE(mode="straight") {#X221:5 %t1172:p};
// %t1173 = $IO_PORT @ATTACH &n246 => @PLACE(238, -983) => @ORIENT("R0");
// %t1173 @TEXT("n246", key="name", size=0.75);
// &n246 @WIRE(mode="straight") {#X222:1 %t1173:p};
// %t1174 = $IO_PORT @ATTACH &n405 => @PLACE(238, -987) => @ORIENT("R0");
// %t1174 @TEXT("n405", key="name", size=0.75);
// &n405 @WIRE(mode="straight") {#X222:2 %t1174:p};
// %t1175 = $IO_PORT @ATTACH &n406 => @PLACE(258, -985) => @ORIENT("MY");
// %t1175 @TEXT("n406", key="name", size=0.75);
// &n406 @WIRE(mode="straight") {#X222:3 %t1175:p};
// %t1176 = $SUPPLY @ATTACH &vdd => @PLACE(248, -974);
// &vdd @WIRE(mode="straight") {#X222:4 %t1176:p};
// %t1177 = $GROUND @ATTACH &vss => @PLACE(248, -996);
// &vss @WIRE(mode="straight") {#X222:5 %t1177:p};
// %t1178 = $IO_PORT @ATTACH &n245 => @PLACE(278, -983) => @ORIENT("R0");
// %t1178 @TEXT("n245", key="name", size=0.75);
// &n245 @WIRE(mode="straight") {#X223:1 %t1178:p};
// %t1179 = $IO_PORT @ATTACH &n407 => @PLACE(278, -987) => @ORIENT("R0");
// %t1179 @TEXT("n407", key="name", size=0.75);
// &n407 @WIRE(mode="straight") {#X223:2 %t1179:p};
// %t1180 = $IO_PORT @ATTACH &n408 => @PLACE(298, -985) => @ORIENT("MY");
// %t1180 @TEXT("n408", key="name", size=0.75);
// &n408 @WIRE(mode="straight") {#X223:3 %t1180:p};
// %t1181 = $SUPPLY @ATTACH &vdd => @PLACE(288, -974);
// &vdd @WIRE(mode="straight") {#X223:4 %t1181:p};
// %t1182 = $GROUND @ATTACH &vss => @PLACE(288, -996);
// &vss @WIRE(mode="straight") {#X223:5 %t1182:p};
// %t1183 = $IO_PORT @ATTACH &n409 => @PLACE(158, -1014) => @ORIENT("R0");
// %t1183 @TEXT("n409", key="name", size=0.75);
// &n409 @WIRE(mode="straight") {#X224:1 %t1183:p};
// %t1184 = $IO_PORT @ATTACH &n410 => @PLACE(158, -1018) => @ORIENT("R0");
// %t1184 @TEXT("n410", key="name", size=0.75);
// &n410 @WIRE(mode="straight") {#X224:2 %t1184:p};
// %t1185 = $IO_PORT @ATTACH &n411 => @PLACE(178, -1016) => @ORIENT("MY");
// %t1185 @TEXT("n411", key="name", size=0.75);
// &n411 @WIRE(mode="straight") {#X224:3 %t1185:p};
// %t1186 = $SUPPLY @ATTACH &vdd => @PLACE(168, -1005);
// &vdd @WIRE(mode="straight") {#X224:4 %t1186:p};
// %t1187 = $GROUND @ATTACH &vss => @PLACE(168, -1027);
// &vss @WIRE(mode="straight") {#X224:5 %t1187:p};
// %t1188 = $IO_PORT @ATTACH &n412 => @PLACE(198, -1014) => @ORIENT("R0");
// %t1188 @TEXT("n412", key="name", size=0.75);
// &n412 @WIRE(mode="straight") {#X225:1 %t1188:p};
// %t1189 = $IO_PORT @ATTACH &n413 => @PLACE(198, -1018) => @ORIENT("R0");
// %t1189 @TEXT("n413", key="name", size=0.75);
// &n413 @WIRE(mode="straight") {#X225:2 %t1189:p};
// %t1190 = $IO_PORT @ATTACH &n414 => @PLACE(218, -1016) => @ORIENT("MY");
// %t1190 @TEXT("n414", key="name", size=0.75);
// &n414 @WIRE(mode="straight") {#X225:3 %t1190:p};
// %t1191 = $SUPPLY @ATTACH &vdd => @PLACE(208, -1005);
// &vdd @WIRE(mode="straight") {#X225:4 %t1191:p};
// %t1192 = $GROUND @ATTACH &vss => @PLACE(208, -1027);
// &vss @WIRE(mode="straight") {#X225:5 %t1192:p};
// %t1193 = $IO_PORT @ATTACH &n415 => @PLACE(238, -1014) => @ORIENT("R0");
// %t1193 @TEXT("n415", key="name", size=0.75);
// &n415 @WIRE(mode="straight") {#X226:1 %t1193:p};
// %t1194 = $IO_PORT @ATTACH &n416 => @PLACE(238, -1018) => @ORIENT("R0");
// %t1194 @TEXT("n416", key="name", size=0.75);
// &n416 @WIRE(mode="straight") {#X226:2 %t1194:p};
// %t1195 = $IO_PORT @ATTACH &n417 => @PLACE(258, -1016) => @ORIENT("MY");
// %t1195 @TEXT("n417", key="name", size=0.75);
// &n417 @WIRE(mode="straight") {#X226:3 %t1195:p};
// %t1196 = $SUPPLY @ATTACH &vdd => @PLACE(248, -1005);
// &vdd @WIRE(mode="straight") {#X226:4 %t1196:p};
// %t1197 = $GROUND @ATTACH &vss => @PLACE(248, -1027);
// &vss @WIRE(mode="straight") {#X226:5 %t1197:p};
// %t1198 = $IO_PORT @ATTACH &n418 => @PLACE(278, -1014) => @ORIENT("R0");
// %t1198 @TEXT("n418", key="name", size=0.75);
// &n418 @WIRE(mode="straight") {#X227:1 %t1198:p};
// %t1199 = $IO_PORT @ATTACH &n419 => @PLACE(278, -1018) => @ORIENT("R0");
// %t1199 @TEXT("n419", key="name", size=0.75);
// &n419 @WIRE(mode="straight") {#X227:2 %t1199:p};
// %t1200 = $IO_PORT @ATTACH &n420 => @PLACE(298, -1016) => @ORIENT("MY");
// %t1200 @TEXT("n420", key="name", size=0.75);
// &n420 @WIRE(mode="straight") {#X227:3 %t1200:p};
// %t1201 = $SUPPLY @ATTACH &vdd => @PLACE(288, -1005);
// &vdd @WIRE(mode="straight") {#X227:4 %t1201:p};
// %t1202 = $GROUND @ATTACH &vss => @PLACE(288, -1027);
// &vss @WIRE(mode="straight") {#X227:5 %t1202:p};
// %t1203 = $IO_PORT @ATTACH &n421 => @PLACE(158, -1045) => @ORIENT("R0");
// %t1203 @TEXT("n421", key="name", size=0.75);
// &n421 @WIRE(mode="straight") {#X228:1 %t1203:p};
// %t1204 = $IO_PORT @ATTACH &n422 => @PLACE(158, -1049) => @ORIENT("R0");
// %t1204 @TEXT("n422", key="name", size=0.75);
// &n422 @WIRE(mode="straight") {#X228:2 %t1204:p};
// %t1205 = $IO_PORT @ATTACH &n423 => @PLACE(178, -1047) => @ORIENT("MY");
// %t1205 @TEXT("n423", key="name", size=0.75);
// &n423 @WIRE(mode="straight") {#X228:3 %t1205:p};
// %t1206 = $SUPPLY @ATTACH &vdd => @PLACE(168, -1036);
// &vdd @WIRE(mode="straight") {#X228:4 %t1206:p};
// %t1207 = $GROUND @ATTACH &vss => @PLACE(168, -1058);
// &vss @WIRE(mode="straight") {#X228:5 %t1207:p};
// %t1208 = $IO_PORT @ATTACH &n424 => @PLACE(198, -1045) => @ORIENT("R0");
// %t1208 @TEXT("n424", key="name", size=0.75);
// &n424 @WIRE(mode="straight") {#X229:1 %t1208:p};
// %t1209 = $IO_PORT @ATTACH &n425 => @PLACE(198, -1049) => @ORIENT("R0");
// %t1209 @TEXT("n425", key="name", size=0.75);
// &n425 @WIRE(mode="straight") {#X229:2 %t1209:p};
// %t1210 = $IO_PORT @ATTACH &n426 => @PLACE(218, -1047) => @ORIENT("MY");
// %t1210 @TEXT("n426", key="name", size=0.75);
// &n426 @WIRE(mode="straight") {#X229:3 %t1210:p};
// %t1211 = $SUPPLY @ATTACH &vdd => @PLACE(208, -1036);
// &vdd @WIRE(mode="straight") {#X229:4 %t1211:p};
// %t1212 = $GROUND @ATTACH &vss => @PLACE(208, -1058);
// &vss @WIRE(mode="straight") {#X229:5 %t1212:p};
// %t1213 = $IO_PORT @ATTACH &n427 => @PLACE(238, -1045) => @ORIENT("R0");
// %t1213 @TEXT("n427", key="name", size=0.75);
// &n427 @WIRE(mode="straight") {#X230:1 %t1213:p};
// %t1214 = $IO_PORT @ATTACH &n428 => @PLACE(238, -1049) => @ORIENT("R0");
// %t1214 @TEXT("n428", key="name", size=0.75);
// &n428 @WIRE(mode="straight") {#X230:2 %t1214:p};
// %t1215 = $IO_PORT @ATTACH &n429 => @PLACE(258, -1047) => @ORIENT("MY");
// %t1215 @TEXT("n429", key="name", size=0.75);
// &n429 @WIRE(mode="straight") {#X230:3 %t1215:p};
// %t1216 = $SUPPLY @ATTACH &vdd => @PLACE(248, -1036);
// &vdd @WIRE(mode="straight") {#X230:4 %t1216:p};
// %t1217 = $GROUND @ATTACH &vss => @PLACE(248, -1058);
// &vss @WIRE(mode="straight") {#X230:5 %t1217:p};
// %t1218 = $IO_PORT @ATTACH &n430 => @PLACE(278, -1045) => @ORIENT("R0");
// %t1218 @TEXT("n430", key="name", size=0.75);
// &n430 @WIRE(mode="straight") {#X231:1 %t1218:p};
// %t1219 = $IO_PORT @ATTACH &n431 => @PLACE(278, -1049) => @ORIENT("R0");
// %t1219 @TEXT("n431", key="name", size=0.75);
// &n431 @WIRE(mode="straight") {#X231:2 %t1219:p};
// %t1220 = $IO_PORT @ATTACH &n432 => @PLACE(298, -1047) => @ORIENT("MY");
// %t1220 @TEXT("n432", key="name", size=0.75);
// &n432 @WIRE(mode="straight") {#X231:3 %t1220:p};
// %t1221 = $SUPPLY @ATTACH &vdd => @PLACE(288, -1036);
// &vdd @WIRE(mode="straight") {#X231:4 %t1221:p};
// %t1222 = $GROUND @ATTACH &vss => @PLACE(288, -1058);
// &vss @WIRE(mode="straight") {#X231:5 %t1222:p};
// %t1223 = $IO_PORT @ATTACH &n433 => @PLACE(158, -1076) => @ORIENT("R0");
// %t1223 @TEXT("n433", key="name", size=0.75);
// &n433 @WIRE(mode="straight") {#X232:1 %t1223:p};
// %t1224 = $IO_PORT @ATTACH &n434 => @PLACE(158, -1080) => @ORIENT("R0");
// %t1224 @TEXT("n434", key="name", size=0.75);
// &n434 @WIRE(mode="straight") {#X232:2 %t1224:p};
// %t1225 = $IO_PORT @ATTACH &n435 => @PLACE(178, -1078) => @ORIENT("MY");
// %t1225 @TEXT("n435", key="name", size=0.75);
// &n435 @WIRE(mode="straight") {#X232:3 %t1225:p};
// %t1226 = $SUPPLY @ATTACH &vdd => @PLACE(168, -1067);
// &vdd @WIRE(mode="straight") {#X232:4 %t1226:p};
// %t1227 = $GROUND @ATTACH &vss => @PLACE(168, -1089);
// &vss @WIRE(mode="straight") {#X232:5 %t1227:p};
// %t1228 = $IO_PORT @ATTACH &n436 => @PLACE(198, -1076) => @ORIENT("R0");
// %t1228 @TEXT("n436", key="name", size=0.75);
// &n436 @WIRE(mode="straight") {#X233:1 %t1228:p};
// %t1229 = $IO_PORT @ATTACH &n437 => @PLACE(198, -1080) => @ORIENT("R0");
// %t1229 @TEXT("n437", key="name", size=0.75);
// &n437 @WIRE(mode="straight") {#X233:2 %t1229:p};
// %t1230 = $IO_PORT @ATTACH &n438 => @PLACE(218, -1078) => @ORIENT("MY");
// %t1230 @TEXT("n438", key="name", size=0.75);
// &n438 @WIRE(mode="straight") {#X233:3 %t1230:p};
// %t1231 = $SUPPLY @ATTACH &vdd => @PLACE(208, -1067);
// &vdd @WIRE(mode="straight") {#X233:4 %t1231:p};
// %t1232 = $GROUND @ATTACH &vss => @PLACE(208, -1089);
// &vss @WIRE(mode="straight") {#X233:5 %t1232:p};
// %t1233 = $IO_PORT @ATTACH &n439 => @PLACE(238, -1076) => @ORIENT("R0");
// %t1233 @TEXT("n439", key="name", size=0.75);
// &n439 @WIRE(mode="straight") {#X234:1 %t1233:p};
// %t1234 = $IO_PORT @ATTACH &n440 => @PLACE(238, -1080) => @ORIENT("R0");
// %t1234 @TEXT("n440", key="name", size=0.75);
// &n440 @WIRE(mode="straight") {#X234:2 %t1234:p};
// %t1235 = $IO_PORT @ATTACH &n441 => @PLACE(258, -1078) => @ORIENT("MY");
// %t1235 @TEXT("n441", key="name", size=0.75);
// &n441 @WIRE(mode="straight") {#X234:3 %t1235:p};
// %t1236 = $SUPPLY @ATTACH &vdd => @PLACE(248, -1067);
// &vdd @WIRE(mode="straight") {#X234:4 %t1236:p};
// %t1237 = $GROUND @ATTACH &vss => @PLACE(248, -1089);
// &vss @WIRE(mode="straight") {#X234:5 %t1237:p};
// %t1238 = $IO_PORT @ATTACH &n442 => @PLACE(278, -1076) => @ORIENT("R0");
// %t1238 @TEXT("n442", key="name", size=0.75);
// &n442 @WIRE(mode="straight") {#X235:1 %t1238:p};
// %t1239 = $IO_PORT @ATTACH &n443 => @PLACE(278, -1080) => @ORIENT("R0");
// %t1239 @TEXT("n443", key="name", size=0.75);
// &n443 @WIRE(mode="straight") {#X235:2 %t1239:p};
// %t1240 = $IO_PORT @ATTACH &n444 => @PLACE(298, -1078) => @ORIENT("MY");
// %t1240 @TEXT("n444", key="name", size=0.75);
// &n444 @WIRE(mode="straight") {#X235:3 %t1240:p};
// %t1241 = $SUPPLY @ATTACH &vdd => @PLACE(288, -1067);
// &vdd @WIRE(mode="straight") {#X235:4 %t1241:p};
// %t1242 = $GROUND @ATTACH &vss => @PLACE(288, -1089);
// &vss @WIRE(mode="straight") {#X235:5 %t1242:p};
// %t1243 = $IO_PORT @ATTACH &n445 => @PLACE(158, -1107) => @ORIENT("R0");
// %t1243 @TEXT("n445", key="name", size=0.75);
// &n445 @WIRE(mode="straight") {#X236:1 %t1243:p};
// %t1244 = $IO_PORT @ATTACH &n446 => @PLACE(158, -1111) => @ORIENT("R0");
// %t1244 @TEXT("n446", key="name", size=0.75);
// &n446 @WIRE(mode="straight") {#X236:2 %t1244:p};
// %t1245 = $IO_PORT @ATTACH &n447 => @PLACE(178, -1109) => @ORIENT("MY");
// %t1245 @TEXT("n447", key="name", size=0.75);
// &n447 @WIRE(mode="straight") {#X236:3 %t1245:p};
// %t1246 = $SUPPLY @ATTACH &vdd => @PLACE(168, -1098);
// &vdd @WIRE(mode="straight") {#X236:4 %t1246:p};
// %t1247 = $GROUND @ATTACH &vss => @PLACE(168, -1120);
// &vss @WIRE(mode="straight") {#X236:5 %t1247:p};
// %t1248 = $IO_PORT @ATTACH &n448 => @PLACE(198, -1107) => @ORIENT("R0");
// %t1248 @TEXT("n448", key="name", size=0.75);
// &n448 @WIRE(mode="straight") {#X237:1 %t1248:p};
// %t1249 = $IO_PORT @ATTACH &n449 => @PLACE(198, -1111) => @ORIENT("R0");
// %t1249 @TEXT("n449", key="name", size=0.75);
// &n449 @WIRE(mode="straight") {#X237:2 %t1249:p};
// %t1250 = $IO_PORT @ATTACH &n450 => @PLACE(218, -1109) => @ORIENT("MY");
// %t1250 @TEXT("n450", key="name", size=0.75);
// &n450 @WIRE(mode="straight") {#X237:3 %t1250:p};
// %t1251 = $SUPPLY @ATTACH &vdd => @PLACE(208, -1098);
// &vdd @WIRE(mode="straight") {#X237:4 %t1251:p};
// %t1252 = $GROUND @ATTACH &vss => @PLACE(208, -1120);
// &vss @WIRE(mode="straight") {#X237:5 %t1252:p};
// %t1253 = $IO_PORT @ATTACH &n451 => @PLACE(238, -1107) => @ORIENT("R0");
// %t1253 @TEXT("n451", key="name", size=0.75);
// &n451 @WIRE(mode="straight") {#X238:1 %t1253:p};
// %t1254 = $IO_PORT @ATTACH &n452 => @PLACE(238, -1111) => @ORIENT("R0");
// %t1254 @TEXT("n452", key="name", size=0.75);
// &n452 @WIRE(mode="straight") {#X238:2 %t1254:p};
// %t1255 = $IO_PORT @ATTACH &n453 => @PLACE(258, -1109) => @ORIENT("MY");
// %t1255 @TEXT("n453", key="name", size=0.75);
// &n453 @WIRE(mode="straight") {#X238:3 %t1255:p};
// %t1256 = $SUPPLY @ATTACH &vdd => @PLACE(248, -1098);
// &vdd @WIRE(mode="straight") {#X238:4 %t1256:p};
// %t1257 = $GROUND @ATTACH &vss => @PLACE(248, -1120);
// &vss @WIRE(mode="straight") {#X238:5 %t1257:p};
// %t1258 = $IO_PORT @ATTACH &n454 => @PLACE(278, -1107) => @ORIENT("R0");
// %t1258 @TEXT("n454", key="name", size=0.75);
// &n454 @WIRE(mode="straight") {#X239:1 %t1258:p};
// %t1259 = $IO_PORT @ATTACH &n455 => @PLACE(278, -1111) => @ORIENT("R0");
// %t1259 @TEXT("n455", key="name", size=0.75);
// &n455 @WIRE(mode="straight") {#X239:2 %t1259:p};
// %t1260 = $IO_PORT @ATTACH &n456 => @PLACE(298, -1109) => @ORIENT("MY");
// %t1260 @TEXT("n456", key="name", size=0.75);
// &n456 @WIRE(mode="straight") {#X239:3 %t1260:p};
// %t1261 = $SUPPLY @ATTACH &vdd => @PLACE(288, -1098);
// &vdd @WIRE(mode="straight") {#X239:4 %t1261:p};
// %t1262 = $GROUND @ATTACH &vss => @PLACE(288, -1120);
// &vss @WIRE(mode="straight") {#X239:5 %t1262:p};
// %t1263 = $IO_PORT @ATTACH &n457 => @PLACE(326, -952) => @ORIENT("R0");
// %t1263 @TEXT("n457", key="name", size=0.75);
// &n457 @WIRE(mode="straight") {#X240:1 %t1263:p};
// %t1264 = $IO_PORT @ATTACH &n458 => @PLACE(326, -956) => @ORIENT("R0");
// %t1264 @TEXT("n458", key="name", size=0.75);
// &n458 @WIRE(mode="straight") {#X240:2 %t1264:p};
// %t1265 = $IO_PORT @ATTACH &n459 => @PLACE(346, -954) => @ORIENT("MY");
// %t1265 @TEXT("n459", key="name", size=0.75);
// &n459 @WIRE(mode="straight") {#X240:3 %t1265:p};
// %t1266 = $SUPPLY @ATTACH &vdd => @PLACE(336, -943);
// &vdd @WIRE(mode="straight") {#X240:4 %t1266:p};
// %t1267 = $GROUND @ATTACH &vss => @PLACE(336, -965);
// &vss @WIRE(mode="straight") {#X240:5 %t1267:p};
// %t1268 = $IO_PORT @ATTACH &target_k5 => @PLACE(366, -952) => @ORIENT("R0");
// %t1268 @TEXT("target_k5", key="name", size=0.75);
// &target_k5 @WIRE(mode="straight") {#X241:1 %t1268:p};
// %t1269 = $IO_PORT @ATTACH &n460 => @PLACE(366, -956) => @ORIENT("R0");
// %t1269 @TEXT("n460", key="name", size=0.75);
// &n460 @WIRE(mode="straight") {#X241:2 %t1269:p};
// %t1270 = $IO_PORT @ATTACH &n461 => @PLACE(386, -954) => @ORIENT("MY");
// %t1270 @TEXT("n461", key="name", size=0.75);
// &n461 @WIRE(mode="straight") {#X241:3 %t1270:p};
// %t1271 = $SUPPLY @ATTACH &vdd => @PLACE(376, -943);
// &vdd @WIRE(mode="straight") {#X241:4 %t1271:p};
// %t1272 = $GROUND @ATTACH &vss => @PLACE(376, -965);
// &vss @WIRE(mode="straight") {#X241:5 %t1272:p};
// %t1273 = $IO_PORT @ATTACH &target_k1 => @PLACE(406, -952) => @ORIENT("R0");
// %t1273 @TEXT("target_k1", key="name", size=0.75);
// &target_k1 @WIRE(mode="straight") {#X242:1 %t1273:p};
// %t1274 = $IO_PORT @ATTACH &target_k0 => @PLACE(406, -956) => @ORIENT("R0");
// %t1274 @TEXT("target_k0", key="name", size=0.75);
// &target_k0 @WIRE(mode="straight") {#X242:2 %t1274:p};
// %t1275 = $IO_PORT @ATTACH &n462 => @PLACE(426, -954) => @ORIENT("MY");
// %t1275 @TEXT("n462", key="name", size=0.75);
// &n462 @WIRE(mode="straight") {#X242:3 %t1275:p};
// %t1276 = $SUPPLY @ATTACH &vdd => @PLACE(416, -943);
// &vdd @WIRE(mode="straight") {#X242:4 %t1276:p};
// %t1277 = $GROUND @ATTACH &vss => @PLACE(416, -965);
// &vss @WIRE(mode="straight") {#X242:5 %t1277:p};
// %t1278 = $IO_PORT @ATTACH &n463 => @PLACE(446, -952) => @ORIENT("R0");
// %t1278 @TEXT("n463", key="name", size=0.75);
// &n463 @WIRE(mode="straight") {#X243:1 %t1278:p};
// %t1279 = $IO_PORT @ATTACH &n464 => @PLACE(446, -956) => @ORIENT("R0");
// %t1279 @TEXT("n464", key="name", size=0.75);
// &n464 @WIRE(mode="straight") {#X243:2 %t1279:p};
// %t1280 = $IO_PORT @ATTACH &n465 => @PLACE(466, -954) => @ORIENT("MY");
// %t1280 @TEXT("n465", key="name", size=0.75);
// &n465 @WIRE(mode="straight") {#X243:3 %t1280:p};
// %t1281 = $SUPPLY @ATTACH &vdd => @PLACE(456, -943);
// &vdd @WIRE(mode="straight") {#X243:4 %t1281:p};
// %t1282 = $GROUND @ATTACH &vss => @PLACE(456, -965);
// &vss @WIRE(mode="straight") {#X243:5 %t1282:p};
// %t1283 = $IO_PORT @ATTACH &n466 => @PLACE(326, -983) => @ORIENT("R0");
// %t1283 @TEXT("n466", key="name", size=0.75);
// &n466 @WIRE(mode="straight") {#X244:1 %t1283:p};
// %t1284 = $IO_PORT @ATTACH &n467 => @PLACE(326, -987) => @ORIENT("R0");
// %t1284 @TEXT("n467", key="name", size=0.75);
// &n467 @WIRE(mode="straight") {#X244:2 %t1284:p};
// %t1285 = $IO_PORT @ATTACH &n468 => @PLACE(346, -985) => @ORIENT("MY");
// %t1285 @TEXT("n468", key="name", size=0.75);
// &n468 @WIRE(mode="straight") {#X244:3 %t1285:p};
// %t1286 = $SUPPLY @ATTACH &vdd => @PLACE(336, -974);
// &vdd @WIRE(mode="straight") {#X244:4 %t1286:p};
// %t1287 = $GROUND @ATTACH &vss => @PLACE(336, -996);
// &vss @WIRE(mode="straight") {#X244:5 %t1287:p};
// %t1288 = $IO_PORT @ATTACH &n469 => @PLACE(366, -983) => @ORIENT("R0");
// %t1288 @TEXT("n469", key="name", size=0.75);
// &n469 @WIRE(mode="straight") {#X245:1 %t1288:p};
// %t1289 = $IO_PORT @ATTACH &n470 => @PLACE(366, -987) => @ORIENT("R0");
// %t1289 @TEXT("n470", key="name", size=0.75);
// &n470 @WIRE(mode="straight") {#X245:2 %t1289:p};
// %t1290 = $IO_PORT @ATTACH &n471 => @PLACE(386, -985) => @ORIENT("MY");
// %t1290 @TEXT("n471", key="name", size=0.75);
// &n471 @WIRE(mode="straight") {#X245:3 %t1290:p};
// %t1291 = $SUPPLY @ATTACH &vdd => @PLACE(376, -974);
// &vdd @WIRE(mode="straight") {#X245:4 %t1291:p};
// %t1292 = $GROUND @ATTACH &vss => @PLACE(376, -996);
// &vss @WIRE(mode="straight") {#X245:5 %t1292:p};
// %t1293 = $IO_PORT @ATTACH &target_k4 => @PLACE(406, -983) => @ORIENT("R0");
// %t1293 @TEXT("target_k4", key="name", size=0.75);
// &target_k4 @WIRE(mode="straight") {#X246:1 %t1293:p};
// %t1294 = $IO_PORT @ATTACH &n472 => @PLACE(406, -987) => @ORIENT("R0");
// %t1294 @TEXT("n472", key="name", size=0.75);
// &n472 @WIRE(mode="straight") {#X246:2 %t1294:p};
// %t1295 = $IO_PORT @ATTACH &n473 => @PLACE(426, -985) => @ORIENT("MY");
// %t1295 @TEXT("n473", key="name", size=0.75);
// &n473 @WIRE(mode="straight") {#X246:3 %t1295:p};
// %t1296 = $SUPPLY @ATTACH &vdd => @PLACE(416, -974);
// &vdd @WIRE(mode="straight") {#X246:4 %t1296:p};
// %t1297 = $GROUND @ATTACH &vss => @PLACE(416, -996);
// &vss @WIRE(mode="straight") {#X246:5 %t1297:p};
// %t1298 = $IO_PORT @ATTACH &target_k5 => @PLACE(446, -983) => @ORIENT("R0");
// %t1298 @TEXT("target_k5", key="name", size=0.75);
// &target_k5 @WIRE(mode="straight") {#X247:1 %t1298:p};
// %t1299 = $IO_PORT @ATTACH &n474 => @PLACE(446, -987) => @ORIENT("R0");
// %t1299 @TEXT("n474", key="name", size=0.75);
// &n474 @WIRE(mode="straight") {#X247:2 %t1299:p};
// %t1300 = $IO_PORT @ATTACH &n475 => @PLACE(466, -985) => @ORIENT("MY");
// %t1300 @TEXT("n475", key="name", size=0.75);
// &n475 @WIRE(mode="straight") {#X247:3 %t1300:p};
// %t1301 = $SUPPLY @ATTACH &vdd => @PLACE(456, -974);
// &vdd @WIRE(mode="straight") {#X247:4 %t1301:p};
// %t1302 = $GROUND @ATTACH &vss => @PLACE(456, -996);
// &vss @WIRE(mode="straight") {#X247:5 %t1302:p};
// %t1303 = $IO_PORT @ATTACH &n454 => @PLACE(326, -1014) => @ORIENT("R0");
// %t1303 @TEXT("n454", key="name", size=0.75);
// &n454 @WIRE(mode="straight") {#X248:1 %t1303:p};
// %t1304 = $IO_PORT @ATTACH &n476 => @PLACE(326, -1018) => @ORIENT("R0");
// %t1304 @TEXT("n476", key="name", size=0.75);
// &n476 @WIRE(mode="straight") {#X248:2 %t1304:p};
// %t1305 = $IO_PORT @ATTACH &n477 => @PLACE(346, -1016) => @ORIENT("MY");
// %t1305 @TEXT("n477", key="name", size=0.75);
// &n477 @WIRE(mode="straight") {#X248:3 %t1305:p};
// %t1306 = $SUPPLY @ATTACH &vdd => @PLACE(336, -1005);
// &vdd @WIRE(mode="straight") {#X248:4 %t1306:p};
// %t1307 = $GROUND @ATTACH &vss => @PLACE(336, -1027);
// &vss @WIRE(mode="straight") {#X248:5 %t1307:p};
// %t1308 = $IO_PORT @ATTACH &n457 => @PLACE(366, -1014) => @ORIENT("R0");
// %t1308 @TEXT("n457", key="name", size=0.75);
// &n457 @WIRE(mode="straight") {#X249:1 %t1308:p};
// %t1309 = $IO_PORT @ATTACH &n478 => @PLACE(366, -1018) => @ORIENT("R0");
// %t1309 @TEXT("n478", key="name", size=0.75);
// &n478 @WIRE(mode="straight") {#X249:2 %t1309:p};
// %t1310 = $IO_PORT @ATTACH &n479 => @PLACE(386, -1016) => @ORIENT("MY");
// %t1310 @TEXT("n479", key="name", size=0.75);
// &n479 @WIRE(mode="straight") {#X249:3 %t1310:p};
// %t1311 = $SUPPLY @ATTACH &vdd => @PLACE(376, -1005);
// &vdd @WIRE(mode="straight") {#X249:4 %t1311:p};
// %t1312 = $GROUND @ATTACH &vss => @PLACE(376, -1027);
// &vss @WIRE(mode="straight") {#X249:5 %t1312:p};
// %t1313 = $IO_PORT @ATTACH &target_k5 => @PLACE(406, -1014) => @ORIENT("R0");
// %t1313 @TEXT("target_k5", key="name", size=0.75);
// &target_k5 @WIRE(mode="straight") {#X250:1 %t1313:p};
// %t1314 = $IO_PORT @ATTACH &n480 => @PLACE(406, -1018) => @ORIENT("R0");
// %t1314 @TEXT("n480", key="name", size=0.75);
// &n480 @WIRE(mode="straight") {#X250:2 %t1314:p};
// %t1315 = $IO_PORT @ATTACH &n481 => @PLACE(426, -1016) => @ORIENT("MY");
// %t1315 @TEXT("n481", key="name", size=0.75);
// &n481 @WIRE(mode="straight") {#X250:3 %t1315:p};
// %t1316 = $SUPPLY @ATTACH &vdd => @PLACE(416, -1005);
// &vdd @WIRE(mode="straight") {#X250:4 %t1316:p};
// %t1317 = $GROUND @ATTACH &vss => @PLACE(416, -1027);
// &vss @WIRE(mode="straight") {#X250:5 %t1317:p};
// %t1318 = $IO_PORT @ATTACH &n482 => @PLACE(446, -1014) => @ORIENT("R0");
// %t1318 @TEXT("n482", key="name", size=0.75);
// &n482 @WIRE(mode="straight") {#X251:1 %t1318:p};
// %t1319 = $IO_PORT @ATTACH &n449 => @PLACE(446, -1018) => @ORIENT("R0");
// %t1319 @TEXT("n449", key="name", size=0.75);
// &n449 @WIRE(mode="straight") {#X251:2 %t1319:p};
// %t1320 = $IO_PORT @ATTACH &n483 => @PLACE(466, -1016) => @ORIENT("MY");
// %t1320 @TEXT("n483", key="name", size=0.75);
// &n483 @WIRE(mode="straight") {#X251:3 %t1320:p};
// %t1321 = $SUPPLY @ATTACH &vdd => @PLACE(456, -1005);
// &vdd @WIRE(mode="straight") {#X251:4 %t1321:p};
// %t1322 = $GROUND @ATTACH &vss => @PLACE(456, -1027);
// &vss @WIRE(mode="straight") {#X251:5 %t1322:p};
// %t1323 = $IO_PORT @ATTACH &n484 => @PLACE(326, -1045) => @ORIENT("R0");
// %t1323 @TEXT("n484", key="name", size=0.75);
// &n484 @WIRE(mode="straight") {#X252:1 %t1323:p};
// %t1324 = $IO_PORT @ATTACH &n485 => @PLACE(326, -1049) => @ORIENT("R0");
// %t1324 @TEXT("n485", key="name", size=0.75);
// &n485 @WIRE(mode="straight") {#X252:2 %t1324:p};
// %t1325 = $IO_PORT @ATTACH &n486 => @PLACE(346, -1047) => @ORIENT("MY");
// %t1325 @TEXT("n486", key="name", size=0.75);
// &n486 @WIRE(mode="straight") {#X252:3 %t1325:p};
// %t1326 = $SUPPLY @ATTACH &vdd => @PLACE(336, -1036);
// &vdd @WIRE(mode="straight") {#X252:4 %t1326:p};
// %t1327 = $GROUND @ATTACH &vss => @PLACE(336, -1058);
// &vss @WIRE(mode="straight") {#X252:5 %t1327:p};
// %t1328 = $IO_PORT @ATTACH &n487 => @PLACE(366, -1045) => @ORIENT("R0");
// %t1328 @TEXT("n487", key="name", size=0.75);
// &n487 @WIRE(mode="straight") {#X253:1 %t1328:p};
// %t1329 = $IO_PORT @ATTACH &n488 => @PLACE(366, -1049) => @ORIENT("R0");
// %t1329 @TEXT("n488", key="name", size=0.75);
// &n488 @WIRE(mode="straight") {#X253:2 %t1329:p};
// %t1330 = $IO_PORT @ATTACH &n489 => @PLACE(386, -1047) => @ORIENT("MY");
// %t1330 @TEXT("n489", key="name", size=0.75);
// &n489 @WIRE(mode="straight") {#X253:3 %t1330:p};
// %t1331 = $SUPPLY @ATTACH &vdd => @PLACE(376, -1036);
// &vdd @WIRE(mode="straight") {#X253:4 %t1331:p};
// %t1332 = $GROUND @ATTACH &vss => @PLACE(376, -1058);
// &vss @WIRE(mode="straight") {#X253:5 %t1332:p};
// %t1333 = $IO_PORT @ATTACH &n490 => @PLACE(406, -1045) => @ORIENT("R0");
// %t1333 @TEXT("n490", key="name", size=0.75);
// &n490 @WIRE(mode="straight") {#X254:1 %t1333:p};
// %t1334 = $IO_PORT @ATTACH &n491 => @PLACE(406, -1049) => @ORIENT("R0");
// %t1334 @TEXT("n491", key="name", size=0.75);
// &n491 @WIRE(mode="straight") {#X254:2 %t1334:p};
// %t1335 = $IO_PORT @ATTACH &n492 => @PLACE(426, -1047) => @ORIENT("MY");
// %t1335 @TEXT("n492", key="name", size=0.75);
// &n492 @WIRE(mode="straight") {#X254:3 %t1335:p};
// %t1336 = $SUPPLY @ATTACH &vdd => @PLACE(416, -1036);
// &vdd @WIRE(mode="straight") {#X254:4 %t1336:p};
// %t1337 = $GROUND @ATTACH &vss => @PLACE(416, -1058);
// &vss @WIRE(mode="straight") {#X254:5 %t1337:p};
// %t1338 = $IO_PORT @ATTACH &n479 => @PLACE(446, -1045) => @ORIENT("R0");
// %t1338 @TEXT("n479", key="name", size=0.75);
// &n479 @WIRE(mode="straight") {#X255:1 %t1338:p};
// %t1339 = $IO_PORT @ATTACH &n493 => @PLACE(446, -1049) => @ORIENT("R0");
// %t1339 @TEXT("n493", key="name", size=0.75);
// &n493 @WIRE(mode="straight") {#X255:2 %t1339:p};
// %t1340 = $IO_PORT @ATTACH &n494 => @PLACE(466, -1047) => @ORIENT("MY");
// %t1340 @TEXT("n494", key="name", size=0.75);
// &n494 @WIRE(mode="straight") {#X255:3 %t1340:p};
// %t1341 = $SUPPLY @ATTACH &vdd => @PLACE(456, -1036);
// &vdd @WIRE(mode="straight") {#X255:4 %t1341:p};
// %t1342 = $GROUND @ATTACH &vss => @PLACE(456, -1058);
// &vss @WIRE(mode="straight") {#X255:5 %t1342:p};
// %t1343 = $IO_PORT @ATTACH &n481 => @PLACE(326, -1076) => @ORIENT("R0");
// %t1343 @TEXT("n481", key="name", size=0.75);
// &n481 @WIRE(mode="straight") {#X256:1 %t1343:p};
// %t1344 = $IO_PORT @ATTACH &n495 => @PLACE(326, -1080) => @ORIENT("R0");
// %t1344 @TEXT("n495", key="name", size=0.75);
// &n495 @WIRE(mode="straight") {#X256:2 %t1344:p};
// %t1345 = $IO_PORT @ATTACH &n496 => @PLACE(346, -1078) => @ORIENT("MY");
// %t1345 @TEXT("n496", key="name", size=0.75);
// &n496 @WIRE(mode="straight") {#X256:3 %t1345:p};
// %t1346 = $SUPPLY @ATTACH &vdd => @PLACE(336, -1067);
// &vdd @WIRE(mode="straight") {#X256:4 %t1346:p};
// %t1347 = $GROUND @ATTACH &vss => @PLACE(336, -1089);
// &vss @WIRE(mode="straight") {#X256:5 %t1347:p};
// %t1348 = $IO_PORT @ATTACH &n497 => @PLACE(366, -1076) => @ORIENT("R0");
// %t1348 @TEXT("n497", key="name", size=0.75);
// &n497 @WIRE(mode="straight") {#X257:1 %t1348:p};
// %t1349 = $IO_PORT @ATTACH &n498 => @PLACE(366, -1080) => @ORIENT("R0");
// %t1349 @TEXT("n498", key="name", size=0.75);
// &n498 @WIRE(mode="straight") {#X257:2 %t1349:p};
// %t1350 = $IO_PORT @ATTACH &n499 => @PLACE(386, -1078) => @ORIENT("MY");
// %t1350 @TEXT("n499", key="name", size=0.75);
// &n499 @WIRE(mode="straight") {#X257:3 %t1350:p};
// %t1351 = $SUPPLY @ATTACH &vdd => @PLACE(376, -1067);
// &vdd @WIRE(mode="straight") {#X257:4 %t1351:p};
// %t1352 = $GROUND @ATTACH &vss => @PLACE(376, -1089);
// &vss @WIRE(mode="straight") {#X257:5 %t1352:p};
// %t1353 = $IO_PORT @ATTACH &n500 => @PLACE(406, -1076) => @ORIENT("R0");
// %t1353 @TEXT("n500", key="name", size=0.75);
// &n500 @WIRE(mode="straight") {#X258:1 %t1353:p};
// %t1354 = $IO_PORT @ATTACH &dac0 => @PLACE(406, -1080) => @ORIENT("R0");
// %t1354 @TEXT("dac0", key="name", size=0.75);
// &dac0 @WIRE(mode="straight") {#X258:2 %t1354:p};
// %t1355 = $IO_PORT @ATTACH &n501 => @PLACE(426, -1078) => @ORIENT("MY");
// %t1355 @TEXT("n501", key="name", size=0.75);
// &n501 @WIRE(mode="straight") {#X258:3 %t1355:p};
// %t1356 = $SUPPLY @ATTACH &vdd => @PLACE(416, -1067);
// &vdd @WIRE(mode="straight") {#X258:4 %t1356:p};
// %t1357 = $GROUND @ATTACH &vss => @PLACE(416, -1089);
// &vss @WIRE(mode="straight") {#X258:5 %t1357:p};
// %t1358 = $IO_PORT @ATTACH &n211 => @PLACE(446, -1076) => @ORIENT("R0");
// %t1358 @TEXT("n211", key="name", size=0.75);
// &n211 @WIRE(mode="straight") {#X259:1 %t1358:p};
// %t1359 = $IO_PORT @ATTACH &n502 => @PLACE(446, -1080) => @ORIENT("R0");
// %t1359 @TEXT("n502", key="name", size=0.75);
// &n502 @WIRE(mode="straight") {#X259:2 %t1359:p};
// %t1360 = $IO_PORT @ATTACH &n503 => @PLACE(466, -1078) => @ORIENT("MY");
// %t1360 @TEXT("n503", key="name", size=0.75);
// &n503 @WIRE(mode="straight") {#X259:3 %t1360:p};
// %t1361 = $SUPPLY @ATTACH &vdd => @PLACE(456, -1067);
// &vdd @WIRE(mode="straight") {#X259:4 %t1361:p};
// %t1362 = $GROUND @ATTACH &vss => @PLACE(456, -1089);
// &vss @WIRE(mode="straight") {#X259:5 %t1362:p};
// %t1363 = $IO_PORT @ATTACH &n504 => @PLACE(326, -1107) => @ORIENT("R0");
// %t1363 @TEXT("n504", key="name", size=0.75);
// &n504 @WIRE(mode="straight") {#X260:1 %t1363:p};
// %t1364 = $IO_PORT @ATTACH &n505 => @PLACE(326, -1111) => @ORIENT("R0");
// %t1364 @TEXT("n505", key="name", size=0.75);
// &n505 @WIRE(mode="straight") {#X260:2 %t1364:p};
// %t1365 = $IO_PORT @ATTACH &n506 => @PLACE(346, -1109) => @ORIENT("MY");
// %t1365 @TEXT("n506", key="name", size=0.75);
// &n506 @WIRE(mode="straight") {#X260:3 %t1365:p};
// %t1366 = $SUPPLY @ATTACH &vdd => @PLACE(336, -1098);
// &vdd @WIRE(mode="straight") {#X260:4 %t1366:p};
// %t1367 = $GROUND @ATTACH &vss => @PLACE(336, -1120);
// &vss @WIRE(mode="straight") {#X260:5 %t1367:p};
// %t1368 = $IO_PORT @ATTACH &n507 => @PLACE(366, -1107) => @ORIENT("R0");
// %t1368 @TEXT("n507", key="name", size=0.75);
// &n507 @WIRE(mode="straight") {#X261:1 %t1368:p};
// %t1369 = $IO_PORT @ATTACH &n508 => @PLACE(366, -1111) => @ORIENT("R0");
// %t1369 @TEXT("n508", key="name", size=0.75);
// &n508 @WIRE(mode="straight") {#X261:2 %t1369:p};
// %t1370 = $IO_PORT @ATTACH &n509 => @PLACE(386, -1109) => @ORIENT("MY");
// %t1370 @TEXT("n509", key="name", size=0.75);
// &n509 @WIRE(mode="straight") {#X261:3 %t1370:p};
// %t1371 = $SUPPLY @ATTACH &vdd => @PLACE(376, -1098);
// &vdd @WIRE(mode="straight") {#X261:4 %t1371:p};
// %t1372 = $GROUND @ATTACH &vss => @PLACE(376, -1120);
// &vss @WIRE(mode="straight") {#X261:5 %t1372:p};
// %t1373 = $IO_PORT @ATTACH &n510 => @PLACE(406, -1107) => @ORIENT("R0");
// %t1373 @TEXT("n510", key="name", size=0.75);
// &n510 @WIRE(mode="straight") {#X262:1 %t1373:p};
// %t1374 = $IO_PORT @ATTACH &n511 => @PLACE(406, -1111) => @ORIENT("R0");
// %t1374 @TEXT("n511", key="name", size=0.75);
// &n511 @WIRE(mode="straight") {#X262:2 %t1374:p};
// %t1375 = $IO_PORT @ATTACH &n512 => @PLACE(426, -1109) => @ORIENT("MY");
// %t1375 @TEXT("n512", key="name", size=0.75);
// &n512 @WIRE(mode="straight") {#X262:3 %t1375:p};
// %t1376 = $SUPPLY @ATTACH &vdd => @PLACE(416, -1098);
// &vdd @WIRE(mode="straight") {#X262:4 %t1376:p};
// %t1377 = $GROUND @ATTACH &vss => @PLACE(416, -1120);
// &vss @WIRE(mode="straight") {#X262:5 %t1377:p};
// %t1378 = $IO_PORT @ATTACH &n325 => @PLACE(446, -1107) => @ORIENT("R0");
// %t1378 @TEXT("n325", key="name", size=0.75);
// &n325 @WIRE(mode="straight") {#X263:1 %t1378:p};
// %t1379 = $IO_PORT @ATTACH &n251 => @PLACE(446, -1111) => @ORIENT("R0");
// %t1379 @TEXT("n251", key="name", size=0.75);
// &n251 @WIRE(mode="straight") {#X263:2 %t1379:p};
// %t1380 = $IO_PORT @ATTACH &n513 => @PLACE(466, -1109) => @ORIENT("MY");
// %t1380 @TEXT("n513", key="name", size=0.75);
// &n513 @WIRE(mode="straight") {#X263:3 %t1380:p};
// %t1381 = $SUPPLY @ATTACH &vdd => @PLACE(456, -1098);
// &vdd @WIRE(mode="straight") {#X263:4 %t1381:p};
// %t1382 = $GROUND @ATTACH &vss => @PLACE(456, -1120);
// &vss @WIRE(mode="straight") {#X263:5 %t1382:p};
// %t1383 = $IO_PORT @ATTACH &n327 => @PLACE(494, -952) => @ORIENT("R0");
// %t1383 @TEXT("n327", key="name", size=0.75);
// &n327 @WIRE(mode="straight") {#X264:1 %t1383:p};
// %t1384 = $IO_PORT @ATTACH &n514 => @PLACE(494, -956) => @ORIENT("R0");
// %t1384 @TEXT("n514", key="name", size=0.75);
// &n514 @WIRE(mode="straight") {#X264:2 %t1384:p};
// %t1385 = $IO_PORT @ATTACH &n515 => @PLACE(514, -954) => @ORIENT("MY");
// %t1385 @TEXT("n515", key="name", size=0.75);
// &n515 @WIRE(mode="straight") {#X264:3 %t1385:p};
// %t1386 = $SUPPLY @ATTACH &vdd => @PLACE(504, -943);
// &vdd @WIRE(mode="straight") {#X264:4 %t1386:p};
// %t1387 = $GROUND @ATTACH &vss => @PLACE(504, -965);
// &vss @WIRE(mode="straight") {#X264:5 %t1387:p};
// %t1388 = $IO_PORT @ATTACH &n329 => @PLACE(534, -952) => @ORIENT("R0");
// %t1388 @TEXT("n329", key="name", size=0.75);
// &n329 @WIRE(mode="straight") {#X265:1 %t1388:p};
// %t1389 = $IO_PORT @ATTACH &n516 => @PLACE(534, -956) => @ORIENT("R0");
// %t1389 @TEXT("n516", key="name", size=0.75);
// &n516 @WIRE(mode="straight") {#X265:2 %t1389:p};
// %t1390 = $IO_PORT @ATTACH &n517 => @PLACE(554, -954) => @ORIENT("MY");
// %t1390 @TEXT("n517", key="name", size=0.75);
// &n517 @WIRE(mode="straight") {#X265:3 %t1390:p};
// %t1391 = $SUPPLY @ATTACH &vdd => @PLACE(544, -943);
// &vdd @WIRE(mode="straight") {#X265:4 %t1391:p};
// %t1392 = $GROUND @ATTACH &vss => @PLACE(544, -965);
// &vss @WIRE(mode="straight") {#X265:5 %t1392:p};
// %t1393 = $IO_PORT @ATTACH &n331 => @PLACE(574, -952) => @ORIENT("R0");
// %t1393 @TEXT("n331", key="name", size=0.75);
// &n331 @WIRE(mode="straight") {#X266:1 %t1393:p};
// %t1394 = $IO_PORT @ATTACH &n518 => @PLACE(574, -956) => @ORIENT("R0");
// %t1394 @TEXT("n518", key="name", size=0.75);
// &n518 @WIRE(mode="straight") {#X266:2 %t1394:p};
// %t1395 = $IO_PORT @ATTACH &n519 => @PLACE(594, -954) => @ORIENT("MY");
// %t1395 @TEXT("n519", key="name", size=0.75);
// &n519 @WIRE(mode="straight") {#X266:3 %t1395:p};
// %t1396 = $SUPPLY @ATTACH &vdd => @PLACE(584, -943);
// &vdd @WIRE(mode="straight") {#X266:4 %t1396:p};
// %t1397 = $GROUND @ATTACH &vss => @PLACE(584, -965);
// &vss @WIRE(mode="straight") {#X266:5 %t1397:p};
// %t1398 = $IO_PORT @ATTACH &n333 => @PLACE(614, -952) => @ORIENT("R0");
// %t1398 @TEXT("n333", key="name", size=0.75);
// &n333 @WIRE(mode="straight") {#X267:1 %t1398:p};
// %t1399 = $IO_PORT @ATTACH &n520 => @PLACE(614, -956) => @ORIENT("R0");
// %t1399 @TEXT("n520", key="name", size=0.75);
// &n520 @WIRE(mode="straight") {#X267:2 %t1399:p};
// %t1400 = $IO_PORT @ATTACH &n521 => @PLACE(635, -954) => @ORIENT("MY");
// %t1400 @TEXT("n521", key="name", size=0.75);
// &n521 @WIRE(mode="straight") {#X267:3 %t1400:p};
// %t1401 = $SUPPLY @ATTACH &vdd => @PLACE(624, -943);
// &vdd @WIRE(mode="straight") {#X267:4 %t1401:p};
// %t1402 = $GROUND @ATTACH &vss => @PLACE(624, -965);
// &vss @WIRE(mode="straight") {#X267:5 %t1402:p};
// %t1403 = $IO_PORT @ATTACH &n522 => @PLACE(494, -983) => @ORIENT("R0");
// %t1403 @TEXT("n522", key="name", size=0.75);
// &n522 @WIRE(mode="straight") {#X268:1 %t1403:p};
// %t1404 = $IO_PORT @ATTACH &n523 => @PLACE(494, -987) => @ORIENT("R0");
// %t1404 @TEXT("n523", key="name", size=0.75);
// &n523 @WIRE(mode="straight") {#X268:2 %t1404:p};
// %t1405 = $IO_PORT @ATTACH &n524 => @PLACE(514, -985) => @ORIENT("MY");
// %t1405 @TEXT("n524", key="name", size=0.75);
// &n524 @WIRE(mode="straight") {#X268:3 %t1405:p};
// %t1406 = $SUPPLY @ATTACH &vdd => @PLACE(504, -974);
// &vdd @WIRE(mode="straight") {#X268:4 %t1406:p};
// %t1407 = $GROUND @ATTACH &vss => @PLACE(504, -996);
// &vss @WIRE(mode="straight") {#X268:5 %t1407:p};
// %t1408 = $IO_PORT @ATTACH &coarse1 => @PLACE(534, -983) => @ORIENT("R0");
// %t1408 @TEXT("coarse1", key="name", size=0.75);
// &coarse1 @WIRE(mode="straight") {#X269:1 %t1408:p};
// %t1409 = $IO_PORT @ATTACH &coarse0 => @PLACE(534, -987) => @ORIENT("R0");
// %t1409 @TEXT("coarse0", key="name", size=0.75);
// &coarse0 @WIRE(mode="straight") {#X269:2 %t1409:p};
// %t1410 = $IO_PORT @ATTACH &n525 => @PLACE(554, -985) => @ORIENT("MY");
// %t1410 @TEXT("n525", key="name", size=0.75);
// &n525 @WIRE(mode="straight") {#X269:3 %t1410:p};
// %t1411 = $SUPPLY @ATTACH &vdd => @PLACE(544, -974);
// &vdd @WIRE(mode="straight") {#X269:4 %t1411:p};
// %t1412 = $GROUND @ATTACH &vss => @PLACE(544, -996);
// &vss @WIRE(mode="straight") {#X269:5 %t1412:p};
// %t1413 = $IO_PORT @ATTACH &coarse2 => @PLACE(574, -983) => @ORIENT("R0");
// %t1413 @TEXT("coarse2", key="name", size=0.75);
// &coarse2 @WIRE(mode="straight") {#X270:1 %t1413:p};
// %t1414 = $IO_PORT @ATTACH &n526 => @PLACE(574, -987) => @ORIENT("R0");
// %t1414 @TEXT("n526", key="name", size=0.75);
// &n526 @WIRE(mode="straight") {#X270:2 %t1414:p};
// %t1415 = $IO_PORT @ATTACH &n527 => @PLACE(594, -985) => @ORIENT("MY");
// %t1415 @TEXT("n527", key="name", size=0.75);
// &n527 @WIRE(mode="straight") {#X270:3 %t1415:p};
// %t1416 = $SUPPLY @ATTACH &vdd => @PLACE(584, -974);
// &vdd @WIRE(mode="straight") {#X270:4 %t1416:p};
// %t1417 = $GROUND @ATTACH &vss => @PLACE(584, -996);
// &vss @WIRE(mode="straight") {#X270:5 %t1417:p};
// %t1418 = $IO_PORT @ATTACH &coarse3 => @PLACE(614, -983) => @ORIENT("R0");
// %t1418 @TEXT("coarse3", key="name", size=0.75);
// &coarse3 @WIRE(mode="straight") {#X271:1 %t1418:p};
// %t1419 = $IO_PORT @ATTACH &n528 => @PLACE(614, -987) => @ORIENT("R0");
// %t1419 @TEXT("n528", key="name", size=0.75);
// &n528 @WIRE(mode="straight") {#X271:2 %t1419:p};
// %t1420 = $IO_PORT @ATTACH &n529 => @PLACE(635, -985) => @ORIENT("MY");
// %t1420 @TEXT("n529", key="name", size=0.75);
// &n529 @WIRE(mode="straight") {#X271:3 %t1420:p};
// %t1421 = $SUPPLY @ATTACH &vdd => @PLACE(624, -974);
// &vdd @WIRE(mode="straight") {#X271:4 %t1421:p};
// %t1422 = $GROUND @ATTACH &vss => @PLACE(624, -996);
// &vss @WIRE(mode="straight") {#X271:5 %t1422:p};
// %t1423 = $IO_PORT @ATTACH &coarse4 => @PLACE(494, -1014) => @ORIENT("R0");
// %t1423 @TEXT("coarse4", key="name", size=0.75);
// &coarse4 @WIRE(mode="straight") {#X272:1 %t1423:p};
// %t1424 = $IO_PORT @ATTACH &n530 => @PLACE(494, -1018) => @ORIENT("R0");
// %t1424 @TEXT("n530", key="name", size=0.75);
// &n530 @WIRE(mode="straight") {#X272:2 %t1424:p};
// %t1425 = $IO_PORT @ATTACH &n531 => @PLACE(514, -1016) => @ORIENT("MY");
// %t1425 @TEXT("n531", key="name", size=0.75);
// &n531 @WIRE(mode="straight") {#X272:3 %t1425:p};
// %t1426 = $SUPPLY @ATTACH &vdd => @PLACE(504, -1005);
// &vdd @WIRE(mode="straight") {#X272:4 %t1426:p};
// %t1427 = $GROUND @ATTACH &vss => @PLACE(504, -1027);
// &vss @WIRE(mode="straight") {#X272:5 %t1427:p};
// %t1428 = $IO_PORT @ATTACH &coarse5 => @PLACE(534, -1014) => @ORIENT("R0");
// %t1428 @TEXT("coarse5", key="name", size=0.75);
// &coarse5 @WIRE(mode="straight") {#X273:1 %t1428:p};
// %t1429 = $IO_PORT @ATTACH &n532 => @PLACE(534, -1018) => @ORIENT("R0");
// %t1429 @TEXT("n532", key="name", size=0.75);
// &n532 @WIRE(mode="straight") {#X273:2 %t1429:p};
// %t1430 = $IO_PORT @ATTACH &n533 => @PLACE(554, -1016) => @ORIENT("MY");
// %t1430 @TEXT("n533", key="name", size=0.75);
// &n533 @WIRE(mode="straight") {#X273:3 %t1430:p};
// %t1431 = $SUPPLY @ATTACH &vdd => @PLACE(544, -1005);
// &vdd @WIRE(mode="straight") {#X273:4 %t1431:p};
// %t1432 = $GROUND @ATTACH &vss => @PLACE(544, -1027);
// &vss @WIRE(mode="straight") {#X273:5 %t1432:p};
// %t1433 = $IO_PORT @ATTACH &coarse6 => @PLACE(574, -1014) => @ORIENT("R0");
// %t1433 @TEXT("coarse6", key="name", size=0.75);
// &coarse6 @WIRE(mode="straight") {#X274:1 %t1433:p};
// %t1434 = $IO_PORT @ATTACH &n534 => @PLACE(574, -1018) => @ORIENT("R0");
// %t1434 @TEXT("n534", key="name", size=0.75);
// &n534 @WIRE(mode="straight") {#X274:2 %t1434:p};
// %t1435 = $IO_PORT @ATTACH &n535 => @PLACE(594, -1016) => @ORIENT("MY");
// %t1435 @TEXT("n535", key="name", size=0.75);
// &n535 @WIRE(mode="straight") {#X274:3 %t1435:p};
// %t1436 = $SUPPLY @ATTACH &vdd => @PLACE(584, -1005);
// &vdd @WIRE(mode="straight") {#X274:4 %t1436:p};
// %t1437 = $GROUND @ATTACH &vss => @PLACE(584, -1027);
// &vss @WIRE(mode="straight") {#X274:5 %t1437:p};
// %t1438 = $IO_PORT @ATTACH &coarse7 => @PLACE(614, -1014) => @ORIENT("R0");
// %t1438 @TEXT("coarse7", key="name", size=0.75);
// &coarse7 @WIRE(mode="straight") {#X275:1 %t1438:p};
// %t1439 = $IO_PORT @ATTACH &n536 => @PLACE(614, -1018) => @ORIENT("R0");
// %t1439 @TEXT("n536", key="name", size=0.75);
// &n536 @WIRE(mode="straight") {#X275:2 %t1439:p};
// %t1440 = $IO_PORT @ATTACH &n537 => @PLACE(635, -1016) => @ORIENT("MY");
// %t1440 @TEXT("n537", key="name", size=0.75);
// &n537 @WIRE(mode="straight") {#X275:3 %t1440:p};
// %t1441 = $SUPPLY @ATTACH &vdd => @PLACE(624, -1005);
// &vdd @WIRE(mode="straight") {#X275:4 %t1441:p};
// %t1442 = $GROUND @ATTACH &vss => @PLACE(624, -1027);
// &vss @WIRE(mode="straight") {#X275:5 %t1442:p};
// %t1443 = $IO_PORT @ATTACH &n538 => @PLACE(494, -1045) => @ORIENT("R0");
// %t1443 @TEXT("n538", key="name", size=0.75);
// &n538 @WIRE(mode="straight") {#X276:1 %t1443:p};
// %t1444 = $IO_PORT @ATTACH &coarse0 => @PLACE(494, -1049) => @ORIENT("R0");
// %t1444 @TEXT("coarse0", key="name", size=0.75);
// &coarse0 @WIRE(mode="straight") {#X276:2 %t1444:p};
// %t1445 = $IO_PORT @ATTACH &n539 => @PLACE(514, -1047) => @ORIENT("MY");
// %t1445 @TEXT("n539", key="name", size=0.75);
// &n539 @WIRE(mode="straight") {#X276:3 %t1445:p};
// %t1446 = $SUPPLY @ATTACH &vdd => @PLACE(504, -1036);
// &vdd @WIRE(mode="straight") {#X276:4 %t1446:p};
// %t1447 = $GROUND @ATTACH &vss => @PLACE(504, -1058);
// &vss @WIRE(mode="straight") {#X276:5 %t1447:p};
// %t1448 = $IO_PORT @ATTACH &n540 => @PLACE(534, -1045) => @ORIENT("R0");
// %t1448 @TEXT("n540", key="name", size=0.75);
// &n540 @WIRE(mode="straight") {#X277:1 %t1448:p};
// %t1449 = $IO_PORT @ATTACH &n541 => @PLACE(534, -1049) => @ORIENT("R0");
// %t1449 @TEXT("n541", key="name", size=0.75);
// &n541 @WIRE(mode="straight") {#X277:2 %t1449:p};
// %t1450 = $IO_PORT @ATTACH &n542 => @PLACE(554, -1047) => @ORIENT("MY");
// %t1450 @TEXT("n542", key="name", size=0.75);
// &n542 @WIRE(mode="straight") {#X277:3 %t1450:p};
// %t1451 = $SUPPLY @ATTACH &vdd => @PLACE(544, -1036);
// &vdd @WIRE(mode="straight") {#X277:4 %t1451:p};
// %t1452 = $GROUND @ATTACH &vss => @PLACE(544, -1058);
// &vss @WIRE(mode="straight") {#X277:5 %t1452:p};
// %t1453 = $IO_PORT @ATTACH &n543 => @PLACE(574, -1045) => @ORIENT("R0");
// %t1453 @TEXT("n543", key="name", size=0.75);
// &n543 @WIRE(mode="straight") {#X278:1 %t1453:p};
// %t1454 = $IO_PORT @ATTACH &n544 => @PLACE(574, -1049) => @ORIENT("R0");
// %t1454 @TEXT("n544", key="name", size=0.75);
// &n544 @WIRE(mode="straight") {#X278:2 %t1454:p};
// %t1455 = $IO_PORT @ATTACH &n545 => @PLACE(594, -1047) => @ORIENT("MY");
// %t1455 @TEXT("n545", key="name", size=0.75);
// &n545 @WIRE(mode="straight") {#X278:3 %t1455:p};
// %t1456 = $SUPPLY @ATTACH &vdd => @PLACE(584, -1036);
// &vdd @WIRE(mode="straight") {#X278:4 %t1456:p};
// %t1457 = $GROUND @ATTACH &vss => @PLACE(584, -1058);
// &vss @WIRE(mode="straight") {#X278:5 %t1457:p};
// %t1458 = $IO_PORT @ATTACH &n546 => @PLACE(614, -1045) => @ORIENT("R0");
// %t1458 @TEXT("n546", key="name", size=0.75);
// &n546 @WIRE(mode="straight") {#X279:1 %t1458:p};
// %t1459 = $IO_PORT @ATTACH &n547 => @PLACE(614, -1049) => @ORIENT("R0");
// %t1459 @TEXT("n547", key="name", size=0.75);
// &n547 @WIRE(mode="straight") {#X279:2 %t1459:p};
// %t1460 = $IO_PORT @ATTACH &n548 => @PLACE(635, -1047) => @ORIENT("MY");
// %t1460 @TEXT("n548", key="name", size=0.75);
// &n548 @WIRE(mode="straight") {#X279:3 %t1460:p};
// %t1461 = $SUPPLY @ATTACH &vdd => @PLACE(624, -1036);
// &vdd @WIRE(mode="straight") {#X279:4 %t1461:p};
// %t1462 = $GROUND @ATTACH &vss => @PLACE(624, -1058);
// &vss @WIRE(mode="straight") {#X279:5 %t1462:p};
// %t1463 = $IO_PORT @ATTACH &n549 => @PLACE(494, -1076) => @ORIENT("R0");
// %t1463 @TEXT("n549", key="name", size=0.75);
// &n549 @WIRE(mode="straight") {#X280:1 %t1463:p};
// %t1464 = $IO_PORT @ATTACH &n550 => @PLACE(494, -1080) => @ORIENT("R0");
// %t1464 @TEXT("n550", key="name", size=0.75);
// &n550 @WIRE(mode="straight") {#X280:2 %t1464:p};
// %t1465 = $IO_PORT @ATTACH &n551 => @PLACE(514, -1078) => @ORIENT("MY");
// %t1465 @TEXT("n551", key="name", size=0.75);
// &n551 @WIRE(mode="straight") {#X280:3 %t1465:p};
// %t1466 = $SUPPLY @ATTACH &vdd => @PLACE(504, -1067);
// &vdd @WIRE(mode="straight") {#X280:4 %t1466:p};
// %t1467 = $GROUND @ATTACH &vss => @PLACE(504, -1089);
// &vss @WIRE(mode="straight") {#X280:5 %t1467:p};
// %t1468 = $IO_PORT @ATTACH &n552 => @PLACE(534, -1076) => @ORIENT("R0");
// %t1468 @TEXT("n552", key="name", size=0.75);
// &n552 @WIRE(mode="straight") {#X281:1 %t1468:p};
// %t1469 = $IO_PORT @ATTACH &n553 => @PLACE(534, -1080) => @ORIENT("R0");
// %t1469 @TEXT("n553", key="name", size=0.75);
// &n553 @WIRE(mode="straight") {#X281:2 %t1469:p};
// %t1470 = $IO_PORT @ATTACH &n554 => @PLACE(554, -1078) => @ORIENT("MY");
// %t1470 @TEXT("n554", key="name", size=0.75);
// &n554 @WIRE(mode="straight") {#X281:3 %t1470:p};
// %t1471 = $SUPPLY @ATTACH &vdd => @PLACE(544, -1067);
// &vdd @WIRE(mode="straight") {#X281:4 %t1471:p};
// %t1472 = $GROUND @ATTACH &vss => @PLACE(544, -1089);
// &vss @WIRE(mode="straight") {#X281:5 %t1472:p};
// %t1473 = $IO_PORT @ATTACH &n295 => @PLACE(574, -1076) => @ORIENT("R0");
// %t1473 @TEXT("n295", key="name", size=0.75);
// &n295 @WIRE(mode="straight") {#X282:1 %t1473:p};
// %t1474 = $IO_PORT @ATTACH &n555 => @PLACE(574, -1080) => @ORIENT("R0");
// %t1474 @TEXT("n555", key="name", size=0.75);
// &n555 @WIRE(mode="straight") {#X282:2 %t1474:p};
// %t1475 = $IO_PORT @ATTACH &n556 => @PLACE(594, -1078) => @ORIENT("MY");
// %t1475 @TEXT("n556", key="name", size=0.75);
// &n556 @WIRE(mode="straight") {#X282:3 %t1475:p};
// %t1476 = $SUPPLY @ATTACH &vdd => @PLACE(584, -1067);
// &vdd @WIRE(mode="straight") {#X282:4 %t1476:p};
// %t1477 = $GROUND @ATTACH &vss => @PLACE(584, -1089);
// &vss @WIRE(mode="straight") {#X282:5 %t1477:p};
// %t1478 = $IO_PORT @ATTACH &n95 => @PLACE(614, -1076) => @ORIENT("R0");
// %t1478 @TEXT("n95", key="name", size=0.75);
// &n95 @WIRE(mode="straight") {#X283:1 %t1478:p};
// %t1479 = $IO_PORT @ATTACH &n93 => @PLACE(614, -1080) => @ORIENT("R0");
// %t1479 @TEXT("n93", key="name", size=0.75);
// &n93 @WIRE(mode="straight") {#X283:2 %t1479:p};
// %t1480 = $IO_PORT @ATTACH &n557 => @PLACE(635, -1078) => @ORIENT("MY");
// %t1480 @TEXT("n557", key="name", size=0.75);
// &n557 @WIRE(mode="straight") {#X283:3 %t1480:p};
// %t1481 = $SUPPLY @ATTACH &vdd => @PLACE(624, -1067);
// &vdd @WIRE(mode="straight") {#X283:4 %t1481:p};
// %t1482 = $GROUND @ATTACH &vss => @PLACE(624, -1089);
// &vss @WIRE(mode="straight") {#X283:5 %t1482:p};
// %t1483 = $IO_PORT @ATTACH &n97 => @PLACE(494, -1107) => @ORIENT("R0");
// %t1483 @TEXT("n97", key="name", size=0.75);
// &n97 @WIRE(mode="straight") {#X284:1 %t1483:p};
// %t1484 = $IO_PORT @ATTACH &n558 => @PLACE(494, -1111) => @ORIENT("R0");
// %t1484 @TEXT("n558", key="name", size=0.75);
// &n558 @WIRE(mode="straight") {#X284:2 %t1484:p};
// %t1485 = $IO_PORT @ATTACH &n559 => @PLACE(514, -1109) => @ORIENT("MY");
// %t1485 @TEXT("n559", key="name", size=0.75);
// &n559 @WIRE(mode="straight") {#X284:3 %t1485:p};
// %t1486 = $SUPPLY @ATTACH &vdd => @PLACE(504, -1098);
// &vdd @WIRE(mode="straight") {#X284:4 %t1486:p};
// %t1487 = $GROUND @ATTACH &vss => @PLACE(504, -1120);
// &vss @WIRE(mode="straight") {#X284:5 %t1487:p};
// %t1488 = $IO_PORT @ATTACH &n560 => @PLACE(534, -1107) => @ORIENT("R0");
// %t1488 @TEXT("n560", key="name", size=0.75);
// &n560 @WIRE(mode="straight") {#X285:1 %t1488:p};
// %t1489 = $IO_PORT @ATTACH &n561 => @PLACE(534, -1111) => @ORIENT("R0");
// %t1489 @TEXT("n561", key="name", size=0.75);
// &n561 @WIRE(mode="straight") {#X285:2 %t1489:p};
// %t1490 = $IO_PORT @ATTACH &n562 => @PLACE(554, -1109) => @ORIENT("MY");
// %t1490 @TEXT("n562", key="name", size=0.75);
// &n562 @WIRE(mode="straight") {#X285:3 %t1490:p};
// %t1491 = $SUPPLY @ATTACH &vdd => @PLACE(544, -1098);
// &vdd @WIRE(mode="straight") {#X285:4 %t1491:p};
// %t1492 = $GROUND @ATTACH &vss => @PLACE(544, -1120);
// &vss @WIRE(mode="straight") {#X285:5 %t1492:p};
// %t1493 = $IO_PORT @ATTACH &n563 => @PLACE(574, -1107) => @ORIENT("R0");
// %t1493 @TEXT("n563", key="name", size=0.75);
// &n563 @WIRE(mode="straight") {#X286:1 %t1493:p};
// %t1494 = $IO_PORT @ATTACH &n564 => @PLACE(574, -1111) => @ORIENT("R0");
// %t1494 @TEXT("n564", key="name", size=0.75);
// &n564 @WIRE(mode="straight") {#X286:2 %t1494:p};
// %t1495 = $IO_PORT @ATTACH &n565 => @PLACE(594, -1109) => @ORIENT("MY");
// %t1495 @TEXT("n565", key="name", size=0.75);
// &n565 @WIRE(mode="straight") {#X286:3 %t1495:p};
// %t1496 = $SUPPLY @ATTACH &vdd => @PLACE(584, -1098);
// &vdd @WIRE(mode="straight") {#X286:4 %t1496:p};
// %t1497 = $GROUND @ATTACH &vss => @PLACE(584, -1120);
// &vss @WIRE(mode="straight") {#X286:5 %t1497:p};
// %t1498 = $IO_PORT @ATTACH &n566 => @PLACE(614, -1107) => @ORIENT("R0");
// %t1498 @TEXT("n566", key="name", size=0.75);
// &n566 @WIRE(mode="straight") {#X287:1 %t1498:p};
// %t1499 = $IO_PORT @ATTACH &n567 => @PLACE(614, -1111) => @ORIENT("R0");
// %t1499 @TEXT("n567", key="name", size=0.75);
// &n567 @WIRE(mode="straight") {#X287:2 %t1499:p};
// %t1500 = $IO_PORT @ATTACH &n568 => @PLACE(635, -1109) => @ORIENT("MY");
// %t1500 @TEXT("n568", key="name", size=0.75);
// &n568 @WIRE(mode="straight") {#X287:3 %t1500:p};
// %t1501 = $SUPPLY @ATTACH &vdd => @PLACE(624, -1098);
// &vdd @WIRE(mode="straight") {#X287:4 %t1501:p};
// %t1502 = $GROUND @ATTACH &vss => @PLACE(624, -1120);
// &vss @WIRE(mode="straight") {#X287:5 %t1502:p};
// %t1503 = $IO_PORT @ATTACH &n569 => @PLACE(-11, -1150) => @ORIENT("R0");
// %t1503 @TEXT("n569", key="name", size=0.75);
// &n569 @WIRE(mode="straight") {#X288:1 %t1503:p};
// %t1504 = $IO_PORT @ATTACH &n570 => @PLACE(-11, -1154) => @ORIENT("R0");
// %t1504 @TEXT("n570", key="name", size=0.75);
// &n570 @WIRE(mode="straight") {#X288:2 %t1504:p};
// %t1505 = $IO_PORT @ATTACH &n571 => @PLACE(10, -1152) => @ORIENT("MY");
// %t1505 @TEXT("n571", key="name", size=0.75);
// &n571 @WIRE(mode="straight") {#X288:3 %t1505:p};
// %t1506 = $SUPPLY @ATTACH &vdd => @PLACE(0, -1141);
// &vdd @WIRE(mode="straight") {#X288:4 %t1506:p};
// %t1507 = $GROUND @ATTACH &vss => @PLACE(0, -1163);
// &vss @WIRE(mode="straight") {#X288:5 %t1507:p};
// %t1508 = $IO_PORT @ATTACH &n572 => @PLACE(30, -1150) => @ORIENT("R0");
// %t1508 @TEXT("n572", key="name", size=0.75);
// &n572 @WIRE(mode="straight") {#X289:1 %t1508:p};
// %t1509 = $IO_PORT @ATTACH &n573 => @PLACE(30, -1154) => @ORIENT("R0");
// %t1509 @TEXT("n573", key="name", size=0.75);
// &n573 @WIRE(mode="straight") {#X289:2 %t1509:p};
// %t1510 = $IO_PORT @ATTACH &n574 => @PLACE(50, -1152) => @ORIENT("MY");
// %t1510 @TEXT("n574", key="name", size=0.75);
// &n574 @WIRE(mode="straight") {#X289:3 %t1510:p};
// %t1511 = $SUPPLY @ATTACH &vdd => @PLACE(40, -1141);
// &vdd @WIRE(mode="straight") {#X289:4 %t1511:p};
// %t1512 = $GROUND @ATTACH &vss => @PLACE(40, -1163);
// &vss @WIRE(mode="straight") {#X289:5 %t1512:p};
// %t1513 = $IO_PORT @ATTACH &n575 => @PLACE(70, -1150) => @ORIENT("R0");
// %t1513 @TEXT("n575", key="name", size=0.75);
// &n575 @WIRE(mode="straight") {#X290:1 %t1513:p};
// %t1514 = $IO_PORT @ATTACH &n576 => @PLACE(70, -1154) => @ORIENT("R0");
// %t1514 @TEXT("n576", key="name", size=0.75);
// &n576 @WIRE(mode="straight") {#X290:2 %t1514:p};
// %t1515 = $IO_PORT @ATTACH &n577 => @PLACE(90, -1152) => @ORIENT("MY");
// %t1515 @TEXT("n577", key="name", size=0.75);
// &n577 @WIRE(mode="straight") {#X290:3 %t1515:p};
// %t1516 = $SUPPLY @ATTACH &vdd => @PLACE(80, -1141);
// &vdd @WIRE(mode="straight") {#X290:4 %t1516:p};
// %t1517 = $GROUND @ATTACH &vss => @PLACE(80, -1163);
// &vss @WIRE(mode="straight") {#X290:5 %t1517:p};
// %t1518 = $IO_PORT @ATTACH &n578 => @PLACE(110, -1150) => @ORIENT("R0");
// %t1518 @TEXT("n578", key="name", size=0.75);
// &n578 @WIRE(mode="straight") {#X291:1 %t1518:p};
// %t1519 = $IO_PORT @ATTACH &n579 => @PLACE(110, -1154) => @ORIENT("R0");
// %t1519 @TEXT("n579", key="name", size=0.75);
// &n579 @WIRE(mode="straight") {#X291:2 %t1519:p};
// %t1520 = $IO_PORT @ATTACH &n580 => @PLACE(130, -1152) => @ORIENT("MY");
// %t1520 @TEXT("n580", key="name", size=0.75);
// &n580 @WIRE(mode="straight") {#X291:3 %t1520:p};
// %t1521 = $SUPPLY @ATTACH &vdd => @PLACE(120, -1141);
// &vdd @WIRE(mode="straight") {#X291:4 %t1521:p};
// %t1522 = $GROUND @ATTACH &vss => @PLACE(120, -1163);
// &vss @WIRE(mode="straight") {#X291:5 %t1522:p};
// %t1523 = $IO_PORT @ATTACH &dac3 => @PLACE(-11, -1181) => @ORIENT("R0");
// %t1523 @TEXT("dac3", key="name", size=0.75);
// &dac3 @WIRE(mode="straight") {#X292:1 %t1523:p};
// %t1524 = $IO_PORT @ATTACH &n581 => @PLACE(-11, -1185) => @ORIENT("R0");
// %t1524 @TEXT("n581", key="name", size=0.75);
// &n581 @WIRE(mode="straight") {#X292:2 %t1524:p};
// %t1525 = $IO_PORT @ATTACH &n582 => @PLACE(10, -1183) => @ORIENT("MY");
// %t1525 @TEXT("n582", key="name", size=0.75);
// &n582 @WIRE(mode="straight") {#X292:3 %t1525:p};
// %t1526 = $SUPPLY @ATTACH &vdd => @PLACE(0, -1172);
// &vdd @WIRE(mode="straight") {#X292:4 %t1526:p};
// %t1527 = $GROUND @ATTACH &vss => @PLACE(0, -1194);
// &vss @WIRE(mode="straight") {#X292:5 %t1527:p};
// %t1528 = $IO_PORT @ATTACH &n101 => @PLACE(30, -1181) => @ORIENT("R0");
// %t1528 @TEXT("n101", key="name", size=0.75);
// &n101 @WIRE(mode="straight") {#X293:1 %t1528:p};
// %t1529 = $IO_PORT @ATTACH &n99 => @PLACE(30, -1185) => @ORIENT("R0");
// %t1529 @TEXT("n99", key="name", size=0.75);
// &n99 @WIRE(mode="straight") {#X293:2 %t1529:p};
// %t1530 = $IO_PORT @ATTACH &n583 => @PLACE(50, -1183) => @ORIENT("MY");
// %t1530 @TEXT("n583", key="name", size=0.75);
// &n583 @WIRE(mode="straight") {#X293:3 %t1530:p};
// %t1531 = $SUPPLY @ATTACH &vdd => @PLACE(40, -1172);
// &vdd @WIRE(mode="straight") {#X293:4 %t1531:p};
// %t1532 = $GROUND @ATTACH &vss => @PLACE(40, -1194);
// &vss @WIRE(mode="straight") {#X293:5 %t1532:p};
// %t1533 = $IO_PORT @ATTACH &n103 => @PLACE(70, -1181) => @ORIENT("R0");
// %t1533 @TEXT("n103", key="name", size=0.75);
// &n103 @WIRE(mode="straight") {#X294:1 %t1533:p};
// %t1534 = $IO_PORT @ATTACH &n584 => @PLACE(70, -1185) => @ORIENT("R0");
// %t1534 @TEXT("n584", key="name", size=0.75);
// &n584 @WIRE(mode="straight") {#X294:2 %t1534:p};
// %t1535 = $IO_PORT @ATTACH &n585 => @PLACE(90, -1183) => @ORIENT("MY");
// %t1535 @TEXT("n585", key="name", size=0.75);
// &n585 @WIRE(mode="straight") {#X294:3 %t1535:p};
// %t1536 = $SUPPLY @ATTACH &vdd => @PLACE(80, -1172);
// &vdd @WIRE(mode="straight") {#X294:4 %t1536:p};
// %t1537 = $GROUND @ATTACH &vss => @PLACE(80, -1194);
// &vss @WIRE(mode="straight") {#X294:5 %t1537:p};
// %t1538 = $IO_PORT @ATTACH &n105 => @PLACE(110, -1181) => @ORIENT("R0");
// %t1538 @TEXT("n105", key="name", size=0.75);
// &n105 @WIRE(mode="straight") {#X295:1 %t1538:p};
// %t1539 = $IO_PORT @ATTACH &n586 => @PLACE(110, -1185) => @ORIENT("R0");
// %t1539 @TEXT("n586", key="name", size=0.75);
// &n586 @WIRE(mode="straight") {#X295:2 %t1539:p};
// %t1540 = $IO_PORT @ATTACH &n587 => @PLACE(130, -1183) => @ORIENT("MY");
// %t1540 @TEXT("n587", key="name", size=0.75);
// &n587 @WIRE(mode="straight") {#X295:3 %t1540:p};
// %t1541 = $SUPPLY @ATTACH &vdd => @PLACE(120, -1172);
// &vdd @WIRE(mode="straight") {#X295:4 %t1541:p};
// %t1542 = $GROUND @ATTACH &vss => @PLACE(120, -1194);
// &vss @WIRE(mode="straight") {#X295:5 %t1542:p};
// %t1543 = $IO_PORT @ATTACH &n107 => @PLACE(-11, -1212) => @ORIENT("R0");
// %t1543 @TEXT("n107", key="name", size=0.75);
// &n107 @WIRE(mode="straight") {#X296:1 %t1543:p};
// %t1544 = $IO_PORT @ATTACH &n588 => @PLACE(-11, -1216) => @ORIENT("R0");
// %t1544 @TEXT("n588", key="name", size=0.75);
// &n588 @WIRE(mode="straight") {#X296:2 %t1544:p};
// %t1545 = $IO_PORT @ATTACH &n589 => @PLACE(10, -1214) => @ORIENT("MY");
// %t1545 @TEXT("n589", key="name", size=0.75);
// &n589 @WIRE(mode="straight") {#X296:3 %t1545:p};
// %t1546 = $SUPPLY @ATTACH &vdd => @PLACE(0, -1203);
// &vdd @WIRE(mode="straight") {#X296:4 %t1546:p};
// %t1547 = $GROUND @ATTACH &vss => @PLACE(0, -1225);
// &vss @WIRE(mode="straight") {#X296:5 %t1547:p};
// %t1548 = $IO_PORT @ATTACH &n109 => @PLACE(30, -1212) => @ORIENT("R0");
// %t1548 @TEXT("n109", key="name", size=0.75);
// &n109 @WIRE(mode="straight") {#X297:1 %t1548:p};
// %t1549 = $IO_PORT @ATTACH &n590 => @PLACE(30, -1216) => @ORIENT("R0");
// %t1549 @TEXT("n590", key="name", size=0.75);
// &n590 @WIRE(mode="straight") {#X297:2 %t1549:p};
// %t1550 = $IO_PORT @ATTACH &n591 => @PLACE(50, -1214) => @ORIENT("MY");
// %t1550 @TEXT("n591", key="name", size=0.75);
// &n591 @WIRE(mode="straight") {#X297:3 %t1550:p};
// %t1551 = $SUPPLY @ATTACH &vdd => @PLACE(40, -1203);
// &vdd @WIRE(mode="straight") {#X297:4 %t1551:p};
// %t1552 = $GROUND @ATTACH &vss => @PLACE(40, -1225);
// &vss @WIRE(mode="straight") {#X297:5 %t1552:p};
// %t1553 = $IO_PORT @ATTACH &n111 => @PLACE(70, -1212) => @ORIENT("R0");
// %t1553 @TEXT("n111", key="name", size=0.75);
// &n111 @WIRE(mode="straight") {#X298:1 %t1553:p};
// %t1554 = $IO_PORT @ATTACH &n592 => @PLACE(70, -1216) => @ORIENT("R0");
// %t1554 @TEXT("n592", key="name", size=0.75);
// &n592 @WIRE(mode="straight") {#X298:2 %t1554:p};
// %t1555 = $IO_PORT @ATTACH &n593 => @PLACE(90, -1214) => @ORIENT("MY");
// %t1555 @TEXT("n593", key="name", size=0.75);
// &n593 @WIRE(mode="straight") {#X298:3 %t1555:p};
// %t1556 = $SUPPLY @ATTACH &vdd => @PLACE(80, -1203);
// &vdd @WIRE(mode="straight") {#X298:4 %t1556:p};
// %t1557 = $GROUND @ATTACH &vss => @PLACE(80, -1225);
// &vss @WIRE(mode="straight") {#X298:5 %t1557:p};
// %t1558 = $IO_PORT @ATTACH &n113 => @PLACE(110, -1212) => @ORIENT("R0");
// %t1558 @TEXT("n113", key="name", size=0.75);
// &n113 @WIRE(mode="straight") {#X299:1 %t1558:p};
// %t1559 = $IO_PORT @ATTACH &n594 => @PLACE(110, -1216) => @ORIENT("R0");
// %t1559 @TEXT("n594", key="name", size=0.75);
// &n594 @WIRE(mode="straight") {#X299:2 %t1559:p};
// %t1560 = $IO_PORT @ATTACH &n595 => @PLACE(130, -1214) => @ORIENT("MY");
// %t1560 @TEXT("n595", key="name", size=0.75);
// &n595 @WIRE(mode="straight") {#X299:3 %t1560:p};
// %t1561 = $SUPPLY @ATTACH &vdd => @PLACE(120, -1203);
// &vdd @WIRE(mode="straight") {#X299:4 %t1561:p};
// %t1562 = $GROUND @ATTACH &vss => @PLACE(120, -1225);
// &vss @WIRE(mode="straight") {#X299:5 %t1562:p};
// %t1563 = $IO_PORT @ATTACH &n596 => @PLACE(-11, -1243) => @ORIENT("R0");
// %t1563 @TEXT("n596", key="name", size=0.75);
// &n596 @WIRE(mode="straight") {#X300:1 %t1563:p};
// %t1564 = $IO_PORT @ATTACH &n356 => @PLACE(-11, -1247) => @ORIENT("R0");
// %t1564 @TEXT("n356", key="name", size=0.75);
// &n356 @WIRE(mode="straight") {#X300:2 %t1564:p};
// %t1565 = $IO_PORT @ATTACH &n358 => @PLACE(10, -1245) => @ORIENT("MY");
// %t1565 @TEXT("n358", key="name", size=0.75);
// &n358 @WIRE(mode="straight") {#X300:3 %t1565:p};
// %t1566 = $SUPPLY @ATTACH &vdd => @PLACE(0, -1234);
// &vdd @WIRE(mode="straight") {#X300:4 %t1566:p};
// %t1567 = $GROUND @ATTACH &vss => @PLACE(0, -1256);
// &vss @WIRE(mode="straight") {#X300:5 %t1567:p};
// %t1568 = $IO_PORT @ATTACH &dac4 => @PLACE(30, -1243) => @ORIENT("R0");
// %t1568 @TEXT("dac4", key="name", size=0.75);
// &dac4 @WIRE(mode="straight") {#X301:1 %t1568:p};
// %t1569 = $IO_PORT @ATTACH &n358 => @PLACE(30, -1247) => @ORIENT("R0");
// %t1569 @TEXT("n358", key="name", size=0.75);
// &n358 @WIRE(mode="straight") {#X301:2 %t1569:p};
// %t1570 = $IO_PORT @ATTACH &n360 => @PLACE(50, -1245) => @ORIENT("MY");
// %t1570 @TEXT("n360", key="name", size=0.75);
// &n360 @WIRE(mode="straight") {#X301:3 %t1570:p};
// %t1571 = $SUPPLY @ATTACH &vdd => @PLACE(40, -1234);
// &vdd @WIRE(mode="straight") {#X301:4 %t1571:p};
// %t1572 = $GROUND @ATTACH &vss => @PLACE(40, -1256);
// &vss @WIRE(mode="straight") {#X301:5 %t1572:p};
// %t1573 = $IO_PORT @ATTACH &n267 => @PLACE(70, -1243) => @ORIENT("R0");
// %t1573 @TEXT("n267", key="name", size=0.75);
// &n267 @WIRE(mode="straight") {#X302:1 %t1573:p};
// %t1574 = $IO_PORT @ATTACH &n127 => @PLACE(70, -1247) => @ORIENT("R0");
// %t1574 @TEXT("n127", key="name", size=0.75);
// &n127 @WIRE(mode="straight") {#X302:2 %t1574:p};
// %t1575 = $IO_PORT @ATTACH &n363 => @PLACE(90, -1245) => @ORIENT("MY");
// %t1575 @TEXT("n363", key="name", size=0.75);
// &n363 @WIRE(mode="straight") {#X302:3 %t1575:p};
// %t1576 = $SUPPLY @ATTACH &vdd => @PLACE(80, -1234);
// &vdd @WIRE(mode="straight") {#X302:4 %t1576:p};
// %t1577 = $GROUND @ATTACH &vss => @PLACE(80, -1256);
// &vss @WIRE(mode="straight") {#X302:5 %t1577:p};
// %t1578 = $IO_PORT @ATTACH &n355 => @PLACE(110, -1243) => @ORIENT("R0");
// %t1578 @TEXT("n355", key="name", size=0.75);
// &n355 @WIRE(mode="straight") {#X303:1 %t1578:p};
// %t1579 = $IO_PORT @ATTACH &n129 => @PLACE(110, -1247) => @ORIENT("R0");
// %t1579 @TEXT("n129", key="name", size=0.75);
// &n129 @WIRE(mode="straight") {#X303:2 %t1579:p};
// %t1580 = $IO_PORT @ATTACH &n597 => @PLACE(130, -1245) => @ORIENT("MY");
// %t1580 @TEXT("n597", key="name", size=0.75);
// &n597 @WIRE(mode="straight") {#X303:3 %t1580:p};
// %t1581 = $SUPPLY @ATTACH &vdd => @PLACE(120, -1234);
// &vdd @WIRE(mode="straight") {#X303:4 %t1581:p};
// %t1582 = $GROUND @ATTACH &vss => @PLACE(120, -1256);
// &vss @WIRE(mode="straight") {#X303:5 %t1582:p};
// %t1583 = $IO_PORT @ATTACH &n357 => @PLACE(-11, -1274) => @ORIENT("R0");
// %t1583 @TEXT("n357", key="name", size=0.75);
// &n357 @WIRE(mode="straight") {#X304:1 %t1583:p};
// %t1584 = $IO_PORT @ATTACH &n131 => @PLACE(-11, -1278) => @ORIENT("R0");
// %t1584 @TEXT("n131", key="name", size=0.75);
// &n131 @WIRE(mode="straight") {#X304:2 %t1584:p};
// %t1585 = $IO_PORT @ATTACH &n598 => @PLACE(10, -1276) => @ORIENT("MY");
// %t1585 @TEXT("n598", key="name", size=0.75);
// &n598 @WIRE(mode="straight") {#X304:3 %t1585:p};
// %t1586 = $SUPPLY @ATTACH &vdd => @PLACE(0, -1265);
// &vdd @WIRE(mode="straight") {#X304:4 %t1586:p};
// %t1587 = $GROUND @ATTACH &vss => @PLACE(0, -1287);
// &vss @WIRE(mode="straight") {#X304:5 %t1587:p};
// %t1588 = $IO_PORT @ATTACH &n582 => @PLACE(30, -1274) => @ORIENT("R0");
// %t1588 @TEXT("n582", key="name", size=0.75);
// &n582 @WIRE(mode="straight") {#X305:1 %t1588:p};
// %t1589 = $IO_PORT @ATTACH &n133 => @PLACE(30, -1278) => @ORIENT("R0");
// %t1589 @TEXT("n133", key="name", size=0.75);
// &n133 @WIRE(mode="straight") {#X305:2 %t1589:p};
// %t1590 = $IO_PORT @ATTACH &n599 => @PLACE(50, -1276) => @ORIENT("MY");
// %t1590 @TEXT("n599", key="name", size=0.75);
// &n599 @WIRE(mode="straight") {#X305:3 %t1590:p};
// %t1591 = $SUPPLY @ATTACH &vdd => @PLACE(40, -1265);
// &vdd @WIRE(mode="straight") {#X305:4 %t1591:p};
// %t1592 = $GROUND @ATTACH &vss => @PLACE(40, -1287);
// &vss @WIRE(mode="straight") {#X305:5 %t1592:p};
// %t1593 = $IO_PORT @ATTACH &n359 => @PLACE(70, -1274) => @ORIENT("R0");
// %t1593 @TEXT("n359", key="name", size=0.75);
// &n359 @WIRE(mode="straight") {#X306:1 %t1593:p};
// %t1594 = $IO_PORT @ATTACH &n135 => @PLACE(70, -1278) => @ORIENT("R0");
// %t1594 @TEXT("n135", key="name", size=0.75);
// &n135 @WIRE(mode="straight") {#X306:2 %t1594:p};
// %t1595 = $IO_PORT @ATTACH &n600 => @PLACE(90, -1276) => @ORIENT("MY");
// %t1595 @TEXT("n600", key="name", size=0.75);
// &n600 @WIRE(mode="straight") {#X306:3 %t1595:p};
// %t1596 = $SUPPLY @ATTACH &vdd => @PLACE(80, -1265);
// &vdd @WIRE(mode="straight") {#X306:4 %t1596:p};
// %t1597 = $GROUND @ATTACH &vss => @PLACE(80, -1287);
// &vss @WIRE(mode="straight") {#X306:5 %t1597:p};
// %t1598 = $IO_PORT @ATTACH &n361 => @PLACE(110, -1274) => @ORIENT("R0");
// %t1598 @TEXT("n361", key="name", size=0.75);
// &n361 @WIRE(mode="straight") {#X307:1 %t1598:p};
// %t1599 = $IO_PORT @ATTACH &n137 => @PLACE(110, -1278) => @ORIENT("R0");
// %t1599 @TEXT("n137", key="name", size=0.75);
// &n137 @WIRE(mode="straight") {#X307:2 %t1599:p};
// %t1600 = $IO_PORT @ATTACH &n601 => @PLACE(130, -1276) => @ORIENT("MY");
// %t1600 @TEXT("n601", key="name", size=0.75);
// &n601 @WIRE(mode="straight") {#X307:3 %t1600:p};
// %t1601 = $SUPPLY @ATTACH &vdd => @PLACE(120, -1265);
// &vdd @WIRE(mode="straight") {#X307:4 %t1601:p};
// %t1602 = $GROUND @ATTACH &vss => @PLACE(120, -1287);
// &vss @WIRE(mode="straight") {#X307:5 %t1602:p};
// %t1603 = $IO_PORT @ATTACH &n355 => @PLACE(-11, -1305) => @ORIENT("R0");
// %t1603 @TEXT("n355", key="name", size=0.75);
// &n355 @WIRE(mode="straight") {#X308:1 %t1603:p};
// %t1604 = $IO_PORT @ATTACH &n129 => @PLACE(-11, -1309) => @ORIENT("R0");
// %t1604 @TEXT("n129", key="name", size=0.75);
// &n129 @WIRE(mode="straight") {#X308:2 %t1604:p};
// %t1605 = $IO_PORT @ATTACH &n362 => @PLACE(10, -1307) => @ORIENT("MY");
// %t1605 @TEXT("n362", key="name", size=0.75);
// &n362 @WIRE(mode="straight") {#X308:3 %t1605:p};
// %t1606 = $SUPPLY @ATTACH &vdd => @PLACE(0, -1296);
// &vdd @WIRE(mode="straight") {#X308:4 %t1606:p};
// %t1607 = $GROUND @ATTACH &vss => @PLACE(0, -1318);
// &vss @WIRE(mode="straight") {#X308:5 %t1607:p};
// %t1608 = $IO_PORT @ATTACH &n357 => @PLACE(30, -1305) => @ORIENT("R0");
// %t1608 @TEXT("n357", key="name", size=0.75);
// &n357 @WIRE(mode="straight") {#X309:1 %t1608:p};
// %t1609 = $IO_PORT @ATTACH &n131 => @PLACE(30, -1309) => @ORIENT("R0");
// %t1609 @TEXT("n131", key="name", size=0.75);
// &n131 @WIRE(mode="straight") {#X309:2 %t1609:p};
// %t1610 = $IO_PORT @ATTACH &n365 => @PLACE(50, -1307) => @ORIENT("MY");
// %t1610 @TEXT("n365", key="name", size=0.75);
// &n365 @WIRE(mode="straight") {#X309:3 %t1610:p};
// %t1611 = $SUPPLY @ATTACH &vdd => @PLACE(40, -1296);
// &vdd @WIRE(mode="straight") {#X309:4 %t1611:p};
// %t1612 = $GROUND @ATTACH &vss => @PLACE(40, -1318);
// &vss @WIRE(mode="straight") {#X309:5 %t1612:p};
// %t1613 = $IO_PORT @ATTACH &n582 => @PLACE(70, -1305) => @ORIENT("R0");
// %t1613 @TEXT("n582", key="name", size=0.75);
// &n582 @WIRE(mode="straight") {#X310:1 %t1613:p};
// %t1614 = $IO_PORT @ATTACH &n133 => @PLACE(70, -1309) => @ORIENT("R0");
// %t1614 @TEXT("n133", key="name", size=0.75);
// &n133 @WIRE(mode="straight") {#X310:2 %t1614:p};
// %t1615 = $IO_PORT @ATTACH &n368 => @PLACE(90, -1307) => @ORIENT("MY");
// %t1615 @TEXT("n368", key="name", size=0.75);
// &n368 @WIRE(mode="straight") {#X310:3 %t1615:p};
// %t1616 = $SUPPLY @ATTACH &vdd => @PLACE(80, -1296);
// &vdd @WIRE(mode="straight") {#X310:4 %t1616:p};
// %t1617 = $GROUND @ATTACH &vss => @PLACE(80, -1318);
// &vss @WIRE(mode="straight") {#X310:5 %t1617:p};
// %t1618 = $IO_PORT @ATTACH &n359 => @PLACE(110, -1305) => @ORIENT("R0");
// %t1618 @TEXT("n359", key="name", size=0.75);
// &n359 @WIRE(mode="straight") {#X311:1 %t1618:p};
// %t1619 = $IO_PORT @ATTACH &n135 => @PLACE(110, -1309) => @ORIENT("R0");
// %t1619 @TEXT("n135", key="name", size=0.75);
// &n135 @WIRE(mode="straight") {#X311:2 %t1619:p};
// %t1620 = $IO_PORT @ATTACH &n371 => @PLACE(130, -1307) => @ORIENT("MY");
// %t1620 @TEXT("n371", key="name", size=0.75);
// &n371 @WIRE(mode="straight") {#X311:3 %t1620:p};
// %t1621 = $SUPPLY @ATTACH &vdd => @PLACE(120, -1296);
// &vdd @WIRE(mode="straight") {#X311:4 %t1621:p};
// %t1622 = $GROUND @ATTACH &vss => @PLACE(120, -1318);
// &vss @WIRE(mode="straight") {#X311:5 %t1622:p};
// %t1623 = $IO_PORT @ATTACH &n361 => @PLACE(158, -1150) => @ORIENT("R0");
// %t1623 @TEXT("n361", key="name", size=0.75);
// &n361 @WIRE(mode="straight") {#X312:1 %t1623:p};
// %t1624 = $IO_PORT @ATTACH &n137 => @PLACE(158, -1154) => @ORIENT("R0");
// %t1624 @TEXT("n137", key="name", size=0.75);
// &n137 @WIRE(mode="straight") {#X312:2 %t1624:p};
// %t1625 = $IO_PORT @ATTACH &n374 => @PLACE(178, -1152) => @ORIENT("MY");
// %t1625 @TEXT("n374", key="name", size=0.75);
// &n374 @WIRE(mode="straight") {#X312:3 %t1625:p};
// %t1626 = $SUPPLY @ATTACH &vdd => @PLACE(168, -1141);
// &vdd @WIRE(mode="straight") {#X312:4 %t1626:p};
// %t1627 = $GROUND @ATTACH &vss => @PLACE(168, -1163);
// &vss @WIRE(mode="straight") {#X312:5 %t1627:p};
// %t1628 = $IO_PORT @ATTACH &n600 => @PLACE(198, -1150) => @ORIENT("R0");
// %t1628 @TEXT("n600", key="name", size=0.75);
// &n600 @WIRE(mode="straight") {#X313:1 %t1628:p};
// %t1629 = $IO_PORT @ATTACH &n602 => @PLACE(198, -1154) => @ORIENT("R0");
// %t1629 @TEXT("n602", key="name", size=0.75);
// &n602 @WIRE(mode="straight") {#X313:2 %t1629:p};
// %t1630 = $IO_PORT @ATTACH &n375 => @PLACE(218, -1152) => @ORIENT("MY");
// %t1630 @TEXT("n375", key="name", size=0.75);
// &n375 @WIRE(mode="straight") {#X313:3 %t1630:p};
// %t1631 = $SUPPLY @ATTACH &vdd => @PLACE(208, -1141);
// &vdd @WIRE(mode="straight") {#X313:4 %t1631:p};
// %t1632 = $GROUND @ATTACH &vss => @PLACE(208, -1163);
// &vss @WIRE(mode="straight") {#X313:5 %t1632:p};
// %t1633 = $IO_PORT @ATTACH &n598 => @PLACE(238, -1150) => @ORIENT("R0");
// %t1633 @TEXT("n598", key="name", size=0.75);
// &n598 @WIRE(mode="straight") {#X314:1 %t1633:p};
// %t1634 = $IO_PORT @ATTACH &n603 => @PLACE(238, -1154) => @ORIENT("R0");
// %t1634 @TEXT("n603", key="name", size=0.75);
// &n603 @WIRE(mode="straight") {#X314:2 %t1634:p};
// %t1635 = $IO_PORT @ATTACH &n369 => @PLACE(258, -1152) => @ORIENT("MY");
// %t1635 @TEXT("n369", key="name", size=0.75);
// &n369 @WIRE(mode="straight") {#X314:3 %t1635:p};
// %t1636 = $SUPPLY @ATTACH &vdd => @PLACE(248, -1141);
// &vdd @WIRE(mode="straight") {#X314:4 %t1636:p};
// %t1637 = $GROUND @ATTACH &vss => @PLACE(248, -1163);
// &vss @WIRE(mode="straight") {#X314:5 %t1637:p};
// %t1638 = $IO_PORT @ATTACH &n365 => @PLACE(278, -1150) => @ORIENT("R0");
// %t1638 @TEXT("n365", key="name", size=0.75);
// &n365 @WIRE(mode="straight") {#X315:1 %t1638:p};
// %t1639 = $IO_PORT @ATTACH &n366 => @PLACE(278, -1154) => @ORIENT("R0");
// %t1639 @TEXT("n366", key="name", size=0.75);
// &n366 @WIRE(mode="straight") {#X315:2 %t1639:p};
// %t1640 = $IO_PORT @ATTACH &n603 => @PLACE(298, -1152) => @ORIENT("MY");
// %t1640 @TEXT("n603", key="name", size=0.75);
// &n603 @WIRE(mode="straight") {#X315:3 %t1640:p};
// %t1641 = $SUPPLY @ATTACH &vdd => @PLACE(288, -1141);
// &vdd @WIRE(mode="straight") {#X315:4 %t1641:p};
// %t1642 = $GROUND @ATTACH &vss => @PLACE(288, -1163);
// &vss @WIRE(mode="straight") {#X315:5 %t1642:p};
// %t1643 = $IO_PORT @ATTACH &n604 => @PLACE(158, -1181) => @ORIENT("R0");
// %t1643 @TEXT("n604", key="name", size=0.75);
// &n604 @WIRE(mode="straight") {#X316:1 %t1643:p};
// %t1644 = $IO_PORT @ATTACH &n605 => @PLACE(158, -1185) => @ORIENT("R0");
// %t1644 @TEXT("n605", key="name", size=0.75);
// &n605 @WIRE(mode="straight") {#X316:2 %t1644:p};
// %t1645 = $IO_PORT @ATTACH &n378 => @PLACE(178, -1183) => @ORIENT("MY");
// %t1645 @TEXT("n378", key="name", size=0.75);
// &n378 @WIRE(mode="straight") {#X316:3 %t1645:p};
// %t1646 = $SUPPLY @ATTACH &vdd => @PLACE(168, -1172);
// &vdd @WIRE(mode="straight") {#X316:4 %t1646:p};
// %t1647 = $GROUND @ATTACH &vss => @PLACE(168, -1194);
// &vss @WIRE(mode="straight") {#X316:5 %t1647:p};
// %t1648 = $IO_PORT @ATTACH &n606 => @PLACE(198, -1181) => @ORIENT("R0");
// %t1648 @TEXT("n606", key="name", size=0.75);
// &n606 @WIRE(mode="straight") {#X317:1 %t1648:p};
// %t1649 = $IO_PORT @ATTACH &n372 => @PLACE(198, -1185) => @ORIENT("R0");
// %t1649 @TEXT("n372", key="name", size=0.75);
// &n372 @WIRE(mode="straight") {#X317:2 %t1649:p};
// %t1650 = $IO_PORT @ATTACH &n605 => @PLACE(218, -1183) => @ORIENT("MY");
// %t1650 @TEXT("n605", key="name", size=0.75);
// &n605 @WIRE(mode="straight") {#X317:3 %t1650:p};
// %t1651 = $SUPPLY @ATTACH &vdd => @PLACE(208, -1172);
// &vdd @WIRE(mode="straight") {#X317:4 %t1651:p};
// %t1652 = $GROUND @ATTACH &vss => @PLACE(208, -1194);
// &vss @WIRE(mode="straight") {#X317:5 %t1652:p};
// %t1653 = $IO_PORT @ATTACH &n607 => @PLACE(238, -1181) => @ORIENT("R0");
// %t1653 @TEXT("n607", key="name", size=0.75);
// &n607 @WIRE(mode="straight") {#X318:1 %t1653:p};
// %t1654 = $IO_PORT @ATTACH &n608 => @PLACE(238, -1185) => @ORIENT("R0");
// %t1654 @TEXT("n608", key="name", size=0.75);
// &n608 @WIRE(mode="straight") {#X318:2 %t1654:p};
// %t1655 = $IO_PORT @ATTACH &n372 => @PLACE(258, -1183) => @ORIENT("MY");
// %t1655 @TEXT("n372", key="name", size=0.75);
// &n372 @WIRE(mode="straight") {#X318:3 %t1655:p};
// %t1656 = $SUPPLY @ATTACH &vdd => @PLACE(248, -1172);
// &vdd @WIRE(mode="straight") {#X318:4 %t1656:p};
// %t1657 = $GROUND @ATTACH &vss => @PLACE(248, -1194);
// &vss @WIRE(mode="straight") {#X318:5 %t1657:p};
// %t1658 = $IO_PORT @ATTACH &n609 => @PLACE(278, -1181) => @ORIENT("R0");
// %t1658 @TEXT("n609", key="name", size=0.75);
// &n609 @WIRE(mode="straight") {#X319:1 %t1658:p};
// %t1659 = $IO_PORT @ATTACH &n366 => @PLACE(278, -1185) => @ORIENT("R0");
// %t1659 @TEXT("n366", key="name", size=0.75);
// &n366 @WIRE(mode="straight") {#X319:2 %t1659:p};
// %t1660 = $IO_PORT @ATTACH &n608 => @PLACE(298, -1183) => @ORIENT("MY");
// %t1660 @TEXT("n608", key="name", size=0.75);
// &n608 @WIRE(mode="straight") {#X319:3 %t1660:p};
// %t1661 = $SUPPLY @ATTACH &vdd => @PLACE(288, -1172);
// &vdd @WIRE(mode="straight") {#X319:4 %t1661:p};
// %t1662 = $GROUND @ATTACH &vss => @PLACE(288, -1194);
// &vss @WIRE(mode="straight") {#X319:5 %t1662:p};
// %t1663 = $IO_PORT @ATTACH &n374 => @PLACE(158, -1212) => @ORIENT("R0");
// %t1663 @TEXT("n374", key="name", size=0.75);
// &n374 @WIRE(mode="straight") {#X320:1 %t1663:p};
// %t1664 = $IO_PORT @ATTACH &n371 => @PLACE(158, -1216) => @ORIENT("R0");
// %t1664 @TEXT("n371", key="name", size=0.75);
// &n371 @WIRE(mode="straight") {#X320:2 %t1664:p};
// %t1665 = $IO_PORT @ATTACH &n606 => @PLACE(178, -1214) => @ORIENT("MY");
// %t1665 @TEXT("n606", key="name", size=0.75);
// &n606 @WIRE(mode="straight") {#X320:3 %t1665:p};
// %t1666 = $SUPPLY @ATTACH &vdd => @PLACE(168, -1203);
// &vdd @WIRE(mode="straight") {#X320:4 %t1666:p};
// %t1667 = $GROUND @ATTACH &vss => @PLACE(168, -1225);
// &vss @WIRE(mode="straight") {#X320:5 %t1667:p};
// %t1668 = $IO_PORT @ATTACH &n601 => @PLACE(198, -1212) => @ORIENT("R0");
// %t1668 @TEXT("n601", key="name", size=0.75);
// &n601 @WIRE(mode="straight") {#X321:1 %t1668:p};
// %t1669 = $IO_PORT @ATTACH &n610 => @PLACE(198, -1216) => @ORIENT("R0");
// %t1669 @TEXT("n610", key="name", size=0.75);
// &n610 @WIRE(mode="straight") {#X321:2 %t1669:p};
// %t1670 = $IO_PORT @ATTACH &n604 => @PLACE(218, -1214) => @ORIENT("MY");
// %t1670 @TEXT("n604", key="name", size=0.75);
// &n604 @WIRE(mode="straight") {#X321:3 %t1670:p};
// %t1671 = $SUPPLY @ATTACH &vdd => @PLACE(208, -1203);
// &vdd @WIRE(mode="straight") {#X321:4 %t1671:p};
// %t1672 = $GROUND @ATTACH &vss => @PLACE(208, -1225);
// &vss @WIRE(mode="straight") {#X321:5 %t1672:p};
// %t1673 = $IO_PORT @ATTACH &n374 => @PLACE(238, -1212) => @ORIENT("R0");
// %t1673 @TEXT("n374", key="name", size=0.75);
// &n374 @WIRE(mode="straight") {#X322:1 %t1673:p};
// %t1674 = $IO_PORT @ATTACH &n600 => @PLACE(238, -1216) => @ORIENT("R0");
// %t1674 @TEXT("n600", key="name", size=0.75);
// &n600 @WIRE(mode="straight") {#X322:2 %t1674:p};
// %t1675 = $IO_PORT @ATTACH &n610 => @PLACE(258, -1214) => @ORIENT("MY");
// %t1675 @TEXT("n610", key="name", size=0.75);
// &n610 @WIRE(mode="straight") {#X322:3 %t1675:p};
// %t1676 = $SUPPLY @ATTACH &vdd => @PLACE(248, -1203);
// &vdd @WIRE(mode="straight") {#X322:4 %t1676:p};
// %t1677 = $GROUND @ATTACH &vss => @PLACE(248, -1225);
// &vss @WIRE(mode="straight") {#X322:5 %t1677:p};
// %t1678 = $IO_PORT @ATTACH &n368 => @PLACE(278, -1212) => @ORIENT("R0");
// %t1678 @TEXT("n368", key="name", size=0.75);
// &n368 @WIRE(mode="straight") {#X323:1 %t1678:p};
// %t1679 = $IO_PORT @ATTACH &n365 => @PLACE(278, -1216) => @ORIENT("R0");
// %t1679 @TEXT("n365", key="name", size=0.75);
// &n365 @WIRE(mode="straight") {#X323:2 %t1679:p};
// %t1680 = $IO_PORT @ATTACH &n609 => @PLACE(298, -1214) => @ORIENT("MY");
// %t1680 @TEXT("n609", key="name", size=0.75);
// &n609 @WIRE(mode="straight") {#X323:3 %t1680:p};
// %t1681 = $SUPPLY @ATTACH &vdd => @PLACE(288, -1203);
// &vdd @WIRE(mode="straight") {#X323:4 %t1681:p};
// %t1682 = $GROUND @ATTACH &vss => @PLACE(288, -1225);
// &vss @WIRE(mode="straight") {#X323:5 %t1682:p};
// %t1683 = $IO_PORT @ATTACH &n599 => @PLACE(158, -1243) => @ORIENT("R0");
// %t1683 @TEXT("n599", key="name", size=0.75);
// &n599 @WIRE(mode="straight") {#X324:1 %t1683:p};
// %t1684 = $IO_PORT @ATTACH &n611 => @PLACE(158, -1247) => @ORIENT("R0");
// %t1684 @TEXT("n611", key="name", size=0.75);
// &n611 @WIRE(mode="straight") {#X324:2 %t1684:p};
// %t1685 = $IO_PORT @ATTACH &n607 => @PLACE(178, -1245) => @ORIENT("MY");
// %t1685 @TEXT("n607", key="name", size=0.75);
// &n607 @WIRE(mode="straight") {#X324:3 %t1685:p};
// %t1686 = $SUPPLY @ATTACH &vdd => @PLACE(168, -1234);
// &vdd @WIRE(mode="straight") {#X324:4 %t1686:p};
// %t1687 = $GROUND @ATTACH &vss => @PLACE(168, -1256);
// &vss @WIRE(mode="straight") {#X324:5 %t1687:p};
// %t1688 = $IO_PORT @ATTACH &n368 => @PLACE(198, -1243) => @ORIENT("R0");
// %t1688 @TEXT("n368", key="name", size=0.75);
// &n368 @WIRE(mode="straight") {#X325:1 %t1688:p};
// %t1689 = $IO_PORT @ATTACH &n598 => @PLACE(198, -1247) => @ORIENT("R0");
// %t1689 @TEXT("n598", key="name", size=0.75);
// &n598 @WIRE(mode="straight") {#X325:2 %t1689:p};
// %t1690 = $IO_PORT @ATTACH &n611 => @PLACE(218, -1245) => @ORIENT("MY");
// %t1690 @TEXT("n611", key="name", size=0.75);
// &n611 @WIRE(mode="straight") {#X325:3 %t1690:p};
// %t1691 = $SUPPLY @ATTACH &vdd => @PLACE(208, -1234);
// &vdd @WIRE(mode="straight") {#X325:4 %t1691:p};
// %t1692 = $GROUND @ATTACH &vss => @PLACE(208, -1256);
// &vss @WIRE(mode="straight") {#X325:5 %t1692:p};
// %t1693 = $IO_PORT @ATTACH &n371 => @PLACE(238, -1243) => @ORIENT("R0");
// %t1693 @TEXT("n371", key="name", size=0.75);
// &n371 @WIRE(mode="straight") {#X326:1 %t1693:p};
// %t1694 = $IO_PORT @ATTACH &n372 => @PLACE(238, -1247) => @ORIENT("R0");
// %t1694 @TEXT("n372", key="name", size=0.75);
// &n372 @WIRE(mode="straight") {#X326:2 %t1694:p};
// %t1695 = $IO_PORT @ATTACH &n602 => @PLACE(258, -1245) => @ORIENT("MY");
// %t1695 @TEXT("n602", key="name", size=0.75);
// &n602 @WIRE(mode="straight") {#X326:3 %t1695:p};
// %t1696 = $SUPPLY @ATTACH &vdd => @PLACE(248, -1234);
// &vdd @WIRE(mode="straight") {#X326:4 %t1696:p};
// %t1697 = $GROUND @ATTACH &vss => @PLACE(248, -1256);
// &vss @WIRE(mode="straight") {#X326:5 %t1697:p};
// %t1698 = $IO_PORT @ATTACH &n597 => @PLACE(278, -1243) => @ORIENT("R0");
// %t1698 @TEXT("n597", key="name", size=0.75);
// &n597 @WIRE(mode="straight") {#X327:1 %t1698:p};
// %t1699 = $IO_PORT @ATTACH &n612 => @PLACE(278, -1247) => @ORIENT("R0");
// %t1699 @TEXT("n612", key="name", size=0.75);
// &n612 @WIRE(mode="straight") {#X327:2 %t1699:p};
// %t1700 = $IO_PORT @ATTACH &n366 => @PLACE(298, -1245) => @ORIENT("MY");
// %t1700 @TEXT("n366", key="name", size=0.75);
// &n366 @WIRE(mode="straight") {#X327:3 %t1700:p};
// %t1701 = $SUPPLY @ATTACH &vdd => @PLACE(288, -1234);
// &vdd @WIRE(mode="straight") {#X327:4 %t1701:p};
// %t1702 = $GROUND @ATTACH &vss => @PLACE(288, -1256);
// &vss @WIRE(mode="straight") {#X327:5 %t1702:p};
// %t1703 = $IO_PORT @ATTACH &n362 => @PLACE(158, -1274) => @ORIENT("R0");
// %t1703 @TEXT("n362", key="name", size=0.75);
// &n362 @WIRE(mode="straight") {#X328:1 %t1703:p};
// %t1704 = $IO_PORT @ATTACH &n363 => @PLACE(158, -1278) => @ORIENT("R0");
// %t1704 @TEXT("n363", key="name", size=0.75);
// &n363 @WIRE(mode="straight") {#X328:2 %t1704:p};
// %t1705 = $IO_PORT @ATTACH &n612 => @PLACE(178, -1276) => @ORIENT("MY");
// %t1705 @TEXT("n612", key="name", size=0.75);
// &n612 @WIRE(mode="straight") {#X328:3 %t1705:p};
// %t1706 = $SUPPLY @ATTACH &vdd => @PLACE(168, -1265);
// &vdd @WIRE(mode="straight") {#X328:4 %t1706:p};
// %t1707 = $GROUND @ATTACH &vss => @PLACE(168, -1287);
// &vss @WIRE(mode="straight") {#X328:5 %t1707:p};
// %t1708 = $IO_PORT @ATTACH &n75 => @PLACE(198, -1274) => @ORIENT("R0");
// %t1708 @TEXT("n75", key="name", size=0.75);
// &n75 @WIRE(mode="straight") {#X329:1 %t1708:p};
// %t1709 = $IO_PORT @ATTACH &dac0 => @PLACE(198, -1278) => @ORIENT("R0");
// %t1709 @TEXT("dac0", key="name", size=0.75);
// &dac0 @WIRE(mode="straight") {#X329:2 %t1709:p};
// %t1710 = $IO_PORT @ATTACH &n381 => @PLACE(218, -1276) => @ORIENT("MY");
// %t1710 @TEXT("n381", key="name", size=0.75);
// &n381 @WIRE(mode="straight") {#X329:3 %t1710:p};
// %t1711 = $SUPPLY @ATTACH &vdd => @PLACE(208, -1265);
// &vdd @WIRE(mode="straight") {#X329:4 %t1711:p};
// %t1712 = $GROUND @ATTACH &vss => @PLACE(208, -1287);
// &vss @WIRE(mode="straight") {#X329:5 %t1712:p};
// %t1713 = $IO_PORT @ATTACH &n77 => @PLACE(238, -1274) => @ORIENT("R0");
// %t1713 @TEXT("n77", key="name", size=0.75);
// &n77 @WIRE(mode="straight") {#X330:1 %t1713:p};
// %t1714 = $IO_PORT @ATTACH &dac1 => @PLACE(238, -1278) => @ORIENT("R0");
// %t1714 @TEXT("dac1", key="name", size=0.75);
// &dac1 @WIRE(mode="straight") {#X330:2 %t1714:p};
// %t1715 = $IO_PORT @ATTACH &n613 => @PLACE(258, -1276) => @ORIENT("MY");
// %t1715 @TEXT("n613", key="name", size=0.75);
// &n613 @WIRE(mode="straight") {#X330:3 %t1715:p};
// %t1716 = $SUPPLY @ATTACH &vdd => @PLACE(248, -1265);
// &vdd @WIRE(mode="straight") {#X330:4 %t1716:p};
// %t1717 = $GROUND @ATTACH &vss => @PLACE(248, -1287);
// &vss @WIRE(mode="straight") {#X330:5 %t1717:p};
// %t1718 = $IO_PORT @ATTACH &n79 => @PLACE(278, -1274) => @ORIENT("R0");
// %t1718 @TEXT("n79", key="name", size=0.75);
// &n79 @WIRE(mode="straight") {#X331:1 %t1718:p};
// %t1719 = $IO_PORT @ATTACH &dac2 => @PLACE(278, -1278) => @ORIENT("R0");
// %t1719 @TEXT("dac2", key="name", size=0.75);
// &dac2 @WIRE(mode="straight") {#X331:2 %t1719:p};
// %t1720 = $IO_PORT @ATTACH &n614 => @PLACE(298, -1276) => @ORIENT("MY");
// %t1720 @TEXT("n614", key="name", size=0.75);
// &n614 @WIRE(mode="straight") {#X331:3 %t1720:p};
// %t1721 = $SUPPLY @ATTACH &vdd => @PLACE(288, -1265);
// &vdd @WIRE(mode="straight") {#X331:4 %t1721:p};
// %t1722 = $GROUND @ATTACH &vss => @PLACE(288, -1287);
// &vss @WIRE(mode="straight") {#X331:5 %t1722:p};
// %t1723 = $IO_PORT @ATTACH &n81 => @PLACE(158, -1305) => @ORIENT("R0");
// %t1723 @TEXT("n81", key="name", size=0.75);
// &n81 @WIRE(mode="straight") {#X332:1 %t1723:p};
// %t1724 = $IO_PORT @ATTACH &dac3 => @PLACE(158, -1309) => @ORIENT("R0");
// %t1724 @TEXT("dac3", key="name", size=0.75);
// &dac3 @WIRE(mode="straight") {#X332:2 %t1724:p};
// %t1725 = $IO_PORT @ATTACH &n615 => @PLACE(178, -1307) => @ORIENT("MY");
// %t1725 @TEXT("n615", key="name", size=0.75);
// &n615 @WIRE(mode="straight") {#X332:3 %t1725:p};
// %t1726 = $SUPPLY @ATTACH &vdd => @PLACE(168, -1296);
// &vdd @WIRE(mode="straight") {#X332:4 %t1726:p};
// %t1727 = $GROUND @ATTACH &vss => @PLACE(168, -1318);
// &vss @WIRE(mode="straight") {#X332:5 %t1727:p};
// %t1728 = $IO_PORT @ATTACH &n83 => @PLACE(198, -1305) => @ORIENT("R0");
// %t1728 @TEXT("n83", key="name", size=0.75);
// &n83 @WIRE(mode="straight") {#X333:1 %t1728:p};
// %t1729 = $IO_PORT @ATTACH &dac4 => @PLACE(198, -1309) => @ORIENT("R0");
// %t1729 @TEXT("dac4", key="name", size=0.75);
// &dac4 @WIRE(mode="straight") {#X333:2 %t1729:p};
// %t1730 = $IO_PORT @ATTACH &n616 => @PLACE(218, -1307) => @ORIENT("MY");
// %t1730 @TEXT("n616", key="name", size=0.75);
// &n616 @WIRE(mode="straight") {#X333:3 %t1730:p};
// %t1731 = $SUPPLY @ATTACH &vdd => @PLACE(208, -1296);
// &vdd @WIRE(mode="straight") {#X333:4 %t1731:p};
// %t1732 = $GROUND @ATTACH &vss => @PLACE(208, -1318);
// &vss @WIRE(mode="straight") {#X333:5 %t1732:p};
// %t1733 = $IO_PORT @ATTACH &n85 => @PLACE(238, -1305) => @ORIENT("R0");
// %t1733 @TEXT("n85", key="name", size=0.75);
// &n85 @WIRE(mode="straight") {#X334:1 %t1733:p};
// %t1734 = $IO_PORT @ATTACH &dac5 => @PLACE(238, -1309) => @ORIENT("R0");
// %t1734 @TEXT("dac5", key="name", size=0.75);
// &dac5 @WIRE(mode="straight") {#X334:2 %t1734:p};
// %t1735 = $IO_PORT @ATTACH &n617 => @PLACE(258, -1307) => @ORIENT("MY");
// %t1735 @TEXT("n617", key="name", size=0.75);
// &n617 @WIRE(mode="straight") {#X334:3 %t1735:p};
// %t1736 = $SUPPLY @ATTACH &vdd => @PLACE(248, -1296);
// &vdd @WIRE(mode="straight") {#X334:4 %t1736:p};
// %t1737 = $GROUND @ATTACH &vss => @PLACE(248, -1318);
// &vss @WIRE(mode="straight") {#X334:5 %t1737:p};
// %t1738 = $IO_PORT @ATTACH &n75 => @PLACE(278, -1305) => @ORIENT("R0");
// %t1738 @TEXT("n75", key="name", size=0.75);
// &n75 @WIRE(mode="straight") {#X335:1 %t1738:p};
// %t1739 = $IO_PORT @ATTACH &dac0 => @PLACE(278, -1309) => @ORIENT("R0");
// %t1739 @TEXT("dac0", key="name", size=0.75);
// &dac0 @WIRE(mode="straight") {#X335:2 %t1739:p};
// %t1740 = $IO_PORT @ATTACH &n390 => @PLACE(298, -1307) => @ORIENT("MY");
// %t1740 @TEXT("n390", key="name", size=0.75);
// &n390 @WIRE(mode="straight") {#X335:3 %t1740:p};
// %t1741 = $SUPPLY @ATTACH &vdd => @PLACE(288, -1296);
// &vdd @WIRE(mode="straight") {#X335:4 %t1741:p};
// %t1742 = $GROUND @ATTACH &vss => @PLACE(288, -1318);
// &vss @WIRE(mode="straight") {#X335:5 %t1742:p};
// %t1743 = $IO_PORT @ATTACH &n77 => @PLACE(326, -1150) => @ORIENT("R0");
// %t1743 @TEXT("n77", key="name", size=0.75);
// &n77 @WIRE(mode="straight") {#X336:1 %t1743:p};
// %t1744 = $IO_PORT @ATTACH &dac1 => @PLACE(326, -1154) => @ORIENT("R0");
// %t1744 @TEXT("dac1", key="name", size=0.75);
// &dac1 @WIRE(mode="straight") {#X336:2 %t1744:p};
// %t1745 = $IO_PORT @ATTACH &n380 => @PLACE(346, -1152) => @ORIENT("MY");
// %t1745 @TEXT("n380", key="name", size=0.75);
// &n380 @WIRE(mode="straight") {#X336:3 %t1745:p};
// %t1746 = $SUPPLY @ATTACH &vdd => @PLACE(336, -1141);
// &vdd @WIRE(mode="straight") {#X336:4 %t1746:p};
// %t1747 = $GROUND @ATTACH &vss => @PLACE(336, -1163);
// &vss @WIRE(mode="straight") {#X336:5 %t1747:p};
// %t1748 = $IO_PORT @ATTACH &n79 => @PLACE(366, -1150) => @ORIENT("R0");
// %t1748 @TEXT("n79", key="name", size=0.75);
// &n79 @WIRE(mode="straight") {#X337:1 %t1748:p};
// %t1749 = $IO_PORT @ATTACH &dac2 => @PLACE(366, -1154) => @ORIENT("R0");
// %t1749 @TEXT("dac2", key="name", size=0.75);
// &dac2 @WIRE(mode="straight") {#X337:2 %t1749:p};
// %t1750 = $IO_PORT @ATTACH &n382 => @PLACE(386, -1152) => @ORIENT("MY");
// %t1750 @TEXT("n382", key="name", size=0.75);
// &n382 @WIRE(mode="straight") {#X337:3 %t1750:p};
// %t1751 = $SUPPLY @ATTACH &vdd => @PLACE(376, -1141);
// &vdd @WIRE(mode="straight") {#X337:4 %t1751:p};
// %t1752 = $GROUND @ATTACH &vss => @PLACE(376, -1163);
// &vss @WIRE(mode="straight") {#X337:5 %t1752:p};
// %t1753 = $IO_PORT @ATTACH &n81 => @PLACE(406, -1150) => @ORIENT("R0");
// %t1753 @TEXT("n81", key="name", size=0.75);
// &n81 @WIRE(mode="straight") {#X338:1 %t1753:p};
// %t1754 = $IO_PORT @ATTACH &dac3 => @PLACE(406, -1154) => @ORIENT("R0");
// %t1754 @TEXT("dac3", key="name", size=0.75);
// &dac3 @WIRE(mode="straight") {#X338:2 %t1754:p};
// %t1755 = $IO_PORT @ATTACH &n384 => @PLACE(426, -1152) => @ORIENT("MY");
// %t1755 @TEXT("n384", key="name", size=0.75);
// &n384 @WIRE(mode="straight") {#X338:3 %t1755:p};
// %t1756 = $SUPPLY @ATTACH &vdd => @PLACE(416, -1141);
// &vdd @WIRE(mode="straight") {#X338:4 %t1756:p};
// %t1757 = $GROUND @ATTACH &vss => @PLACE(416, -1163);
// &vss @WIRE(mode="straight") {#X338:5 %t1757:p};
// %t1758 = $IO_PORT @ATTACH &n83 => @PLACE(446, -1150) => @ORIENT("R0");
// %t1758 @TEXT("n83", key="name", size=0.75);
// &n83 @WIRE(mode="straight") {#X339:1 %t1758:p};
// %t1759 = $IO_PORT @ATTACH &dac4 => @PLACE(446, -1154) => @ORIENT("R0");
// %t1759 @TEXT("dac4", key="name", size=0.75);
// &dac4 @WIRE(mode="straight") {#X339:2 %t1759:p};
// %t1760 = $IO_PORT @ATTACH &n386 => @PLACE(466, -1152) => @ORIENT("MY");
// %t1760 @TEXT("n386", key="name", size=0.75);
// &n386 @WIRE(mode="straight") {#X339:3 %t1760:p};
// %t1761 = $SUPPLY @ATTACH &vdd => @PLACE(456, -1141);
// &vdd @WIRE(mode="straight") {#X339:4 %t1761:p};
// %t1762 = $GROUND @ATTACH &vss => @PLACE(456, -1163);
// &vss @WIRE(mode="straight") {#X339:5 %t1762:p};
// %t1763 = $IO_PORT @ATTACH &n85 => @PLACE(326, -1181) => @ORIENT("R0");
// %t1763 @TEXT("n85", key="name", size=0.75);
// &n85 @WIRE(mode="straight") {#X340:1 %t1763:p};
// %t1764 = $IO_PORT @ATTACH &dac5 => @PLACE(326, -1185) => @ORIENT("R0");
// %t1764 @TEXT("dac5", key="name", size=0.75);
// &dac5 @WIRE(mode="straight") {#X340:2 %t1764:p};
// %t1765 = $IO_PORT @ATTACH &n388 => @PLACE(346, -1183) => @ORIENT("MY");
// %t1765 @TEXT("n388", key="name", size=0.75);
// &n388 @WIRE(mode="straight") {#X340:3 %t1765:p};
// %t1766 = $SUPPLY @ATTACH &vdd => @PLACE(336, -1172);
// &vdd @WIRE(mode="straight") {#X340:4 %t1766:p};
// %t1767 = $GROUND @ATTACH &vss => @PLACE(336, -1194);
// &vss @WIRE(mode="straight") {#X340:5 %t1767:p};
// %t1768 = $IO_PORT @ATTACH &n616 => @PLACE(366, -1181) => @ORIENT("R0");
// %t1768 @TEXT("n616", key="name", size=0.75);
// &n616 @WIRE(mode="straight") {#X341:1 %t1768:p};
// %t1769 = $IO_PORT @ATTACH &n618 => @PLACE(366, -1185) => @ORIENT("R0");
// %t1769 @TEXT("n618", key="name", size=0.75);
// &n618 @WIRE(mode="straight") {#X341:2 %t1769:p};
// %t1770 = $IO_PORT @ATTACH &n389 => @PLACE(386, -1183) => @ORIENT("MY");
// %t1770 @TEXT("n389", key="name", size=0.75);
// &n389 @WIRE(mode="straight") {#X341:3 %t1770:p};
// %t1771 = $SUPPLY @ATTACH &vdd => @PLACE(376, -1172);
// &vdd @WIRE(mode="straight") {#X341:4 %t1771:p};
// %t1772 = $GROUND @ATTACH &vss => @PLACE(376, -1194);
// &vss @WIRE(mode="straight") {#X341:5 %t1772:p};
// %t1773 = $IO_PORT @ATTACH &n614 => @PLACE(406, -1181) => @ORIENT("R0");
// %t1773 @TEXT("n614", key="name", size=0.75);
// &n614 @WIRE(mode="straight") {#X342:1 %t1773:p};
// %t1774 = $IO_PORT @ATTACH &n619 => @PLACE(406, -1185) => @ORIENT("R0");
// %t1774 @TEXT("n619", key="name", size=0.75);
// &n619 @WIRE(mode="straight") {#X342:2 %t1774:p};
// %t1775 = $IO_PORT @ATTACH &n385 => @PLACE(426, -1183) => @ORIENT("MY");
// %t1775 @TEXT("n385", key="name", size=0.75);
// &n385 @WIRE(mode="straight") {#X342:3 %t1775:p};
// %t1776 = $SUPPLY @ATTACH &vdd => @PLACE(416, -1172);
// &vdd @WIRE(mode="straight") {#X342:4 %t1776:p};
// %t1777 = $GROUND @ATTACH &vss => @PLACE(416, -1194);
// &vss @WIRE(mode="straight") {#X342:5 %t1777:p};
// %t1778 = $IO_PORT @ATTACH &n382 => @PLACE(446, -1181) => @ORIENT("R0");
// %t1778 @TEXT("n382", key="name", size=0.75);
// &n382 @WIRE(mode="straight") {#X343:1 %t1778:p};
// %t1779 = $IO_PORT @ATTACH &n383 => @PLACE(446, -1185) => @ORIENT("R0");
// %t1779 @TEXT("n383", key="name", size=0.75);
// &n383 @WIRE(mode="straight") {#X343:2 %t1779:p};
// %t1780 = $IO_PORT @ATTACH &n619 => @PLACE(466, -1183) => @ORIENT("MY");
// %t1780 @TEXT("n619", key="name", size=0.75);
// &n619 @WIRE(mode="straight") {#X343:3 %t1780:p};
// %t1781 = $SUPPLY @ATTACH &vdd => @PLACE(456, -1172);
// &vdd @WIRE(mode="straight") {#X343:4 %t1781:p};
// %t1782 = $GROUND @ATTACH &vss => @PLACE(456, -1194);
// &vss @WIRE(mode="straight") {#X343:5 %t1782:p};
// %t1783 = $IO_PORT @ATTACH &n620 => @PLACE(326, -1212) => @ORIENT("R0");
// %t1783 @TEXT("n620", key="name", size=0.75);
// &n620 @WIRE(mode="straight") {#X344:1 %t1783:p};
// %t1784 = $IO_PORT @ATTACH &n621 => @PLACE(326, -1216) => @ORIENT("R0");
// %t1784 @TEXT("n621", key="name", size=0.75);
// &n621 @WIRE(mode="straight") {#X344:2 %t1784:p};
// %t1785 = $IO_PORT @ATTACH &n222 => @PLACE(346, -1214) => @ORIENT("MY");
// %t1785 @TEXT("n222", key="name", size=0.75);
// &n222 @WIRE(mode="straight") {#X344:3 %t1785:p};
// %t1786 = $SUPPLY @ATTACH &vdd => @PLACE(336, -1203);
// &vdd @WIRE(mode="straight") {#X344:4 %t1786:p};
// %t1787 = $GROUND @ATTACH &vss => @PLACE(336, -1225);
// &vss @WIRE(mode="straight") {#X344:5 %t1787:p};
// %t1788 = $IO_PORT @ATTACH &n622 => @PLACE(366, -1212) => @ORIENT("R0");
// %t1788 @TEXT("n622", key="name", size=0.75);
// &n622 @WIRE(mode="straight") {#X345:1 %t1788:p};
// %t1789 = $IO_PORT @ATTACH &n387 => @PLACE(366, -1216) => @ORIENT("R0");
// %t1789 @TEXT("n387", key="name", size=0.75);
// &n387 @WIRE(mode="straight") {#X345:2 %t1789:p};
// %t1790 = $IO_PORT @ATTACH &n621 => @PLACE(386, -1214) => @ORIENT("MY");
// %t1790 @TEXT("n621", key="name", size=0.75);
// &n621 @WIRE(mode="straight") {#X345:3 %t1790:p};
// %t1791 = $SUPPLY @ATTACH &vdd => @PLACE(376, -1203);
// &vdd @WIRE(mode="straight") {#X345:4 %t1791:p};
// %t1792 = $GROUND @ATTACH &vss => @PLACE(376, -1225);
// &vss @WIRE(mode="straight") {#X345:5 %t1792:p};
// %t1793 = $IO_PORT @ATTACH &n623 => @PLACE(406, -1212) => @ORIENT("R0");
// %t1793 @TEXT("n623", key="name", size=0.75);
// &n623 @WIRE(mode="straight") {#X346:1 %t1793:p};
// %t1794 = $IO_PORT @ATTACH &n624 => @PLACE(406, -1216) => @ORIENT("R0");
// %t1794 @TEXT("n624", key="name", size=0.75);
// &n624 @WIRE(mode="straight") {#X346:2 %t1794:p};
// %t1795 = $IO_PORT @ATTACH &n387 => @PLACE(426, -1214) => @ORIENT("MY");
// %t1795 @TEXT("n387", key="name", size=0.75);
// &n387 @WIRE(mode="straight") {#X346:3 %t1795:p};
// %t1796 = $SUPPLY @ATTACH &vdd => @PLACE(416, -1203);
// &vdd @WIRE(mode="straight") {#X346:4 %t1796:p};
// %t1797 = $GROUND @ATTACH &vss => @PLACE(416, -1225);
// &vss @WIRE(mode="straight") {#X346:5 %t1797:p};
// %t1798 = $IO_PORT @ATTACH &n625 => @PLACE(446, -1212) => @ORIENT("R0");
// %t1798 @TEXT("n625", key="name", size=0.75);
// &n625 @WIRE(mode="straight") {#X347:1 %t1798:p};
// %t1799 = $IO_PORT @ATTACH &n383 => @PLACE(446, -1216) => @ORIENT("R0");
// %t1799 @TEXT("n383", key="name", size=0.75);
// &n383 @WIRE(mode="straight") {#X347:2 %t1799:p};
// %t1800 = $IO_PORT @ATTACH &n624 => @PLACE(466, -1214) => @ORIENT("MY");
// %t1800 @TEXT("n624", key="name", size=0.75);
// &n624 @WIRE(mode="straight") {#X347:3 %t1800:p};
// %t1801 = $SUPPLY @ATTACH &vdd => @PLACE(456, -1203);
// &vdd @WIRE(mode="straight") {#X347:4 %t1801:p};
// %t1802 = $GROUND @ATTACH &vss => @PLACE(456, -1225);
// &vss @WIRE(mode="straight") {#X347:5 %t1802:p};
// %t1803 = $IO_PORT @ATTACH &n388 => @PLACE(326, -1243) => @ORIENT("R0");
// %t1803 @TEXT("n388", key="name", size=0.75);
// &n388 @WIRE(mode="straight") {#X348:1 %t1803:p};
// %t1804 = $IO_PORT @ATTACH &n386 => @PLACE(326, -1247) => @ORIENT("R0");
// %t1804 @TEXT("n386", key="name", size=0.75);
// &n386 @WIRE(mode="straight") {#X348:2 %t1804:p};
// %t1805 = $IO_PORT @ATTACH &n622 => @PLACE(346, -1245) => @ORIENT("MY");
// %t1805 @TEXT("n622", key="name", size=0.75);
// &n622 @WIRE(mode="straight") {#X348:3 %t1805:p};
// %t1806 = $SUPPLY @ATTACH &vdd => @PLACE(336, -1234);
// &vdd @WIRE(mode="straight") {#X348:4 %t1806:p};
// %t1807 = $GROUND @ATTACH &vss => @PLACE(336, -1256);
// &vss @WIRE(mode="straight") {#X348:5 %t1807:p};
// %t1808 = $IO_PORT @ATTACH &n617 => @PLACE(366, -1243) => @ORIENT("R0");
// %t1808 @TEXT("n617", key="name", size=0.75);
// &n617 @WIRE(mode="straight") {#X349:1 %t1808:p};
// %t1809 = $IO_PORT @ATTACH &n626 => @PLACE(366, -1247) => @ORIENT("R0");
// %t1809 @TEXT("n626", key="name", size=0.75);
// &n626 @WIRE(mode="straight") {#X349:2 %t1809:p};
// %t1810 = $IO_PORT @ATTACH &n620 => @PLACE(386, -1245) => @ORIENT("MY");
// %t1810 @TEXT("n620", key="name", size=0.75);
// &n620 @WIRE(mode="straight") {#X349:3 %t1810:p};
// %t1811 = $SUPPLY @ATTACH &vdd => @PLACE(376, -1234);
// &vdd @WIRE(mode="straight") {#X349:4 %t1811:p};
// %t1812 = $GROUND @ATTACH &vss => @PLACE(376, -1256);
// &vss @WIRE(mode="straight") {#X349:5 %t1812:p};
// %t1813 = $IO_PORT @ATTACH &n388 => @PLACE(406, -1243) => @ORIENT("R0");
// %t1813 @TEXT("n388", key="name", size=0.75);
// &n388 @WIRE(mode="straight") {#X350:1 %t1813:p};
// %t1814 = $IO_PORT @ATTACH &n616 => @PLACE(406, -1247) => @ORIENT("R0");
// %t1814 @TEXT("n616", key="name", size=0.75);
// &n616 @WIRE(mode="straight") {#X350:2 %t1814:p};
// %t1815 = $IO_PORT @ATTACH &n626 => @PLACE(426, -1245) => @ORIENT("MY");
// %t1815 @TEXT("n626", key="name", size=0.75);
// &n626 @WIRE(mode="straight") {#X350:3 %t1815:p};
// %t1816 = $SUPPLY @ATTACH &vdd => @PLACE(416, -1234);
// &vdd @WIRE(mode="straight") {#X350:4 %t1816:p};
// %t1817 = $GROUND @ATTACH &vss => @PLACE(416, -1256);
// &vss @WIRE(mode="straight") {#X350:5 %t1817:p};
// %t1818 = $IO_PORT @ATTACH &n384 => @PLACE(446, -1243) => @ORIENT("R0");
// %t1818 @TEXT("n384", key="name", size=0.75);
// &n384 @WIRE(mode="straight") {#X351:1 %t1818:p};
// %t1819 = $IO_PORT @ATTACH &n382 => @PLACE(446, -1247) => @ORIENT("R0");
// %t1819 @TEXT("n382", key="name", size=0.75);
// &n382 @WIRE(mode="straight") {#X351:2 %t1819:p};
// %t1820 = $IO_PORT @ATTACH &n625 => @PLACE(466, -1245) => @ORIENT("MY");
// %t1820 @TEXT("n625", key="name", size=0.75);
// &n625 @WIRE(mode="straight") {#X351:3 %t1820:p};
// %t1821 = $SUPPLY @ATTACH &vdd => @PLACE(456, -1234);
// &vdd @WIRE(mode="straight") {#X351:4 %t1821:p};
// %t1822 = $GROUND @ATTACH &vss => @PLACE(456, -1256);
// &vss @WIRE(mode="straight") {#X351:5 %t1822:p};
// %t1823 = $IO_PORT @ATTACH &n615 => @PLACE(326, -1274) => @ORIENT("R0");
// %t1823 @TEXT("n615", key="name", size=0.75);
// &n615 @WIRE(mode="straight") {#X352:1 %t1823:p};
// %t1824 = $IO_PORT @ATTACH &n627 => @PLACE(326, -1278) => @ORIENT("R0");
// %t1824 @TEXT("n627", key="name", size=0.75);
// &n627 @WIRE(mode="straight") {#X352:2 %t1824:p};
// %t1825 = $IO_PORT @ATTACH &n623 => @PLACE(346, -1276) => @ORIENT("MY");
// %t1825 @TEXT("n623", key="name", size=0.75);
// &n623 @WIRE(mode="straight") {#X352:3 %t1825:p};
// %t1826 = $SUPPLY @ATTACH &vdd => @PLACE(336, -1265);
// &vdd @WIRE(mode="straight") {#X352:4 %t1826:p};
// %t1827 = $GROUND @ATTACH &vss => @PLACE(336, -1287);
// &vss @WIRE(mode="straight") {#X352:5 %t1827:p};
// %t1828 = $IO_PORT @ATTACH &n384 => @PLACE(366, -1274) => @ORIENT("R0");
// %t1828 @TEXT("n384", key="name", size=0.75);
// &n384 @WIRE(mode="straight") {#X353:1 %t1828:p};
// %t1829 = $IO_PORT @ATTACH &n614 => @PLACE(366, -1278) => @ORIENT("R0");
// %t1829 @TEXT("n614", key="name", size=0.75);
// &n614 @WIRE(mode="straight") {#X353:2 %t1829:p};
// %t1830 = $IO_PORT @ATTACH &n627 => @PLACE(386, -1276) => @ORIENT("MY");
// %t1830 @TEXT("n627", key="name", size=0.75);
// &n627 @WIRE(mode="straight") {#X353:3 %t1830:p};
// %t1831 = $SUPPLY @ATTACH &vdd => @PLACE(376, -1265);
// &vdd @WIRE(mode="straight") {#X353:4 %t1831:p};
// %t1832 = $GROUND @ATTACH &vss => @PLACE(376, -1287);
// &vss @WIRE(mode="straight") {#X353:5 %t1832:p};
// %t1833 = $IO_PORT @ATTACH &n386 => @PLACE(406, -1274) => @ORIENT("R0");
// %t1833 @TEXT("n386", key="name", size=0.75);
// &n386 @WIRE(mode="straight") {#X354:1 %t1833:p};
// %t1834 = $IO_PORT @ATTACH &n387 => @PLACE(406, -1278) => @ORIENT("R0");
// %t1834 @TEXT("n387", key="name", size=0.75);
// &n387 @WIRE(mode="straight") {#X354:2 %t1834:p};
// %t1835 = $IO_PORT @ATTACH &n618 => @PLACE(426, -1276) => @ORIENT("MY");
// %t1835 @TEXT("n618", key="name", size=0.75);
// &n618 @WIRE(mode="straight") {#X354:3 %t1835:p};
// %t1836 = $SUPPLY @ATTACH &vdd => @PLACE(416, -1265);
// &vdd @WIRE(mode="straight") {#X354:4 %t1836:p};
// %t1837 = $GROUND @ATTACH &vss => @PLACE(416, -1287);
// &vss @WIRE(mode="straight") {#X354:5 %t1837:p};
// %t1838 = $IO_PORT @ATTACH &n613 => @PLACE(446, -1274) => @ORIENT("R0");
// %t1838 @TEXT("n613", key="name", size=0.75);
// &n613 @WIRE(mode="straight") {#X355:1 %t1838:p};
// %t1839 = $IO_PORT @ATTACH &n628 => @PLACE(446, -1278) => @ORIENT("R0");
// %t1839 @TEXT("n628", key="name", size=0.75);
// &n628 @WIRE(mode="straight") {#X355:2 %t1839:p};
// %t1840 = $IO_PORT @ATTACH &n383 => @PLACE(466, -1276) => @ORIENT("MY");
// %t1840 @TEXT("n383", key="name", size=0.75);
// &n383 @WIRE(mode="straight") {#X355:3 %t1840:p};
// %t1841 = $SUPPLY @ATTACH &vdd => @PLACE(456, -1265);
// &vdd @WIRE(mode="straight") {#X355:4 %t1841:p};
// %t1842 = $GROUND @ATTACH &vss => @PLACE(456, -1287);
// &vss @WIRE(mode="straight") {#X355:5 %t1842:p};
// %t1843 = $IO_PORT @ATTACH &n380 => @PLACE(326, -1305) => @ORIENT("R0");
// %t1843 @TEXT("n380", key="name", size=0.75);
// &n380 @WIRE(mode="straight") {#X356:1 %t1843:p};
// %t1844 = $IO_PORT @ATTACH &n381 => @PLACE(326, -1309) => @ORIENT("R0");
// %t1844 @TEXT("n381", key="name", size=0.75);
// &n381 @WIRE(mode="straight") {#X356:2 %t1844:p};
// %t1845 = $IO_PORT @ATTACH &n628 => @PLACE(346, -1307) => @ORIENT("MY");
// %t1845 @TEXT("n628", key="name", size=0.75);
// &n628 @WIRE(mode="straight") {#X356:3 %t1845:p};
// %t1846 = $SUPPLY @ATTACH &vdd => @PLACE(336, -1296);
// &vdd @WIRE(mode="straight") {#X356:4 %t1846:p};
// %t1847 = $GROUND @ATTACH &vss => @PLACE(336, -1318);
// &vss @WIRE(mode="straight") {#X356:5 %t1847:p};
// %t1848 = $IO_PORT @ATTACH &n218 => @PLACE(366, -1305) => @ORIENT("R0");
// %t1848 @TEXT("n218", key="name", size=0.75);
// &n218 @WIRE(mode="straight") {#X357:1 %t1848:p};
// %t1849 = $IO_PORT @ATTACH &n629 => @PLACE(366, -1309) => @ORIENT("R0");
// %t1849 @TEXT("n629", key="name", size=0.75);
// &n629 @WIRE(mode="straight") {#X357:2 %t1849:p};
// %t1850 = $IO_PORT @ATTACH &n398 => @PLACE(386, -1307) => @ORIENT("MY");
// %t1850 @TEXT("n398", key="name", size=0.75);
// &n398 @WIRE(mode="straight") {#X357:3 %t1850:p};
// %t1851 = $SUPPLY @ATTACH &vdd => @PLACE(376, -1296);
// &vdd @WIRE(mode="straight") {#X357:4 %t1851:p};
// %t1852 = $GROUND @ATTACH &vss => @PLACE(376, -1318);
// &vss @WIRE(mode="straight") {#X357:5 %t1852:p};
// %t1853 = $IO_PORT @ATTACH &n216 => @PLACE(406, -1305) => @ORIENT("R0");
// %t1853 @TEXT("n216", key="name", size=0.75);
// &n216 @WIRE(mode="straight") {#X358:1 %t1853:p};
// %t1854 = $IO_PORT @ATTACH &n630 => @PLACE(406, -1309) => @ORIENT("R0");
// %t1854 @TEXT("n630", key="name", size=0.75);
// &n630 @WIRE(mode="straight") {#X358:2 %t1854:p};
// %t1855 = $IO_PORT @ATTACH &n394 => @PLACE(426, -1307) => @ORIENT("MY");
// %t1855 @TEXT("n394", key="name", size=0.75);
// &n394 @WIRE(mode="straight") {#X358:3 %t1855:p};
// %t1856 = $SUPPLY @ATTACH &vdd => @PLACE(416, -1296);
// &vdd @WIRE(mode="straight") {#X358:4 %t1856:p};
// %t1857 = $GROUND @ATTACH &vss => @PLACE(416, -1318);
// &vss @WIRE(mode="straight") {#X358:5 %t1857:p};
// %t1858 = $IO_PORT @ATTACH &n217 => @PLACE(446, -1305) => @ORIENT("R0");
// %t1858 @TEXT("n217", key="name", size=0.75);
// &n217 @WIRE(mode="straight") {#X359:1 %t1858:p};
// %t1859 = $IO_PORT @ATTACH &n392 => @PLACE(446, -1309) => @ORIENT("R0");
// %t1859 @TEXT("n392", key="name", size=0.75);
// &n392 @WIRE(mode="straight") {#X359:2 %t1859:p};
// %t1860 = $IO_PORT @ATTACH &n630 => @PLACE(466, -1307) => @ORIENT("MY");
// %t1860 @TEXT("n630", key="name", size=0.75);
// &n630 @WIRE(mode="straight") {#X359:3 %t1860:p};
// %t1861 = $SUPPLY @ATTACH &vdd => @PLACE(456, -1296);
// &vdd @WIRE(mode="straight") {#X359:4 %t1861:p};
// %t1862 = $GROUND @ATTACH &vss => @PLACE(456, -1318);
// &vss @WIRE(mode="straight") {#X359:5 %t1862:p};
// %t1863 = $IO_PORT @ATTACH &n631 => @PLACE(494, -1150) => @ORIENT("R0");
// %t1863 @TEXT("n631", key="name", size=0.75);
// &n631 @WIRE(mode="straight") {#X360:1 %t1863:p};
// %t1864 = $IO_PORT @ATTACH &n632 => @PLACE(494, -1154) => @ORIENT("R0");
// %t1864 @TEXT("n632", key="name", size=0.75);
// &n632 @WIRE(mode="straight") {#X360:2 %t1864:p};
// %t1865 = $IO_PORT @ATTACH &n400 => @PLACE(514, -1152) => @ORIENT("MY");
// %t1865 @TEXT("n400", key="name", size=0.75);
// &n400 @WIRE(mode="straight") {#X360:3 %t1865:p};
// %t1866 = $SUPPLY @ATTACH &vdd => @PLACE(504, -1141);
// &vdd @WIRE(mode="straight") {#X360:4 %t1866:p};
// %t1867 = $GROUND @ATTACH &vss => @PLACE(504, -1163);
// &vss @WIRE(mode="straight") {#X360:5 %t1867:p};
// %t1868 = $IO_PORT @ATTACH &n633 => @PLACE(534, -1150) => @ORIENT("R0");
// %t1868 @TEXT("n633", key="name", size=0.75);
// &n633 @WIRE(mode="straight") {#X361:1 %t1868:p};
// %t1869 = $IO_PORT @ATTACH &n396 => @PLACE(534, -1154) => @ORIENT("R0");
// %t1869 @TEXT("n396", key="name", size=0.75);
// &n396 @WIRE(mode="straight") {#X361:2 %t1869:p};
// %t1870 = $IO_PORT @ATTACH &n632 => @PLACE(554, -1152) => @ORIENT("MY");
// %t1870 @TEXT("n632", key="name", size=0.75);
// &n632 @WIRE(mode="straight") {#X361:3 %t1870:p};
// %t1871 = $SUPPLY @ATTACH &vdd => @PLACE(544, -1141);
// &vdd @WIRE(mode="straight") {#X361:4 %t1871:p};
// %t1872 = $GROUND @ATTACH &vss => @PLACE(544, -1163);
// &vss @WIRE(mode="straight") {#X361:5 %t1872:p};
// %t1873 = $IO_PORT @ATTACH &n634 => @PLACE(574, -1150) => @ORIENT("R0");
// %t1873 @TEXT("n634", key="name", size=0.75);
// &n634 @WIRE(mode="straight") {#X362:1 %t1873:p};
// %t1874 = $IO_PORT @ATTACH &n635 => @PLACE(574, -1154) => @ORIENT("R0");
// %t1874 @TEXT("n635", key="name", size=0.75);
// &n635 @WIRE(mode="straight") {#X362:2 %t1874:p};
// %t1875 = $IO_PORT @ATTACH &n396 => @PLACE(594, -1152) => @ORIENT("MY");
// %t1875 @TEXT("n396", key="name", size=0.75);
// &n396 @WIRE(mode="straight") {#X362:3 %t1875:p};
// %t1876 = $SUPPLY @ATTACH &vdd => @PLACE(584, -1141);
// &vdd @WIRE(mode="straight") {#X362:4 %t1876:p};
// %t1877 = $GROUND @ATTACH &vss => @PLACE(584, -1163);
// &vss @WIRE(mode="straight") {#X362:5 %t1877:p};
// %t1878 = $IO_PORT @ATTACH &n636 => @PLACE(614, -1150) => @ORIENT("R0");
// %t1878 @TEXT("n636", key="name", size=0.75);
// &n636 @WIRE(mode="straight") {#X363:1 %t1878:p};
// %t1879 = $IO_PORT @ATTACH &n392 => @PLACE(614, -1154) => @ORIENT("R0");
// %t1879 @TEXT("n392", key="name", size=0.75);
// &n392 @WIRE(mode="straight") {#X363:2 %t1879:p};
// %t1880 = $IO_PORT @ATTACH &n635 => @PLACE(635, -1152) => @ORIENT("MY");
// %t1880 @TEXT("n635", key="name", size=0.75);
// &n635 @WIRE(mode="straight") {#X363:3 %t1880:p};
// %t1881 = $SUPPLY @ATTACH &vdd => @PLACE(624, -1141);
// &vdd @WIRE(mode="straight") {#X363:4 %t1881:p};
// %t1882 = $GROUND @ATTACH &vss => @PLACE(624, -1163);
// &vss @WIRE(mode="straight") {#X363:5 %t1882:p};
// %t1883 = $IO_PORT @ATTACH &n221 => @PLACE(494, -1181) => @ORIENT("R0");
// %t1883 @TEXT("n221", key="name", size=0.75);
// &n221 @WIRE(mode="straight") {#X364:1 %t1883:p};
// %t1884 = $IO_PORT @ATTACH &n219 => @PLACE(494, -1185) => @ORIENT("R0");
// %t1884 @TEXT("n219", key="name", size=0.75);
// &n219 @WIRE(mode="straight") {#X364:2 %t1884:p};
// %t1885 = $IO_PORT @ATTACH &n633 => @PLACE(514, -1183) => @ORIENT("MY");
// %t1885 @TEXT("n633", key="name", size=0.75);
// &n633 @WIRE(mode="straight") {#X364:3 %t1885:p};
// %t1886 = $SUPPLY @ATTACH &vdd => @PLACE(504, -1172);
// &vdd @WIRE(mode="straight") {#X364:4 %t1886:p};
// %t1887 = $GROUND @ATTACH &vss => @PLACE(504, -1194);
// &vss @WIRE(mode="straight") {#X364:5 %t1887:p};
// %t1888 = $IO_PORT @ATTACH &n220 => @PLACE(534, -1181) => @ORIENT("R0");
// %t1888 @TEXT("n220", key="name", size=0.75);
// &n220 @WIRE(mode="straight") {#X365:1 %t1888:p};
// %t1889 = $IO_PORT @ATTACH &n637 => @PLACE(534, -1185) => @ORIENT("R0");
// %t1889 @TEXT("n637", key="name", size=0.75);
// &n637 @WIRE(mode="straight") {#X365:2 %t1889:p};
// %t1890 = $IO_PORT @ATTACH &n631 => @PLACE(554, -1183) => @ORIENT("MY");
// %t1890 @TEXT("n631", key="name", size=0.75);
// &n631 @WIRE(mode="straight") {#X365:3 %t1890:p};
// %t1891 = $SUPPLY @ATTACH &vdd => @PLACE(544, -1172);
// &vdd @WIRE(mode="straight") {#X365:4 %t1891:p};
// %t1892 = $GROUND @ATTACH &vss => @PLACE(544, -1194);
// &vss @WIRE(mode="straight") {#X365:5 %t1892:p};
// %t1893 = $IO_PORT @ATTACH &n221 => @PLACE(574, -1181) => @ORIENT("R0");
// %t1893 @TEXT("n221", key="name", size=0.75);
// &n221 @WIRE(mode="straight") {#X366:1 %t1893:p};
// %t1894 = $IO_PORT @ATTACH &n218 => @PLACE(574, -1185) => @ORIENT("R0");
// %t1894 @TEXT("n218", key="name", size=0.75);
// &n218 @WIRE(mode="straight") {#X366:2 %t1894:p};
// %t1895 = $IO_PORT @ATTACH &n637 => @PLACE(594, -1183) => @ORIENT("MY");
// %t1895 @TEXT("n637", key="name", size=0.75);
// &n637 @WIRE(mode="straight") {#X366:3 %t1895:p};
// %t1896 = $SUPPLY @ATTACH &vdd => @PLACE(584, -1172);
// &vdd @WIRE(mode="straight") {#X366:4 %t1896:p};
// %t1897 = $GROUND @ATTACH &vss => @PLACE(584, -1194);
// &vss @WIRE(mode="straight") {#X366:5 %t1897:p};
// %t1898 = $IO_PORT @ATTACH &n215 => @PLACE(614, -1181) => @ORIENT("R0");
// %t1898 @TEXT("n215", key="name", size=0.75);
// &n215 @WIRE(mode="straight") {#X367:1 %t1898:p};
// %t1899 = $IO_PORT @ATTACH &n217 => @PLACE(614, -1185) => @ORIENT("R0");
// %t1899 @TEXT("n217", key="name", size=0.75);
// &n217 @WIRE(mode="straight") {#X367:2 %t1899:p};
// %t1900 = $IO_PORT @ATTACH &n636 => @PLACE(635, -1183) => @ORIENT("MY");
// %t1900 @TEXT("n636", key="name", size=0.75);
// &n636 @WIRE(mode="straight") {#X367:3 %t1900:p};
// %t1901 = $SUPPLY @ATTACH &vdd => @PLACE(624, -1172);
// &vdd @WIRE(mode="straight") {#X367:4 %t1901:p};
// %t1902 = $GROUND @ATTACH &vss => @PLACE(624, -1194);
// &vss @WIRE(mode="straight") {#X367:5 %t1902:p};
// %t1903 = $IO_PORT @ATTACH &n214 => @PLACE(494, -1212) => @ORIENT("R0");
// %t1903 @TEXT("n214", key="name", size=0.75);
// &n214 @WIRE(mode="straight") {#X368:1 %t1903:p};
// %t1904 = $IO_PORT @ATTACH &n638 => @PLACE(494, -1216) => @ORIENT("R0");
// %t1904 @TEXT("n638", key="name", size=0.75);
// &n638 @WIRE(mode="straight") {#X368:2 %t1904:p};
// %t1905 = $IO_PORT @ATTACH &n634 => @PLACE(514, -1214) => @ORIENT("MY");
// %t1905 @TEXT("n634", key="name", size=0.75);
// &n634 @WIRE(mode="straight") {#X368:3 %t1905:p};
// %t1906 = $SUPPLY @ATTACH &vdd => @PLACE(504, -1203);
// &vdd @WIRE(mode="straight") {#X368:4 %t1906:p};
// %t1907 = $GROUND @ATTACH &vss => @PLACE(504, -1225);
// &vss @WIRE(mode="straight") {#X368:5 %t1907:p};
// %t1908 = $IO_PORT @ATTACH &n215 => @PLACE(534, -1212) => @ORIENT("R0");
// %t1908 @TEXT("n215", key="name", size=0.75);
// &n215 @WIRE(mode="straight") {#X369:1 %t1908:p};
// %t1909 = $IO_PORT @ATTACH &n216 => @PLACE(534, -1216) => @ORIENT("R0");
// %t1909 @TEXT("n216", key="name", size=0.75);
// &n216 @WIRE(mode="straight") {#X369:2 %t1909:p};
// %t1910 = $IO_PORT @ATTACH &n638 => @PLACE(554, -1214) => @ORIENT("MY");
// %t1910 @TEXT("n638", key="name", size=0.75);
// &n638 @WIRE(mode="straight") {#X369:3 %t1910:p};
// %t1911 = $SUPPLY @ATTACH &vdd => @PLACE(544, -1203);
// &vdd @WIRE(mode="straight") {#X369:4 %t1911:p};
// %t1912 = $GROUND @ATTACH &vss => @PLACE(544, -1225);
// &vss @WIRE(mode="straight") {#X369:5 %t1912:p};
// %t1913 = $IO_PORT @ATTACH &n219 => @PLACE(574, -1212) => @ORIENT("R0");
// %t1913 @TEXT("n219", key="name", size=0.75);
// &n219 @WIRE(mode="straight") {#X370:1 %t1913:p};
// %t1914 = $IO_PORT @ATTACH &n396 => @PLACE(574, -1216) => @ORIENT("R0");
// %t1914 @TEXT("n396", key="name", size=0.75);
// &n396 @WIRE(mode="straight") {#X370:2 %t1914:p};
// %t1915 = $IO_PORT @ATTACH &n629 => @PLACE(594, -1214) => @ORIENT("MY");
// %t1915 @TEXT("n629", key="name", size=0.75);
// &n629 @WIRE(mode="straight") {#X370:3 %t1915:p};
// %t1916 = $SUPPLY @ATTACH &vdd => @PLACE(584, -1203);
// &vdd @WIRE(mode="straight") {#X370:4 %t1916:p};
// %t1917 = $GROUND @ATTACH &vss => @PLACE(584, -1225);
// &vss @WIRE(mode="straight") {#X370:5 %t1917:p};
// %t1918 = $IO_PORT @ATTACH &n212 => @PLACE(614, -1212) => @ORIENT("R0");
// %t1918 @TEXT("n212", key="name", size=0.75);
// &n212 @WIRE(mode="straight") {#X371:1 %t1918:p};
// %t1919 = $IO_PORT @ATTACH &n639 => @PLACE(614, -1216) => @ORIENT("R0");
// %t1919 @TEXT("n639", key="name", size=0.75);
// &n639 @WIRE(mode="straight") {#X371:2 %t1919:p};
// %t1920 = $IO_PORT @ATTACH &n392 => @PLACE(635, -1214) => @ORIENT("MY");
// %t1920 @TEXT("n392", key="name", size=0.75);
// &n392 @WIRE(mode="straight") {#X371:3 %t1920:p};
// %t1921 = $SUPPLY @ATTACH &vdd => @PLACE(624, -1203);
// &vdd @WIRE(mode="straight") {#X371:4 %t1921:p};
// %t1922 = $GROUND @ATTACH &vss => @PLACE(624, -1225);
// &vss @WIRE(mode="straight") {#X371:5 %t1922:p};
// %t1923 = $IO_PORT @ATTACH &n213 => @PLACE(494, -1243) => @ORIENT("R0");
// %t1923 @TEXT("n213", key="name", size=0.75);
// &n213 @WIRE(mode="straight") {#X372:1 %t1923:p};
// %t1924 = $IO_PORT @ATTACH &n390 => @PLACE(494, -1247) => @ORIENT("R0");
// %t1924 @TEXT("n390", key="name", size=0.75);
// &n390 @WIRE(mode="straight") {#X372:2 %t1924:p};
// %t1925 = $IO_PORT @ATTACH &n639 => @PLACE(514, -1245) => @ORIENT("MY");
// %t1925 @TEXT("n639", key="name", size=0.75);
// &n639 @WIRE(mode="straight") {#X372:3 %t1925:p};
// %t1926 = $SUPPLY @ATTACH &vdd => @PLACE(504, -1234);
// &vdd @WIRE(mode="straight") {#X372:4 %t1926:p};
// %t1927 = $GROUND @ATTACH &vss => @PLACE(504, -1256);
// &vss @WIRE(mode="straight") {#X372:5 %t1927:p};
// %t1928 = $IO_PORT @ATTACH &n640 => @PLACE(534, -1243) => @ORIENT("R0");
// %t1928 @TEXT("n640", key="name", size=0.75);
// &n640 @WIRE(mode="straight") {#X373:1 %t1928:p};
// %t1929 = $IO_PORT @ATTACH &n641 => @PLACE(534, -1247) => @ORIENT("R0");
// %t1929 @TEXT("n641", key="name", size=0.75);
// &n641 @WIRE(mode="straight") {#X373:2 %t1929:p};
// %t1930 = $IO_PORT @ATTACH &n642 => @PLACE(554, -1245) => @ORIENT("MY");
// %t1930 @TEXT("n642", key="name", size=0.75);
// &n642 @WIRE(mode="straight") {#X373:3 %t1930:p};
// %t1931 = $SUPPLY @ATTACH &vdd => @PLACE(544, -1234);
// &vdd @WIRE(mode="straight") {#X373:4 %t1931:p};
// %t1932 = $GROUND @ATTACH &vss => @PLACE(544, -1256);
// &vss @WIRE(mode="straight") {#X373:5 %t1932:p};
// %t1933 = $IO_PORT @ATTACH &n643 => @PLACE(574, -1243) => @ORIENT("R0");
// %t1933 @TEXT("n643", key="name", size=0.75);
// &n643 @WIRE(mode="straight") {#X374:1 %t1933:p};
// %t1934 = $IO_PORT @ATTACH &n644 => @PLACE(574, -1247) => @ORIENT("R0");
// %t1934 @TEXT("n644", key="name", size=0.75);
// &n644 @WIRE(mode="straight") {#X374:2 %t1934:p};
// %t1935 = $IO_PORT @ATTACH &n645 => @PLACE(594, -1245) => @ORIENT("MY");
// %t1935 @TEXT("n645", key="name", size=0.75);
// &n645 @WIRE(mode="straight") {#X374:3 %t1935:p};
// %t1936 = $SUPPLY @ATTACH &vdd => @PLACE(584, -1234);
// &vdd @WIRE(mode="straight") {#X374:4 %t1936:p};
// %t1937 = $GROUND @ATTACH &vss => @PLACE(584, -1256);
// &vss @WIRE(mode="straight") {#X374:5 %t1937:p};
// %t1938 = $IO_PORT @ATTACH &n646 => @PLACE(614, -1243) => @ORIENT("R0");
// %t1938 @TEXT("n646", key="name", size=0.75);
// &n646 @WIRE(mode="straight") {#X375:1 %t1938:p};
// %t1939 = $IO_PORT @ATTACH &n647 => @PLACE(614, -1247) => @ORIENT("R0");
// %t1939 @TEXT("n647", key="name", size=0.75);
// &n647 @WIRE(mode="straight") {#X375:2 %t1939:p};
// %t1940 = $IO_PORT @ATTACH &n648 => @PLACE(635, -1245) => @ORIENT("MY");
// %t1940 @TEXT("n648", key="name", size=0.75);
// &n648 @WIRE(mode="straight") {#X375:3 %t1940:p};
// %t1941 = $SUPPLY @ATTACH &vdd => @PLACE(624, -1234);
// &vdd @WIRE(mode="straight") {#X375:4 %t1941:p};
// %t1942 = $GROUND @ATTACH &vss => @PLACE(624, -1256);
// &vss @WIRE(mode="straight") {#X375:5 %t1942:p};
// %t1943 = $IO_PORT @ATTACH &n649 => @PLACE(494, -1274) => @ORIENT("R0");
// %t1943 @TEXT("n649", key="name", size=0.75);
// &n649 @WIRE(mode="straight") {#X376:1 %t1943:p};
// %t1944 = $IO_PORT @ATTACH &n650 => @PLACE(494, -1278) => @ORIENT("R0");
// %t1944 @TEXT("n650", key="name", size=0.75);
// &n650 @WIRE(mode="straight") {#X376:2 %t1944:p};
// %t1945 = $IO_PORT @ATTACH &n651 => @PLACE(514, -1276) => @ORIENT("MY");
// %t1945 @TEXT("n651", key="name", size=0.75);
// &n651 @WIRE(mode="straight") {#X376:3 %t1945:p};
// %t1946 = $SUPPLY @ATTACH &vdd => @PLACE(504, -1265);
// &vdd @WIRE(mode="straight") {#X376:4 %t1946:p};
// %t1947 = $GROUND @ATTACH &vss => @PLACE(504, -1287);
// &vss @WIRE(mode="straight") {#X376:5 %t1947:p};
// %t1948 = $IO_PORT @ATTACH &n652 => @PLACE(534, -1274) => @ORIENT("R0");
// %t1948 @TEXT("n652", key="name", size=0.75);
// &n652 @WIRE(mode="straight") {#X377:1 %t1948:p};
// %t1949 = $IO_PORT @ATTACH &n653 => @PLACE(534, -1278) => @ORIENT("R0");
// %t1949 @TEXT("n653", key="name", size=0.75);
// &n653 @WIRE(mode="straight") {#X377:2 %t1949:p};
// %t1950 = $IO_PORT @ATTACH &n654 => @PLACE(554, -1276) => @ORIENT("MY");
// %t1950 @TEXT("n654", key="name", size=0.75);
// &n654 @WIRE(mode="straight") {#X377:3 %t1950:p};
// %t1951 = $SUPPLY @ATTACH &vdd => @PLACE(544, -1265);
// &vdd @WIRE(mode="straight") {#X377:4 %t1951:p};
// %t1952 = $GROUND @ATTACH &vss => @PLACE(544, -1287);
// &vss @WIRE(mode="straight") {#X377:5 %t1952:p};
// %t1953 = $IO_PORT @ATTACH &n655 => @PLACE(574, -1274) => @ORIENT("R0");
// %t1953 @TEXT("n655", key="name", size=0.75);
// &n655 @WIRE(mode="straight") {#X378:1 %t1953:p};
// %t1954 = $IO_PORT @ATTACH &n656 => @PLACE(574, -1278) => @ORIENT("R0");
// %t1954 @TEXT("n656", key="name", size=0.75);
// &n656 @WIRE(mode="straight") {#X378:2 %t1954:p};
// %t1955 = $IO_PORT @ATTACH &n657 => @PLACE(594, -1276) => @ORIENT("MY");
// %t1955 @TEXT("n657", key="name", size=0.75);
// &n657 @WIRE(mode="straight") {#X378:3 %t1955:p};
// %t1956 = $SUPPLY @ATTACH &vdd => @PLACE(584, -1265);
// &vdd @WIRE(mode="straight") {#X378:4 %t1956:p};
// %t1957 = $GROUND @ATTACH &vss => @PLACE(584, -1287);
// &vss @WIRE(mode="straight") {#X378:5 %t1957:p};
// %t1958 = $IO_PORT @ATTACH &n658 => @PLACE(614, -1274) => @ORIENT("R0");
// %t1958 @TEXT("n658", key="name", size=0.75);
// &n658 @WIRE(mode="straight") {#X379:1 %t1958:p};
// %t1959 = $IO_PORT @ATTACH &n659 => @PLACE(614, -1278) => @ORIENT("R0");
// %t1959 @TEXT("n659", key="name", size=0.75);
// &n659 @WIRE(mode="straight") {#X379:2 %t1959:p};
// %t1960 = $IO_PORT @ATTACH &n660 => @PLACE(635, -1276) => @ORIENT("MY");
// %t1960 @TEXT("n660", key="name", size=0.75);
// &n660 @WIRE(mode="straight") {#X379:3 %t1960:p};
// %t1961 = $SUPPLY @ATTACH &vdd => @PLACE(624, -1265);
// &vdd @WIRE(mode="straight") {#X379:4 %t1961:p};
// %t1962 = $GROUND @ATTACH &vss => @PLACE(624, -1287);
// &vss @WIRE(mode="straight") {#X379:5 %t1962:p};
// %t1963 = $IO_PORT @ATTACH &n661 => @PLACE(494, -1305) => @ORIENT("R0");
// %t1963 @TEXT("n661", key="name", size=0.75);
// &n661 @WIRE(mode="straight") {#X380:1 %t1963:p};
// %t1964 = $IO_PORT @ATTACH &n662 => @PLACE(494, -1309) => @ORIENT("R0");
// %t1964 @TEXT("n662", key="name", size=0.75);
// &n662 @WIRE(mode="straight") {#X380:2 %t1964:p};
// %t1965 = $IO_PORT @ATTACH &n663 => @PLACE(514, -1307) => @ORIENT("MY");
// %t1965 @TEXT("n663", key="name", size=0.75);
// &n663 @WIRE(mode="straight") {#X380:3 %t1965:p};
// %t1966 = $SUPPLY @ATTACH &vdd => @PLACE(504, -1296);
// &vdd @WIRE(mode="straight") {#X380:4 %t1966:p};
// %t1967 = $GROUND @ATTACH &vss => @PLACE(504, -1318);
// &vss @WIRE(mode="straight") {#X380:5 %t1967:p};
// %t1968 = $IO_PORT @ATTACH &n664 => @PLACE(534, -1305) => @ORIENT("R0");
// %t1968 @TEXT("n664", key="name", size=0.75);
// &n664 @WIRE(mode="straight") {#X381:1 %t1968:p};
// %t1969 = $IO_PORT @ATTACH &n665 => @PLACE(534, -1309) => @ORIENT("R0");
// %t1969 @TEXT("n665", key="name", size=0.75);
// &n665 @WIRE(mode="straight") {#X381:2 %t1969:p};
// %t1970 = $IO_PORT @ATTACH &n666 => @PLACE(554, -1307) => @ORIENT("MY");
// %t1970 @TEXT("n666", key="name", size=0.75);
// &n666 @WIRE(mode="straight") {#X381:3 %t1970:p};
// %t1971 = $SUPPLY @ATTACH &vdd => @PLACE(544, -1296);
// &vdd @WIRE(mode="straight") {#X381:4 %t1971:p};
// %t1972 = $GROUND @ATTACH &vss => @PLACE(544, -1318);
// &vss @WIRE(mode="straight") {#X381:5 %t1972:p};
// %t1973 = $IO_PORT @ATTACH &n640 => @PLACE(574, -1305) => @ORIENT("R0");
// %t1973 @TEXT("n640", key="name", size=0.75);
// &n640 @WIRE(mode="straight") {#X382:1 %t1973:p};
// %t1974 = $IO_PORT @ATTACH &n641 => @PLACE(574, -1309) => @ORIENT("R0");
// %t1974 @TEXT("n641", key="name", size=0.75);
// &n641 @WIRE(mode="straight") {#X382:2 %t1974:p};
// %t1975 = $IO_PORT @ATTACH &n409 => @PLACE(594, -1307) => @ORIENT("MY");
// %t1975 @TEXT("n409", key="name", size=0.75);
// &n409 @WIRE(mode="straight") {#X382:3 %t1975:p};
// %t1976 = $SUPPLY @ATTACH &vdd => @PLACE(584, -1296);
// &vdd @WIRE(mode="straight") {#X382:4 %t1976:p};
// %t1977 = $GROUND @ATTACH &vss => @PLACE(584, -1318);
// &vss @WIRE(mode="straight") {#X382:5 %t1977:p};
// %t1978 = $IO_PORT @ATTACH &n643 => @PLACE(614, -1305) => @ORIENT("R0");
// %t1978 @TEXT("n643", key="name", size=0.75);
// &n643 @WIRE(mode="straight") {#X383:1 %t1978:p};
// %t1979 = $IO_PORT @ATTACH &n644 => @PLACE(614, -1309) => @ORIENT("R0");
// %t1979 @TEXT("n644", key="name", size=0.75);
// &n644 @WIRE(mode="straight") {#X383:2 %t1979:p};
// %t1980 = $IO_PORT @ATTACH &n412 => @PLACE(635, -1307) => @ORIENT("MY");
// %t1980 @TEXT("n412", key="name", size=0.75);
// &n412 @WIRE(mode="straight") {#X383:3 %t1980:p};
// %t1981 = $SUPPLY @ATTACH &vdd => @PLACE(624, -1296);
// &vdd @WIRE(mode="straight") {#X383:4 %t1981:p};
// %t1982 = $GROUND @ATTACH &vss => @PLACE(624, -1318);
// &vss @WIRE(mode="straight") {#X383:5 %t1982:p};
// %t1983 = $IO_PORT @ATTACH &n646 => @PLACE(-11, -1348) => @ORIENT("R0");
// %t1983 @TEXT("n646", key="name", size=0.75);
// &n646 @WIRE(mode="straight") {#X384:1 %t1983:p};
// %t1984 = $IO_PORT @ATTACH &n647 => @PLACE(-11, -1352) => @ORIENT("R0");
// %t1984 @TEXT("n647", key="name", size=0.75);
// &n647 @WIRE(mode="straight") {#X384:2 %t1984:p};
// %t1985 = $IO_PORT @ATTACH &n415 => @PLACE(10, -1350) => @ORIENT("MY");
// %t1985 @TEXT("n415", key="name", size=0.75);
// &n415 @WIRE(mode="straight") {#X384:3 %t1985:p};
// %t1986 = $SUPPLY @ATTACH &vdd => @PLACE(0, -1339);
// &vdd @WIRE(mode="straight") {#X384:4 %t1986:p};
// %t1987 = $GROUND @ATTACH &vss => @PLACE(0, -1361);
// &vss @WIRE(mode="straight") {#X384:5 %t1987:p};
// %t1988 = $IO_PORT @ATTACH &n649 => @PLACE(30, -1348) => @ORIENT("R0");
// %t1988 @TEXT("n649", key="name", size=0.75);
// &n649 @WIRE(mode="straight") {#X385:1 %t1988:p};
// %t1989 = $IO_PORT @ATTACH &n650 => @PLACE(30, -1352) => @ORIENT("R0");
// %t1989 @TEXT("n650", key="name", size=0.75);
// &n650 @WIRE(mode="straight") {#X385:2 %t1989:p};
// %t1990 = $IO_PORT @ATTACH &n418 => @PLACE(50, -1350) => @ORIENT("MY");
// %t1990 @TEXT("n418", key="name", size=0.75);
// &n418 @WIRE(mode="straight") {#X385:3 %t1990:p};
// %t1991 = $SUPPLY @ATTACH &vdd => @PLACE(40, -1339);
// &vdd @WIRE(mode="straight") {#X385:4 %t1991:p};
// %t1992 = $GROUND @ATTACH &vss => @PLACE(40, -1361);
// &vss @WIRE(mode="straight") {#X385:5 %t1992:p};
// %t1993 = $IO_PORT @ATTACH &n652 => @PLACE(70, -1348) => @ORIENT("R0");
// %t1993 @TEXT("n652", key="name", size=0.75);
// &n652 @WIRE(mode="straight") {#X386:1 %t1993:p};
// %t1994 = $IO_PORT @ATTACH &n653 => @PLACE(70, -1352) => @ORIENT("R0");
// %t1994 @TEXT("n653", key="name", size=0.75);
// &n653 @WIRE(mode="straight") {#X386:2 %t1994:p};
// %t1995 = $IO_PORT @ATTACH &n421 => @PLACE(90, -1350) => @ORIENT("MY");
// %t1995 @TEXT("n421", key="name", size=0.75);
// &n421 @WIRE(mode="straight") {#X386:3 %t1995:p};
// %t1996 = $SUPPLY @ATTACH &vdd => @PLACE(80, -1339);
// &vdd @WIRE(mode="straight") {#X386:4 %t1996:p};
// %t1997 = $GROUND @ATTACH &vss => @PLACE(80, -1361);
// &vss @WIRE(mode="straight") {#X386:5 %t1997:p};
// %t1998 = $IO_PORT @ATTACH &n655 => @PLACE(110, -1348) => @ORIENT("R0");
// %t1998 @TEXT("n655", key="name", size=0.75);
// &n655 @WIRE(mode="straight") {#X387:1 %t1998:p};
// %t1999 = $IO_PORT @ATTACH &n656 => @PLACE(110, -1352) => @ORIENT("R0");
// %t1999 @TEXT("n656", key="name", size=0.75);
// &n656 @WIRE(mode="straight") {#X387:2 %t1999:p};
// %t2000 = $IO_PORT @ATTACH &n424 => @PLACE(130, -1350) => @ORIENT("MY");
// %t2000 @TEXT("n424", key="name", size=0.75);
// &n424 @WIRE(mode="straight") {#X387:3 %t2000:p};
// %t2001 = $SUPPLY @ATTACH &vdd => @PLACE(120, -1339);
// &vdd @WIRE(mode="straight") {#X387:4 %t2001:p};
// %t2002 = $GROUND @ATTACH &vss => @PLACE(120, -1361);
// &vss @WIRE(mode="straight") {#X387:5 %t2002:p};
// %t2003 = $IO_PORT @ATTACH &n658 => @PLACE(-11, -1379) => @ORIENT("R0");
// %t2003 @TEXT("n658", key="name", size=0.75);
// &n658 @WIRE(mode="straight") {#X388:1 %t2003:p};
// %t2004 = $IO_PORT @ATTACH &n659 => @PLACE(-11, -1383) => @ORIENT("R0");
// %t2004 @TEXT("n659", key="name", size=0.75);
// &n659 @WIRE(mode="straight") {#X388:2 %t2004:p};
// %t2005 = $IO_PORT @ATTACH &n427 => @PLACE(10, -1381) => @ORIENT("MY");
// %t2005 @TEXT("n427", key="name", size=0.75);
// &n427 @WIRE(mode="straight") {#X388:3 %t2005:p};
// %t2006 = $SUPPLY @ATTACH &vdd => @PLACE(0, -1370);
// &vdd @WIRE(mode="straight") {#X388:4 %t2006:p};
// %t2007 = $GROUND @ATTACH &vss => @PLACE(0, -1392);
// &vss @WIRE(mode="straight") {#X388:5 %t2007:p};
// %t2008 = $IO_PORT @ATTACH &n661 => @PLACE(30, -1379) => @ORIENT("R0");
// %t2008 @TEXT("n661", key="name", size=0.75);
// &n661 @WIRE(mode="straight") {#X389:1 %t2008:p};
// %t2009 = $IO_PORT @ATTACH &n662 => @PLACE(30, -1383) => @ORIENT("R0");
// %t2009 @TEXT("n662", key="name", size=0.75);
// &n662 @WIRE(mode="straight") {#X389:2 %t2009:p};
// %t2010 = $IO_PORT @ATTACH &n430 => @PLACE(50, -1381) => @ORIENT("MY");
// %t2010 @TEXT("n430", key="name", size=0.75);
// &n430 @WIRE(mode="straight") {#X389:3 %t2010:p};
// %t2011 = $SUPPLY @ATTACH &vdd => @PLACE(40, -1370);
// &vdd @WIRE(mode="straight") {#X389:4 %t2011:p};
// %t2012 = $GROUND @ATTACH &vss => @PLACE(40, -1392);
// &vss @WIRE(mode="straight") {#X389:5 %t2012:p};
// %t2013 = $IO_PORT @ATTACH &n664 => @PLACE(70, -1379) => @ORIENT("R0");
// %t2013 @TEXT("n664", key="name", size=0.75);
// &n664 @WIRE(mode="straight") {#X390:1 %t2013:p};
// %t2014 = $IO_PORT @ATTACH &n665 => @PLACE(70, -1383) => @ORIENT("R0");
// %t2014 @TEXT("n665", key="name", size=0.75);
// &n665 @WIRE(mode="straight") {#X390:2 %t2014:p};
// %t2015 = $IO_PORT @ATTACH &n433 => @PLACE(90, -1381) => @ORIENT("MY");
// %t2015 @TEXT("n433", key="name", size=0.75);
// &n433 @WIRE(mode="straight") {#X390:3 %t2015:p};
// %t2016 = $SUPPLY @ATTACH &vdd => @PLACE(80, -1370);
// &vdd @WIRE(mode="straight") {#X390:4 %t2016:p};
// %t2017 = $GROUND @ATTACH &vss => @PLACE(80, -1392);
// &vss @WIRE(mode="straight") {#X390:5 %t2017:p};
// %t2018 = $IO_PORT @ATTACH &n667 => @PLACE(110, -1379) => @ORIENT("R0");
// %t2018 @TEXT("n667", key="name", size=0.75);
// &n667 @WIRE(mode="straight") {#X391:1 %t2018:p};
// %t2019 = $IO_PORT @ATTACH &n668 => @PLACE(110, -1383) => @ORIENT("R0");
// %t2019 @TEXT("n668", key="name", size=0.75);
// &n668 @WIRE(mode="straight") {#X391:2 %t2019:p};
// %t2020 = $IO_PORT @ATTACH &n436 => @PLACE(130, -1381) => @ORIENT("MY");
// %t2020 @TEXT("n436", key="name", size=0.75);
// &n436 @WIRE(mode="straight") {#X391:3 %t2020:p};
// %t2021 = $SUPPLY @ATTACH &vdd => @PLACE(120, -1370);
// &vdd @WIRE(mode="straight") {#X391:4 %t2021:p};
// %t2022 = $GROUND @ATTACH &vss => @PLACE(120, -1392);
// &vss @WIRE(mode="straight") {#X391:5 %t2022:p};
// %t2023 = $IO_PORT @ATTACH &n642 => @PLACE(-11, -1410) => @ORIENT("R0");
// %t2023 @TEXT("n642", key="name", size=0.75);
// &n642 @WIRE(mode="straight") {#X392:1 %t2023:p};
// %t2024 = $IO_PORT @ATTACH &n669 => @PLACE(-11, -1414) => @ORIENT("R0");
// %t2024 @TEXT("n669", key="name", size=0.75);
// &n669 @WIRE(mode="straight") {#X392:2 %t2024:p};
// %t2025 = $IO_PORT @ATTACH &n413 => @PLACE(10, -1412) => @ORIENT("MY");
// %t2025 @TEXT("n413", key="name", size=0.75);
// &n413 @WIRE(mode="straight") {#X392:3 %t2025:p};
// %t2026 = $SUPPLY @ATTACH &vdd => @PLACE(0, -1401);
// &vdd @WIRE(mode="straight") {#X392:4 %t2026:p};
// %t2027 = $GROUND @ATTACH &vss => @PLACE(0, -1423);
// &vss @WIRE(mode="straight") {#X392:5 %t2027:p};
// %t2028 = $IO_PORT @ATTACH &n409 => @PLACE(30, -1410) => @ORIENT("R0");
// %t2028 @TEXT("n409", key="name", size=0.75);
// &n409 @WIRE(mode="straight") {#X393:1 %t2028:p};
// %t2029 = $IO_PORT @ATTACH &n410 => @PLACE(30, -1414) => @ORIENT("R0");
// %t2029 @TEXT("n410", key="name", size=0.75);
// &n410 @WIRE(mode="straight") {#X393:2 %t2029:p};
// %t2030 = $IO_PORT @ATTACH &n669 => @PLACE(50, -1412) => @ORIENT("MY");
// %t2030 @TEXT("n669", key="name", size=0.75);
// &n669 @WIRE(mode="straight") {#X393:3 %t2030:p};
// %t2031 = $SUPPLY @ATTACH &vdd => @PLACE(40, -1401);
// &vdd @WIRE(mode="straight") {#X393:4 %t2031:p};
// %t2032 = $GROUND @ATTACH &vss => @PLACE(40, -1423);
// &vss @WIRE(mode="straight") {#X393:5 %t2032:p};
// %t2033 = $IO_PORT @ATTACH &n654 => @PLACE(70, -1410) => @ORIENT("R0");
// %t2033 @TEXT("n654", key="name", size=0.75);
// &n654 @WIRE(mode="straight") {#X394:1 %t2033:p};
// %t2034 = $IO_PORT @ATTACH &n670 => @PLACE(70, -1414) => @ORIENT("R0");
// %t2034 @TEXT("n670", key="name", size=0.75);
// &n670 @WIRE(mode="straight") {#X394:2 %t2034:p};
// %t2035 = $IO_PORT @ATTACH &n425 => @PLACE(90, -1412) => @ORIENT("MY");
// %t2035 @TEXT("n425", key="name", size=0.75);
// &n425 @WIRE(mode="straight") {#X394:3 %t2035:p};
// %t2036 = $SUPPLY @ATTACH &vdd => @PLACE(80, -1401);
// &vdd @WIRE(mode="straight") {#X394:4 %t2036:p};
// %t2037 = $GROUND @ATTACH &vss => @PLACE(80, -1423);
// &vss @WIRE(mode="straight") {#X394:5 %t2037:p};
// %t2038 = $IO_PORT @ATTACH &n246 => @PLACE(110, -1410) => @ORIENT("R0");
// %t2038 @TEXT("n246", key="name", size=0.75);
// &n246 @WIRE(mode="straight") {#X395:1 %t2038:p};
// %t2039 = $IO_PORT @ATTACH &n405 => @PLACE(110, -1414) => @ORIENT("R0");
// %t2039 @TEXT("n405", key="name", size=0.75);
// &n405 @WIRE(mode="straight") {#X395:2 %t2039:p};
// %t2040 = $IO_PORT @ATTACH &n407 => @PLACE(130, -1412) => @ORIENT("MY");
// %t2040 @TEXT("n407", key="name", size=0.75);
// &n407 @WIRE(mode="straight") {#X395:3 %t2040:p};
// %t2041 = $SUPPLY @ATTACH &vdd => @PLACE(120, -1401);
// &vdd @WIRE(mode="straight") {#X395:4 %t2041:p};
// %t2042 = $GROUND @ATTACH &vss => @PLACE(120, -1423);
// &vss @WIRE(mode="straight") {#X395:5 %t2042:p};
// %t2043 = $IO_PORT @ATTACH &n648 => @PLACE(-11, -1441) => @ORIENT("R0");
// %t2043 @TEXT("n648", key="name", size=0.75);
// &n648 @WIRE(mode="straight") {#X396:1 %t2043:p};
// %t2044 = $IO_PORT @ATTACH &n671 => @PLACE(-11, -1445) => @ORIENT("R0");
// %t2044 @TEXT("n671", key="name", size=0.75);
// &n671 @WIRE(mode="straight") {#X396:2 %t2044:p};
// %t2045 = $IO_PORT @ATTACH &n419 => @PLACE(10, -1443) => @ORIENT("MY");
// %t2045 @TEXT("n419", key="name", size=0.75);
// &n419 @WIRE(mode="straight") {#X396:3 %t2045:p};
// %t2046 = $SUPPLY @ATTACH &vdd => @PLACE(0, -1432);
// &vdd @WIRE(mode="straight") {#X396:4 %t2046:p};
// %t2047 = $GROUND @ATTACH &vss => @PLACE(0, -1454);
// &vss @WIRE(mode="straight") {#X396:5 %t2047:p};
// %t2048 = $IO_PORT @ATTACH &n427 => @PLACE(30, -1441) => @ORIENT("R0");
// %t2048 @TEXT("n427", key="name", size=0.75);
// &n427 @WIRE(mode="straight") {#X397:1 %t2048:p};
// %t2049 = $IO_PORT @ATTACH &n428 => @PLACE(30, -1445) => @ORIENT("R0");
// %t2049 @TEXT("n428", key="name", size=0.75);
// &n428 @WIRE(mode="straight") {#X397:2 %t2049:p};
// %t2050 = $IO_PORT @ATTACH &n672 => @PLACE(50, -1443) => @ORIENT("MY");
// %t2050 @TEXT("n672", key="name", size=0.75);
// &n672 @WIRE(mode="straight") {#X397:3 %t2050:p};
// %t2051 = $SUPPLY @ATTACH &vdd => @PLACE(40, -1432);
// &vdd @WIRE(mode="straight") {#X397:4 %t2051:p};
// %t2052 = $GROUND @ATTACH &vss => @PLACE(40, -1454);
// &vss @WIRE(mode="straight") {#X397:5 %t2052:p};
// %t2053 = $IO_PORT @ATTACH &n673 => @PLACE(70, -1441) => @ORIENT("R0");
// %t2053 @TEXT("n673", key="name", size=0.75);
// &n673 @WIRE(mode="straight") {#X398:1 %t2053:p};
// %t2054 = $IO_PORT @ATTACH &n674 => @PLACE(70, -1445) => @ORIENT("R0");
// %t2054 @TEXT("n674", key="name", size=0.75);
// &n674 @WIRE(mode="straight") {#X398:2 %t2054:p};
// %t2055 = $IO_PORT @ATTACH &n428 => @PLACE(90, -1443) => @ORIENT("MY");
// %t2055 @TEXT("n428", key="name", size=0.75);
// &n428 @WIRE(mode="straight") {#X398:3 %t2055:p};
// %t2056 = $SUPPLY @ATTACH &vdd => @PLACE(80, -1432);
// &vdd @WIRE(mode="straight") {#X398:4 %t2056:p};
// %t2057 = $GROUND @ATTACH &vss => @PLACE(80, -1454);
// &vss @WIRE(mode="straight") {#X398:5 %t2057:p};
// %t2058 = $IO_PORT @ATTACH &n675 => @PLACE(110, -1441) => @ORIENT("R0");
// %t2058 @TEXT("n675", key="name", size=0.75);
// &n675 @WIRE(mode="straight") {#X399:1 %t2058:p};
// %t2059 = $IO_PORT @ATTACH &n422 => @PLACE(110, -1445) => @ORIENT("R0");
// %t2059 @TEXT("n422", key="name", size=0.75);
// &n422 @WIRE(mode="straight") {#X399:2 %t2059:p};
// %t2060 = $IO_PORT @ATTACH &n674 => @PLACE(130, -1443) => @ORIENT("MY");
// %t2060 @TEXT("n674", key="name", size=0.75);
// &n674 @WIRE(mode="straight") {#X399:3 %t2060:p};
// %t2061 = $SUPPLY @ATTACH &vdd => @PLACE(120, -1432);
// &vdd @WIRE(mode="straight") {#X399:4 %t2061:p};
// %t2062 = $GROUND @ATTACH &vss => @PLACE(120, -1454);
// &vss @WIRE(mode="straight") {#X399:5 %t2062:p};
// %t2063 = $IO_PORT @ATTACH &n660 => @PLACE(-11, -1472) => @ORIENT("R0");
// %t2063 @TEXT("n660", key="name", size=0.75);
// &n660 @WIRE(mode="straight") {#X400:1 %t2063:p};
// %t2064 = $IO_PORT @ATTACH &n672 => @PLACE(-11, -1476) => @ORIENT("R0");
// %t2064 @TEXT("n672", key="name", size=0.75);
// &n672 @WIRE(mode="straight") {#X400:2 %t2064:p};
// %t2065 = $IO_PORT @ATTACH &n431 => @PLACE(10, -1474) => @ORIENT("MY");
// %t2065 @TEXT("n431", key="name", size=0.75);
// &n431 @WIRE(mode="straight") {#X400:3 %t2065:p};
// %t2066 = $SUPPLY @ATTACH &vdd => @PLACE(0, -1463);
// &vdd @WIRE(mode="straight") {#X400:4 %t2066:p};
// %t2067 = $GROUND @ATTACH &vss => @PLACE(0, -1485);
// &vss @WIRE(mode="straight") {#X400:5 %t2067:p};
// %t2068 = $IO_PORT @ATTACH &n676 => @PLACE(30, -1472) => @ORIENT("R0");
// %t2068 @TEXT("n676", key="name", size=0.75);
// &n676 @WIRE(mode="straight") {#X401:1 %t2068:p};
// %t2069 = $IO_PORT @ATTACH &n677 => @PLACE(30, -1476) => @ORIENT("R0");
// %t2069 @TEXT("n677", key="name", size=0.75);
// &n677 @WIRE(mode="straight") {#X401:2 %t2069:p};
// %t2070 = $IO_PORT @ATTACH &n416 => @PLACE(50, -1474) => @ORIENT("MY");
// %t2070 @TEXT("n416", key="name", size=0.75);
// &n416 @WIRE(mode="straight") {#X401:3 %t2070:p};
// %t2071 = $SUPPLY @ATTACH &vdd => @PLACE(40, -1463);
// &vdd @WIRE(mode="straight") {#X401:4 %t2071:p};
// %t2072 = $GROUND @ATTACH &vss => @PLACE(40, -1485);
// &vss @WIRE(mode="straight") {#X401:5 %t2072:p};
// %t2073 = $IO_PORT @ATTACH &n678 => @PLACE(70, -1472) => @ORIENT("R0");
// %t2073 @TEXT("n678", key="name", size=0.75);
// &n678 @WIRE(mode="straight") {#X402:1 %t2073:p};
// %t2074 = $IO_PORT @ATTACH &n410 => @PLACE(70, -1476) => @ORIENT("R0");
// %t2074 @TEXT("n410", key="name", size=0.75);
// &n410 @WIRE(mode="straight") {#X402:2 %t2074:p};
// %t2075 = $IO_PORT @ATTACH &n677 => @PLACE(90, -1474) => @ORIENT("MY");
// %t2075 @TEXT("n677", key="name", size=0.75);
// &n677 @WIRE(mode="straight") {#X402:3 %t2075:p};
// %t2076 = $SUPPLY @ATTACH &vdd => @PLACE(80, -1463);
// &vdd @WIRE(mode="straight") {#X402:4 %t2076:p};
// %t2077 = $GROUND @ATTACH &vss => @PLACE(80, -1485);
// &vss @WIRE(mode="straight") {#X402:5 %t2077:p};
// %t2078 = $IO_PORT @ATTACH &n415 => @PLACE(110, -1472) => @ORIENT("R0");
// %t2078 @TEXT("n415", key="name", size=0.75);
// &n415 @WIRE(mode="straight") {#X403:1 %t2078:p};
// %t2079 = $IO_PORT @ATTACH &n416 => @PLACE(110, -1476) => @ORIENT("R0");
// %t2079 @TEXT("n416", key="name", size=0.75);
// &n416 @WIRE(mode="straight") {#X403:2 %t2079:p};
// %t2080 = $IO_PORT @ATTACH &n671 => @PLACE(130, -1474) => @ORIENT("MY");
// %t2080 @TEXT("n671", key="name", size=0.75);
// &n671 @WIRE(mode="straight") {#X403:3 %t2080:p};
// %t2081 = $SUPPLY @ATTACH &vdd => @PLACE(120, -1463);
// &vdd @WIRE(mode="straight") {#X403:4 %t2081:p};
// %t2082 = $GROUND @ATTACH &vss => @PLACE(120, -1485);
// &vss @WIRE(mode="straight") {#X403:5 %t2082:p};
// %t2083 = $IO_PORT @ATTACH &n679 => @PLACE(-11, -1503) => @ORIENT("R0");
// %t2083 @TEXT("n679", key="name", size=0.75);
// &n679 @WIRE(mode="straight") {#X404:1 %t2083:p};
// %t2084 = $IO_PORT @ATTACH &n680 => @PLACE(-11, -1507) => @ORIENT("R0");
// %t2084 @TEXT("n680", key="name", size=0.75);
// &n680 @WIRE(mode="straight") {#X404:2 %t2084:p};
// %t2085 = $IO_PORT @ATTACH &n434 => @PLACE(10, -1505) => @ORIENT("MY");
// %t2085 @TEXT("n434", key="name", size=0.75);
// &n434 @WIRE(mode="straight") {#X404:3 %t2085:p};
// %t2086 = $SUPPLY @ATTACH &vdd => @PLACE(0, -1494);
// &vdd @WIRE(mode="straight") {#X404:4 %t2086:p};
// %t2087 = $GROUND @ATTACH &vss => @PLACE(0, -1516);
// &vss @WIRE(mode="straight") {#X404:5 %t2087:p};
// %t2088 = $IO_PORT @ATTACH &n681 => @PLACE(30, -1503) => @ORIENT("R0");
// %t2088 @TEXT("n681", key="name", size=0.75);
// &n681 @WIRE(mode="straight") {#X405:1 %t2088:p};
// %t2089 = $IO_PORT @ATTACH &n422 => @PLACE(30, -1507) => @ORIENT("R0");
// %t2089 @TEXT("n422", key="name", size=0.75);
// &n422 @WIRE(mode="straight") {#X405:2 %t2089:p};
// %t2090 = $IO_PORT @ATTACH &n680 => @PLACE(50, -1505) => @ORIENT("MY");
// %t2090 @TEXT("n680", key="name", size=0.75);
// &n680 @WIRE(mode="straight") {#X405:3 %t2090:p};
// %t2091 = $SUPPLY @ATTACH &vdd => @PLACE(40, -1494);
// &vdd @WIRE(mode="straight") {#X405:4 %t2091:p};
// %t2092 = $GROUND @ATTACH &vss => @PLACE(40, -1516);
// &vss @WIRE(mode="straight") {#X405:5 %t2092:p};
// %t2093 = $IO_PORT @ATTACH &n433 => @PLACE(70, -1503) => @ORIENT("R0");
// %t2093 @TEXT("n433", key="name", size=0.75);
// &n433 @WIRE(mode="straight") {#X406:1 %t2093:p};
// %t2094 = $IO_PORT @ATTACH &n434 => @PLACE(70, -1507) => @ORIENT("R0");
// %t2094 @TEXT("n434", key="name", size=0.75);
// &n434 @WIRE(mode="straight") {#X406:2 %t2094:p};
// %t2095 = $IO_PORT @ATTACH &n682 => @PLACE(90, -1505) => @ORIENT("MY");
// %t2095 @TEXT("n682", key="name", size=0.75);
// &n682 @WIRE(mode="straight") {#X406:3 %t2095:p};
// %t2096 = $SUPPLY @ATTACH &vdd => @PLACE(80, -1494);
// &vdd @WIRE(mode="straight") {#X406:4 %t2096:p};
// %t2097 = $GROUND @ATTACH &vss => @PLACE(80, -1516);
// &vss @WIRE(mode="straight") {#X406:5 %t2097:p};
// %t2098 = $IO_PORT @ATTACH &n683 => @PLACE(110, -1503) => @ORIENT("R0");
// %t2098 @TEXT("n683", key="name", size=0.75);
// &n683 @WIRE(mode="straight") {#X407:1 %t2098:p};
// %t2099 = $IO_PORT @ATTACH &n684 => @PLACE(110, -1507) => @ORIENT("R0");
// %t2099 @TEXT("n684", key="name", size=0.75);
// &n684 @WIRE(mode="straight") {#X407:2 %t2099:p};
// %t2100 = $IO_PORT @ATTACH &n422 => @PLACE(130, -1505) => @ORIENT("MY");
// %t2100 @TEXT("n422", key="name", size=0.75);
// &n422 @WIRE(mode="straight") {#X407:3 %t2100:p};
// %t2101 = $SUPPLY @ATTACH &vdd => @PLACE(120, -1494);
// &vdd @WIRE(mode="straight") {#X407:4 %t2101:p};
// %t2102 = $GROUND @ATTACH &vss => @PLACE(120, -1516);
// &vss @WIRE(mode="straight") {#X407:5 %t2102:p};
// %t2103 = $IO_PORT @ATTACH &n685 => @PLACE(158, -1348) => @ORIENT("R0");
// %t2103 @TEXT("n685", key="name", size=0.75);
// &n685 @WIRE(mode="straight") {#X408:1 %t2103:p};
// %t2104 = $IO_PORT @ATTACH &n410 => @PLACE(158, -1352) => @ORIENT("R0");
// %t2104 @TEXT("n410", key="name", size=0.75);
// &n410 @WIRE(mode="straight") {#X408:2 %t2104:p};
// %t2105 = $IO_PORT @ATTACH &n684 => @PLACE(178, -1350) => @ORIENT("MY");
// %t2105 @TEXT("n684", key="name", size=0.75);
// &n684 @WIRE(mode="straight") {#X408:3 %t2105:p};
// %t2106 = $SUPPLY @ATTACH &vdd => @PLACE(168, -1339);
// &vdd @WIRE(mode="straight") {#X408:4 %t2106:p};
// %t2107 = $GROUND @ATTACH &vss => @PLACE(168, -1361);
// &vss @WIRE(mode="straight") {#X408:5 %t2107:p};
// %t2108 = $IO_PORT @ATTACH &n686 => @PLACE(198, -1348) => @ORIENT("R0");
// %t2108 @TEXT("n686", key="name", size=0.75);
// &n686 @WIRE(mode="straight") {#X409:1 %t2108:p};
// %t2109 = $IO_PORT @ATTACH &n675 => @PLACE(198, -1352) => @ORIENT("R0");
// %t2109 @TEXT("n675", key="name", size=0.75);
// &n675 @WIRE(mode="straight") {#X409:2 %t2109:p};
// %t2110 = $IO_PORT @ATTACH &n681 => @PLACE(218, -1350) => @ORIENT("MY");
// %t2110 @TEXT("n681", key="name", size=0.75);
// &n681 @WIRE(mode="straight") {#X409:3 %t2110:p};
// %t2111 = $SUPPLY @ATTACH &vdd => @PLACE(208, -1339);
// &vdd @WIRE(mode="straight") {#X409:4 %t2111:p};
// %t2112 = $GROUND @ATTACH &vss => @PLACE(208, -1361);
// &vss @WIRE(mode="straight") {#X409:5 %t2112:p};
// %t2113 = $IO_PORT @ATTACH &n687 => @PLACE(238, -1348) => @ORIENT("R0");
// %t2113 @TEXT("n687", key="name", size=0.75);
// &n687 @WIRE(mode="straight") {#X410:1 %t2113:p};
// %t2114 = $IO_PORT @ATTACH &n688 => @PLACE(238, -1352) => @ORIENT("R0");
// %t2114 @TEXT("n688", key="name", size=0.75);
// &n688 @WIRE(mode="straight") {#X410:2 %t2114:p};
// %t2115 = $IO_PORT @ATTACH &n679 => @PLACE(258, -1350) => @ORIENT("MY");
// %t2115 @TEXT("n679", key="name", size=0.75);
// &n679 @WIRE(mode="straight") {#X410:3 %t2115:p};
// %t2116 = $SUPPLY @ATTACH &vdd => @PLACE(248, -1339);
// &vdd @WIRE(mode="straight") {#X410:4 %t2116:p};
// %t2117 = $GROUND @ATTACH &vss => @PLACE(248, -1361);
// &vss @WIRE(mode="straight") {#X410:5 %t2117:p};
// %t2118 = $IO_PORT @ATTACH &n686 => @PLACE(278, -1348) => @ORIENT("R0");
// %t2118 @TEXT("n686", key="name", size=0.75);
// &n686 @WIRE(mode="straight") {#X411:1 %t2118:p};
// %t2119 = $IO_PORT @ATTACH &n673 => @PLACE(278, -1352) => @ORIENT("R0");
// %t2119 @TEXT("n673", key="name", size=0.75);
// &n673 @WIRE(mode="straight") {#X411:2 %t2119:p};
// %t2120 = $IO_PORT @ATTACH &n688 => @PLACE(298, -1350) => @ORIENT("MY");
// %t2120 @TEXT("n688", key="name", size=0.75);
// &n688 @WIRE(mode="straight") {#X411:3 %t2120:p};
// %t2121 = $SUPPLY @ATTACH &vdd => @PLACE(288, -1339);
// &vdd @WIRE(mode="straight") {#X411:4 %t2121:p};
// %t2122 = $GROUND @ATTACH &vss => @PLACE(288, -1361);
// &vss @WIRE(mode="straight") {#X411:5 %t2122:p};
// %t2123 = $IO_PORT @ATTACH &n689 => @PLACE(158, -1379) => @ORIENT("R0");
// %t2123 @TEXT("n689", key="name", size=0.75);
// &n689 @WIRE(mode="straight") {#X412:1 %t2123:p};
// %t2124 = $IO_PORT @ATTACH &n678 => @PLACE(158, -1383) => @ORIENT("R0");
// %t2124 @TEXT("n678", key="name", size=0.75);
// &n678 @WIRE(mode="straight") {#X412:2 %t2124:p};
// %t2125 = $IO_PORT @ATTACH &n685 => @PLACE(178, -1381) => @ORIENT("MY");
// %t2125 @TEXT("n685", key="name", size=0.75);
// &n685 @WIRE(mode="straight") {#X412:3 %t2125:p};
// %t2126 = $SUPPLY @ATTACH &vdd => @PLACE(168, -1370);
// &vdd @WIRE(mode="straight") {#X412:4 %t2126:p};
// %t2127 = $GROUND @ATTACH &vss => @PLACE(168, -1392);
// &vss @WIRE(mode="straight") {#X412:5 %t2127:p};
// %t2128 = $IO_PORT @ATTACH &n690 => @PLACE(198, -1379) => @ORIENT("R0");
// %t2128 @TEXT("n690", key="name", size=0.75);
// &n690 @WIRE(mode="straight") {#X413:1 %t2128:p};
// %t2129 = $IO_PORT @ATTACH &n691 => @PLACE(198, -1383) => @ORIENT("R0");
// %t2129 @TEXT("n691", key="name", size=0.75);
// &n691 @WIRE(mode="straight") {#X413:2 %t2129:p};
// %t2130 = $IO_PORT @ATTACH &n683 => @PLACE(218, -1381) => @ORIENT("MY");
// %t2130 @TEXT("n683", key="name", size=0.75);
// &n683 @WIRE(mode="straight") {#X413:3 %t2130:p};
// %t2131 = $SUPPLY @ATTACH &vdd => @PLACE(208, -1370);
// &vdd @WIRE(mode="straight") {#X413:4 %t2131:p};
// %t2132 = $GROUND @ATTACH &vss => @PLACE(208, -1392);
// &vss @WIRE(mode="straight") {#X413:5 %t2132:p};
// %t2133 = $IO_PORT @ATTACH &n689 => @PLACE(238, -1379) => @ORIENT("R0");
// %t2133 @TEXT("n689", key="name", size=0.75);
// &n689 @WIRE(mode="straight") {#X414:1 %t2133:p};
// %t2134 = $IO_PORT @ATTACH &n676 => @PLACE(238, -1383) => @ORIENT("R0");
// %t2134 @TEXT("n676", key="name", size=0.75);
// &n676 @WIRE(mode="straight") {#X414:2 %t2134:p};
// %t2135 = $IO_PORT @ATTACH &n691 => @PLACE(258, -1381) => @ORIENT("MY");
// %t2135 @TEXT("n691", key="name", size=0.75);
// &n691 @WIRE(mode="straight") {#X414:3 %t2135:p};
// %t2136 = $SUPPLY @ATTACH &vdd => @PLACE(248, -1370);
// &vdd @WIRE(mode="straight") {#X414:4 %t2136:p};
// %t2137 = $GROUND @ATTACH &vss => @PLACE(248, -1392);
// &vss @WIRE(mode="straight") {#X414:5 %t2137:p};
// %t2138 = $IO_PORT @ATTACH &n666 => @PLACE(278, -1379) => @ORIENT("R0");
// %t2138 @TEXT("n666", key="name", size=0.75);
// &n666 @WIRE(mode="straight") {#X415:1 %t2138:p};
// %t2139 = $IO_PORT @ATTACH &n682 => @PLACE(278, -1383) => @ORIENT("R0");
// %t2139 @TEXT("n682", key="name", size=0.75);
// &n682 @WIRE(mode="straight") {#X415:2 %t2139:p};
// %t2140 = $IO_PORT @ATTACH &n437 => @PLACE(298, -1381) => @ORIENT("MY");
// %t2140 @TEXT("n437", key="name", size=0.75);
// &n437 @WIRE(mode="straight") {#X415:3 %t2140:p};
// %t2141 = $SUPPLY @ATTACH &vdd => @PLACE(288, -1370);
// &vdd @WIRE(mode="straight") {#X415:4 %t2141:p};
// %t2142 = $GROUND @ATTACH &vss => @PLACE(288, -1392);
// &vss @WIRE(mode="straight") {#X415:5 %t2142:p};
// %t2143 = $IO_PORT @ATTACH &n430 => @PLACE(158, -1410) => @ORIENT("R0");
// %t2143 @TEXT("n430", key="name", size=0.75);
// &n430 @WIRE(mode="straight") {#X416:1 %t2143:p};
// %t2144 = $IO_PORT @ATTACH &n427 => @PLACE(158, -1414) => @ORIENT("R0");
// %t2144 @TEXT("n427", key="name", size=0.75);
// &n427 @WIRE(mode="straight") {#X416:2 %t2144:p};
// %t2145 = $IO_PORT @ATTACH &n686 => @PLACE(178, -1412) => @ORIENT("MY");
// %t2145 @TEXT("n686", key="name", size=0.75);
// &n686 @WIRE(mode="straight") {#X416:3 %t2145:p};
// %t2146 = $SUPPLY @ATTACH &vdd => @PLACE(168, -1401);
// &vdd @WIRE(mode="straight") {#X416:4 %t2146:p};
// %t2147 = $GROUND @ATTACH &vss => @PLACE(168, -1423);
// &vss @WIRE(mode="straight") {#X416:5 %t2147:p};
// %t2148 = $IO_PORT @ATTACH &n663 => @PLACE(198, -1410) => @ORIENT("R0");
// %t2148 @TEXT("n663", key="name", size=0.75);
// &n663 @WIRE(mode="straight") {#X417:1 %t2148:p};
// %t2149 = $IO_PORT @ATTACH &n692 => @PLACE(198, -1414) => @ORIENT("R0");
// %t2149 @TEXT("n692", key="name", size=0.75);
// &n692 @WIRE(mode="straight") {#X417:2 %t2149:p};
// %t2150 = $IO_PORT @ATTACH &n687 => @PLACE(218, -1412) => @ORIENT("MY");
// %t2150 @TEXT("n687", key="name", size=0.75);
// &n687 @WIRE(mode="straight") {#X417:3 %t2150:p};
// %t2151 = $SUPPLY @ATTACH &vdd => @PLACE(208, -1401);
// &vdd @WIRE(mode="straight") {#X417:4 %t2151:p};
// %t2152 = $GROUND @ATTACH &vss => @PLACE(208, -1423);
// &vss @WIRE(mode="straight") {#X417:5 %t2152:p};
// %t2153 = $IO_PORT @ATTACH &n430 => @PLACE(238, -1410) => @ORIENT("R0");
// %t2153 @TEXT("n430", key="name", size=0.75);
// &n430 @WIRE(mode="straight") {#X418:1 %t2153:p};
// %t2154 = $IO_PORT @ATTACH &n660 => @PLACE(238, -1414) => @ORIENT("R0");
// %t2154 @TEXT("n660", key="name", size=0.75);
// &n660 @WIRE(mode="straight") {#X418:2 %t2154:p};
// %t2155 = $IO_PORT @ATTACH &n692 => @PLACE(258, -1412) => @ORIENT("MY");
// %t2155 @TEXT("n692", key="name", size=0.75);
// &n692 @WIRE(mode="straight") {#X418:3 %t2155:p};
// %t2156 = $SUPPLY @ATTACH &vdd => @PLACE(248, -1401);
// &vdd @WIRE(mode="straight") {#X418:4 %t2156:p};
// %t2157 = $GROUND @ATTACH &vss => @PLACE(248, -1423);
// &vss @WIRE(mode="straight") {#X418:5 %t2157:p};
// %t2158 = $IO_PORT @ATTACH &n424 => @PLACE(278, -1410) => @ORIENT("R0");
// %t2158 @TEXT("n424", key="name", size=0.75);
// &n424 @WIRE(mode="straight") {#X419:1 %t2158:p};
// %t2159 = $IO_PORT @ATTACH &n421 => @PLACE(278, -1414) => @ORIENT("R0");
// %t2159 @TEXT("n421", key="name", size=0.75);
// &n421 @WIRE(mode="straight") {#X419:2 %t2159:p};
// %t2160 = $IO_PORT @ATTACH &n675 => @PLACE(298, -1412) => @ORIENT("MY");
// %t2160 @TEXT("n675", key="name", size=0.75);
// &n675 @WIRE(mode="straight") {#X419:3 %t2160:p};
// %t2161 = $SUPPLY @ATTACH &vdd => @PLACE(288, -1401);
// &vdd @WIRE(mode="straight") {#X419:4 %t2161:p};
// %t2162 = $GROUND @ATTACH &vss => @PLACE(288, -1423);
// &vss @WIRE(mode="straight") {#X419:5 %t2162:p};
// %t2163 = $IO_PORT @ATTACH &n657 => @PLACE(158, -1441) => @ORIENT("R0");
// %t2163 @TEXT("n657", key="name", size=0.75);
// &n657 @WIRE(mode="straight") {#X420:1 %t2163:p};
// %t2164 = $IO_PORT @ATTACH &n693 => @PLACE(158, -1445) => @ORIENT("R0");
// %t2164 @TEXT("n693", key="name", size=0.75);
// &n693 @WIRE(mode="straight") {#X420:2 %t2164:p};
// %t2165 = $IO_PORT @ATTACH &n673 => @PLACE(178, -1443) => @ORIENT("MY");
// %t2165 @TEXT("n673", key="name", size=0.75);
// &n673 @WIRE(mode="straight") {#X420:3 %t2165:p};
// %t2166 = $SUPPLY @ATTACH &vdd => @PLACE(168, -1432);
// &vdd @WIRE(mode="straight") {#X420:4 %t2166:p};
// %t2167 = $GROUND @ATTACH &vss => @PLACE(168, -1454);
// &vss @WIRE(mode="straight") {#X420:5 %t2167:p};
// %t2168 = $IO_PORT @ATTACH &n424 => @PLACE(198, -1441) => @ORIENT("R0");
// %t2168 @TEXT("n424", key="name", size=0.75);
// &n424 @WIRE(mode="straight") {#X421:1 %t2168:p};
// %t2169 = $IO_PORT @ATTACH &n654 => @PLACE(198, -1445) => @ORIENT("R0");
// %t2169 @TEXT("n654", key="name", size=0.75);
// &n654 @WIRE(mode="straight") {#X421:2 %t2169:p};
// %t2170 = $IO_PORT @ATTACH &n693 => @PLACE(218, -1443) => @ORIENT("MY");
// %t2170 @TEXT("n693", key="name", size=0.75);
// &n693 @WIRE(mode="straight") {#X421:3 %t2170:p};
// %t2171 = $SUPPLY @ATTACH &vdd => @PLACE(208, -1432);
// &vdd @WIRE(mode="straight") {#X421:4 %t2171:p};
// %t2172 = $GROUND @ATTACH &vss => @PLACE(208, -1454);
// &vss @WIRE(mode="straight") {#X421:5 %t2172:p};
// %t2173 = $IO_PORT @ATTACH &n418 => @PLACE(238, -1441) => @ORIENT("R0");
// %t2173 @TEXT("n418", key="name", size=0.75);
// &n418 @WIRE(mode="straight") {#X422:1 %t2173:p};
// %t2174 = $IO_PORT @ATTACH &n415 => @PLACE(238, -1445) => @ORIENT("R0");
// %t2174 @TEXT("n415", key="name", size=0.75);
// &n415 @WIRE(mode="straight") {#X422:2 %t2174:p};
// %t2175 = $IO_PORT @ATTACH &n689 => @PLACE(258, -1443) => @ORIENT("MY");
// %t2175 @TEXT("n689", key="name", size=0.75);
// &n689 @WIRE(mode="straight") {#X422:3 %t2175:p};
// %t2176 = $SUPPLY @ATTACH &vdd => @PLACE(248, -1432);
// &vdd @WIRE(mode="straight") {#X422:4 %t2176:p};
// %t2177 = $GROUND @ATTACH &vss => @PLACE(248, -1454);
// &vss @WIRE(mode="straight") {#X422:5 %t2177:p};
// %t2178 = $IO_PORT @ATTACH &n651 => @PLACE(278, -1441) => @ORIENT("R0");
// %t2178 @TEXT("n651", key="name", size=0.75);
// &n651 @WIRE(mode="straight") {#X423:1 %t2178:p};
// %t2179 = $IO_PORT @ATTACH &n694 => @PLACE(278, -1445) => @ORIENT("R0");
// %t2179 @TEXT("n694", key="name", size=0.75);
// &n694 @WIRE(mode="straight") {#X423:2 %t2179:p};
// %t2180 = $IO_PORT @ATTACH &n690 => @PLACE(298, -1443) => @ORIENT("MY");
// %t2180 @TEXT("n690", key="name", size=0.75);
// &n690 @WIRE(mode="straight") {#X423:3 %t2180:p};
// %t2181 = $SUPPLY @ATTACH &vdd => @PLACE(288, -1432);
// &vdd @WIRE(mode="straight") {#X423:4 %t2181:p};
// %t2182 = $GROUND @ATTACH &vss => @PLACE(288, -1454);
// &vss @WIRE(mode="straight") {#X423:5 %t2182:p};
// %t2183 = $IO_PORT @ATTACH &n418 => @PLACE(158, -1472) => @ORIENT("R0");
// %t2183 @TEXT("n418", key="name", size=0.75);
// &n418 @WIRE(mode="straight") {#X424:1 %t2183:p};
// %t2184 = $IO_PORT @ATTACH &n648 => @PLACE(158, -1476) => @ORIENT("R0");
// %t2184 @TEXT("n648", key="name", size=0.75);
// &n648 @WIRE(mode="straight") {#X424:2 %t2184:p};
// %t2185 = $IO_PORT @ATTACH &n694 => @PLACE(178, -1474) => @ORIENT("MY");
// %t2185 @TEXT("n694", key="name", size=0.75);
// &n694 @WIRE(mode="straight") {#X424:3 %t2185:p};
// %t2186 = $SUPPLY @ATTACH &vdd => @PLACE(168, -1463);
// &vdd @WIRE(mode="straight") {#X424:4 %t2186:p};
// %t2187 = $GROUND @ATTACH &vss => @PLACE(168, -1485);
// &vss @WIRE(mode="straight") {#X424:5 %t2187:p};
// %t2188 = $IO_PORT @ATTACH &n412 => @PLACE(198, -1472) => @ORIENT("R0");
// %t2188 @TEXT("n412", key="name", size=0.75);
// &n412 @WIRE(mode="straight") {#X425:1 %t2188:p};
// %t2189 = $IO_PORT @ATTACH &n409 => @PLACE(198, -1476) => @ORIENT("R0");
// %t2189 @TEXT("n409", key="name", size=0.75);
// &n409 @WIRE(mode="straight") {#X425:2 %t2189:p};
// %t2190 = $IO_PORT @ATTACH &n678 => @PLACE(218, -1474) => @ORIENT("MY");
// %t2190 @TEXT("n678", key="name", size=0.75);
// &n678 @WIRE(mode="straight") {#X425:3 %t2190:p};
// %t2191 = $SUPPLY @ATTACH &vdd => @PLACE(208, -1463);
// &vdd @WIRE(mode="straight") {#X425:4 %t2191:p};
// %t2192 = $GROUND @ATTACH &vss => @PLACE(208, -1485);
// &vss @WIRE(mode="straight") {#X425:5 %t2192:p};
// %t2193 = $IO_PORT @ATTACH &n645 => @PLACE(238, -1472) => @ORIENT("R0");
// %t2193 @TEXT("n645", key="name", size=0.75);
// &n645 @WIRE(mode="straight") {#X426:1 %t2193:p};
// %t2194 = $IO_PORT @ATTACH &n695 => @PLACE(238, -1476) => @ORIENT("R0");
// %t2194 @TEXT("n695", key="name", size=0.75);
// &n695 @WIRE(mode="straight") {#X426:2 %t2194:p};
// %t2195 = $IO_PORT @ATTACH &n676 => @PLACE(258, -1474) => @ORIENT("MY");
// %t2195 @TEXT("n676", key="name", size=0.75);
// &n676 @WIRE(mode="straight") {#X426:3 %t2195:p};
// %t2196 = $SUPPLY @ATTACH &vdd => @PLACE(248, -1463);
// &vdd @WIRE(mode="straight") {#X426:4 %t2196:p};
// %t2197 = $GROUND @ATTACH &vss => @PLACE(248, -1485);
// &vss @WIRE(mode="straight") {#X426:5 %t2197:p};
// %t2198 = $IO_PORT @ATTACH &n412 => @PLACE(278, -1472) => @ORIENT("R0");
// %t2198 @TEXT("n412", key="name", size=0.75);
// &n412 @WIRE(mode="straight") {#X427:1 %t2198:p};
// %t2199 = $IO_PORT @ATTACH &n642 => @PLACE(278, -1476) => @ORIENT("R0");
// %t2199 @TEXT("n642", key="name", size=0.75);
// &n642 @WIRE(mode="straight") {#X427:2 %t2199:p};
// %t2200 = $IO_PORT @ATTACH &n695 => @PLACE(298, -1474) => @ORIENT("MY");
// %t2200 @TEXT("n695", key="name", size=0.75);
// &n695 @WIRE(mode="straight") {#X427:3 %t2200:p};
// %t2201 = $SUPPLY @ATTACH &vdd => @PLACE(288, -1463);
// &vdd @WIRE(mode="straight") {#X427:4 %t2201:p};
// %t2202 = $GROUND @ATTACH &vss => @PLACE(288, -1485);
// &vss @WIRE(mode="straight") {#X427:5 %t2202:p};
// %t2203 = $IO_PORT @ATTACH &n421 => @PLACE(158, -1503) => @ORIENT("R0");
// %t2203 @TEXT("n421", key="name", size=0.75);
// &n421 @WIRE(mode="straight") {#X428:1 %t2203:p};
// %t2204 = $IO_PORT @ATTACH &n422 => @PLACE(158, -1507) => @ORIENT("R0");
// %t2204 @TEXT("n422", key="name", size=0.75);
// &n422 @WIRE(mode="straight") {#X428:2 %t2204:p};
// %t2205 = $IO_PORT @ATTACH &n670 => @PLACE(178, -1505) => @ORIENT("MY");
// %t2205 @TEXT("n670", key="name", size=0.75);
// &n670 @WIRE(mode="straight") {#X428:3 %t2205:p};
// %t2206 = $SUPPLY @ATTACH &vdd => @PLACE(168, -1494);
// &vdd @WIRE(mode="straight") {#X428:4 %t2206:p};
// %t2207 = $GROUND @ATTACH &vss => @PLACE(168, -1516);
// &vss @WIRE(mode="straight") {#X428:5 %t2207:p};
// %t2208 = $IO_PORT @ATTACH &measured4 => @PLACE(198, -1503) => @ORIENT("R0");
// %t2208 @TEXT("measured4", key="name", size=0.75);
// &measured4 @WIRE(mode="straight") {#X429:1 %t2208:p};
// %t2209 = $IO_PORT @ATTACH &n696 => @PLACE(198, -1507) => @ORIENT("R0");
// %t2209 @TEXT("n696", key="name", size=0.75);
// &n696 @WIRE(mode="straight") {#X429:2 %t2209:p};
// %t2210 = $IO_PORT @ATTACH &n697 => @PLACE(218, -1505) => @ORIENT("MY");
// %t2210 @TEXT("n697", key="name", size=0.75);
// &n697 @WIRE(mode="straight") {#X429:3 %t2210:p};
// %t2211 = $SUPPLY @ATTACH &vdd => @PLACE(208, -1494);
// &vdd @WIRE(mode="straight") {#X429:4 %t2211:p};
// %t2212 = $GROUND @ATTACH &vss => @PLACE(208, -1516);
// &vss @WIRE(mode="straight") {#X429:5 %t2212:p};
// %t2213 = $IO_PORT @ATTACH &measured5 => @PLACE(238, -1503) => @ORIENT("R0");
// %t2213 @TEXT("measured5", key="name", size=0.75);
// &measured5 @WIRE(mode="straight") {#X430:1 %t2213:p};
// %t2214 = $IO_PORT @ATTACH &n698 => @PLACE(238, -1507) => @ORIENT("R0");
// %t2214 @TEXT("n698", key="name", size=0.75);
// &n698 @WIRE(mode="straight") {#X430:2 %t2214:p};
// %t2215 = $IO_PORT @ATTACH &n442 => @PLACE(258, -1505) => @ORIENT("MY");
// %t2215 @TEXT("n442", key="name", size=0.75);
// &n442 @WIRE(mode="straight") {#X430:3 %t2215:p};
// %t2216 = $SUPPLY @ATTACH &vdd => @PLACE(248, -1494);
// &vdd @WIRE(mode="straight") {#X430:4 %t2216:p};
// %t2217 = $GROUND @ATTACH &vss => @PLACE(248, -1516);
// &vss @WIRE(mode="straight") {#X430:5 %t2217:p};
// %t2218 = $IO_PORT @ATTACH &measured7 => @PLACE(278, -1503) => @ORIENT("R0");
// %t2218 @TEXT("measured7", key="name", size=0.75);
// &measured7 @WIRE(mode="straight") {#X431:1 %t2218:p};
// %t2219 = $IO_PORT @ATTACH &n699 => @PLACE(278, -1507) => @ORIENT("R0");
// %t2219 @TEXT("n699", key="name", size=0.75);
// &n699 @WIRE(mode="straight") {#X431:2 %t2219:p};
// %t2220 = $IO_PORT @ATTACH &n504 => @PLACE(298, -1505) => @ORIENT("MY");
// %t2220 @TEXT("n504", key="name", size=0.75);
// &n504 @WIRE(mode="straight") {#X431:3 %t2220:p};
// %t2221 = $SUPPLY @ATTACH &vdd => @PLACE(288, -1494);
// &vdd @WIRE(mode="straight") {#X431:4 %t2221:p};
// %t2222 = $GROUND @ATTACH &vss => @PLACE(288, -1516);
// &vss @WIRE(mode="straight") {#X431:5 %t2222:p};
// %t2223 = $IO_PORT @ATTACH &measured12 => @PLACE(326, -1348) => @ORIENT("R0");
// %t2223 @TEXT("measured12", key="name", size=0.75);
// &measured12 @WIRE(mode="straight") {#X432:1 %t2223:p};
// %t2224 = $IO_PORT @ATTACH &n700 => @PLACE(326, -1352) => @ORIENT("R0");
// %t2224 @TEXT("n700", key="name", size=0.75);
// &n700 @WIRE(mode="straight") {#X432:2 %t2224:p};
// %t2225 = $IO_PORT @ATTACH &n566 => @PLACE(346, -1350) => @ORIENT("MY");
// %t2225 @TEXT("n566", key="name", size=0.75);
// &n566 @WIRE(mode="straight") {#X432:3 %t2225:p};
// %t2226 = $SUPPLY @ATTACH &vdd => @PLACE(336, -1339);
// &vdd @WIRE(mode="straight") {#X432:4 %t2226:p};
// %t2227 = $GROUND @ATTACH &vss => @PLACE(336, -1361);
// &vss @WIRE(mode="straight") {#X432:5 %t2227:p};
// %t2228 = $IO_PORT @ATTACH &measured5 => @PLACE(366, -1348) => @ORIENT("R0");
// %t2228 @TEXT("measured5", key="name", size=0.75);
// &measured5 @WIRE(mode="straight") {#X433:1 %t2228:p};
// %t2229 = $IO_PORT @ATTACH &n698 => @PLACE(366, -1352) => @ORIENT("R0");
// %t2229 @TEXT("n698", key="name", size=0.75);
// &n698 @WIRE(mode="straight") {#X433:2 %t2229:p};
// %t2230 = $IO_PORT @ATTACH &n701 => @PLACE(386, -1350) => @ORIENT("MY");
// %t2230 @TEXT("n701", key="name", size=0.75);
// &n701 @WIRE(mode="straight") {#X433:3 %t2230:p};
// %t2231 = $SUPPLY @ATTACH &vdd => @PLACE(376, -1339);
// &vdd @WIRE(mode="straight") {#X433:4 %t2231:p};
// %t2232 = $GROUND @ATTACH &vss => @PLACE(376, -1361);
// &vss @WIRE(mode="straight") {#X433:5 %t2232:p};
// %t2233 = $IO_PORT @ATTACH &measured11 => @PLACE(406, -1348) => @ORIENT("R0");
// %t2233 @TEXT("measured11", key="name", size=0.75);
// &measured11 @WIRE(mode="straight") {#X434:1 %t2233:p};
// %t2234 = $IO_PORT @ATTACH &n702 => @PLACE(406, -1352) => @ORIENT("R0");
// %t2234 @TEXT("n702", key="name", size=0.75);
// &n702 @WIRE(mode="straight") {#X434:2 %t2234:p};
// %t2235 = $IO_PORT @ATTACH &n703 => @PLACE(426, -1350) => @ORIENT("MY");
// %t2235 @TEXT("n703", key="name", size=0.75);
// &n703 @WIRE(mode="straight") {#X434:3 %t2235:p};
// %t2236 = $SUPPLY @ATTACH &vdd => @PLACE(416, -1339);
// &vdd @WIRE(mode="straight") {#X434:4 %t2236:p};
// %t2237 = $GROUND @ATTACH &vss => @PLACE(416, -1361);
// &vss @WIRE(mode="straight") {#X434:5 %t2237:p};
// %t2238 = $IO_PORT @ATTACH &measured12 => @PLACE(446, -1348) => @ORIENT("R0");
// %t2238 @TEXT("measured12", key="name", size=0.75);
// &measured12 @WIRE(mode="straight") {#X435:1 %t2238:p};
// %t2239 = $IO_PORT @ATTACH &n700 => @PLACE(446, -1352) => @ORIENT("R0");
// %t2239 @TEXT("n700", key="name", size=0.75);
// &n700 @WIRE(mode="straight") {#X435:2 %t2239:p};
// %t2240 = $IO_PORT @ATTACH &n704 => @PLACE(466, -1350) => @ORIENT("MY");
// %t2240 @TEXT("n704", key="name", size=0.75);
// &n704 @WIRE(mode="straight") {#X435:3 %t2240:p};
// %t2241 = $SUPPLY @ATTACH &vdd => @PLACE(456, -1339);
// &vdd @WIRE(mode="straight") {#X435:4 %t2241:p};
// %t2242 = $GROUND @ATTACH &vss => @PLACE(456, -1361);
// &vss @WIRE(mode="straight") {#X435:5 %t2242:p};
// %t2243 = $IO_PORT @ATTACH &measured11 => @PLACE(326, -1379) => @ORIENT("R0");
// %t2243 @TEXT("measured11", key="name", size=0.75);
// &measured11 @WIRE(mode="straight") {#X436:1 %t2243:p};
// %t2244 = $IO_PORT @ATTACH &n702 => @PLACE(326, -1383) => @ORIENT("R0");
// %t2244 @TEXT("n702", key="name", size=0.75);
// &n702 @WIRE(mode="straight") {#X436:2 %t2244:p};
// %t2245 = $IO_PORT @ATTACH &n510 => @PLACE(346, -1381) => @ORIENT("MY");
// %t2245 @TEXT("n510", key="name", size=0.75);
// &n510 @WIRE(mode="straight") {#X436:3 %t2245:p};
// %t2246 = $SUPPLY @ATTACH &vdd => @PLACE(336, -1370);
// &vdd @WIRE(mode="straight") {#X436:4 %t2246:p};
// %t2247 = $GROUND @ATTACH &vss => @PLACE(336, -1392);
// &vss @WIRE(mode="straight") {#X436:5 %t2247:p};
// %t2248 = $IO_PORT @ATTACH &n705 => @PLACE(366, -1379) => @ORIENT("R0");
// %t2248 @TEXT("n705", key="name", size=0.75);
// &n705 @WIRE(mode="straight") {#X437:1 %t2248:p};
// %t2249 = $IO_PORT @ATTACH &n706 => @PLACE(366, -1383) => @ORIENT("R0");
// %t2249 @TEXT("n706", key="name", size=0.75);
// &n706 @WIRE(mode="straight") {#X437:2 %t2249:p};
// %t2250 = $IO_PORT @ATTACH &n564 => @PLACE(386, -1381) => @ORIENT("MY");
// %t2250 @TEXT("n564", key="name", size=0.75);
// &n564 @WIRE(mode="straight") {#X437:3 %t2250:p};
// %t2251 = $SUPPLY @ATTACH &vdd => @PLACE(376, -1370);
// &vdd @WIRE(mode="straight") {#X437:4 %t2251:p};
// %t2252 = $GROUND @ATTACH &vss => @PLACE(376, -1392);
// &vss @WIRE(mode="straight") {#X437:5 %t2252:p};
// %t2253 = $IO_PORT @ATTACH &n707 => @PLACE(406, -1379) => @ORIENT("R0");
// %t2253 @TEXT("n707", key="name", size=0.75);
// &n707 @WIRE(mode="straight") {#X438:1 %t2253:p};
// %t2254 = $IO_PORT @ATTACH &n708 => @PLACE(406, -1383) => @ORIENT("R0");
// %t2254 @TEXT("n708", key="name", size=0.75);
// &n708 @WIRE(mode="straight") {#X438:2 %t2254:p};
// %t2255 = $IO_PORT @ATTACH &n508 => @PLACE(426, -1381) => @ORIENT("MY");
// %t2255 @TEXT("n508", key="name", size=0.75);
// &n508 @WIRE(mode="straight") {#X438:3 %t2255:p};
// %t2256 = $SUPPLY @ATTACH &vdd => @PLACE(416, -1370);
// &vdd @WIRE(mode="straight") {#X438:4 %t2256:p};
// %t2257 = $GROUND @ATTACH &vss => @PLACE(416, -1392);
// &vss @WIRE(mode="straight") {#X438:5 %t2257:p};
// %t2258 = $IO_PORT @ATTACH &n709 => @PLACE(446, -1379) => @ORIENT("R0");
// %t2258 @TEXT("n709", key="name", size=0.75);
// &n709 @WIRE(mode="straight") {#X439:1 %t2258:p};
// %t2259 = $IO_PORT @ATTACH &n710 => @PLACE(446, -1383) => @ORIENT("R0");
// %t2259 @TEXT("n710", key="name", size=0.75);
// &n710 @WIRE(mode="straight") {#X439:2 %t2259:p};
// %t2260 = $IO_PORT @ATTACH &n511 => @PLACE(466, -1381) => @ORIENT("MY");
// %t2260 @TEXT("n511", key="name", size=0.75);
// &n511 @WIRE(mode="straight") {#X439:3 %t2260:p};
// %t2261 = $SUPPLY @ATTACH &vdd => @PLACE(456, -1370);
// &vdd @WIRE(mode="straight") {#X439:4 %t2261:p};
// %t2262 = $GROUND @ATTACH &vss => @PLACE(456, -1392);
// &vss @WIRE(mode="straight") {#X439:5 %t2262:p};
// %t2263 = $IO_PORT @ATTACH &n566 => @PLACE(326, -1410) => @ORIENT("R0");
// %t2263 @TEXT("n566", key="name", size=0.75);
// &n566 @WIRE(mode="straight") {#X440:1 %t2263:p};
// %t2264 = $IO_PORT @ATTACH &n567 => @PLACE(326, -1414) => @ORIENT("R0");
// %t2264 @TEXT("n567", key="name", size=0.75);
// &n567 @WIRE(mode="straight") {#X440:2 %t2264:p};
// %t2265 = $IO_PORT @ATTACH &n711 => @PLACE(346, -1412) => @ORIENT("MY");
// %t2265 @TEXT("n711", key="name", size=0.75);
// &n711 @WIRE(mode="straight") {#X440:3 %t2265:p};
// %t2266 = $SUPPLY @ATTACH &vdd => @PLACE(336, -1401);
// &vdd @WIRE(mode="straight") {#X440:4 %t2266:p};
// %t2267 = $GROUND @ATTACH &vss => @PLACE(336, -1423);
// &vss @WIRE(mode="straight") {#X440:5 %t2267:p};
// %t2268 = $IO_PORT @ATTACH &n712 => @PLACE(366, -1410) => @ORIENT("R0");
// %t2268 @TEXT("n712", key="name", size=0.75);
// &n712 @WIRE(mode="straight") {#X441:1 %t2268:p};
// %t2269 = $IO_PORT @ATTACH &n713 => @PLACE(366, -1414) => @ORIENT("R0");
// %t2269 @TEXT("n713", key="name", size=0.75);
// &n713 @WIRE(mode="straight") {#X441:2 %t2269:p};
// %t2270 = $IO_PORT @ATTACH &n561 => @PLACE(386, -1412) => @ORIENT("MY");
// %t2270 @TEXT("n561", key="name", size=0.75);
// &n561 @WIRE(mode="straight") {#X441:3 %t2270:p};
// %t2271 = $SUPPLY @ATTACH &vdd => @PLACE(376, -1401);
// &vdd @WIRE(mode="straight") {#X441:4 %t2271:p};
// %t2272 = $GROUND @ATTACH &vss => @PLACE(376, -1423);
// &vss @WIRE(mode="straight") {#X441:5 %t2272:p};
// %t2273 = $IO_PORT @ATTACH &n704 => @PLACE(406, -1410) => @ORIENT("R0");
// %t2273 @TEXT("n704", key="name", size=0.75);
// &n704 @WIRE(mode="straight") {#X442:1 %t2273:p};
// %t2274 = $IO_PORT @ATTACH &n711 => @PLACE(406, -1414) => @ORIENT("R0");
// %t2274 @TEXT("n711", key="name", size=0.75);
// &n711 @WIRE(mode="straight") {#X442:2 %t2274:p};
// %t2275 = $IO_PORT @ATTACH &n570 => @PLACE(426, -1412) => @ORIENT("MY");
// %t2275 @TEXT("n570", key="name", size=0.75);
// &n570 @WIRE(mode="straight") {#X442:3 %t2275:p};
// %t2276 = $SUPPLY @ATTACH &vdd => @PLACE(416, -1401);
// &vdd @WIRE(mode="straight") {#X442:4 %t2276:p};
// %t2277 = $GROUND @ATTACH &vss => @PLACE(416, -1423);
// &vss @WIRE(mode="straight") {#X442:5 %t2277:p};
// %t2278 = $IO_PORT @ATTACH &n714 => @PLACE(446, -1410) => @ORIENT("R0");
// %t2278 @TEXT("n714", key="name", size=0.75);
// &n714 @WIRE(mode="straight") {#X443:1 %t2278:p};
// %t2279 = $IO_PORT @ATTACH &n715 => @PLACE(446, -1414) => @ORIENT("R0");
// %t2279 @TEXT("n715", key="name", size=0.75);
// &n715 @WIRE(mode="straight") {#X443:2 %t2279:p};
// %t2280 = $IO_PORT @ATTACH &n440 => @PLACE(466, -1412) => @ORIENT("MY");
// %t2280 @TEXT("n440", key="name", size=0.75);
// &n440 @WIRE(mode="straight") {#X443:3 %t2280:p};
// %t2281 = $SUPPLY @ATTACH &vdd => @PLACE(456, -1401);
// &vdd @WIRE(mode="straight") {#X443:4 %t2281:p};
// %t2282 = $GROUND @ATTACH &vss => @PLACE(456, -1423);
// &vss @WIRE(mode="straight") {#X443:5 %t2282:p};
// %t2283 = $IO_PORT @ATTACH &n569 => @PLACE(326, -1441) => @ORIENT("R0");
// %t2283 @TEXT("n569", key="name", size=0.75);
// &n569 @WIRE(mode="straight") {#X444:1 %t2283:p};
// %t2284 = $IO_PORT @ATTACH &n566 => @PLACE(326, -1445) => @ORIENT("R0");
// %t2284 @TEXT("n566", key="name", size=0.75);
// &n566 @WIRE(mode="straight") {#X444:2 %t2284:p};
// %t2285 = $IO_PORT @ATTACH &n716 => @PLACE(346, -1443) => @ORIENT("MY");
// %t2285 @TEXT("n716", key="name", size=0.75);
// &n716 @WIRE(mode="straight") {#X444:3 %t2285:p};
// %t2286 = $SUPPLY @ATTACH &vdd => @PLACE(336, -1432);
// &vdd @WIRE(mode="straight") {#X444:4 %t2286:p};
// %t2287 = $GROUND @ATTACH &vss => @PLACE(336, -1454);
// &vss @WIRE(mode="straight") {#X444:5 %t2287:p};
// %t2288 = $IO_PORT @ATTACH &n703 => @PLACE(366, -1441) => @ORIENT("R0");
// %t2288 @TEXT("n703", key="name", size=0.75);
// &n703 @WIRE(mode="straight") {#X445:1 %t2288:p};
// %t2289 = $IO_PORT @ATTACH &n717 => @PLACE(366, -1445) => @ORIENT("R0");
// %t2289 @TEXT("n717", key="name", size=0.75);
// &n717 @WIRE(mode="straight") {#X445:2 %t2289:p};
// %t2290 = $IO_PORT @ATTACH &n718 => @PLACE(386, -1443) => @ORIENT("MY");
// %t2290 @TEXT("n718", key="name", size=0.75);
// &n718 @WIRE(mode="straight") {#X445:3 %t2290:p};
// %t2291 = $SUPPLY @ATTACH &vdd => @PLACE(376, -1432);
// &vdd @WIRE(mode="straight") {#X445:4 %t2291:p};
// %t2292 = $GROUND @ATTACH &vss => @PLACE(376, -1454);
// &vss @WIRE(mode="straight") {#X445:5 %t2292:p};
// %t2293 = $IO_PORT @ATTACH &n563 => @PLACE(406, -1441) => @ORIENT("R0");
// %t2293 @TEXT("n563", key="name", size=0.75);
// &n563 @WIRE(mode="straight") {#X446:1 %t2293:p};
// %t2294 = $IO_PORT @ATTACH &n560 => @PLACE(406, -1445) => @ORIENT("R0");
// %t2294 @TEXT("n560", key="name", size=0.75);
// &n560 @WIRE(mode="straight") {#X446:2 %t2294:p};
// %t2295 = $IO_PORT @ATTACH &n719 => @PLACE(426, -1443) => @ORIENT("MY");
// %t2295 @TEXT("n719", key="name", size=0.75);
// &n719 @WIRE(mode="straight") {#X446:3 %t2295:p};
// %t2296 = $SUPPLY @ATTACH &vdd => @PLACE(416, -1432);
// &vdd @WIRE(mode="straight") {#X446:4 %t2296:p};
// %t2297 = $GROUND @ATTACH &vss => @PLACE(416, -1454);
// &vss @WIRE(mode="straight") {#X446:5 %t2297:p};
// %t2298 = $IO_PORT @ATTACH &n720 => @PLACE(446, -1441) => @ORIENT("R0");
// %t2298 @TEXT("n720", key="name", size=0.75);
// &n720 @WIRE(mode="straight") {#X447:1 %t2298:p};
// %t2299 = $IO_PORT @ATTACH &n721 => @PLACE(446, -1445) => @ORIENT("R0");
// %t2299 @TEXT("n721", key="name", size=0.75);
// &n721 @WIRE(mode="straight") {#X447:2 %t2299:p};
// %t2300 = $IO_PORT @ATTACH &n707 => @PLACE(466, -1443) => @ORIENT("MY");
// %t2300 @TEXT("n707", key="name", size=0.75);
// &n707 @WIRE(mode="straight") {#X447:3 %t2300:p};
// %t2301 = $SUPPLY @ATTACH &vdd => @PLACE(456, -1432);
// &vdd @WIRE(mode="straight") {#X447:4 %t2301:p};
// %t2302 = $GROUND @ATTACH &vss => @PLACE(456, -1454);
// &vss @WIRE(mode="straight") {#X447:5 %t2302:p};
// %t2303 = $IO_PORT @ATTACH &n722 => @PLACE(326, -1472) => @ORIENT("R0");
// %t2303 @TEXT("n722", key="name", size=0.75);
// &n722 @WIRE(mode="straight") {#X448:1 %t2303:p};
// %t2304 = $IO_PORT @ATTACH &n723 => @PLACE(326, -1476) => @ORIENT("R0");
// %t2304 @TEXT("n723", key="name", size=0.75);
// &n723 @WIRE(mode="straight") {#X448:2 %t2304:p};
// %t2305 = $IO_PORT @ATTACH &n724 => @PLACE(346, -1474) => @ORIENT("MY");
// %t2305 @TEXT("n724", key="name", size=0.75);
// &n724 @WIRE(mode="straight") {#X448:3 %t2305:p};
// %t2306 = $SUPPLY @ATTACH &vdd => @PLACE(336, -1463);
// &vdd @WIRE(mode="straight") {#X448:4 %t2306:p};
// %t2307 = $GROUND @ATTACH &vss => @PLACE(336, -1485);
// &vss @WIRE(mode="straight") {#X448:5 %t2307:p};
// %t2308 = $IO_PORT @ATTACH &n442 => @PLACE(366, -1472) => @ORIENT("R0");
// %t2308 @TEXT("n442", key="name", size=0.75);
// &n442 @WIRE(mode="straight") {#X449:1 %t2308:p};
// %t2309 = $IO_PORT @ATTACH &n439 => @PLACE(366, -1476) => @ORIENT("R0");
// %t2309 @TEXT("n439", key="name", size=0.75);
// &n439 @WIRE(mode="straight") {#X449:2 %t2309:p};
// %t2310 = $IO_PORT @ATTACH &n725 => @PLACE(386, -1474) => @ORIENT("MY");
// %t2310 @TEXT("n725", key="name", size=0.75);
// &n725 @WIRE(mode="straight") {#X449:3 %t2310:p};
// %t2311 = $SUPPLY @ATTACH &vdd => @PLACE(376, -1463);
// &vdd @WIRE(mode="straight") {#X449:4 %t2311:p};
// %t2312 = $GROUND @ATTACH &vss => @PLACE(376, -1485);
// &vss @WIRE(mode="straight") {#X449:5 %t2312:p};
// %t2313 = $IO_PORT @ATTACH &n701 => @PLACE(406, -1472) => @ORIENT("R0");
// %t2313 @TEXT("n701", key="name", size=0.75);
// &n701 @WIRE(mode="straight") {#X450:1 %t2313:p};
// %t2314 = $IO_PORT @ATTACH &n726 => @PLACE(406, -1476) => @ORIENT("R0");
// %t2314 @TEXT("n726", key="name", size=0.75);
// &n726 @WIRE(mode="straight") {#X450:2 %t2314:p};
// %t2315 = $IO_PORT @ATTACH &n727 => @PLACE(426, -1474) => @ORIENT("MY");
// %t2315 @TEXT("n727", key="name", size=0.75);
// &n727 @WIRE(mode="straight") {#X450:3 %t2315:p};
// %t2316 = $SUPPLY @ATTACH &vdd => @PLACE(416, -1463);
// &vdd @WIRE(mode="straight") {#X450:4 %t2316:p};
// %t2317 = $GROUND @ATTACH &vss => @PLACE(416, -1485);
// &vss @WIRE(mode="straight") {#X450:5 %t2317:p};
// %t2318 = $IO_PORT @ATTACH &n245 => @PLACE(446, -1472) => @ORIENT("R0");
// %t2318 @TEXT("n245", key="name", size=0.75);
// &n245 @WIRE(mode="straight") {#X451:1 %t2318:p};
// %t2319 = $IO_PORT @ATTACH &measured2 => @PLACE(446, -1476) => @ORIENT("R0");
// %t2319 @TEXT("measured2", key="name", size=0.75);
// &measured2 @WIRE(mode="straight") {#X451:2 %t2319:p};
// %t2320 = $IO_PORT @ATTACH &n728 => @PLACE(466, -1474) => @ORIENT("MY");
// %t2320 @TEXT("n728", key="name", size=0.75);
// &n728 @WIRE(mode="straight") {#X451:3 %t2320:p};
// %t2321 = $SUPPLY @ATTACH &vdd => @PLACE(456, -1463);
// &vdd @WIRE(mode="straight") {#X451:4 %t2321:p};
// %t2322 = $GROUND @ATTACH &vss => @PLACE(456, -1485);
// &vss @WIRE(mode="straight") {#X451:5 %t2322:p};
// %t2323 = $IO_PORT @ATTACH &n560 => @PLACE(326, -1503) => @ORIENT("R0");
// %t2323 @TEXT("n560", key="name", size=0.75);
// &n560 @WIRE(mode="straight") {#X452:1 %t2323:p};
// %t2324 = $IO_PORT @ATTACH &n561 => @PLACE(326, -1507) => @ORIENT("R0");
// %t2324 @TEXT("n561", key="name", size=0.75);
// &n561 @WIRE(mode="straight") {#X452:2 %t2324:p};
// %t2325 = $IO_PORT @ATTACH &n706 => @PLACE(346, -1505) => @ORIENT("MY");
// %t2325 @TEXT("n706", key="name", size=0.75);
// &n706 @WIRE(mode="straight") {#X452:3 %t2325:p};
// %t2326 = $SUPPLY @ATTACH &vdd => @PLACE(336, -1494);
// &vdd @WIRE(mode="straight") {#X452:4 %t2326:p};
// %t2327 = $GROUND @ATTACH &vss => @PLACE(336, -1516);
// &vss @WIRE(mode="straight") {#X452:5 %t2327:p};
// %t2328 = $IO_PORT @ATTACH &target_k4 => @PLACE(366, -1503) => @ORIENT("R0");
// %t2328 @TEXT("target_k4", key="name", size=0.75);
// &target_k4 @WIRE(mode="straight") {#X453:1 %t2328:p};
// %t2329 = $IO_PORT @ATTACH &target_k5 => @PLACE(366, -1507) => @ORIENT("R0");
// %t2329 @TEXT("target_k5", key="name", size=0.75);
// &target_k5 @WIRE(mode="straight") {#X453:2 %t2329:p};
// %t2330 = $IO_PORT @ATTACH &n729 => @PLACE(386, -1505) => @ORIENT("MY");
// %t2330 @TEXT("n729", key="name", size=0.75);
// &n729 @WIRE(mode="straight") {#X453:3 %t2330:p};
// %t2331 = $SUPPLY @ATTACH &vdd => @PLACE(376, -1494);
// &vdd @WIRE(mode="straight") {#X453:4 %t2331:p};
// %t2332 = $GROUND @ATTACH &vss => @PLACE(376, -1516);
// &vss @WIRE(mode="straight") {#X453:5 %t2332:p};
// %t2333 = $IO_PORT @ATTACH &target_k1 => @PLACE(406, -1503) => @ORIENT("R0");
// %t2333 @TEXT("target_k1", key="name", size=0.75);
// &target_k1 @WIRE(mode="straight") {#X454:1 %t2333:p};
// %t2334 = $IO_PORT @ATTACH &target_k2 => @PLACE(406, -1507) => @ORIENT("R0");
// %t2334 @TEXT("target_k2", key="name", size=0.75);
// &target_k2 @WIRE(mode="straight") {#X454:2 %t2334:p};
// %t2335 = $IO_PORT @ATTACH &n448 => @PLACE(426, -1505) => @ORIENT("MY");
// %t2335 @TEXT("n448", key="name", size=0.75);
// &n448 @WIRE(mode="straight") {#X454:3 %t2335:p};
// %t2336 = $SUPPLY @ATTACH &vdd => @PLACE(416, -1494);
// &vdd @WIRE(mode="straight") {#X454:4 %t2336:p};
// %t2337 = $GROUND @ATTACH &vss => @PLACE(416, -1516);
// &vss @WIRE(mode="straight") {#X454:5 %t2337:p};
// %t2338 = $IO_PORT @ATTACH &target_k2 => @PLACE(446, -1503) => @ORIENT("R0");
// %t2338 @TEXT("target_k2", key="name", size=0.75);
// &target_k2 @WIRE(mode="straight") {#X455:1 %t2338:p};
// %t2339 = $IO_PORT @ATTACH &target_k3 => @PLACE(446, -1507) => @ORIENT("R0");
// %t2339 @TEXT("target_k3", key="name", size=0.75);
// &target_k3 @WIRE(mode="straight") {#X455:2 %t2339:p};
// %t2340 = $IO_PORT @ATTACH &n451 => @PLACE(466, -1505) => @ORIENT("MY");
// %t2340 @TEXT("n451", key="name", size=0.75);
// &n451 @WIRE(mode="straight") {#X455:3 %t2340:p};
// %t2341 = $SUPPLY @ATTACH &vdd => @PLACE(456, -1494);
// &vdd @WIRE(mode="straight") {#X455:4 %t2341:p};
// %t2342 = $GROUND @ATTACH &vss => @PLACE(456, -1516);
// &vss @WIRE(mode="straight") {#X455:5 %t2342:p};
// %t2343 = $IO_PORT @ATTACH &target_k3 => @PLACE(494, -1348) => @ORIENT("R0");
// %t2343 @TEXT("target_k3", key="name", size=0.75);
// &target_k3 @WIRE(mode="straight") {#X456:1 %t2343:p};
// %t2344 = $IO_PORT @ATTACH &target_k4 => @PLACE(494, -1352) => @ORIENT("R0");
// %t2344 @TEXT("target_k4", key="name", size=0.75);
// &target_k4 @WIRE(mode="straight") {#X456:2 %t2344:p};
// %t2345 = $IO_PORT @ATTACH &n454 => @PLACE(514, -1350) => @ORIENT("MY");
// %t2345 @TEXT("n454", key="name", size=0.75);
// &n454 @WIRE(mode="straight") {#X456:3 %t2345:p};
// %t2346 = $SUPPLY @ATTACH &vdd => @PLACE(504, -1339);
// &vdd @WIRE(mode="straight") {#X456:4 %t2346:p};
// %t2347 = $GROUND @ATTACH &vss => @PLACE(504, -1361);
// &vss @WIRE(mode="straight") {#X456:5 %t2347:p};
// %t2348 = $IO_PORT @ATTACH &target_k4 => @PLACE(534, -1348) => @ORIENT("R0");
// %t2348 @TEXT("target_k4", key="name", size=0.75);
// &target_k4 @WIRE(mode="straight") {#X457:1 %t2348:p};
// %t2349 = $IO_PORT @ATTACH &target_k5 => @PLACE(534, -1352) => @ORIENT("R0");
// %t2349 @TEXT("target_k5", key="name", size=0.75);
// &target_k5 @WIRE(mode="straight") {#X457:2 %t2349:p};
// %t2350 = $IO_PORT @ATTACH &n457 => @PLACE(554, -1350) => @ORIENT("MY");
// %t2350 @TEXT("n457", key="name", size=0.75);
// &n457 @WIRE(mode="straight") {#X457:3 %t2350:p};
// %t2351 = $SUPPLY @ATTACH &vdd => @PLACE(544, -1339);
// &vdd @WIRE(mode="straight") {#X457:4 %t2351:p};
// %t2352 = $GROUND @ATTACH &vss => @PLACE(544, -1361);
// &vss @WIRE(mode="straight") {#X457:5 %t2352:p};
// %t2353 = $IO_PORT @ATTACH &n730 => @PLACE(574, -1348) => @ORIENT("R0");
// %t2353 @TEXT("n730", key="name", size=0.75);
// &n730 @WIRE(mode="straight") {#X458:1 %t2353:p};
// %t2354 = $IO_PORT @ATTACH &n731 => @PLACE(574, -1352) => @ORIENT("R0");
// %t2354 @TEXT("n731", key="name", size=0.75);
// &n731 @WIRE(mode="straight") {#X458:2 %t2354:p};
// %t2355 = $IO_PORT @ATTACH &n458 => @PLACE(594, -1350) => @ORIENT("MY");
// %t2355 @TEXT("n458", key="name", size=0.75);
// &n458 @WIRE(mode="straight") {#X458:3 %t2355:p};
// %t2356 = $SUPPLY @ATTACH &vdd => @PLACE(584, -1339);
// &vdd @WIRE(mode="straight") {#X458:4 %t2356:p};
// %t2357 = $GROUND @ATTACH &vss => @PLACE(584, -1361);
// &vss @WIRE(mode="straight") {#X458:5 %t2357:p};
// %t2358 = $IO_PORT @ATTACH &n732 => @PLACE(614, -1348) => @ORIENT("R0");
// %t2358 @TEXT("n732", key="name", size=0.75);
// &n732 @WIRE(mode="straight") {#X459:1 %t2358:p};
// %t2359 = $IO_PORT @ATTACH &n733 => @PLACE(614, -1352) => @ORIENT("R0");
// %t2359 @TEXT("n733", key="name", size=0.75);
// &n733 @WIRE(mode="straight") {#X459:2 %t2359:p};
// %t2360 = $IO_PORT @ATTACH &n452 => @PLACE(635, -1350) => @ORIENT("MY");
// %t2360 @TEXT("n452", key="name", size=0.75);
// &n452 @WIRE(mode="straight") {#X459:3 %t2360:p};
// %t2361 = $SUPPLY @ATTACH &vdd => @PLACE(624, -1339);
// &vdd @WIRE(mode="straight") {#X459:4 %t2361:p};
// %t2362 = $GROUND @ATTACH &vss => @PLACE(624, -1361);
// &vss @WIRE(mode="straight") {#X459:5 %t2362:p};
// %t2363 = $IO_PORT @ATTACH &target_k5 => @PLACE(494, -1379) => @ORIENT("R0");
// %t2363 @TEXT("target_k5", key="name", size=0.75);
// &target_k5 @WIRE(mode="straight") {#X460:1 %t2363:p};
// %t2364 = $IO_PORT @ATTACH &n460 => @PLACE(494, -1383) => @ORIENT("R0");
// %t2364 @TEXT("n460", key="name", size=0.75);
// &n460 @WIRE(mode="straight") {#X460:2 %t2364:p};
// %t2365 = $IO_PORT @ATTACH &n734 => @PLACE(514, -1381) => @ORIENT("MY");
// %t2365 @TEXT("n734", key="name", size=0.75);
// &n734 @WIRE(mode="straight") {#X460:3 %t2365:p};
// %t2366 = $SUPPLY @ATTACH &vdd => @PLACE(504, -1370);
// &vdd @WIRE(mode="straight") {#X460:4 %t2366:p};
// %t2367 = $GROUND @ATTACH &vss => @PLACE(504, -1392);
// &vss @WIRE(mode="straight") {#X460:5 %t2367:p};
// %t2368 = $IO_PORT @ATTACH &n735 => @PLACE(534, -1379) => @ORIENT("R0");
// %t2368 @TEXT("n735", key="name", size=0.75);
// &n735 @WIRE(mode="straight") {#X461:1 %t2368:p};
// %t2369 = $IO_PORT @ATTACH &n736 => @PLACE(534, -1383) => @ORIENT("R0");
// %t2369 @TEXT("n736", key="name", size=0.75);
// &n736 @WIRE(mode="straight") {#X461:2 %t2369:p};
// %t2370 = $IO_PORT @ATTACH &n460 => @PLACE(554, -1381) => @ORIENT("MY");
// %t2370 @TEXT("n460", key="name", size=0.75);
// &n460 @WIRE(mode="straight") {#X461:3 %t2370:p};
// %t2371 = $SUPPLY @ATTACH &vdd => @PLACE(544, -1370);
// &vdd @WIRE(mode="straight") {#X461:4 %t2371:p};
// %t2372 = $GROUND @ATTACH &vss => @PLACE(544, -1392);
// &vss @WIRE(mode="straight") {#X461:5 %t2372:p};
// %t2373 = $IO_PORT @ATTACH &n737 => @PLACE(574, -1379) => @ORIENT("R0");
// %t2373 @TEXT("n737", key="name", size=0.75);
// &n737 @WIRE(mode="straight") {#X462:1 %t2373:p};
// %t2374 = $IO_PORT @ATTACH &n455 => @PLACE(574, -1383) => @ORIENT("R0");
// %t2374 @TEXT("n455", key="name", size=0.75);
// &n455 @WIRE(mode="straight") {#X462:2 %t2374:p};
// %t2375 = $IO_PORT @ATTACH &n736 => @PLACE(594, -1381) => @ORIENT("MY");
// %t2375 @TEXT("n736", key="name", size=0.75);
// &n736 @WIRE(mode="straight") {#X462:3 %t2375:p};
// %t2376 = $SUPPLY @ATTACH &vdd => @PLACE(584, -1370);
// &vdd @WIRE(mode="straight") {#X462:4 %t2376:p};
// %t2377 = $GROUND @ATTACH &vss => @PLACE(584, -1392);
// &vss @WIRE(mode="straight") {#X462:5 %t2377:p};
// %t2378 = $IO_PORT @ATTACH &n448 => @PLACE(614, -1379) => @ORIENT("R0");
// %t2378 @TEXT("n448", key="name", size=0.75);
// &n448 @WIRE(mode="straight") {#X463:1 %t2378:p};
// %t2379 = $IO_PORT @ATTACH &n449 => @PLACE(614, -1383) => @ORIENT("R0");
// %t2379 @TEXT("n449", key="name", size=0.75);
// &n449 @WIRE(mode="straight") {#X463:2 %t2379:p};
// %t2380 = $IO_PORT @ATTACH &n733 => @PLACE(635, -1381) => @ORIENT("MY");
// %t2380 @TEXT("n733", key="name", size=0.75);
// &n733 @WIRE(mode="straight") {#X463:3 %t2380:p};
// %t2381 = $SUPPLY @ATTACH &vdd => @PLACE(624, -1370);
// &vdd @WIRE(mode="straight") {#X463:4 %t2381:p};
// %t2382 = $GROUND @ATTACH &vss => @PLACE(624, -1392);
// &vss @WIRE(mode="straight") {#X463:5 %t2382:p};
// %t2383 = $IO_PORT @ATTACH &n738 => @PLACE(494, -1410) => @ORIENT("R0");
// %t2383 @TEXT("n738", key="name", size=0.75);
// &n738 @WIRE(mode="straight") {#X464:1 %t2383:p};
// %t2384 = $IO_PORT @ATTACH &n739 => @PLACE(494, -1414) => @ORIENT("R0");
// %t2384 @TEXT("n739", key="name", size=0.75);
// &n739 @WIRE(mode="straight") {#X464:2 %t2384:p};
// %t2385 = $IO_PORT @ATTACH &n455 => @PLACE(514, -1412) => @ORIENT("MY");
// %t2385 @TEXT("n455", key="name", size=0.75);
// &n455 @WIRE(mode="straight") {#X464:3 %t2385:p};
// %t2386 = $SUPPLY @ATTACH &vdd => @PLACE(504, -1401);
// &vdd @WIRE(mode="straight") {#X464:4 %t2386:p};
// %t2387 = $GROUND @ATTACH &vss => @PLACE(504, -1423);
// &vss @WIRE(mode="straight") {#X464:5 %t2387:p};
// %t2388 = $IO_PORT @ATTACH &n740 => @PLACE(534, -1410) => @ORIENT("R0");
// %t2388 @TEXT("n740", key="name", size=0.75);
// &n740 @WIRE(mode="straight") {#X465:1 %t2388:p};
// %t2389 = $IO_PORT @ATTACH &n449 => @PLACE(534, -1414) => @ORIENT("R0");
// %t2389 @TEXT("n449", key="name", size=0.75);
// &n449 @WIRE(mode="straight") {#X465:2 %t2389:p};
// %t2390 = $IO_PORT @ATTACH &n739 => @PLACE(554, -1412) => @ORIENT("MY");
// %t2390 @TEXT("n739", key="name", size=0.75);
// &n739 @WIRE(mode="straight") {#X465:3 %t2390:p};
// %t2391 = $SUPPLY @ATTACH &vdd => @PLACE(544, -1401);
// &vdd @WIRE(mode="straight") {#X465:4 %t2391:p};
// %t2392 = $GROUND @ATTACH &vss => @PLACE(544, -1423);
// &vss @WIRE(mode="straight") {#X465:5 %t2392:p};
// %t2393 = $IO_PORT @ATTACH &n457 => @PLACE(574, -1410) => @ORIENT("R0");
// %t2393 @TEXT("n457", key="name", size=0.75);
// &n457 @WIRE(mode="straight") {#X466:1 %t2393:p};
// %t2394 = $IO_PORT @ATTACH &n454 => @PLACE(574, -1414) => @ORIENT("R0");
// %t2394 @TEXT("n454", key="name", size=0.75);
// &n454 @WIRE(mode="straight") {#X466:2 %t2394:p};
// %t2395 = $IO_PORT @ATTACH &n737 => @PLACE(594, -1412) => @ORIENT("MY");
// %t2395 @TEXT("n737", key="name", size=0.75);
// &n737 @WIRE(mode="straight") {#X466:3 %t2395:p};
// %t2396 = $SUPPLY @ATTACH &vdd => @PLACE(584, -1401);
// &vdd @WIRE(mode="straight") {#X466:4 %t2396:p};
// %t2397 = $GROUND @ATTACH &vss => @PLACE(584, -1423);
// &vss @WIRE(mode="straight") {#X466:5 %t2397:p};
// %t2398 = $IO_PORT @ATTACH &n729 => @PLACE(614, -1410) => @ORIENT("R0");
// %t2398 @TEXT("n729", key="name", size=0.75);
// &n729 @WIRE(mode="straight") {#X467:1 %t2398:p};
// %t2399 = $IO_PORT @ATTACH &n741 => @PLACE(614, -1414) => @ORIENT("R0");
// %t2399 @TEXT("n741", key="name", size=0.75);
// &n741 @WIRE(mode="straight") {#X467:2 %t2399:p};
// %t2400 = $IO_PORT @ATTACH &n735 => @PLACE(635, -1412) => @ORIENT("MY");
// %t2400 @TEXT("n735", key="name", size=0.75);
// &n735 @WIRE(mode="straight") {#X467:3 %t2400:p};
// %t2401 = $SUPPLY @ATTACH &vdd => @PLACE(624, -1401);
// &vdd @WIRE(mode="straight") {#X467:4 %t2401:p};
// %t2402 = $GROUND @ATTACH &vss => @PLACE(624, -1423);
// &vss @WIRE(mode="straight") {#X467:5 %t2402:p};
// %t2403 = $IO_PORT @ATTACH &n457 => @PLACE(494, -1441) => @ORIENT("R0");
// %t2403 @TEXT("n457", key="name", size=0.75);
// &n457 @WIRE(mode="straight") {#X468:1 %t2403:p};
// %t2404 = $IO_PORT @ATTACH &n730 => @PLACE(494, -1445) => @ORIENT("R0");
// %t2404 @TEXT("n730", key="name", size=0.75);
// &n730 @WIRE(mode="straight") {#X468:2 %t2404:p};
// %t2405 = $IO_PORT @ATTACH &n741 => @PLACE(514, -1443) => @ORIENT("MY");
// %t2405 @TEXT("n741", key="name", size=0.75);
// &n741 @WIRE(mode="straight") {#X468:3 %t2405:p};
// %t2406 = $SUPPLY @ATTACH &vdd => @PLACE(504, -1432);
// &vdd @WIRE(mode="straight") {#X468:4 %t2406:p};
// %t2407 = $GROUND @ATTACH &vss => @PLACE(504, -1454);
// &vss @WIRE(mode="straight") {#X468:5 %t2407:p};
// %t2408 = $IO_PORT @ATTACH &n451 => @PLACE(534, -1441) => @ORIENT("R0");
// %t2408 @TEXT("n451", key="name", size=0.75);
// &n451 @WIRE(mode="straight") {#X469:1 %t2408:p};
// %t2409 = $IO_PORT @ATTACH &n448 => @PLACE(534, -1445) => @ORIENT("R0");
// %t2409 @TEXT("n448", key="name", size=0.75);
// &n448 @WIRE(mode="straight") {#X469:2 %t2409:p};
// %t2410 = $IO_PORT @ATTACH &n740 => @PLACE(554, -1443) => @ORIENT("MY");
// %t2410 @TEXT("n740", key="name", size=0.75);
// &n740 @WIRE(mode="straight") {#X469:3 %t2410:p};
// %t2411 = $SUPPLY @ATTACH &vdd => @PLACE(544, -1432);
// &vdd @WIRE(mode="straight") {#X469:4 %t2411:p};
// %t2412 = $GROUND @ATTACH &vss => @PLACE(544, -1454);
// &vss @WIRE(mode="straight") {#X469:5 %t2412:p};
// %t2413 = $IO_PORT @ATTACH &n742 => @PLACE(574, -1441) => @ORIENT("R0");
// %t2413 @TEXT("n742", key="name", size=0.75);
// &n742 @WIRE(mode="straight") {#X470:1 %t2413:p};
// %t2414 = $IO_PORT @ATTACH &n743 => @PLACE(574, -1445) => @ORIENT("R0");
// %t2414 @TEXT("n743", key="name", size=0.75);
// &n743 @WIRE(mode="straight") {#X470:2 %t2414:p};
// %t2415 = $IO_PORT @ATTACH &n738 => @PLACE(594, -1443) => @ORIENT("MY");
// %t2415 @TEXT("n738", key="name", size=0.75);
// &n738 @WIRE(mode="straight") {#X470:3 %t2415:p};
// %t2416 = $SUPPLY @ATTACH &vdd => @PLACE(584, -1432);
// &vdd @WIRE(mode="straight") {#X470:4 %t2416:p};
// %t2417 = $GROUND @ATTACH &vss => @PLACE(584, -1454);
// &vss @WIRE(mode="straight") {#X470:5 %t2417:p};
// %t2418 = $IO_PORT @ATTACH &n451 => @PLACE(614, -1441) => @ORIENT("R0");
// %t2418 @TEXT("n451", key="name", size=0.75);
// &n451 @WIRE(mode="straight") {#X471:1 %t2418:p};
// %t2419 = $IO_PORT @ATTACH &n732 => @PLACE(614, -1445) => @ORIENT("R0");
// %t2419 @TEXT("n732", key="name", size=0.75);
// &n732 @WIRE(mode="straight") {#X471:2 %t2419:p};
// %t2420 = $IO_PORT @ATTACH &n743 => @PLACE(635, -1443) => @ORIENT("MY");
// %t2420 @TEXT("n743", key="name", size=0.75);
// &n743 @WIRE(mode="straight") {#X471:3 %t2420:p};
// %t2421 = $SUPPLY @ATTACH &vdd => @PLACE(624, -1432);
// &vdd @WIRE(mode="straight") {#X471:4 %t2421:p};
// %t2422 = $GROUND @ATTACH &vss => @PLACE(624, -1454);
// &vss @WIRE(mode="straight") {#X471:5 %t2422:p};
// %t2423 = $IO_PORT @ATTACH &n454 => @PLACE(494, -1472) => @ORIENT("R0");
// %t2423 @TEXT("n454", key="name", size=0.75);
// &n454 @WIRE(mode="straight") {#X472:1 %t2423:p};
// %t2424 = $IO_PORT @ATTACH &n455 => @PLACE(494, -1476) => @ORIENT("R0");
// %t2424 @TEXT("n455", key="name", size=0.75);
// &n455 @WIRE(mode="straight") {#X472:2 %t2424:p};
// %t2425 = $IO_PORT @ATTACH &n731 => @PLACE(514, -1474) => @ORIENT("MY");
// %t2425 @TEXT("n731", key="name", size=0.75);
// &n731 @WIRE(mode="straight") {#X472:3 %t2425:p};
// %t2426 = $SUPPLY @ATTACH &vdd => @PLACE(504, -1463);
// &vdd @WIRE(mode="straight") {#X472:4 %t2426:p};
// %t2427 = $GROUND @ATTACH &vss => @PLACE(504, -1485);
// &vss @WIRE(mode="straight") {#X472:5 %t2427:p};
// %t2428 = $IO_PORT @ATTACH &target_k5 => @PLACE(534, -1472) => @ORIENT("R0");
// %t2428 @TEXT("target_k5", key="name", size=0.75);
// &target_k5 @WIRE(mode="straight") {#X473:1 %t2428:p};
// %t2429 = $IO_PORT @ATTACH &n744 => @PLACE(534, -1476) => @ORIENT("R0");
// %t2429 @TEXT("n744", key="name", size=0.75);
// &n744 @WIRE(mode="straight") {#X473:2 %t2429:p};
// %t2430 = $IO_PORT @ATTACH &n263 => @PLACE(554, -1474) => @ORIENT("MY");
// %t2430 @TEXT("n263", key="name", size=0.75);
// &n263 @WIRE(mode="straight") {#X473:3 %t2430:p};
// %t2431 = $SUPPLY @ATTACH &vdd => @PLACE(544, -1463);
// &vdd @WIRE(mode="straight") {#X473:4 %t2431:p};
// %t2432 = $GROUND @ATTACH &vss => @PLACE(544, -1485);
// &vss @WIRE(mode="straight") {#X473:5 %t2432:p};
// %t2433 = $IO_PORT @ATTACH &n745 => @PLACE(574, -1472) => @ORIENT("R0");
// %t2433 @TEXT("n745", key="name", size=0.75);
// &n745 @WIRE(mode="straight") {#X474:1 %t2433:p};
// %t2434 = $IO_PORT @ATTACH &n746 => @PLACE(574, -1476) => @ORIENT("R0");
// %t2434 @TEXT("n746", key="name", size=0.75);
// &n746 @WIRE(mode="straight") {#X474:2 %t2434:p};
// %t2435 = $IO_PORT @ATTACH &n744 => @PLACE(594, -1474) => @ORIENT("MY");
// %t2435 @TEXT("n744", key="name", size=0.75);
// &n744 @WIRE(mode="straight") {#X474:3 %t2435:p};
// %t2436 = $SUPPLY @ATTACH &vdd => @PLACE(584, -1463);
// &vdd @WIRE(mode="straight") {#X474:4 %t2436:p};
// %t2437 = $GROUND @ATTACH &vss => @PLACE(584, -1485);
// &vss @WIRE(mode="straight") {#X474:5 %t2437:p};
// %t2438 = $IO_PORT @ATTACH &n747 => @PLACE(614, -1472) => @ORIENT("R0");
// %t2438 @TEXT("n747", key="name", size=0.75);
// &n747 @WIRE(mode="straight") {#X475:1 %t2438:p};
// %t2439 = $IO_PORT @ATTACH &target_k4 => @PLACE(614, -1476) => @ORIENT("R0");
// %t2439 @TEXT("target_k4", key="name", size=0.75);
// &target_k4 @WIRE(mode="straight") {#X475:2 %t2439:p};
// %t2440 = $IO_PORT @ATTACH &n745 => @PLACE(635, -1474) => @ORIENT("MY");
// %t2440 @TEXT("n745", key="name", size=0.75);
// &n745 @WIRE(mode="straight") {#X475:3 %t2440:p};
// %t2441 = $SUPPLY @ATTACH &vdd => @PLACE(624, -1463);
// &vdd @WIRE(mode="straight") {#X475:4 %t2441:p};
// %t2442 = $GROUND @ATTACH &vss => @PLACE(624, -1485);
// &vss @WIRE(mode="straight") {#X475:5 %t2442:p};
// %t2443 = $IO_PORT @ATTACH &n745 => @PLACE(494, -1503) => @ORIENT("R0");
// %t2443 @TEXT("n745", key="name", size=0.75);
// &n745 @WIRE(mode="straight") {#X476:1 %t2443:p};
// %t2444 = $IO_PORT @ATTACH &n748 => @PLACE(494, -1507) => @ORIENT("R0");
// %t2444 @TEXT("n748", key="name", size=0.75);
// &n748 @WIRE(mode="straight") {#X476:2 %t2444:p};
// %t2445 = $IO_PORT @ATTACH &n749 => @PLACE(514, -1505) => @ORIENT("MY");
// %t2445 @TEXT("n749", key="name", size=0.75);
// &n749 @WIRE(mode="straight") {#X476:3 %t2445:p};
// %t2446 = $SUPPLY @ATTACH &vdd => @PLACE(504, -1494);
// &vdd @WIRE(mode="straight") {#X476:4 %t2446:p};
// %t2447 = $GROUND @ATTACH &vss => @PLACE(504, -1516);
// &vss @WIRE(mode="straight") {#X476:5 %t2447:p};
// %t2448 = $IO_PORT @ATTACH &target_k5 => @PLACE(534, -1503) => @ORIENT("R0");
// %t2448 @TEXT("target_k5", key="name", size=0.75);
// &target_k5 @WIRE(mode="straight") {#X477:1 %t2448:p};
// %t2449 = $IO_PORT @ATTACH &n749 => @PLACE(534, -1507) => @ORIENT("R0");
// %t2449 @TEXT("n749", key="name", size=0.75);
// &n749 @WIRE(mode="straight") {#X477:2 %t2449:p};
// %t2450 = $IO_PORT @ATTACH &n261 => @PLACE(554, -1505) => @ORIENT("MY");
// %t2450 @TEXT("n261", key="name", size=0.75);
// &n261 @WIRE(mode="straight") {#X477:3 %t2450:p};
// %t2451 = $SUPPLY @ATTACH &vdd => @PLACE(544, -1494);
// &vdd @WIRE(mode="straight") {#X477:4 %t2451:p};
// %t2452 = $GROUND @ATTACH &vss => @PLACE(544, -1516);
// &vss @WIRE(mode="straight") {#X477:5 %t2452:p};
// %t2453 = $IO_PORT @ATTACH &n750 => @PLACE(574, -1503) => @ORIENT("R0");
// %t2453 @TEXT("n750", key="name", size=0.75);
// &n750 @WIRE(mode="straight") {#X478:1 %t2453:p};
// %t2454 = $IO_PORT @ATTACH &n751 => @PLACE(574, -1507) => @ORIENT("R0");
// %t2454 @TEXT("n751", key="name", size=0.75);
// &n751 @WIRE(mode="straight") {#X478:2 %t2454:p};
// %t2455 = $IO_PORT @ATTACH &n748 => @PLACE(594, -1505) => @ORIENT("MY");
// %t2455 @TEXT("n748", key="name", size=0.75);
// &n748 @WIRE(mode="straight") {#X478:3 %t2455:p};
// %t2456 = $SUPPLY @ATTACH &vdd => @PLACE(584, -1494);
// &vdd @WIRE(mode="straight") {#X478:4 %t2456:p};
// %t2457 = $GROUND @ATTACH &vss => @PLACE(584, -1516);
// &vss @WIRE(mode="straight") {#X478:5 %t2457:p};
// %t2458 = $IO_PORT @ATTACH &n752 => @PLACE(614, -1503) => @ORIENT("R0");
// %t2458 @TEXT("n752", key="name", size=0.75);
// &n752 @WIRE(mode="straight") {#X479:1 %t2458:p};
// %t2459 = $IO_PORT @ATTACH &target_k1 => @PLACE(614, -1507) => @ORIENT("R0");
// %t2459 @TEXT("target_k1", key="name", size=0.75);
// &target_k1 @WIRE(mode="straight") {#X479:2 %t2459:p};
// %t2460 = $IO_PORT @ATTACH &n751 => @PLACE(635, -1505) => @ORIENT("MY");
// %t2460 @TEXT("n751", key="name", size=0.75);
// &n751 @WIRE(mode="straight") {#X479:3 %t2460:p};
// %t2461 = $SUPPLY @ATTACH &vdd => @PLACE(624, -1494);
// &vdd @WIRE(mode="straight") {#X479:4 %t2461:p};
// %t2462 = $GROUND @ATTACH &vss => @PLACE(624, -1516);
// &vss @WIRE(mode="straight") {#X479:5 %t2462:p};
// %t2463 = $IO_PORT @ATTACH &target_k3 => @PLACE(-11, -1546) => @ORIENT("R0");
// %t2463 @TEXT("target_k3", key="name", size=0.75);
// &target_k3 @WIRE(mode="straight") {#X480:1 %t2463:p};
// %t2464 = $IO_PORT @ATTACH &n753 => @PLACE(-11, -1550) => @ORIENT("R0");
// %t2464 @TEXT("n753", key="name", size=0.75);
// &n753 @WIRE(mode="straight") {#X480:2 %t2464:p};
// %t2465 = $IO_PORT @ATTACH &n750 => @PLACE(10, -1548) => @ORIENT("MY");
// %t2465 @TEXT("n750", key="name", size=0.75);
// &n750 @WIRE(mode="straight") {#X480:3 %t2465:p};
// %t2466 = $SUPPLY @ATTACH &vdd => @PLACE(0, -1537);
// &vdd @WIRE(mode="straight") {#X480:4 %t2466:p};
// %t2467 = $GROUND @ATTACH &vss => @PLACE(0, -1559);
// &vss @WIRE(mode="straight") {#X480:5 %t2467:p};
// %t2468 = $IO_PORT @ATTACH &n754 => @PLACE(30, -1546) => @ORIENT("R0");
// %t2468 @TEXT("n754", key="name", size=0.75);
// &n754 @WIRE(mode="straight") {#X481:1 %t2468:p};
// %t2469 = $IO_PORT @ATTACH &target_k2 => @PLACE(30, -1550) => @ORIENT("R0");
// %t2469 @TEXT("target_k2", key="name", size=0.75);
// &target_k2 @WIRE(mode="straight") {#X481:2 %t2469:p};
// %t2470 = $IO_PORT @ATTACH &n753 => @PLACE(50, -1548) => @ORIENT("MY");
// %t2470 @TEXT("n753", key="name", size=0.75);
// &n753 @WIRE(mode="straight") {#X481:3 %t2470:p};
// %t2471 = $SUPPLY @ATTACH &vdd => @PLACE(40, -1537);
// &vdd @WIRE(mode="straight") {#X481:4 %t2471:p};
// %t2472 = $GROUND @ATTACH &vss => @PLACE(40, -1559);
// &vss @WIRE(mode="straight") {#X481:5 %t2472:p};
// %t2473 = $IO_PORT @ATTACH &target_k0 => @PLACE(70, -1546) => @ORIENT("R0");
// %t2473 @TEXT("target_k0", key="name", size=0.75);
// &target_k0 @WIRE(mode="straight") {#X482:1 %t2473:p};
// %t2474 = $IO_PORT @ATTACH &target_k2 => @PLACE(70, -1550) => @ORIENT("R0");
// %t2474 @TEXT("target_k2", key="name", size=0.75);
// &target_k2 @WIRE(mode="straight") {#X482:2 %t2474:p};
// %t2475 = $IO_PORT @ATTACH &n464 => @PLACE(90, -1548) => @ORIENT("MY");
// %t2475 @TEXT("n464", key="name", size=0.75);
// &n464 @WIRE(mode="straight") {#X482:3 %t2475:p};
// %t2476 = $SUPPLY @ATTACH &vdd => @PLACE(80, -1537);
// &vdd @WIRE(mode="straight") {#X482:4 %t2476:p};
// %t2477 = $GROUND @ATTACH &vss => @PLACE(80, -1559);
// &vss @WIRE(mode="straight") {#X482:5 %t2477:p};
// %t2478 = $IO_PORT @ATTACH &target_k1 => @PLACE(110, -1546) => @ORIENT("R0");
// %t2478 @TEXT("target_k1", key="name", size=0.75);
// &target_k1 @WIRE(mode="straight") {#X483:1 %t2478:p};
// %t2479 = $IO_PORT @ATTACH &target_k3 => @PLACE(110, -1550) => @ORIENT("R0");
// %t2479 @TEXT("target_k3", key="name", size=0.75);
// &target_k3 @WIRE(mode="straight") {#X483:2 %t2479:p};
// %t2480 = $IO_PORT @ATTACH &n755 => @PLACE(130, -1548) => @ORIENT("MY");
// %t2480 @TEXT("n755", key="name", size=0.75);
// &n755 @WIRE(mode="straight") {#X483:3 %t2480:p};
// %t2481 = $SUPPLY @ATTACH &vdd => @PLACE(120, -1537);
// &vdd @WIRE(mode="straight") {#X483:4 %t2481:p};
// %t2482 = $GROUND @ATTACH &vss => @PLACE(120, -1559);
// &vss @WIRE(mode="straight") {#X483:5 %t2482:p};
// %t2483 = $IO_PORT @ATTACH &target_k2 => @PLACE(-11, -1577) => @ORIENT("R0");
// %t2483 @TEXT("target_k2", key="name", size=0.75);
// &target_k2 @WIRE(mode="straight") {#X484:1 %t2483:p};
// %t2484 = $IO_PORT @ATTACH &target_k4 => @PLACE(-11, -1581) => @ORIENT("R0");
// %t2484 @TEXT("target_k4", key="name", size=0.75);
// &target_k4 @WIRE(mode="straight") {#X484:2 %t2484:p};
// %t2485 = $IO_PORT @ATTACH &n756 => @PLACE(10, -1579) => @ORIENT("MY");
// %t2485 @TEXT("n756", key="name", size=0.75);
// &n756 @WIRE(mode="straight") {#X484:3 %t2485:p};
// %t2486 = $SUPPLY @ATTACH &vdd => @PLACE(0, -1568);
// &vdd @WIRE(mode="straight") {#X484:4 %t2486:p};
// %t2487 = $GROUND @ATTACH &vss => @PLACE(0, -1590);
// &vss @WIRE(mode="straight") {#X484:5 %t2487:p};
// %t2488 = $IO_PORT @ATTACH &target_k3 => @PLACE(30, -1577) => @ORIENT("R0");
// %t2488 @TEXT("target_k3", key="name", size=0.75);
// &target_k3 @WIRE(mode="straight") {#X485:1 %t2488:p};
// %t2489 = $IO_PORT @ATTACH &target_k5 => @PLACE(30, -1581) => @ORIENT("R0");
// %t2489 @TEXT("target_k5", key="name", size=0.75);
// &target_k5 @WIRE(mode="straight") {#X485:2 %t2489:p};
// %t2490 = $IO_PORT @ATTACH &n757 => @PLACE(50, -1579) => @ORIENT("MY");
// %t2490 @TEXT("n757", key="name", size=0.75);
// &n757 @WIRE(mode="straight") {#X485:3 %t2490:p};
// %t2491 = $SUPPLY @ATTACH &vdd => @PLACE(40, -1568);
// &vdd @WIRE(mode="straight") {#X485:4 %t2491:p};
// %t2492 = $GROUND @ATTACH &vss => @PLACE(40, -1590);
// &vss @WIRE(mode="straight") {#X485:5 %t2492:p};
// %t2493 = $IO_PORT @ATTACH &target_k0 => @PLACE(70, -1577) => @ORIENT("R0");
// %t2493 @TEXT("target_k0", key="name", size=0.75);
// &target_k0 @WIRE(mode="straight") {#X486:1 %t2493:p};
// %t2494 = $IO_PORT @ATTACH &target_k2 => @PLACE(70, -1581) => @ORIENT("R0");
// %t2494 @TEXT("target_k2", key="name", size=0.75);
// &target_k2 @WIRE(mode="straight") {#X486:2 %t2494:p};
// %t2495 = $IO_PORT @ATTACH &n758 => @PLACE(90, -1579) => @ORIENT("MY");
// %t2495 @TEXT("n758", key="name", size=0.75);
// &n758 @WIRE(mode="straight") {#X486:3 %t2495:p};
// %t2496 = $SUPPLY @ATTACH &vdd => @PLACE(80, -1568);
// &vdd @WIRE(mode="straight") {#X486:4 %t2496:p};
// %t2497 = $GROUND @ATTACH &vss => @PLACE(80, -1590);
// &vss @WIRE(mode="straight") {#X486:5 %t2497:p};
// %t2498 = $IO_PORT @ATTACH &target_k1 => @PLACE(110, -1577) => @ORIENT("R0");
// %t2498 @TEXT("target_k1", key="name", size=0.75);
// &target_k1 @WIRE(mode="straight") {#X487:1 %t2498:p};
// %t2499 = $IO_PORT @ATTACH &target_k3 => @PLACE(110, -1581) => @ORIENT("R0");
// %t2499 @TEXT("target_k3", key="name", size=0.75);
// &target_k3 @WIRE(mode="straight") {#X487:2 %t2499:p};
// %t2500 = $IO_PORT @ATTACH &n463 => @PLACE(130, -1579) => @ORIENT("MY");
// %t2500 @TEXT("n463", key="name", size=0.75);
// &n463 @WIRE(mode="straight") {#X487:3 %t2500:p};
// %t2501 = $SUPPLY @ATTACH &vdd => @PLACE(120, -1568);
// &vdd @WIRE(mode="straight") {#X487:4 %t2501:p};
// %t2502 = $GROUND @ATTACH &vss => @PLACE(120, -1590);
// &vss @WIRE(mode="straight") {#X487:5 %t2502:p};
// %t2503 = $IO_PORT @ATTACH &target_k2 => @PLACE(-11, -1608) => @ORIENT("R0");
// %t2503 @TEXT("target_k2", key="name", size=0.75);
// &target_k2 @WIRE(mode="straight") {#X488:1 %t2503:p};
// %t2504 = $IO_PORT @ATTACH &target_k4 => @PLACE(-11, -1612) => @ORIENT("R0");
// %t2504 @TEXT("target_k4", key="name", size=0.75);
// &target_k4 @WIRE(mode="straight") {#X488:2 %t2504:p};
// %t2505 = $IO_PORT @ATTACH &n466 => @PLACE(10, -1610) => @ORIENT("MY");
// %t2505 @TEXT("n466", key="name", size=0.75);
// &n466 @WIRE(mode="straight") {#X488:3 %t2505:p};
// %t2506 = $SUPPLY @ATTACH &vdd => @PLACE(0, -1599);
// &vdd @WIRE(mode="straight") {#X488:4 %t2506:p};
// %t2507 = $GROUND @ATTACH &vss => @PLACE(0, -1621);
// &vss @WIRE(mode="straight") {#X488:5 %t2507:p};
// %t2508 = $IO_PORT @ATTACH &target_k3 => @PLACE(30, -1608) => @ORIENT("R0");
// %t2508 @TEXT("target_k3", key="name", size=0.75);
// &target_k3 @WIRE(mode="straight") {#X489:1 %t2508:p};
// %t2509 = $IO_PORT @ATTACH &target_k5 => @PLACE(30, -1612) => @ORIENT("R0");
// %t2509 @TEXT("target_k5", key="name", size=0.75);
// &target_k5 @WIRE(mode="straight") {#X489:2 %t2509:p};
// %t2510 = $IO_PORT @ATTACH &n469 => @PLACE(50, -1610) => @ORIENT("MY");
// %t2510 @TEXT("n469", key="name", size=0.75);
// &n469 @WIRE(mode="straight") {#X489:3 %t2510:p};
// %t2511 = $SUPPLY @ATTACH &vdd => @PLACE(40, -1599);
// &vdd @WIRE(mode="straight") {#X489:4 %t2511:p};
// %t2512 = $GROUND @ATTACH &vss => @PLACE(40, -1621);
// &vss @WIRE(mode="straight") {#X489:5 %t2512:p};
// %t2513 = $IO_PORT @ATTACH &n756 => @PLACE(70, -1608) => @ORIENT("R0");
// %t2513 @TEXT("n756", key="name", size=0.75);
// &n756 @WIRE(mode="straight") {#X490:1 %t2513:p};
// %t2514 = $IO_PORT @ATTACH &n759 => @PLACE(70, -1612) => @ORIENT("R0");
// %t2514 @TEXT("n759", key="name", size=0.75);
// &n759 @WIRE(mode="straight") {#X490:2 %t2514:p};
// %t2515 = $IO_PORT @ATTACH &n470 => @PLACE(90, -1610) => @ORIENT("MY");
// %t2515 @TEXT("n470", key="name", size=0.75);
// &n470 @WIRE(mode="straight") {#X490:3 %t2515:p};
// %t2516 = $SUPPLY @ATTACH &vdd => @PLACE(80, -1599);
// &vdd @WIRE(mode="straight") {#X490:4 %t2516:p};
// %t2517 = $GROUND @ATTACH &vss => @PLACE(80, -1621);
// &vss @WIRE(mode="straight") {#X490:5 %t2517:p};
// %t2518 = $IO_PORT @ATTACH &target_k4 => @PLACE(110, -1608) => @ORIENT("R0");
// %t2518 @TEXT("target_k4", key="name", size=0.75);
// &target_k4 @WIRE(mode="straight") {#X491:1 %t2518:p};
// %t2519 = $IO_PORT @ATTACH &n472 => @PLACE(110, -1612) => @ORIENT("R0");
// %t2519 @TEXT("n472", key="name", size=0.75);
// &n472 @WIRE(mode="straight") {#X491:2 %t2519:p};
// %t2520 = $IO_PORT @ATTACH &n474 => @PLACE(130, -1610) => @ORIENT("MY");
// %t2520 @TEXT("n474", key="name", size=0.75);
// &n474 @WIRE(mode="straight") {#X491:3 %t2520:p};
// %t2521 = $SUPPLY @ATTACH &vdd => @PLACE(120, -1599);
// &vdd @WIRE(mode="straight") {#X491:4 %t2521:p};
// %t2522 = $GROUND @ATTACH &vss => @PLACE(120, -1621);
// &vss @WIRE(mode="straight") {#X491:5 %t2522:p};
// %t2523 = $IO_PORT @ATTACH &n760 => @PLACE(-11, -1639) => @ORIENT("R0");
// %t2523 @TEXT("n760", key="name", size=0.75);
// &n760 @WIRE(mode="straight") {#X492:1 %t2523:p};
// %t2524 = $IO_PORT @ATTACH &n761 => @PLACE(-11, -1643) => @ORIENT("R0");
// %t2524 @TEXT("n761", key="name", size=0.75);
// &n761 @WIRE(mode="straight") {#X492:2 %t2524:p};
// %t2525 = $IO_PORT @ATTACH &n472 => @PLACE(10, -1641) => @ORIENT("MY");
// %t2525 @TEXT("n472", key="name", size=0.75);
// &n472 @WIRE(mode="straight") {#X492:3 %t2525:p};
// %t2526 = $SUPPLY @ATTACH &vdd => @PLACE(0, -1630);
// &vdd @WIRE(mode="straight") {#X492:4 %t2526:p};
// %t2527 = $GROUND @ATTACH &vss => @PLACE(0, -1652);
// &vss @WIRE(mode="straight") {#X492:5 %t2527:p};
// %t2528 = $IO_PORT @ATTACH &n762 => @PLACE(30, -1639) => @ORIENT("R0");
// %t2528 @TEXT("n762", key="name", size=0.75);
// &n762 @WIRE(mode="straight") {#X493:1 %t2528:p};
// %t2529 = $IO_PORT @ATTACH &n467 => @PLACE(30, -1643) => @ORIENT("R0");
// %t2529 @TEXT("n467", key="name", size=0.75);
// &n467 @WIRE(mode="straight") {#X493:2 %t2529:p};
// %t2530 = $IO_PORT @ATTACH &n761 => @PLACE(50, -1641) => @ORIENT("MY");
// %t2530 @TEXT("n761", key="name", size=0.75);
// &n761 @WIRE(mode="straight") {#X493:3 %t2530:p};
// %t2531 = $SUPPLY @ATTACH &vdd => @PLACE(40, -1630);
// &vdd @WIRE(mode="straight") {#X493:4 %t2531:p};
// %t2532 = $GROUND @ATTACH &vss => @PLACE(40, -1652);
// &vss @WIRE(mode="straight") {#X493:5 %t2532:p};
// %t2533 = $IO_PORT @ATTACH &n763 => @PLACE(70, -1639) => @ORIENT("R0");
// %t2533 @TEXT("n763", key="name", size=0.75);
// &n763 @WIRE(mode="straight") {#X494:1 %t2533:p};
// %t2534 = $IO_PORT @ATTACH &n764 => @PLACE(70, -1643) => @ORIENT("R0");
// %t2534 @TEXT("n764", key="name", size=0.75);
// &n764 @WIRE(mode="straight") {#X494:2 %t2534:p};
// %t2535 = $IO_PORT @ATTACH &n765 => @PLACE(90, -1641) => @ORIENT("MY");
// %t2535 @TEXT("n765", key="name", size=0.75);
// &n765 @WIRE(mode="straight") {#X494:3 %t2535:p};
// %t2536 = $SUPPLY @ATTACH &vdd => @PLACE(80, -1630);
// &vdd @WIRE(mode="straight") {#X494:4 %t2536:p};
// %t2537 = $GROUND @ATTACH &vss => @PLACE(80, -1652);
// &vss @WIRE(mode="straight") {#X494:5 %t2537:p};
// %t2538 = $IO_PORT @ATTACH &n766 => @PLACE(110, -1639) => @ORIENT("R0");
// %t2538 @TEXT("n766", key="name", size=0.75);
// &n766 @WIRE(mode="straight") {#X495:1 %t2538:p};
// %t2539 = $IO_PORT @ATTACH &n467 => @PLACE(110, -1643) => @ORIENT("R0");
// %t2539 @TEXT("n467", key="name", size=0.75);
// &n467 @WIRE(mode="straight") {#X495:2 %t2539:p};
// %t2540 = $IO_PORT @ATTACH &n764 => @PLACE(130, -1641) => @ORIENT("MY");
// %t2540 @TEXT("n764", key="name", size=0.75);
// &n764 @WIRE(mode="straight") {#X495:3 %t2540:p};
// %t2541 = $SUPPLY @ATTACH &vdd => @PLACE(120, -1630);
// &vdd @WIRE(mode="straight") {#X495:4 %t2541:p};
// %t2542 = $GROUND @ATTACH &vss => @PLACE(120, -1652);
// &vss @WIRE(mode="straight") {#X495:5 %t2542:p};
// %t2543 = $IO_PORT @ATTACH &n729 => @PLACE(-11, -1670) => @ORIENT("R0");
// %t2543 @TEXT("n729", key="name", size=0.75);
// &n729 @WIRE(mode="straight") {#X496:1 %t2543:p};
// %t2544 = $IO_PORT @ATTACH &n762 => @PLACE(-11, -1674) => @ORIENT("R0");
// %t2544 @TEXT("n762", key="name", size=0.75);
// &n762 @WIRE(mode="straight") {#X496:2 %t2544:p};
// %t2545 = $IO_PORT @ATTACH &n766 => @PLACE(10, -1672) => @ORIENT("MY");
// %t2545 @TEXT("n766", key="name", size=0.75);
// &n766 @WIRE(mode="straight") {#X496:3 %t2545:p};
// %t2546 = $SUPPLY @ATTACH &vdd => @PLACE(0, -1661);
// &vdd @WIRE(mode="straight") {#X496:4 %t2546:p};
// %t2547 = $GROUND @ATTACH &vss => @PLACE(0, -1683);
// &vss @WIRE(mode="straight") {#X496:5 %t2547:p};
// %t2548 = $IO_PORT @ATTACH &n729 => @PLACE(30, -1670) => @ORIENT("R0");
// %t2548 @TEXT("n729", key="name", size=0.75);
// &n729 @WIRE(mode="straight") {#X497:1 %t2548:p};
// %t2549 = $IO_PORT @ATTACH &n760 => @PLACE(30, -1674) => @ORIENT("R0");
// %t2549 @TEXT("n760", key="name", size=0.75);
// &n760 @WIRE(mode="straight") {#X497:2 %t2549:p};
// %t2550 = $IO_PORT @ATTACH &n763 => @PLACE(50, -1672) => @ORIENT("MY");
// %t2550 @TEXT("n763", key="name", size=0.75);
// &n763 @WIRE(mode="straight") {#X497:3 %t2550:p};
// %t2551 = $SUPPLY @ATTACH &vdd => @PLACE(40, -1661);
// &vdd @WIRE(mode="straight") {#X497:4 %t2551:p};
// %t2552 = $GROUND @ATTACH &vss => @PLACE(40, -1683);
// &vss @WIRE(mode="straight") {#X497:5 %t2552:p};
// %t2553 = $IO_PORT @ATTACH &n469 => @PLACE(70, -1670) => @ORIENT("R0");
// %t2553 @TEXT("n469", key="name", size=0.75);
// &n469 @WIRE(mode="straight") {#X498:1 %t2553:p};
// %t2554 = $IO_PORT @ATTACH &n466 => @PLACE(70, -1674) => @ORIENT("R0");
// %t2554 @TEXT("n466", key="name", size=0.75);
// &n466 @WIRE(mode="straight") {#X498:2 %t2554:p};
// %t2555 = $IO_PORT @ATTACH &n762 => @PLACE(90, -1672) => @ORIENT("MY");
// %t2555 @TEXT("n762", key="name", size=0.75);
// &n762 @WIRE(mode="straight") {#X498:3 %t2555:p};
// %t2556 = $SUPPLY @ATTACH &vdd => @PLACE(80, -1661);
// &vdd @WIRE(mode="straight") {#X498:4 %t2556:p};
// %t2557 = $GROUND @ATTACH &vss => @PLACE(80, -1683);
// &vss @WIRE(mode="straight") {#X498:5 %t2557:p};
// %t2558 = $IO_PORT @ATTACH &n757 => @PLACE(110, -1670) => @ORIENT("R0");
// %t2558 @TEXT("n757", key="name", size=0.75);
// &n757 @WIRE(mode="straight") {#X499:1 %t2558:p};
// %t2559 = $IO_PORT @ATTACH &n767 => @PLACE(110, -1674) => @ORIENT("R0");
// %t2559 @TEXT("n767", key="name", size=0.75);
// &n767 @WIRE(mode="straight") {#X499:2 %t2559:p};
// %t2560 = $IO_PORT @ATTACH &n760 => @PLACE(130, -1672) => @ORIENT("MY");
// %t2560 @TEXT("n760", key="name", size=0.75);
// &n760 @WIRE(mode="straight") {#X499:3 %t2560:p};
// %t2561 = $SUPPLY @ATTACH &vdd => @PLACE(120, -1661);
// &vdd @WIRE(mode="straight") {#X499:4 %t2561:p};
// %t2562 = $GROUND @ATTACH &vss => @PLACE(120, -1683);
// &vss @WIRE(mode="straight") {#X499:5 %t2562:p};
// %t2563 = $IO_PORT @ATTACH &n469 => @PLACE(-11, -1701) => @ORIENT("R0");
// %t2563 @TEXT("n469", key="name", size=0.75);
// &n469 @WIRE(mode="straight") {#X500:1 %t2563:p};
// %t2564 = $IO_PORT @ATTACH &n756 => @PLACE(-11, -1705) => @ORIENT("R0");
// %t2564 @TEXT("n756", key="name", size=0.75);
// &n756 @WIRE(mode="straight") {#X500:2 %t2564:p};
// %t2565 = $IO_PORT @ATTACH &n767 => @PLACE(10, -1703) => @ORIENT("MY");
// %t2565 @TEXT("n767", key="name", size=0.75);
// &n767 @WIRE(mode="straight") {#X500:3 %t2565:p};
// %t2566 = $SUPPLY @ATTACH &vdd => @PLACE(0, -1692);
// &vdd @WIRE(mode="straight") {#X500:4 %t2566:p};
// %t2567 = $GROUND @ATTACH &vss => @PLACE(0, -1714);
// &vss @WIRE(mode="straight") {#X500:5 %t2567:p};
// %t2568 = $IO_PORT @ATTACH &n755 => @PLACE(30, -1701) => @ORIENT("R0");
// %t2568 @TEXT("n755", key="name", size=0.75);
// &n755 @WIRE(mode="straight") {#X501:1 %t2568:p};
// %t2569 = $IO_PORT @ATTACH &n768 => @PLACE(30, -1705) => @ORIENT("R0");
// %t2569 @TEXT("n768", key="name", size=0.75);
// &n768 @WIRE(mode="straight") {#X501:2 %t2569:p};
// %t2570 = $IO_PORT @ATTACH &n467 => @PLACE(50, -1703) => @ORIENT("MY");
// %t2570 @TEXT("n467", key="name", size=0.75);
// &n467 @WIRE(mode="straight") {#X501:3 %t2570:p};
// %t2571 = $SUPPLY @ATTACH &vdd => @PLACE(40, -1692);
// &vdd @WIRE(mode="straight") {#X501:4 %t2571:p};
// %t2572 = $GROUND @ATTACH &vss => @PLACE(40, -1714);
// &vss @WIRE(mode="straight") {#X501:5 %t2572:p};
// %t2573 = $IO_PORT @ATTACH &n463 => @PLACE(70, -1701) => @ORIENT("R0");
// %t2573 @TEXT("n463", key="name", size=0.75);
// &n463 @WIRE(mode="straight") {#X502:1 %t2573:p};
// %t2574 = $IO_PORT @ATTACH &n464 => @PLACE(70, -1705) => @ORIENT("R0");
// %t2574 @TEXT("n464", key="name", size=0.75);
// &n464 @WIRE(mode="straight") {#X502:2 %t2574:p};
// %t2575 = $IO_PORT @ATTACH &n768 => @PLACE(90, -1703) => @ORIENT("MY");
// %t2575 @TEXT("n768", key="name", size=0.75);
// &n768 @WIRE(mode="straight") {#X502:3 %t2575:p};
// %t2576 = $SUPPLY @ATTACH &vdd => @PLACE(80, -1692);
// &vdd @WIRE(mode="straight") {#X502:4 %t2576:p};
// %t2577 = $GROUND @ATTACH &vss => @PLACE(80, -1714);
// &vss @WIRE(mode="straight") {#X502:5 %t2577:p};
// %t2578 = $IO_PORT @ATTACH &n466 => @PLACE(110, -1701) => @ORIENT("R0");
// %t2578 @TEXT("n466", key="name", size=0.75);
// &n466 @WIRE(mode="straight") {#X503:1 %t2578:p};
// %t2579 = $IO_PORT @ATTACH &n467 => @PLACE(110, -1705) => @ORIENT("R0");
// %t2579 @TEXT("n467", key="name", size=0.75);
// &n467 @WIRE(mode="straight") {#X503:2 %t2579:p};
// %t2580 = $IO_PORT @ATTACH &n759 => @PLACE(130, -1703) => @ORIENT("MY");
// %t2580 @TEXT("n759", key="name", size=0.75);
// &n759 @WIRE(mode="straight") {#X503:3 %t2580:p};
// %t2581 = $SUPPLY @ATTACH &vdd => @PLACE(120, -1692);
// &vdd @WIRE(mode="straight") {#X503:4 %t2581:p};
// %t2582 = $GROUND @ATTACH &vss => @PLACE(120, -1714);
// &vss @WIRE(mode="straight") {#X503:5 %t2582:p};
// %t2583 = $IO_PORT @ATTACH &n769 => @PLACE(158, -1546) => @ORIENT("R0");
// %t2583 @TEXT("n769", key="name", size=0.75);
// &n769 @WIRE(mode="straight") {#X504:1 %t2583:p};
// %t2584 = $IO_PORT @ATTACH &n770 => @PLACE(158, -1550) => @ORIENT("R0");
// %t2584 @TEXT("n770", key="name", size=0.75);
// &n770 @WIRE(mode="straight") {#X504:2 %t2584:p};
// %t2585 = $IO_PORT @ATTACH &n771 => @PLACE(178, -1548) => @ORIENT("MY");
// %t2585 @TEXT("n771", key="name", size=0.75);
// &n771 @WIRE(mode="straight") {#X504:3 %t2585:p};
// %t2586 = $SUPPLY @ATTACH &vdd => @PLACE(168, -1537);
// &vdd @WIRE(mode="straight") {#X504:4 %t2586:p};
// %t2587 = $GROUND @ATTACH &vss => @PLACE(168, -1559);
// &vss @WIRE(mode="straight") {#X504:5 %t2587:p};
// %t2588 = $IO_PORT @ATTACH &n772 => @PLACE(198, -1546) => @ORIENT("R0");
// %t2588 @TEXT("n772", key="name", size=0.75);
// &n772 @WIRE(mode="straight") {#X505:1 %t2588:p};
// %t2589 = $IO_PORT @ATTACH &n771 => @PLACE(198, -1550) => @ORIENT("R0");
// %t2589 @TEXT("n771", key="name", size=0.75);
// &n771 @WIRE(mode="straight") {#X505:2 %t2589:p};
// %t2590 = $IO_PORT @ATTACH &n259 => @PLACE(218, -1548) => @ORIENT("MY");
// %t2590 @TEXT("n259", key="name", size=0.75);
// &n259 @WIRE(mode="straight") {#X505:3 %t2590:p};
// %t2591 = $SUPPLY @ATTACH &vdd => @PLACE(208, -1537);
// &vdd @WIRE(mode="straight") {#X505:4 %t2591:p};
// %t2592 = $GROUND @ATTACH &vss => @PLACE(208, -1559);
// &vss @WIRE(mode="straight") {#X505:5 %t2592:p};
// %t2593 = $IO_PORT @ATTACH &n742 => @PLACE(238, -1546) => @ORIENT("R0");
// %t2593 @TEXT("n742", key="name", size=0.75);
// &n742 @WIRE(mode="straight") {#X506:1 %t2593:p};
// %t2594 = $IO_PORT @ATTACH &n773 => @PLACE(238, -1550) => @ORIENT("R0");
// %t2594 @TEXT("n773", key="name", size=0.75);
// &n773 @WIRE(mode="straight") {#X506:2 %t2594:p};
// %t2595 = $IO_PORT @ATTACH &n770 => @PLACE(258, -1548) => @ORIENT("MY");
// %t2595 @TEXT("n770", key="name", size=0.75);
// &n770 @WIRE(mode="straight") {#X506:3 %t2595:p};
// %t2596 = $SUPPLY @ATTACH &vdd => @PLACE(248, -1537);
// &vdd @WIRE(mode="straight") {#X506:4 %t2596:p};
// %t2597 = $GROUND @ATTACH &vss => @PLACE(248, -1559);
// &vss @WIRE(mode="straight") {#X506:5 %t2597:p};
// %t2598 = $IO_PORT @ATTACH &target_k5 => @PLACE(278, -1546) => @ORIENT("R0");
// %t2598 @TEXT("target_k5", key="name", size=0.75);
// &target_k5 @WIRE(mode="straight") {#X507:1 %t2598:p};
// %t2599 = $IO_PORT @ATTACH &n745 => @PLACE(278, -1550) => @ORIENT("R0");
// %t2599 @TEXT("n745", key="name", size=0.75);
// &n745 @WIRE(mode="straight") {#X507:2 %t2599:p};
// %t2600 = $IO_PORT @ATTACH &n772 => @PLACE(298, -1548) => @ORIENT("MY");
// %t2600 @TEXT("n772", key="name", size=0.75);
// &n772 @WIRE(mode="straight") {#X507:3 %t2600:p};
// %t2601 = $SUPPLY @ATTACH &vdd => @PLACE(288, -1537);
// &vdd @WIRE(mode="straight") {#X507:4 %t2601:p};
// %t2602 = $GROUND @ATTACH &vss => @PLACE(288, -1559);
// &vss @WIRE(mode="straight") {#X507:5 %t2602:p};
// %t2603 = $IO_PORT @ATTACH &target_k1 => @PLACE(158, -1577) => @ORIENT("R0");
// %t2603 @TEXT("target_k1", key="name", size=0.75);
// &target_k1 @WIRE(mode="straight") {#X508:1 %t2603:p};
// %t2604 = $IO_PORT @ATTACH &n774 => @PLACE(158, -1581) => @ORIENT("R0");
// %t2604 @TEXT("n774", key="name", size=0.75);
// &n774 @WIRE(mode="straight") {#X508:2 %t2604:p};
// %t2605 = $IO_PORT @ATTACH &n773 => @PLACE(178, -1579) => @ORIENT("MY");
// %t2605 @TEXT("n773", key="name", size=0.75);
// &n773 @WIRE(mode="straight") {#X508:3 %t2605:p};
// %t2606 = $SUPPLY @ATTACH &vdd => @PLACE(168, -1568);
// &vdd @WIRE(mode="straight") {#X508:4 %t2606:p};
// %t2607 = $GROUND @ATTACH &vss => @PLACE(168, -1590);
// &vss @WIRE(mode="straight") {#X508:5 %t2607:p};
// %t2608 = $IO_PORT @ATTACH &target_k1 => @PLACE(198, -1577) => @ORIENT("R0");
// %t2608 @TEXT("target_k1", key="name", size=0.75);
// &target_k1 @WIRE(mode="straight") {#X509:1 %t2608:p};
// %t2609 = $IO_PORT @ATTACH &target_k2 => @PLACE(198, -1581) => @ORIENT("R0");
// %t2609 @TEXT("target_k2", key="name", size=0.75);
// &target_k2 @WIRE(mode="straight") {#X509:2 %t2609:p};
// %t2610 = $IO_PORT @ATTACH &n732 => @PLACE(218, -1579) => @ORIENT("MY");
// %t2610 @TEXT("n732", key="name", size=0.75);
// &n732 @WIRE(mode="straight") {#X509:3 %t2610:p};
// %t2611 = $SUPPLY @ATTACH &vdd => @PLACE(208, -1568);
// &vdd @WIRE(mode="straight") {#X509:4 %t2611:p};
// %t2612 = $GROUND @ATTACH &vss => @PLACE(208, -1590);
// &vss @WIRE(mode="straight") {#X509:5 %t2612:p};
// %t2613 = $IO_PORT @ATTACH &target_k3 => @PLACE(238, -1577) => @ORIENT("R0");
// %t2613 @TEXT("target_k3", key="name", size=0.75);
// &target_k3 @WIRE(mode="straight") {#X510:1 %t2613:p};
// %t2614 = $IO_PORT @ATTACH &target_k4 => @PLACE(238, -1581) => @ORIENT("R0");
// %t2614 @TEXT("target_k4", key="name", size=0.75);
// &target_k4 @WIRE(mode="straight") {#X510:2 %t2614:p};
// %t2615 = $IO_PORT @ATTACH &n730 => @PLACE(258, -1579) => @ORIENT("MY");
// %t2615 @TEXT("n730", key="name", size=0.75);
// &n730 @WIRE(mode="straight") {#X510:3 %t2615:p};
// %t2616 = $SUPPLY @ATTACH &vdd => @PLACE(248, -1568);
// &vdd @WIRE(mode="straight") {#X510:4 %t2616:p};
// %t2617 = $GROUND @ATTACH &vss => @PLACE(248, -1590);
// &vss @WIRE(mode="straight") {#X510:5 %t2617:p};
// %t2618 = $IO_PORT @ATTACH &n742 => @PLACE(278, -1577) => @ORIENT("R0");
// %t2618 @TEXT("n742", key="name", size=0.75);
// &n742 @WIRE(mode="straight") {#X511:1 %t2618:p};
// %t2619 = $IO_PORT @ATTACH &n775 => @PLACE(278, -1581) => @ORIENT("R0");
// %t2619 @TEXT("n775", key="name", size=0.75);
// &n775 @WIRE(mode="straight") {#X511:2 %t2619:p};
// %t2620 = $IO_PORT @ATTACH &n476 => @PLACE(298, -1579) => @ORIENT("MY");
// %t2620 @TEXT("n476", key="name", size=0.75);
// &n476 @WIRE(mode="straight") {#X511:3 %t2620:p};
// %t2621 = $SUPPLY @ATTACH &vdd => @PLACE(288, -1568);
// &vdd @WIRE(mode="straight") {#X511:4 %t2621:p};
// %t2622 = $GROUND @ATTACH &vss => @PLACE(288, -1590);
// &vss @WIRE(mode="straight") {#X511:5 %t2622:p};
// %t2623 = $IO_PORT @ATTACH &n457 => @PLACE(158, -1608) => @ORIENT("R0");
// %t2623 @TEXT("n457", key="name", size=0.75);
// &n457 @WIRE(mode="straight") {#X512:1 %t2623:p};
// %t2624 = $IO_PORT @ATTACH &n478 => @PLACE(158, -1612) => @ORIENT("R0");
// %t2624 @TEXT("n478", key="name", size=0.75);
// &n478 @WIRE(mode="straight") {#X512:2 %t2624:p};
// %t2625 = $IO_PORT @ATTACH &n776 => @PLACE(178, -1610) => @ORIENT("MY");
// %t2625 @TEXT("n776", key="name", size=0.75);
// &n776 @WIRE(mode="straight") {#X512:3 %t2625:p};
// %t2626 = $SUPPLY @ATTACH &vdd => @PLACE(168, -1599);
// &vdd @WIRE(mode="straight") {#X512:4 %t2626:p};
// %t2627 = $GROUND @ATTACH &vss => @PLACE(168, -1621);
// &vss @WIRE(mode="straight") {#X512:5 %t2627:p};
// %t2628 = $IO_PORT @ATTACH &n777 => @PLACE(198, -1608) => @ORIENT("R0");
// %t2628 @TEXT("n777", key="name", size=0.75);
// &n777 @WIRE(mode="straight") {#X513:1 %t2628:p};
// %t2629 = $IO_PORT @ATTACH &n778 => @PLACE(198, -1612) => @ORIENT("R0");
// %t2629 @TEXT("n778", key="name", size=0.75);
// &n778 @WIRE(mode="straight") {#X513:2 %t2629:p};
// %t2630 = $IO_PORT @ATTACH &n478 => @PLACE(218, -1610) => @ORIENT("MY");
// %t2630 @TEXT("n478", key="name", size=0.75);
// &n478 @WIRE(mode="straight") {#X513:3 %t2630:p};
// %t2631 = $SUPPLY @ATTACH &vdd => @PLACE(208, -1599);
// &vdd @WIRE(mode="straight") {#X513:4 %t2631:p};
// %t2632 = $GROUND @ATTACH &vss => @PLACE(208, -1621);
// &vss @WIRE(mode="straight") {#X513:5 %t2632:p};
// %t2633 = $IO_PORT @ATTACH &n779 => @PLACE(238, -1608) => @ORIENT("R0");
// %t2633 @TEXT("n779", key="name", size=0.75);
// &n779 @WIRE(mode="straight") {#X514:1 %t2633:p};
// %t2634 = $IO_PORT @ATTACH &n452 => @PLACE(238, -1612) => @ORIENT("R0");
// %t2634 @TEXT("n452", key="name", size=0.75);
// &n452 @WIRE(mode="straight") {#X514:2 %t2634:p};
// %t2635 = $IO_PORT @ATTACH &n778 => @PLACE(258, -1610) => @ORIENT("MY");
// %t2635 @TEXT("n778", key="name", size=0.75);
// &n778 @WIRE(mode="straight") {#X514:3 %t2635:p};
// %t2636 = $SUPPLY @ATTACH &vdd => @PLACE(248, -1599);
// &vdd @WIRE(mode="straight") {#X514:4 %t2636:p};
// %t2637 = $GROUND @ATTACH &vss => @PLACE(248, -1621);
// &vss @WIRE(mode="straight") {#X514:5 %t2637:p};
// %t2638 = $IO_PORT @ATTACH &n729 => @PLACE(278, -1608) => @ORIENT("R0");
// %t2638 @TEXT("n729", key="name", size=0.75);
// &n729 @WIRE(mode="straight") {#X515:1 %t2638:p};
// %t2639 = $IO_PORT @ATTACH &n776 => @PLACE(278, -1612) => @ORIENT("R0");
// %t2639 @TEXT("n776", key="name", size=0.75);
// &n776 @WIRE(mode="straight") {#X515:2 %t2639:p};
// %t2640 = $IO_PORT @ATTACH &n480 => @PLACE(298, -1610) => @ORIENT("MY");
// %t2640 @TEXT("n480", key="name", size=0.75);
// &n480 @WIRE(mode="straight") {#X515:3 %t2640:p};
// %t2641 = $SUPPLY @ATTACH &vdd => @PLACE(288, -1599);
// &vdd @WIRE(mode="straight") {#X515:4 %t2641:p};
// %t2642 = $GROUND @ATTACH &vss => @PLACE(288, -1621);
// &vss @WIRE(mode="straight") {#X515:5 %t2642:p};
// %t2643 = $IO_PORT @ATTACH &n780 => @PLACE(158, -1639) => @ORIENT("R0");
// %t2643 @TEXT("n780", key="name", size=0.75);
// &n780 @WIRE(mode="straight") {#X516:1 %t2643:p};
// %t2644 = $IO_PORT @ATTACH &n781 => @PLACE(158, -1643) => @ORIENT("R0");
// %t2644 @TEXT("n781", key="name", size=0.75);
// &n781 @WIRE(mode="straight") {#X516:2 %t2644:p};
// %t2645 = $IO_PORT @ATTACH &n497 => @PLACE(178, -1641) => @ORIENT("MY");
// %t2645 @TEXT("n497", key="name", size=0.75);
// &n497 @WIRE(mode="straight") {#X516:3 %t2645:p};
// %t2646 = $SUPPLY @ATTACH &vdd => @PLACE(168, -1630);
// &vdd @WIRE(mode="straight") {#X516:4 %t2646:p};
// %t2647 = $GROUND @ATTACH &vss => @PLACE(168, -1652);
// &vss @WIRE(mode="straight") {#X516:5 %t2647:p};
// %t2648 = $IO_PORT @ATTACH &n782 => @PLACE(198, -1639) => @ORIENT("R0");
// %t2648 @TEXT("n782", key="name", size=0.75);
// &n782 @WIRE(mode="straight") {#X517:1 %t2648:p};
// %t2649 = $IO_PORT @ATTACH &n452 => @PLACE(198, -1643) => @ORIENT("R0");
// %t2649 @TEXT("n452", key="name", size=0.75);
// &n452 @WIRE(mode="straight") {#X517:2 %t2649:p};
// %t2650 = $IO_PORT @ATTACH &n781 => @PLACE(218, -1641) => @ORIENT("MY");
// %t2650 @TEXT("n781", key="name", size=0.75);
// &n781 @WIRE(mode="straight") {#X517:3 %t2650:p};
// %t2651 = $SUPPLY @ATTACH &vdd => @PLACE(208, -1630);
// &vdd @WIRE(mode="straight") {#X517:4 %t2651:p};
// %t2652 = $GROUND @ATTACH &vss => @PLACE(208, -1652);
// &vss @WIRE(mode="straight") {#X517:5 %t2652:p};
// %t2653 = $IO_PORT @ATTACH &n783 => @PLACE(238, -1639) => @ORIENT("R0");
// %t2653 @TEXT("n783", key="name", size=0.75);
// &n783 @WIRE(mode="straight") {#X518:1 %t2653:p};
// %t2654 = $IO_PORT @ATTACH &n779 => @PLACE(238, -1643) => @ORIENT("R0");
// %t2654 @TEXT("n779", key="name", size=0.75);
// &n779 @WIRE(mode="straight") {#X518:2 %t2654:p};
// %t2655 = $IO_PORT @ATTACH &n782 => @PLACE(258, -1641) => @ORIENT("MY");
// %t2655 @TEXT("n782", key="name", size=0.75);
// &n782 @WIRE(mode="straight") {#X518:3 %t2655:p};
// %t2656 = $SUPPLY @ATTACH &vdd => @PLACE(248, -1630);
// &vdd @WIRE(mode="straight") {#X518:4 %t2656:p};
// %t2657 = $GROUND @ATTACH &vss => @PLACE(248, -1652);
// &vss @WIRE(mode="straight") {#X518:5 %t2657:p};
// %t2658 = $IO_PORT @ATTACH &n784 => @PLACE(278, -1639) => @ORIENT("R0");
// %t2658 @TEXT("n784", key="name", size=0.75);
// &n784 @WIRE(mode="straight") {#X519:1 %t2658:p};
// %t2659 = $IO_PORT @ATTACH &n785 => @PLACE(278, -1643) => @ORIENT("R0");
// %t2659 @TEXT("n785", key="name", size=0.75);
// &n785 @WIRE(mode="straight") {#X519:2 %t2659:p};
// %t2660 = $IO_PORT @ATTACH &n780 => @PLACE(298, -1641) => @ORIENT("MY");
// %t2660 @TEXT("n780", key="name", size=0.75);
// &n780 @WIRE(mode="straight") {#X519:3 %t2660:p};
// %t2661 = $SUPPLY @ATTACH &vdd => @PLACE(288, -1630);
// &vdd @WIRE(mode="straight") {#X519:4 %t2661:p};
// %t2662 = $GROUND @ATTACH &vss => @PLACE(288, -1652);
// &vss @WIRE(mode="straight") {#X519:5 %t2662:p};
// %t2663 = $IO_PORT @ATTACH &n783 => @PLACE(158, -1670) => @ORIENT("R0");
// %t2663 @TEXT("n783", key="name", size=0.75);
// &n783 @WIRE(mode="straight") {#X520:1 %t2663:p};
// %t2664 = $IO_PORT @ATTACH &n777 => @PLACE(158, -1674) => @ORIENT("R0");
// %t2664 @TEXT("n777", key="name", size=0.75);
// &n777 @WIRE(mode="straight") {#X520:2 %t2664:p};
// %t2665 = $IO_PORT @ATTACH &n785 => @PLACE(178, -1672) => @ORIENT("MY");
// %t2665 @TEXT("n785", key="name", size=0.75);
// &n785 @WIRE(mode="straight") {#X520:3 %t2665:p};
// %t2666 = $SUPPLY @ATTACH &vdd => @PLACE(168, -1661);
// &vdd @WIRE(mode="straight") {#X520:4 %t2666:p};
// %t2667 = $GROUND @ATTACH &vss => @PLACE(168, -1683);
// &vss @WIRE(mode="straight") {#X520:5 %t2667:p};
// %t2668 = $IO_PORT @ATTACH &target_k5 => @PLACE(198, -1670) => @ORIENT("R0");
// %t2668 @TEXT("target_k5", key="name", size=0.75);
// &target_k5 @WIRE(mode="straight") {#X521:1 %t2668:p};
// %t2669 = $IO_PORT @ATTACH &n457 => @PLACE(198, -1674) => @ORIENT("R0");
// %t2669 @TEXT("n457", key="name", size=0.75);
// &n457 @WIRE(mode="straight") {#X521:2 %t2669:p};
// %t2670 = $IO_PORT @ATTACH &n783 => @PLACE(218, -1672) => @ORIENT("MY");
// %t2670 @TEXT("n783", key="name", size=0.75);
// &n783 @WIRE(mode="straight") {#X521:3 %t2670:p};
// %t2671 = $SUPPLY @ATTACH &vdd => @PLACE(208, -1661);
// &vdd @WIRE(mode="straight") {#X521:4 %t2671:p};
// %t2672 = $GROUND @ATTACH &vss => @PLACE(208, -1683);
// &vss @WIRE(mode="straight") {#X521:5 %t2672:p};
// %t2673 = $IO_PORT @ATTACH &target_k5 => @PLACE(238, -1670) => @ORIENT("R0");
// %t2673 @TEXT("target_k5", key="name", size=0.75);
// &target_k5 @WIRE(mode="straight") {#X522:1 %t2673:p};
// %t2674 = $IO_PORT @ATTACH &n729 => @PLACE(238, -1674) => @ORIENT("R0");
// %t2674 @TEXT("n729", key="name", size=0.75);
// &n729 @WIRE(mode="straight") {#X522:2 %t2674:p};
// %t2675 = $IO_PORT @ATTACH &n784 => @PLACE(258, -1672) => @ORIENT("MY");
// %t2675 @TEXT("n784", key="name", size=0.75);
// &n784 @WIRE(mode="straight") {#X522:3 %t2675:p};
// %t2676 = $SUPPLY @ATTACH &vdd => @PLACE(248, -1661);
// &vdd @WIRE(mode="straight") {#X522:4 %t2676:p};
// %t2677 = $GROUND @ATTACH &vss => @PLACE(248, -1683);
// &vss @WIRE(mode="straight") {#X522:5 %t2677:p};
// %t2678 = $IO_PORT @ATTACH &n454 => @PLACE(278, -1670) => @ORIENT("R0");
// %t2678 @TEXT("n454", key="name", size=0.75);
// &n454 @WIRE(mode="straight") {#X523:1 %t2678:p};
// %t2679 = $IO_PORT @ATTACH &n451 => @PLACE(278, -1674) => @ORIENT("R0");
// %t2679 @TEXT("n451", key="name", size=0.75);
// &n451 @WIRE(mode="straight") {#X523:2 %t2679:p};
// %t2680 = $IO_PORT @ATTACH &n779 => @PLACE(298, -1672) => @ORIENT("MY");
// %t2680 @TEXT("n779", key="name", size=0.75);
// &n779 @WIRE(mode="straight") {#X523:3 %t2680:p};
// %t2681 = $SUPPLY @ATTACH &vdd => @PLACE(288, -1661);
// &vdd @WIRE(mode="straight") {#X523:4 %t2681:p};
// %t2682 = $GROUND @ATTACH &vss => @PLACE(288, -1683);
// &vss @WIRE(mode="straight") {#X523:5 %t2682:p};
// %t2683 = $IO_PORT @ATTACH &n730 => @PLACE(158, -1701) => @ORIENT("R0");
// %t2683 @TEXT("n730", key="name", size=0.75);
// &n730 @WIRE(mode="straight") {#X524:1 %t2683:p};
// %t2684 = $IO_PORT @ATTACH &n786 => @PLACE(158, -1705) => @ORIENT("R0");
// %t2684 @TEXT("n786", key="name", size=0.75);
// &n786 @WIRE(mode="straight") {#X524:2 %t2684:p};
// %t2685 = $IO_PORT @ATTACH &n777 => @PLACE(178, -1703) => @ORIENT("MY");
// %t2685 @TEXT("n777", key="name", size=0.75);
// &n777 @WIRE(mode="straight") {#X524:3 %t2685:p};
// %t2686 = $SUPPLY @ATTACH &vdd => @PLACE(168, -1692);
// &vdd @WIRE(mode="straight") {#X524:4 %t2686:p};
// %t2687 = $GROUND @ATTACH &vss => @PLACE(168, -1714);
// &vss @WIRE(mode="straight") {#X524:5 %t2687:p};
// %t2688 = $IO_PORT @ATTACH &n454 => @PLACE(198, -1701) => @ORIENT("R0");
// %t2688 @TEXT("n454", key="name", size=0.75);
// &n454 @WIRE(mode="straight") {#X525:1 %t2688:p};
// %t2689 = $IO_PORT @ATTACH &n742 => @PLACE(198, -1705) => @ORIENT("R0");
// %t2689 @TEXT("n742", key="name", size=0.75);
// &n742 @WIRE(mode="straight") {#X525:2 %t2689:p};
// %t2690 = $IO_PORT @ATTACH &n786 => @PLACE(218, -1703) => @ORIENT("MY");
// %t2690 @TEXT("n786", key="name", size=0.75);
// &n786 @WIRE(mode="straight") {#X525:3 %t2690:p};
// %t2691 = $SUPPLY @ATTACH &vdd => @PLACE(208, -1692);
// &vdd @WIRE(mode="straight") {#X525:4 %t2691:p};
// %t2692 = $GROUND @ATTACH &vss => @PLACE(208, -1714);
// &vss @WIRE(mode="straight") {#X525:5 %t2692:p};
// %t2693 = $IO_PORT @ATTACH &n451 => @PLACE(238, -1701) => @ORIENT("R0");
// %t2693 @TEXT("n451", key="name", size=0.75);
// &n451 @WIRE(mode="straight") {#X526:1 %t2693:p};
// %t2694 = $IO_PORT @ATTACH &n452 => @PLACE(238, -1705) => @ORIENT("R0");
// %t2694 @TEXT("n452", key="name", size=0.75);
// &n452 @WIRE(mode="straight") {#X526:2 %t2694:p};
// %t2695 = $IO_PORT @ATTACH &n775 => @PLACE(258, -1703) => @ORIENT("MY");
// %t2695 @TEXT("n775", key="name", size=0.75);
// &n775 @WIRE(mode="straight") {#X526:3 %t2695:p};
// %t2696 = $SUPPLY @ATTACH &vdd => @PLACE(248, -1692);
// &vdd @WIRE(mode="straight") {#X526:4 %t2696:p};
// %t2697 = $GROUND @ATTACH &vss => @PLACE(248, -1714);
// &vss @WIRE(mode="straight") {#X526:5 %t2697:p};
// %t2698 = $IO_PORT @ATTACH &n772 => @PLACE(278, -1701) => @ORIENT("R0");
// %t2698 @TEXT("n772", key="name", size=0.75);
// &n772 @WIRE(mode="straight") {#X527:1 %t2698:p};
// %t2699 = $IO_PORT @ATTACH &n787 => @PLACE(278, -1705) => @ORIENT("R0");
// %t2699 @TEXT("n787", key="name", size=0.75);
// &n787 @WIRE(mode="straight") {#X527:2 %t2699:p};
// %t2700 = $IO_PORT @ATTACH &n257 => @PLACE(298, -1703) => @ORIENT("MY");
// %t2700 @TEXT("n257", key="name", size=0.75);
// &n257 @WIRE(mode="straight") {#X527:3 %t2700:p};
// %t2701 = $SUPPLY @ATTACH &vdd => @PLACE(288, -1692);
// &vdd @WIRE(mode="straight") {#X527:4 %t2701:p};
// %t2702 = $GROUND @ATTACH &vss => @PLACE(288, -1714);
// &vss @WIRE(mode="straight") {#X527:5 %t2702:p};
// %t2703 = $IO_PORT @ATTACH &n769 => @PLACE(326, -1546) => @ORIENT("R0");
// %t2703 @TEXT("n769", key="name", size=0.75);
// &n769 @WIRE(mode="straight") {#X528:1 %t2703:p};
// %t2704 = $IO_PORT @ATTACH &n746 => @PLACE(326, -1550) => @ORIENT("R0");
// %t2704 @TEXT("n746", key="name", size=0.75);
// &n746 @WIRE(mode="straight") {#X528:2 %t2704:p};
// %t2705 = $IO_PORT @ATTACH &n787 => @PLACE(346, -1548) => @ORIENT("MY");
// %t2705 @TEXT("n787", key="name", size=0.75);
// &n787 @WIRE(mode="straight") {#X528:3 %t2705:p};
// %t2706 = $SUPPLY @ATTACH &vdd => @PLACE(336, -1537);
// &vdd @WIRE(mode="straight") {#X528:4 %t2706:p};
// %t2707 = $GROUND @ATTACH &vss => @PLACE(336, -1559);
// &vss @WIRE(mode="straight") {#X528:5 %t2707:p};
// %t2708 = $IO_PORT @ATTACH &n742 => @PLACE(366, -1546) => @ORIENT("R0");
// %t2708 @TEXT("n742", key="name", size=0.75);
// &n742 @WIRE(mode="straight") {#X529:1 %t2708:p};
// %t2709 = $IO_PORT @ATTACH &n788 => @PLACE(366, -1550) => @ORIENT("R0");
// %t2709 @TEXT("n788", key="name", size=0.75);
// &n788 @WIRE(mode="straight") {#X529:2 %t2709:p};
// %t2710 = $IO_PORT @ATTACH &n746 => @PLACE(386, -1548) => @ORIENT("MY");
// %t2710 @TEXT("n746", key="name", size=0.75);
// &n746 @WIRE(mode="straight") {#X529:3 %t2710:p};
// %t2711 = $SUPPLY @ATTACH &vdd => @PLACE(376, -1537);
// &vdd @WIRE(mode="straight") {#X529:4 %t2711:p};
// %t2712 = $GROUND @ATTACH &vss => @PLACE(376, -1559);
// &vss @WIRE(mode="straight") {#X529:5 %t2712:p};
// %t2713 = $IO_PORT @ATTACH &target_k0 => @PLACE(406, -1546) => @ORIENT("R0");
// %t2713 @TEXT("target_k0", key="name", size=0.75);
// &target_k0 @WIRE(mode="straight") {#X530:1 %t2713:p};
// %t2714 = $IO_PORT @ATTACH &target_k1 => @PLACE(406, -1550) => @ORIENT("R0");
// %t2714 @TEXT("target_k1", key="name", size=0.75);
// &target_k1 @WIRE(mode="straight") {#X530:2 %t2714:p};
// %t2715 = $IO_PORT @ATTACH &n449 => @PLACE(426, -1548) => @ORIENT("MY");
// %t2715 @TEXT("n449", key="name", size=0.75);
// &n449 @WIRE(mode="straight") {#X530:3 %t2715:p};
// %t2716 = $SUPPLY @ATTACH &vdd => @PLACE(416, -1537);
// &vdd @WIRE(mode="straight") {#X530:4 %t2716:p};
// %t2717 = $GROUND @ATTACH &vss => @PLACE(416, -1559);
// &vss @WIRE(mode="straight") {#X530:5 %t2717:p};
// %t2718 = $IO_PORT @ATTACH &n462 => @PLACE(446, -1546) => @ORIENT("R0");
// %t2718 @TEXT("n462", key="name", size=0.75);
// &n462 @WIRE(mode="straight") {#X531:1 %t2718:p};
// %t2719 = $IO_PORT @ATTACH &target_k2 => @PLACE(446, -1550) => @ORIENT("R0");
// %t2719 @TEXT("target_k2", key="name", size=0.75);
// &target_k2 @WIRE(mode="straight") {#X531:2 %t2719:p};
// %t2720 = $IO_PORT @ATTACH &n789 => @PLACE(466, -1548) => @ORIENT("MY");
// %t2720 @TEXT("n789", key="name", size=0.75);
// &n789 @WIRE(mode="straight") {#X531:3 %t2720:p};
// %t2721 = $SUPPLY @ATTACH &vdd => @PLACE(456, -1537);
// &vdd @WIRE(mode="straight") {#X531:4 %t2721:p};
// %t2722 = $GROUND @ATTACH &vss => @PLACE(456, -1559);
// &vss @WIRE(mode="straight") {#X531:5 %t2722:p};
// %t2723 = $IO_PORT @ATTACH &n450 => @PLACE(326, -1577) => @ORIENT("R0");
// %t2723 @TEXT("n450", key="name", size=0.75);
// &n450 @WIRE(mode="straight") {#X532:1 %t2723:p};
// %t2724 = $IO_PORT @ATTACH &target_k3 => @PLACE(326, -1581) => @ORIENT("R0");
// %t2724 @TEXT("target_k3", key="name", size=0.75);
// &target_k3 @WIRE(mode="straight") {#X532:2 %t2724:p};
// %t2725 = $IO_PORT @ATTACH &n790 => @PLACE(346, -1579) => @ORIENT("MY");
// %t2725 @TEXT("n790", key="name", size=0.75);
// &n790 @WIRE(mode="straight") {#X532:3 %t2725:p};
// %t2726 = $SUPPLY @ATTACH &vdd => @PLACE(336, -1568);
// &vdd @WIRE(mode="straight") {#X532:4 %t2726:p};
// %t2727 = $GROUND @ATTACH &vss => @PLACE(336, -1590);
// &vss @WIRE(mode="straight") {#X532:5 %t2727:p};
// %t2728 = $IO_PORT @ATTACH &n453 => @PLACE(366, -1577) => @ORIENT("R0");
// %t2728 @TEXT("n453", key="name", size=0.75);
// &n453 @WIRE(mode="straight") {#X533:1 %t2728:p};
// %t2729 = $IO_PORT @ATTACH &target_k4 => @PLACE(366, -1581) => @ORIENT("R0");
// %t2729 @TEXT("target_k4", key="name", size=0.75);
// &target_k4 @WIRE(mode="straight") {#X533:2 %t2729:p};
// %t2730 = $IO_PORT @ATTACH &n791 => @PLACE(386, -1579) => @ORIENT("MY");
// %t2730 @TEXT("n791", key="name", size=0.75);
// &n791 @WIRE(mode="straight") {#X533:3 %t2730:p};
// %t2731 = $SUPPLY @ATTACH &vdd => @PLACE(376, -1568);
// &vdd @WIRE(mode="straight") {#X533:4 %t2731:p};
// %t2732 = $GROUND @ATTACH &vss => @PLACE(376, -1590);
// &vss @WIRE(mode="straight") {#X533:5 %t2732:p};
// %t2733 = $IO_PORT @ATTACH &n477 => @PLACE(406, -1577) => @ORIENT("R0");
// %t2733 @TEXT("n477", key="name", size=0.75);
// &n477 @WIRE(mode="straight") {#X534:1 %t2733:p};
// %t2734 = $IO_PORT @ATTACH &target_k5 => @PLACE(406, -1581) => @ORIENT("R0");
// %t2734 @TEXT("target_k5", key="name", size=0.75);
// &target_k5 @WIRE(mode="straight") {#X534:2 %t2734:p};
// %t2735 = $IO_PORT @ATTACH &n792 => @PLACE(426, -1579) => @ORIENT("MY");
// %t2735 @TEXT("n792", key="name", size=0.75);
// &n792 @WIRE(mode="straight") {#X534:3 %t2735:p};
// %t2736 = $SUPPLY @ATTACH &vdd => @PLACE(416, -1568);
// &vdd @WIRE(mode="straight") {#X534:4 %t2736:p};
// %t2737 = $GROUND @ATTACH &vss => @PLACE(416, -1590);
// &vss @WIRE(mode="straight") {#X534:5 %t2737:p};
// %t2738 = $IO_PORT @ATTACH &n462 => @PLACE(446, -1577) => @ORIENT("R0");
// %t2738 @TEXT("n462", key="name", size=0.75);
// &n462 @WIRE(mode="straight") {#X535:1 %t2738:p};
// %t2739 = $IO_PORT @ATTACH &target_k2 => @PLACE(446, -1581) => @ORIENT("R0");
// %t2739 @TEXT("target_k2", key="name", size=0.75);
// &target_k2 @WIRE(mode="straight") {#X535:2 %t2739:p};
// %t2740 = $IO_PORT @ATTACH &n482 => @PLACE(466, -1579) => @ORIENT("MY");
// %t2740 @TEXT("n482", key="name", size=0.75);
// &n482 @WIRE(mode="straight") {#X535:3 %t2740:p};
// %t2741 = $SUPPLY @ATTACH &vdd => @PLACE(456, -1568);
// &vdd @WIRE(mode="straight") {#X535:4 %t2741:p};
// %t2742 = $GROUND @ATTACH &vss => @PLACE(456, -1590);
// &vss @WIRE(mode="straight") {#X535:5 %t2742:p};
// %t2743 = $IO_PORT @ATTACH &n450 => @PLACE(326, -1608) => @ORIENT("R0");
// %t2743 @TEXT("n450", key="name", size=0.75);
// &n450 @WIRE(mode="straight") {#X536:1 %t2743:p};
// %t2744 = $IO_PORT @ATTACH &target_k3 => @PLACE(326, -1612) => @ORIENT("R0");
// %t2744 @TEXT("target_k3", key="name", size=0.75);
// &target_k3 @WIRE(mode="straight") {#X536:2 %t2744:p};
// %t2745 = $IO_PORT @ATTACH &n484 => @PLACE(346, -1610) => @ORIENT("MY");
// %t2745 @TEXT("n484", key="name", size=0.75);
// &n484 @WIRE(mode="straight") {#X536:3 %t2745:p};
// %t2746 = $SUPPLY @ATTACH &vdd => @PLACE(336, -1599);
// &vdd @WIRE(mode="straight") {#X536:4 %t2746:p};
// %t2747 = $GROUND @ATTACH &vss => @PLACE(336, -1621);
// &vss @WIRE(mode="straight") {#X536:5 %t2747:p};
// %t2748 = $IO_PORT @ATTACH &n453 => @PLACE(366, -1608) => @ORIENT("R0");
// %t2748 @TEXT("n453", key="name", size=0.75);
// &n453 @WIRE(mode="straight") {#X537:1 %t2748:p};
// %t2749 = $IO_PORT @ATTACH &target_k4 => @PLACE(366, -1612) => @ORIENT("R0");
// %t2749 @TEXT("target_k4", key="name", size=0.75);
// &target_k4 @WIRE(mode="straight") {#X537:2 %t2749:p};
// %t2750 = $IO_PORT @ATTACH &n487 => @PLACE(386, -1610) => @ORIENT("MY");
// %t2750 @TEXT("n487", key="name", size=0.75);
// &n487 @WIRE(mode="straight") {#X537:3 %t2750:p};
// %t2751 = $SUPPLY @ATTACH &vdd => @PLACE(376, -1599);
// &vdd @WIRE(mode="straight") {#X537:4 %t2751:p};
// %t2752 = $GROUND @ATTACH &vss => @PLACE(376, -1621);
// &vss @WIRE(mode="straight") {#X537:5 %t2752:p};
// %t2753 = $IO_PORT @ATTACH &n477 => @PLACE(406, -1608) => @ORIENT("R0");
// %t2753 @TEXT("n477", key="name", size=0.75);
// &n477 @WIRE(mode="straight") {#X538:1 %t2753:p};
// %t2754 = $IO_PORT @ATTACH &target_k5 => @PLACE(406, -1612) => @ORIENT("R0");
// %t2754 @TEXT("target_k5", key="name", size=0.75);
// &target_k5 @WIRE(mode="straight") {#X538:2 %t2754:p};
// %t2755 = $IO_PORT @ATTACH &n490 => @PLACE(426, -1610) => @ORIENT("MY");
// %t2755 @TEXT("n490", key="name", size=0.75);
// &n490 @WIRE(mode="straight") {#X538:3 %t2755:p};
// %t2756 = $SUPPLY @ATTACH &vdd => @PLACE(416, -1599);
// &vdd @WIRE(mode="straight") {#X538:4 %t2756:p};
// %t2757 = $GROUND @ATTACH &vss => @PLACE(416, -1621);
// &vss @WIRE(mode="straight") {#X538:5 %t2757:p};
// %t2758 = $IO_PORT @ATTACH &n791 => @PLACE(446, -1608) => @ORIENT("R0");
// %t2758 @TEXT("n791", key="name", size=0.75);
// &n791 @WIRE(mode="straight") {#X539:1 %t2758:p};
// %t2759 = $IO_PORT @ATTACH &n793 => @PLACE(446, -1612) => @ORIENT("R0");
// %t2759 @TEXT("n793", key="name", size=0.75);
// &n793 @WIRE(mode="straight") {#X539:2 %t2759:p};
// %t2760 = $IO_PORT @ATTACH &n491 => @PLACE(466, -1610) => @ORIENT("MY");
// %t2760 @TEXT("n491", key="name", size=0.75);
// &n491 @WIRE(mode="straight") {#X539:3 %t2760:p};
// %t2761 = $SUPPLY @ATTACH &vdd => @PLACE(456, -1599);
// &vdd @WIRE(mode="straight") {#X539:4 %t2761:p};
// %t2762 = $GROUND @ATTACH &vss => @PLACE(456, -1621);
// &vss @WIRE(mode="straight") {#X539:5 %t2762:p};
// %t2763 = $IO_PORT @ATTACH &n789 => @PLACE(326, -1639) => @ORIENT("R0");
// %t2763 @TEXT("n789", key="name", size=0.75);
// &n789 @WIRE(mode="straight") {#X540:1 %t2763:p};
// %t2764 = $IO_PORT @ATTACH &n794 => @PLACE(326, -1643) => @ORIENT("R0");
// %t2764 @TEXT("n794", key="name", size=0.75);
// &n794 @WIRE(mode="straight") {#X540:2 %t2764:p};
// %t2765 = $IO_PORT @ATTACH &n485 => @PLACE(346, -1641) => @ORIENT("MY");
// %t2765 @TEXT("n485", key="name", size=0.75);
// &n485 @WIRE(mode="straight") {#X540:3 %t2765:p};
// %t2766 = $SUPPLY @ATTACH &vdd => @PLACE(336, -1630);
// &vdd @WIRE(mode="straight") {#X540:4 %t2766:p};
// %t2767 = $GROUND @ATTACH &vss => @PLACE(336, -1652);
// &vss @WIRE(mode="straight") {#X540:5 %t2767:p};
// %t2768 = $IO_PORT @ATTACH &n479 => @PLACE(366, -1639) => @ORIENT("R0");
// %t2768 @TEXT("n479", key="name", size=0.75);
// &n479 @WIRE(mode="straight") {#X541:1 %t2768:p};
// %t2769 = $IO_PORT @ATTACH &n493 => @PLACE(366, -1643) => @ORIENT("R0");
// %t2769 @TEXT("n493", key="name", size=0.75);
// &n493 @WIRE(mode="straight") {#X541:2 %t2769:p};
// %t2770 = $IO_PORT @ATTACH &n495 => @PLACE(386, -1641) => @ORIENT("MY");
// %t2770 @TEXT("n495", key="name", size=0.75);
// &n495 @WIRE(mode="straight") {#X541:3 %t2770:p};
// %t2771 = $SUPPLY @ATTACH &vdd => @PLACE(376, -1630);
// &vdd @WIRE(mode="straight") {#X541:4 %t2771:p};
// %t2772 = $GROUND @ATTACH &vss => @PLACE(376, -1652);
// &vss @WIRE(mode="straight") {#X541:5 %t2772:p};
// %t2773 = $IO_PORT @ATTACH &n795 => @PLACE(406, -1639) => @ORIENT("R0");
// %t2773 @TEXT("n795", key="name", size=0.75);
// &n795 @WIRE(mode="straight") {#X542:1 %t2773:p};
// %t2774 = $IO_PORT @ATTACH &n796 => @PLACE(406, -1643) => @ORIENT("R0");
// %t2774 @TEXT("n796", key="name", size=0.75);
// &n796 @WIRE(mode="straight") {#X542:2 %t2774:p};
// %t2775 = $IO_PORT @ATTACH &n493 => @PLACE(426, -1641) => @ORIENT("MY");
// %t2775 @TEXT("n493", key="name", size=0.75);
// &n493 @WIRE(mode="straight") {#X542:3 %t2775:p};
// %t2776 = $SUPPLY @ATTACH &vdd => @PLACE(416, -1630);
// &vdd @WIRE(mode="straight") {#X542:4 %t2776:p};
// %t2777 = $GROUND @ATTACH &vss => @PLACE(416, -1652);
// &vss @WIRE(mode="straight") {#X542:5 %t2777:p};
// %t2778 = $IO_PORT @ATTACH &n797 => @PLACE(446, -1639) => @ORIENT("R0");
// %t2778 @TEXT("n797", key="name", size=0.75);
// &n797 @WIRE(mode="straight") {#X543:1 %t2778:p};
// %t2779 = $IO_PORT @ATTACH &n488 => @PLACE(446, -1643) => @ORIENT("R0");
// %t2779 @TEXT("n488", key="name", size=0.75);
// &n488 @WIRE(mode="straight") {#X543:2 %t2779:p};
// %t2780 = $IO_PORT @ATTACH &n796 => @PLACE(466, -1641) => @ORIENT("MY");
// %t2780 @TEXT("n796", key="name", size=0.75);
// &n796 @WIRE(mode="straight") {#X543:3 %t2780:p};
// %t2781 = $SUPPLY @ATTACH &vdd => @PLACE(456, -1630);
// &vdd @WIRE(mode="straight") {#X543:4 %t2781:p};
// %t2782 = $GROUND @ATTACH &vss => @PLACE(456, -1652);
// &vss @WIRE(mode="straight") {#X543:5 %t2782:p};
// %t2783 = $IO_PORT @ATTACH &n482 => @PLACE(326, -1670) => @ORIENT("R0");
// %t2783 @TEXT("n482", key="name", size=0.75);
// &n482 @WIRE(mode="straight") {#X544:1 %t2783:p};
// %t2784 = $IO_PORT @ATTACH &n449 => @PLACE(326, -1674) => @ORIENT("R0");
// %t2784 @TEXT("n449", key="name", size=0.75);
// &n449 @WIRE(mode="straight") {#X544:2 %t2784:p};
// %t2785 = $IO_PORT @ATTACH &n794 => @PLACE(346, -1672) => @ORIENT("MY");
// %t2785 @TEXT("n794", key="name", size=0.75);
// &n794 @WIRE(mode="straight") {#X544:3 %t2785:p};
// %t2786 = $SUPPLY @ATTACH &vdd => @PLACE(336, -1661);
// &vdd @WIRE(mode="straight") {#X544:4 %t2786:p};
// %t2787 = $GROUND @ATTACH &vss => @PLACE(336, -1683);
// &vss @WIRE(mode="straight") {#X544:5 %t2787:p};
// %t2788 = $IO_PORT @ATTACH &n798 => @PLACE(366, -1670) => @ORIENT("R0");
// %t2788 @TEXT("n798", key="name", size=0.75);
// &n798 @WIRE(mode="straight") {#X545:1 %t2788:p};
// %t2789 = $IO_PORT @ATTACH &n799 => @PLACE(366, -1674) => @ORIENT("R0");
// %t2789 @TEXT("n799", key="name", size=0.75);
// &n799 @WIRE(mode="straight") {#X545:2 %t2789:p};
// %t2790 = $IO_PORT @ATTACH &n498 => @PLACE(386, -1672) => @ORIENT("MY");
// %t2790 @TEXT("n498", key="name", size=0.75);
// &n498 @WIRE(mode="straight") {#X545:3 %t2790:p};
// %t2791 = $SUPPLY @ATTACH &vdd => @PLACE(376, -1661);
// &vdd @WIRE(mode="straight") {#X545:4 %t2791:p};
// %t2792 = $GROUND @ATTACH &vss => @PLACE(376, -1683);
// &vss @WIRE(mode="straight") {#X545:5 %t2792:p};
// %t2793 = $IO_PORT @ATTACH &n800 => @PLACE(406, -1670) => @ORIENT("R0");
// %t2793 @TEXT("n800", key="name", size=0.75);
// &n800 @WIRE(mode="straight") {#X546:1 %t2793:p};
// %t2794 = $IO_PORT @ATTACH &n488 => @PLACE(406, -1674) => @ORIENT("R0");
// %t2794 @TEXT("n488", key="name", size=0.75);
// &n488 @WIRE(mode="straight") {#X546:2 %t2794:p};
// %t2795 = $IO_PORT @ATTACH &n799 => @PLACE(426, -1672) => @ORIENT("MY");
// %t2795 @TEXT("n799", key="name", size=0.75);
// &n799 @WIRE(mode="straight") {#X546:3 %t2795:p};
// %t2796 = $SUPPLY @ATTACH &vdd => @PLACE(416, -1661);
// &vdd @WIRE(mode="straight") {#X546:4 %t2796:p};
// %t2797 = $GROUND @ATTACH &vss => @PLACE(416, -1683);
// &vss @WIRE(mode="straight") {#X546:5 %t2797:p};
// %t2798 = $IO_PORT @ATTACH &n497 => @PLACE(446, -1670) => @ORIENT("R0");
// %t2798 @TEXT("n497", key="name", size=0.75);
// &n497 @WIRE(mode="straight") {#X547:1 %t2798:p};
// %t2799 = $IO_PORT @ATTACH &n498 => @PLACE(446, -1674) => @ORIENT("R0");
// %t2799 @TEXT("n498", key="name", size=0.75);
// &n498 @WIRE(mode="straight") {#X547:2 %t2799:p};
// %t2800 = $IO_PORT @ATTACH &n801 => @PLACE(466, -1672) => @ORIENT("MY");
// %t2800 @TEXT("n801", key="name", size=0.75);
// &n801 @WIRE(mode="straight") {#X547:3 %t2800:p};
// %t2801 = $SUPPLY @ATTACH &vdd => @PLACE(456, -1661);
// &vdd @WIRE(mode="straight") {#X547:4 %t2801:p};
// %t2802 = $GROUND @ATTACH &vss => @PLACE(456, -1683);
// &vss @WIRE(mode="straight") {#X547:5 %t2802:p};
// %t2803 = $IO_PORT @ATTACH &n802 => @PLACE(326, -1701) => @ORIENT("R0");
// %t2803 @TEXT("n802", key="name", size=0.75);
// &n802 @WIRE(mode="straight") {#X548:1 %t2803:p};
// %t2804 = $IO_PORT @ATTACH &n797 => @PLACE(326, -1705) => @ORIENT("R0");
// %t2804 @TEXT("n797", key="name", size=0.75);
// &n797 @WIRE(mode="straight") {#X548:2 %t2804:p};
// %t2805 = $IO_PORT @ATTACH &n800 => @PLACE(346, -1703) => @ORIENT("MY");
// %t2805 @TEXT("n800", key="name", size=0.75);
// &n800 @WIRE(mode="straight") {#X548:3 %t2805:p};
// %t2806 = $SUPPLY @ATTACH &vdd => @PLACE(336, -1692);
// &vdd @WIRE(mode="straight") {#X548:4 %t2806:p};
// %t2807 = $GROUND @ATTACH &vss => @PLACE(336, -1714);
// &vss @WIRE(mode="straight") {#X548:5 %t2807:p};
// %t2808 = $IO_PORT @ATTACH &n802 => @PLACE(366, -1701) => @ORIENT("R0");
// %t2808 @TEXT("n802", key="name", size=0.75);
// &n802 @WIRE(mode="straight") {#X549:1 %t2808:p};
// %t2809 = $IO_PORT @ATTACH &n795 => @PLACE(366, -1705) => @ORIENT("R0");
// %t2809 @TEXT("n795", key="name", size=0.75);
// &n795 @WIRE(mode="straight") {#X549:2 %t2809:p};
// %t2810 = $IO_PORT @ATTACH &n798 => @PLACE(386, -1703) => @ORIENT("MY");
// %t2810 @TEXT("n798", key="name", size=0.75);
// &n798 @WIRE(mode="straight") {#X549:3 %t2810:p};
// %t2811 = $SUPPLY @ATTACH &vdd => @PLACE(376, -1692);
// &vdd @WIRE(mode="straight") {#X549:4 %t2811:p};
// %t2812 = $GROUND @ATTACH &vss => @PLACE(376, -1714);
// &vss @WIRE(mode="straight") {#X549:5 %t2812:p};
// %t2813 = $IO_PORT @ATTACH &n803 => @PLACE(406, -1701) => @ORIENT("R0");
// %t2813 @TEXT("n803", key="name", size=0.75);
// &n803 @WIRE(mode="straight") {#X550:1 %t2813:p};
// %t2814 = $IO_PORT @ATTACH &n804 => @PLACE(406, -1705) => @ORIENT("R0");
// %t2814 @TEXT("n804", key="name", size=0.75);
// &n804 @WIRE(mode="straight") {#X550:2 %t2814:p};
// %t2815 = $IO_PORT @ATTACH &n488 => @PLACE(426, -1703) => @ORIENT("MY");
// %t2815 @TEXT("n488", key="name", size=0.75);
// &n488 @WIRE(mode="straight") {#X550:3 %t2815:p};
// %t2816 = $SUPPLY @ATTACH &vdd => @PLACE(416, -1692);
// &vdd @WIRE(mode="straight") {#X550:4 %t2816:p};
// %t2817 = $GROUND @ATTACH &vss => @PLACE(416, -1714);
// &vss @WIRE(mode="straight") {#X550:5 %t2817:p};
// %t2818 = $IO_PORT @ATTACH &n805 => @PLACE(446, -1701) => @ORIENT("R0");
// %t2818 @TEXT("n805", key="name", size=0.75);
// &n805 @WIRE(mode="straight") {#X551:1 %t2818:p};
// %t2819 = $IO_PORT @ATTACH &n449 => @PLACE(446, -1705) => @ORIENT("R0");
// %t2819 @TEXT("n449", key="name", size=0.75);
// &n449 @WIRE(mode="straight") {#X551:2 %t2819:p};
// %t2820 = $IO_PORT @ATTACH &n804 => @PLACE(466, -1703) => @ORIENT("MY");
// %t2820 @TEXT("n804", key="name", size=0.75);
// &n804 @WIRE(mode="straight") {#X551:3 %t2820:p};
// %t2821 = $SUPPLY @ATTACH &vdd => @PLACE(456, -1692);
// &vdd @WIRE(mode="straight") {#X551:4 %t2821:p};
// %t2822 = $GROUND @ATTACH &vss => @PLACE(456, -1714);
// &vss @WIRE(mode="straight") {#X551:5 %t2822:p};
// %t2823 = $IO_PORT @ATTACH &n481 => @PLACE(494, -1546) => @ORIENT("R0");
// %t2823 @TEXT("n481", key="name", size=0.75);
// &n481 @WIRE(mode="straight") {#X552:1 %t2823:p};
// %t2824 = $IO_PORT @ATTACH &n479 => @PLACE(494, -1550) => @ORIENT("R0");
// %t2824 @TEXT("n479", key="name", size=0.75);
// &n479 @WIRE(mode="straight") {#X552:2 %t2824:p};
// %t2825 = $IO_PORT @ATTACH &n802 => @PLACE(514, -1548) => @ORIENT("MY");
// %t2825 @TEXT("n802", key="name", size=0.75);
// &n802 @WIRE(mode="straight") {#X552:3 %t2825:p};
// %t2826 = $SUPPLY @ATTACH &vdd => @PLACE(504, -1537);
// &vdd @WIRE(mode="straight") {#X552:4 %t2826:p};
// %t2827 = $GROUND @ATTACH &vss => @PLACE(504, -1559);
// &vss @WIRE(mode="straight") {#X552:5 %t2827:p};
// %t2828 = $IO_PORT @ATTACH &n490 => @PLACE(534, -1546) => @ORIENT("R0");
// %t2828 @TEXT("n490", key="name", size=0.75);
// &n490 @WIRE(mode="straight") {#X553:1 %t2828:p};
// %t2829 = $IO_PORT @ATTACH &n487 => @PLACE(534, -1550) => @ORIENT("R0");
// %t2829 @TEXT("n487", key="name", size=0.75);
// &n487 @WIRE(mode="straight") {#X553:2 %t2829:p};
// %t2830 = $IO_PORT @ATTACH &n797 => @PLACE(554, -1548) => @ORIENT("MY");
// %t2830 @TEXT("n797", key="name", size=0.75);
// &n797 @WIRE(mode="straight") {#X553:3 %t2830:p};
// %t2831 = $SUPPLY @ATTACH &vdd => @PLACE(544, -1537);
// &vdd @WIRE(mode="straight") {#X553:4 %t2831:p};
// %t2832 = $GROUND @ATTACH &vss => @PLACE(544, -1559);
// &vss @WIRE(mode="straight") {#X553:5 %t2832:p};
// %t2833 = $IO_PORT @ATTACH &n792 => @PLACE(574, -1546) => @ORIENT("R0");
// %t2833 @TEXT("n792", key="name", size=0.75);
// &n792 @WIRE(mode="straight") {#X554:1 %t2833:p};
// %t2834 = $IO_PORT @ATTACH &n806 => @PLACE(574, -1550) => @ORIENT("R0");
// %t2834 @TEXT("n806", key="name", size=0.75);
// &n806 @WIRE(mode="straight") {#X554:2 %t2834:p};
// %t2835 = $IO_PORT @ATTACH &n795 => @PLACE(594, -1548) => @ORIENT("MY");
// %t2835 @TEXT("n795", key="name", size=0.75);
// &n795 @WIRE(mode="straight") {#X554:3 %t2835:p};
// %t2836 = $SUPPLY @ATTACH &vdd => @PLACE(584, -1537);
// &vdd @WIRE(mode="straight") {#X554:4 %t2836:p};
// %t2837 = $GROUND @ATTACH &vss => @PLACE(584, -1559);
// &vss @WIRE(mode="straight") {#X554:5 %t2837:p};
// %t2838 = $IO_PORT @ATTACH &n490 => @PLACE(614, -1546) => @ORIENT("R0");
// %t2838 @TEXT("n490", key="name", size=0.75);
// &n490 @WIRE(mode="straight") {#X555:1 %t2838:p};
// %t2839 = $IO_PORT @ATTACH &n791 => @PLACE(614, -1550) => @ORIENT("R0");
// %t2839 @TEXT("n791", key="name", size=0.75);
// &n791 @WIRE(mode="straight") {#X555:2 %t2839:p};
// %t2840 = $IO_PORT @ATTACH &n806 => @PLACE(635, -1548) => @ORIENT("MY");
// %t2840 @TEXT("n806", key="name", size=0.75);
// &n806 @WIRE(mode="straight") {#X555:3 %t2840:p};
// %t2841 = $SUPPLY @ATTACH &vdd => @PLACE(624, -1537);
// &vdd @WIRE(mode="straight") {#X555:4 %t2841:p};
// %t2842 = $GROUND @ATTACH &vss => @PLACE(624, -1559);
// &vss @WIRE(mode="straight") {#X555:5 %t2842:p};
// %t2843 = $IO_PORT @ATTACH &n484 => @PLACE(494, -1577) => @ORIENT("R0");
// %t2843 @TEXT("n484", key="name", size=0.75);
// &n484 @WIRE(mode="straight") {#X556:1 %t2843:p};
// %t2844 = $IO_PORT @ATTACH &n482 => @PLACE(494, -1581) => @ORIENT("R0");
// %t2844 @TEXT("n482", key="name", size=0.75);
// &n482 @WIRE(mode="straight") {#X556:2 %t2844:p};
// %t2845 = $IO_PORT @ATTACH &n805 => @PLACE(514, -1579) => @ORIENT("MY");
// %t2845 @TEXT("n805", key="name", size=0.75);
// &n805 @WIRE(mode="straight") {#X556:3 %t2845:p};
// %t2846 = $SUPPLY @ATTACH &vdd => @PLACE(504, -1568);
// &vdd @WIRE(mode="straight") {#X556:4 %t2846:p};
// %t2847 = $GROUND @ATTACH &vss => @PLACE(504, -1590);
// &vss @WIRE(mode="straight") {#X556:5 %t2847:p};
// %t2848 = $IO_PORT @ATTACH &n790 => @PLACE(534, -1577) => @ORIENT("R0");
// %t2848 @TEXT("n790", key="name", size=0.75);
// &n790 @WIRE(mode="straight") {#X557:1 %t2848:p};
// %t2849 = $IO_PORT @ATTACH &n807 => @PLACE(534, -1581) => @ORIENT("R0");
// %t2849 @TEXT("n807", key="name", size=0.75);
// &n807 @WIRE(mode="straight") {#X557:2 %t2849:p};
// %t2850 = $IO_PORT @ATTACH &n803 => @PLACE(554, -1579) => @ORIENT("MY");
// %t2850 @TEXT("n803", key="name", size=0.75);
// &n803 @WIRE(mode="straight") {#X557:3 %t2850:p};
// %t2851 = $SUPPLY @ATTACH &vdd => @PLACE(544, -1568);
// &vdd @WIRE(mode="straight") {#X557:4 %t2851:p};
// %t2852 = $GROUND @ATTACH &vss => @PLACE(544, -1590);
// &vss @WIRE(mode="straight") {#X557:5 %t2852:p};
// %t2853 = $IO_PORT @ATTACH &n484 => @PLACE(574, -1577) => @ORIENT("R0");
// %t2853 @TEXT("n484", key="name", size=0.75);
// &n484 @WIRE(mode="straight") {#X558:1 %t2853:p};
// %t2854 = $IO_PORT @ATTACH &n789 => @PLACE(574, -1581) => @ORIENT("R0");
// %t2854 @TEXT("n789", key="name", size=0.75);
// &n789 @WIRE(mode="straight") {#X558:2 %t2854:p};
// %t2855 = $IO_PORT @ATTACH &n807 => @PLACE(594, -1579) => @ORIENT("MY");
// %t2855 @TEXT("n807", key="name", size=0.75);
// &n807 @WIRE(mode="straight") {#X558:3 %t2855:p};
// %t2856 = $SUPPLY @ATTACH &vdd => @PLACE(584, -1568);
// &vdd @WIRE(mode="straight") {#X558:4 %t2856:p};
// %t2857 = $GROUND @ATTACH &vss => @PLACE(584, -1590);
// &vss @WIRE(mode="straight") {#X558:5 %t2857:p};
// %t2858 = $IO_PORT @ATTACH &n487 => @PLACE(614, -1577) => @ORIENT("R0");
// %t2858 @TEXT("n487", key="name", size=0.75);
// &n487 @WIRE(mode="straight") {#X559:1 %t2858:p};
// %t2859 = $IO_PORT @ATTACH &n488 => @PLACE(614, -1581) => @ORIENT("R0");
// %t2859 @TEXT("n488", key="name", size=0.75);
// &n488 @WIRE(mode="straight") {#X559:2 %t2859:p};
// %t2860 = $IO_PORT @ATTACH &n793 => @PLACE(635, -1579) => @ORIENT("MY");
// %t2860 @TEXT("n793", key="name", size=0.75);
// &n793 @WIRE(mode="straight") {#X559:3 %t2860:p};
// %t2861 = $SUPPLY @ATTACH &vdd => @PLACE(624, -1568);
// &vdd @WIRE(mode="straight") {#X559:4 %t2861:p};
// %t2862 = $GROUND @ATTACH &vss => @PLACE(624, -1590);
// &vss @WIRE(mode="straight") {#X559:5 %t2862:p};
// %t2863 = $IO_PORT @ATTACH &n808 => @PLACE(494, -1608) => @ORIENT("R0");
// %t2863 @TEXT("n808", key="name", size=0.75);
// &n808 @WIRE(mode="straight") {#X560:1 %t2863:p};
// %t2864 = $IO_PORT @ATTACH &n809 => @PLACE(494, -1612) => @ORIENT("R0");
// %t2864 @TEXT("n809", key="name", size=0.75);
// &n809 @WIRE(mode="straight") {#X560:2 %t2864:p};
// %t2865 = $IO_PORT @ATTACH &n255 => @PLACE(514, -1610) => @ORIENT("MY");
// %t2865 @TEXT("n255", key="name", size=0.75);
// &n255 @WIRE(mode="straight") {#X560:3 %t2865:p};
// %t2866 = $SUPPLY @ATTACH &vdd => @PLACE(504, -1599);
// &vdd @WIRE(mode="straight") {#X560:4 %t2866:p};
// %t2867 = $GROUND @ATTACH &vss => @PLACE(504, -1621);
// &vss @WIRE(mode="straight") {#X560:5 %t2867:p};
// %t2868 = $IO_PORT @ATTACH &n810 => @PLACE(534, -1608) => @ORIENT("R0");
// %t2868 @TEXT("n810", key="name", size=0.75);
// &n810 @WIRE(mode="straight") {#X561:1 %t2868:p};
// %t2869 = $IO_PORT @ATTACH &n358 => @PLACE(534, -1612) => @ORIENT("R0");
// %t2869 @TEXT("n358", key="name", size=0.75);
// &n358 @WIRE(mode="straight") {#X561:2 %t2869:p};
// %t2870 = $IO_PORT @ATTACH &n809 => @PLACE(554, -1610) => @ORIENT("MY");
// %t2870 @TEXT("n809", key="name", size=0.75);
// &n809 @WIRE(mode="straight") {#X561:3 %t2870:p};
// %t2871 = $SUPPLY @ATTACH &vdd => @PLACE(544, -1599);
// &vdd @WIRE(mode="straight") {#X561:4 %t2871:p};
// %t2872 = $GROUND @ATTACH &vss => @PLACE(544, -1621);
// &vss @WIRE(mode="straight") {#X561:5 %t2872:p};
// %t2873 = $IO_PORT @ATTACH &n578 => @PLACE(574, -1608) => @ORIENT("R0");
// %t2873 @TEXT("n578", key="name", size=0.75);
// &n578 @WIRE(mode="straight") {#X562:1 %t2873:p};
// %t2874 = $IO_PORT @ATTACH &n575 => @PLACE(574, -1612) => @ORIENT("R0");
// %t2874 @TEXT("n575", key="name", size=0.75);
// &n575 @WIRE(mode="straight") {#X562:2 %t2874:p};
// %t2875 = $IO_PORT @ATTACH &n810 => @PLACE(594, -1610) => @ORIENT("MY");
// %t2875 @TEXT("n810", key="name", size=0.75);
// &n810 @WIRE(mode="straight") {#X562:3 %t2875:p};
// %t2876 = $SUPPLY @ATTACH &vdd => @PLACE(584, -1599);
// &vdd @WIRE(mode="straight") {#X562:4 %t2876:p};
// %t2877 = $GROUND @ATTACH &vss => @PLACE(584, -1621);
// &vss @WIRE(mode="straight") {#X562:5 %t2877:p};
// %t2878 = $IO_PORT @ATTACH &dac5 => @PLACE(614, -1608) => @ORIENT("R0");
// %t2878 @TEXT("dac5", key="name", size=0.75);
// &dac5 @WIRE(mode="straight") {#X563:1 %t2878:p};
// %t2879 = $IO_PORT @ATTACH &n811 => @PLACE(614, -1612) => @ORIENT("R0");
// %t2879 @TEXT("n811", key="name", size=0.75);
// &n811 @WIRE(mode="straight") {#X563:2 %t2879:p};
// %t2880 = $IO_PORT @ATTACH &n808 => @PLACE(635, -1610) => @ORIENT("MY");
// %t2880 @TEXT("n808", key="name", size=0.75);
// &n808 @WIRE(mode="straight") {#X563:3 %t2880:p};
// %t2881 = $SUPPLY @ATTACH &vdd => @PLACE(624, -1599);
// &vdd @WIRE(mode="straight") {#X563:4 %t2881:p};
// %t2882 = $GROUND @ATTACH &vss => @PLACE(624, -1621);
// &vss @WIRE(mode="straight") {#X563:5 %t2882:p};
// %t2883 = $IO_PORT @ATTACH &n578 => @PLACE(494, -1639) => @ORIENT("R0");
// %t2883 @TEXT("n578", key="name", size=0.75);
// &n578 @WIRE(mode="straight") {#X564:1 %t2883:p};
// %t2884 = $IO_PORT @ATTACH &dac4 => @PLACE(494, -1643) => @ORIENT("R0");
// %t2884 @TEXT("dac4", key="name", size=0.75);
// &dac4 @WIRE(mode="straight") {#X564:2 %t2884:p};
// %t2885 = $IO_PORT @ATTACH &n811 => @PLACE(514, -1641) => @ORIENT("MY");
// %t2885 @TEXT("n811", key="name", size=0.75);
// &n811 @WIRE(mode="straight") {#X564:3 %t2885:p};
// %t2886 = $SUPPLY @ATTACH &vdd => @PLACE(504, -1630);
// &vdd @WIRE(mode="straight") {#X564:4 %t2886:p};
// %t2887 = $GROUND @ATTACH &vss => @PLACE(504, -1652);
// &vss @WIRE(mode="straight") {#X564:5 %t2887:p};
// %t2888 = $IO_PORT @ATTACH &n572 => @PLACE(534, -1639) => @ORIENT("R0");
// %t2888 @TEXT("n572", key="name", size=0.75);
// &n572 @WIRE(mode="straight") {#X565:1 %t2888:p};
// %t2889 = $IO_PORT @ATTACH &n573 => @PLACE(534, -1643) => @ORIENT("R0");
// %t2889 @TEXT("n573", key="name", size=0.75);
// &n573 @WIRE(mode="straight") {#X565:2 %t2889:p};
// %t2890 = $IO_PORT @ATTACH &n812 => @PLACE(554, -1641) => @ORIENT("MY");
// %t2890 @TEXT("n812", key="name", size=0.75);
// &n812 @WIRE(mode="straight") {#X565:3 %t2890:p};
// %t2891 = $SUPPLY @ATTACH &vdd => @PLACE(544, -1630);
// &vdd @WIRE(mode="straight") {#X565:4 %t2891:p};
// %t2892 = $GROUND @ATTACH &vss => @PLACE(544, -1652);
// &vss @WIRE(mode="straight") {#X565:5 %t2892:p};
// %t2893 = $IO_PORT @ATTACH &n813 => @PLACE(574, -1639) => @ORIENT("R0");
// %t2893 @TEXT("n813", key="name", size=0.75);
// &n813 @WIRE(mode="straight") {#X566:1 %t2893:p};
// %t2894 = $IO_PORT @ATTACH &n576 => @PLACE(574, -1643) => @ORIENT("R0");
// %t2894 @TEXT("n576", key="name", size=0.75);
// &n576 @WIRE(mode="straight") {#X566:2 %t2894:p};
// %t2895 = $IO_PORT @ATTACH &n253 => @PLACE(594, -1641) => @ORIENT("MY");
// %t2895 @TEXT("n253", key="name", size=0.75);
// &n253 @WIRE(mode="straight") {#X566:3 %t2895:p};
// %t2896 = $SUPPLY @ATTACH &vdd => @PLACE(584, -1630);
// &vdd @WIRE(mode="straight") {#X566:4 %t2896:p};
// %t2897 = $GROUND @ATTACH &vss => @PLACE(584, -1652);
// &vss @WIRE(mode="straight") {#X566:5 %t2897:p};
// %t2898 = $IO_PORT @ATTACH &n814 => @PLACE(614, -1639) => @ORIENT("R0");
// %t2898 @TEXT("n814", key="name", size=0.75);
// &n814 @WIRE(mode="straight") {#X567:1 %t2898:p};
// %t2899 = $IO_PORT @ATTACH &n573 => @PLACE(614, -1643) => @ORIENT("R0");
// %t2899 @TEXT("n573", key="name", size=0.75);
// &n573 @WIRE(mode="straight") {#X567:2 %t2899:p};
// %t2900 = $IO_PORT @ATTACH &n815 => @PLACE(635, -1641) => @ORIENT("MY");
// %t2900 @TEXT("n815", key="name", size=0.75);
// &n815 @WIRE(mode="straight") {#X567:3 %t2900:p};
// %t2901 = $SUPPLY @ATTACH &vdd => @PLACE(624, -1630);
// &vdd @WIRE(mode="straight") {#X567:4 %t2901:p};
// %t2902 = $GROUND @ATTACH &vss => @PLACE(624, -1652);
// &vss @WIRE(mode="straight") {#X567:5 %t2902:p};
// %t2903 = $IO_PORT @ATTACH &dac5 => @PLACE(494, -1670) => @ORIENT("R0");
// %t2903 @TEXT("dac5", key="name", size=0.75);
// &dac5 @WIRE(mode="straight") {#X568:1 %t2903:p};
// %t2904 = $IO_PORT @ATTACH &dac4 => @PLACE(494, -1674) => @ORIENT("R0");
// %t2904 @TEXT("dac4", key="name", size=0.75);
// &dac4 @WIRE(mode="straight") {#X568:2 %t2904:p};
// %t2905 = $IO_PORT @ATTACH &n813 => @PLACE(514, -1672) => @ORIENT("MY");
// %t2905 @TEXT("n813", key="name", size=0.75);
// &n813 @WIRE(mode="straight") {#X568:3 %t2905:p};
// %t2906 = $SUPPLY @ATTACH &vdd => @PLACE(504, -1661);
// &vdd @WIRE(mode="straight") {#X568:4 %t2906:p};
// %t2907 = $GROUND @ATTACH &vss => @PLACE(504, -1683);
// &vss @WIRE(mode="straight") {#X568:5 %t2907:p};
// %t2908 = $IO_PORT @ATTACH &measured8 => @PLACE(534, -1670) => @ORIENT("R0");
// %t2908 @TEXT("measured8", key="name", size=0.75);
// &measured8 @WIRE(mode="straight") {#X569:1 %t2908:p};
// %t2909 = $IO_PORT @ATTACH &n816 => @PLACE(534, -1674) => @ORIENT("R0");
// %t2909 @TEXT("n816", key="name", size=0.75);
// &n816 @WIRE(mode="straight") {#X569:2 %t2909:p};
// %t2910 = $IO_PORT @ATTACH &n705 => @PLACE(554, -1672) => @ORIENT("MY");
// %t2910 @TEXT("n705", key="name", size=0.75);
// &n705 @WIRE(mode="straight") {#X569:3 %t2910:p};
// %t2911 = $SUPPLY @ATTACH &vdd => @PLACE(544, -1661);
// &vdd @WIRE(mode="straight") {#X569:4 %t2911:p};
// %t2912 = $GROUND @ATTACH &vss => @PLACE(544, -1683);
// &vss @WIRE(mode="straight") {#X569:5 %t2912:p};
// %t2913 = $IO_PORT @ATTACH &measured9 => @PLACE(574, -1670) => @ORIENT("R0");
// %t2913 @TEXT("measured9", key="name", size=0.75);
// &measured9 @WIRE(mode="straight") {#X570:1 %t2913:p};
// %t2914 = $IO_PORT @ATTACH &n817 => @PLACE(574, -1674) => @ORIENT("R0");
// %t2914 @TEXT("n817", key="name", size=0.75);
// &n817 @WIRE(mode="straight") {#X570:2 %t2914:p};
// %t2915 = $IO_PORT @ATTACH &n720 => @PLACE(594, -1672) => @ORIENT("MY");
// %t2915 @TEXT("n720", key="name", size=0.75);
// &n720 @WIRE(mode="straight") {#X570:3 %t2915:p};
// %t2916 = $SUPPLY @ATTACH &vdd => @PLACE(584, -1661);
// &vdd @WIRE(mode="straight") {#X570:4 %t2916:p};
// %t2917 = $GROUND @ATTACH &vss => @PLACE(584, -1683);
// &vss @WIRE(mode="straight") {#X570:5 %t2917:p};
// %t2918 = $IO_PORT @ATTACH &measured10 => @PLACE(614, -1670) => @ORIENT("R0");
// %t2918 @TEXT("measured10", key="name", size=0.75);
// &measured10 @WIRE(mode="straight") {#X571:1 %t2918:p};
// %t2919 = $IO_PORT @ATTACH &n818 => @PLACE(614, -1674) => @ORIENT("R0");
// %t2919 @TEXT("n818", key="name", size=0.75);
// &n818 @WIRE(mode="straight") {#X571:2 %t2919:p};
// %t2920 = $IO_PORT @ATTACH &n709 => @PLACE(635, -1672) => @ORIENT("MY");
// %t2920 @TEXT("n709", key="name", size=0.75);
// &n709 @WIRE(mode="straight") {#X571:3 %t2920:p};
// %t2921 = $SUPPLY @ATTACH &vdd => @PLACE(624, -1661);
// &vdd @WIRE(mode="straight") {#X571:4 %t2921:p};
// %t2922 = $GROUND @ATTACH &vss => @PLACE(624, -1683);
// &vss @WIRE(mode="straight") {#X571:5 %t2922:p};
// %t2923 = $IO_PORT @ATTACH &measured8 => @PLACE(494, -1701) => @ORIENT("R0");
// %t2923 @TEXT("measured8", key="name", size=0.75);
// &measured8 @WIRE(mode="straight") {#X572:1 %t2923:p};
// %t2924 = $IO_PORT @ATTACH &n816 => @PLACE(494, -1705) => @ORIENT("R0");
// %t2924 @TEXT("n816", key="name", size=0.75);
// &n816 @WIRE(mode="straight") {#X572:2 %t2924:p};
// %t2925 = $IO_PORT @ATTACH &n560 => @PLACE(514, -1703) => @ORIENT("MY");
// %t2925 @TEXT("n560", key="name", size=0.75);
// &n560 @WIRE(mode="straight") {#X572:3 %t2925:p};
// %t2926 = $SUPPLY @ATTACH &vdd => @PLACE(504, -1692);
// &vdd @WIRE(mode="straight") {#X572:4 %t2926:p};
// %t2927 = $GROUND @ATTACH &vss => @PLACE(504, -1714);
// &vss @WIRE(mode="straight") {#X572:5 %t2927:p};
// %t2928 = $IO_PORT @ATTACH &measured10 => @PLACE(534, -1701) => @ORIENT("R0");
// %t2928 @TEXT("measured10", key="name", size=0.75);
// &measured10 @WIRE(mode="straight") {#X573:1 %t2928:p};
// %t2929 = $IO_PORT @ATTACH &n818 => @PLACE(534, -1705) => @ORIENT("R0");
// %t2929 @TEXT("n818", key="name", size=0.75);
// &n818 @WIRE(mode="straight") {#X573:2 %t2929:p};
// %t2930 = $IO_PORT @ATTACH &n507 => @PLACE(554, -1703) => @ORIENT("MY");
// %t2930 @TEXT("n507", key="name", size=0.75);
// &n507 @WIRE(mode="straight") {#X573:3 %t2930:p};
// %t2931 = $SUPPLY @ATTACH &vdd => @PLACE(544, -1692);
// &vdd @WIRE(mode="straight") {#X573:4 %t2931:p};
// %t2932 = $GROUND @ATTACH &vss => @PLACE(544, -1714);
// &vss @WIRE(mode="straight") {#X573:5 %t2932:p};
// %t2933 = $IO_PORT @ATTACH &n697 => @PLACE(574, -1701) => @ORIENT("R0");
// %t2933 @TEXT("n697", key="name", size=0.75);
// &n697 @WIRE(mode="straight") {#X574:1 %t2933:p};
// %t2934 = $IO_PORT @ATTACH &n819 => @PLACE(574, -1705) => @ORIENT("R0");
// %t2934 @TEXT("n819", key="name", size=0.75);
// &n819 @WIRE(mode="straight") {#X574:2 %t2934:p};
// %t2935 = $IO_PORT @ATTACH &n443 => @PLACE(594, -1703) => @ORIENT("MY");
// %t2935 @TEXT("n443", key="name", size=0.75);
// &n443 @WIRE(mode="straight") {#X574:3 %t2935:p};
// %t2936 = $SUPPLY @ATTACH &vdd => @PLACE(584, -1692);
// &vdd @WIRE(mode="straight") {#X574:4 %t2936:p};
// %t2937 = $GROUND @ATTACH &vss => @PLACE(584, -1714);
// &vss @WIRE(mode="straight") {#X574:5 %t2937:p};
// %t2938 = $IO_PORT @ATTACH &n820 => @PLACE(614, -1701) => @ORIENT("R0");
// %t2938 @TEXT("n820", key="name", size=0.75);
// &n820 @WIRE(mode="straight") {#X575:1 %t2938:p};
// %t2939 = $IO_PORT @ATTACH &n821 => @PLACE(614, -1705) => @ORIENT("R0");
// %t2939 @TEXT("n821", key="name", size=0.75);
// &n821 @WIRE(mode="straight") {#X575:2 %t2939:p};
// %t2940 = $IO_PORT @ATTACH &n505 => @PLACE(635, -1703) => @ORIENT("MY");
// %t2940 @TEXT("n505", key="name", size=0.75);
// &n505 @WIRE(mode="straight") {#X575:3 %t2940:p};
// %t2941 = $SUPPLY @ATTACH &vdd => @PLACE(624, -1692);
// &vdd @WIRE(mode="straight") {#X575:4 %t2941:p};
// %t2942 = $GROUND @ATTACH &vss => @PLACE(624, -1714);
// &vss @WIRE(mode="straight") {#X575:5 %t2942:p};
// %t2943 = $IO_PORT @ATTACH &n822 => @PLACE(-11, -1744) => @ORIENT("R0");
// %t2943 @TEXT("n822", key="name", size=0.75);
// &n822 @WIRE(mode="straight") {#X576:1 %t2943:p};
// %t2944 = $IO_PORT @ATTACH &n823 => @PLACE(-11, -1748) => @ORIENT("R0");
// %t2944 @TEXT("n823", key="name", size=0.75);
// &n823 @WIRE(mode="straight") {#X576:2 %t2944:p};
// %t2945 = $IO_PORT @ATTACH &n824 => @PLACE(10, -1746) => @ORIENT("MY");
// %t2945 @TEXT("n824", key="name", size=0.75);
// &n824 @WIRE(mode="straight") {#X576:3 %t2945:p};
// %t2946 = $SUPPLY @ATTACH &vdd => @PLACE(0, -1735);
// &vdd @WIRE(mode="straight") {#X576:4 %t2946:p};
// %t2947 = $GROUND @ATTACH &vss => @PLACE(0, -1757);
// &vss @WIRE(mode="straight") {#X576:5 %t2947:p};
// %t2948 = $IO_PORT @ATTACH &n716 => @PLACE(30, -1744) => @ORIENT("R0");
// %t2948 @TEXT("n716", key="name", size=0.75);
// &n716 @WIRE(mode="straight") {#X577:1 %t2948:p};
// %t2949 = $IO_PORT @ATTACH &n567 => @PLACE(30, -1748) => @ORIENT("R0");
// %t2949 @TEXT("n567", key="name", size=0.75);
// &n567 @WIRE(mode="straight") {#X577:2 %t2949:p};
// %t2950 = $IO_PORT @ATTACH &n823 => @PLACE(50, -1746) => @ORIENT("MY");
// %t2950 @TEXT("n823", key="name", size=0.75);
// &n823 @WIRE(mode="straight") {#X577:3 %t2950:p};
// %t2951 = $SUPPLY @ATTACH &vdd => @PLACE(40, -1735);
// &vdd @WIRE(mode="straight") {#X577:4 %t2951:p};
// %t2952 = $GROUND @ATTACH &vss => @PLACE(40, -1757);
// &vss @WIRE(mode="straight") {#X577:5 %t2952:p};
// %t2953 = $IO_PORT @ATTACH &n507 => @PLACE(70, -1744) => @ORIENT("R0");
// %t2953 @TEXT("n507", key="name", size=0.75);
// &n507 @WIRE(mode="straight") {#X578:1 %t2953:p};
// %t2954 = $IO_PORT @ATTACH &n508 => @PLACE(70, -1748) => @ORIENT("R0");
// %t2954 @TEXT("n508", key="name", size=0.75);
// &n508 @WIRE(mode="straight") {#X578:2 %t2954:p};
// %t2955 = $IO_PORT @ATTACH &n710 => @PLACE(90, -1746) => @ORIENT("MY");
// %t2955 @TEXT("n710", key="name", size=0.75);
// &n710 @WIRE(mode="straight") {#X578:3 %t2955:p};
// %t2956 = $SUPPLY @ATTACH &vdd => @PLACE(80, -1735);
// &vdd @WIRE(mode="straight") {#X578:4 %t2956:p};
// %t2957 = $GROUND @ATTACH &vss => @PLACE(80, -1757);
// &vss @WIRE(mode="straight") {#X578:5 %t2957:p};
// %t2958 = $IO_PORT @ATTACH &n719 => @PLACE(110, -1744) => @ORIENT("R0");
// %t2958 @TEXT("n719", key="name", size=0.75);
// &n719 @WIRE(mode="straight") {#X579:1 %t2958:p};
// %t2959 = $IO_PORT @ATTACH &n561 => @PLACE(110, -1748) => @ORIENT("R0");
// %t2959 @TEXT("n561", key="name", size=0.75);
// &n561 @WIRE(mode="straight") {#X579:2 %t2959:p};
// %t2960 = $IO_PORT @ATTACH &n708 => @PLACE(130, -1746) => @ORIENT("MY");
// %t2960 @TEXT("n708", key="name", size=0.75);
// &n708 @WIRE(mode="straight") {#X579:3 %t2960:p};
// %t2961 = $SUPPLY @ATTACH &vdd => @PLACE(120, -1735);
// &vdd @WIRE(mode="straight") {#X579:4 %t2961:p};
// %t2962 = $GROUND @ATTACH &vss => @PLACE(120, -1757);
// &vss @WIRE(mode="straight") {#X579:5 %t2962:p};
// %t2963 = $IO_PORT @ATTACH &n727 => @PLACE(-11, -1775) => @ORIENT("R0");
// %t2963 @TEXT("n727", key="name", size=0.75);
// &n727 @WIRE(mode="straight") {#X580:1 %t2963:p};
// %t2964 = $IO_PORT @ATTACH &n825 => @PLACE(-11, -1779) => @ORIENT("R0");
// %t2964 @TEXT("n825", key="name", size=0.75);
// &n825 @WIRE(mode="straight") {#X580:2 %t2964:p};
// %t2965 = $IO_PORT @ATTACH &n446 => @PLACE(10, -1777) => @ORIENT("MY");
// %t2965 @TEXT("n446", key="name", size=0.75);
// &n446 @WIRE(mode="straight") {#X580:3 %t2965:p};
// %t2966 = $SUPPLY @ATTACH &vdd => @PLACE(0, -1766);
// &vdd @WIRE(mode="straight") {#X580:4 %t2966:p};
// %t2967 = $GROUND @ATTACH &vss => @PLACE(0, -1788);
// &vss @WIRE(mode="straight") {#X580:5 %t2967:p};
// %t2968 = $IO_PORT @ATTACH &n725 => @PLACE(30, -1775) => @ORIENT("R0");
// %t2968 @TEXT("n725", key="name", size=0.75);
// &n725 @WIRE(mode="straight") {#X581:1 %t2968:p};
// %t2969 = $IO_PORT @ATTACH &n440 => @PLACE(30, -1779) => @ORIENT("R0");
// %t2969 @TEXT("n440", key="name", size=0.75);
// &n440 @WIRE(mode="straight") {#X581:2 %t2969:p};
// %t2970 = $IO_PORT @ATTACH &n825 => @PLACE(50, -1777) => @ORIENT("MY");
// %t2970 @TEXT("n825", key="name", size=0.75);
// &n825 @WIRE(mode="straight") {#X581:3 %t2970:p};
// %t2971 = $SUPPLY @ATTACH &vdd => @PLACE(40, -1766);
// &vdd @WIRE(mode="straight") {#X581:4 %t2971:p};
// %t2972 = $GROUND @ATTACH &vss => @PLACE(40, -1788);
// &vss @WIRE(mode="straight") {#X581:5 %t2972:p};
// %t2973 = $IO_PORT @ATTACH &n826 => @PLACE(70, -1775) => @ORIENT("R0");
// %t2973 @TEXT("n826", key="name", size=0.75);
// &n826 @WIRE(mode="straight") {#X582:1 %t2973:p};
// %t2974 = $IO_PORT @ATTACH &n719 => @PLACE(70, -1779) => @ORIENT("R0");
// %t2974 @TEXT("n719", key="name", size=0.75);
// &n719 @WIRE(mode="straight") {#X582:2 %t2974:p};
// %t2975 = $IO_PORT @ATTACH &n827 => @PLACE(90, -1777) => @ORIENT("MY");
// %t2975 @TEXT("n827", key="name", size=0.75);
// &n827 @WIRE(mode="straight") {#X582:3 %t2975:p};
// %t2976 = $SUPPLY @ATTACH &vdd => @PLACE(80, -1766);
// &vdd @WIRE(mode="straight") {#X582:4 %t2976:p};
// %t2977 = $GROUND @ATTACH &vss => @PLACE(80, -1788);
// &vss @WIRE(mode="straight") {#X582:5 %t2977:p};
// %t2978 = $IO_PORT @ATTACH &n718 => @PLACE(110, -1775) => @ORIENT("R0");
// %t2978 @TEXT("n718", key="name", size=0.75);
// &n718 @WIRE(mode="straight") {#X583:1 %t2978:p};
// %t2979 = $IO_PORT @ATTACH &n828 => @PLACE(110, -1779) => @ORIENT("R0");
// %t2979 @TEXT("n828", key="name", size=0.75);
// &n828 @WIRE(mode="straight") {#X583:2 %t2979:p};
// %t2980 = $IO_PORT @ATTACH &n829 => @PLACE(130, -1777) => @ORIENT("MY");
// %t2980 @TEXT("n829", key="name", size=0.75);
// &n829 @WIRE(mode="straight") {#X583:3 %t2980:p};
// %t2981 = $SUPPLY @ATTACH &vdd => @PLACE(120, -1766);
// &vdd @WIRE(mode="straight") {#X583:4 %t2981:p};
// %t2982 = $GROUND @ATTACH &vss => @PLACE(120, -1788);
// &vss @WIRE(mode="straight") {#X583:5 %t2982:p};
// %t2983 = $IO_PORT @ATTACH &n826 => @PLACE(-11, -1806) => @ORIENT("R0");
// %t2983 @TEXT("n826", key="name", size=0.75);
// &n826 @WIRE(mode="straight") {#X584:1 %t2983:p};
// %t2984 = $IO_PORT @ATTACH &n707 => @PLACE(-11, -1810) => @ORIENT("R0");
// %t2984 @TEXT("n707", key="name", size=0.75);
// &n707 @WIRE(mode="straight") {#X584:2 %t2984:p};
// %t2985 = $IO_PORT @ATTACH &n828 => @PLACE(10, -1808) => @ORIENT("MY");
// %t2985 @TEXT("n828", key="name", size=0.75);
// &n828 @WIRE(mode="straight") {#X584:3 %t2985:p};
// %t2986 = $SUPPLY @ATTACH &vdd => @PLACE(0, -1797);
// &vdd @WIRE(mode="straight") {#X584:4 %t2986:p};
// %t2987 = $GROUND @ATTACH &vss => @PLACE(0, -1819);
// &vss @WIRE(mode="straight") {#X584:5 %t2987:p};
// %t2988 = $IO_PORT @ATTACH &n830 => @PLACE(30, -1806) => @ORIENT("R0");
// %t2988 @TEXT("n830", key="name", size=0.75);
// &n830 @WIRE(mode="straight") {#X585:1 %t2988:p};
// %t2989 = $IO_PORT @ATTACH &n725 => @PLACE(30, -1810) => @ORIENT("R0");
// %t2989 @TEXT("n725", key="name", size=0.75);
// &n725 @WIRE(mode="straight") {#X585:2 %t2989:p};
// %t2990 = $IO_PORT @ATTACH &n831 => @PLACE(50, -1808) => @ORIENT("MY");
// %t2990 @TEXT("n831", key="name", size=0.75);
// &n831 @WIRE(mode="straight") {#X585:3 %t2990:p};
// %t2991 = $SUPPLY @ATTACH &vdd => @PLACE(40, -1797);
// &vdd @WIRE(mode="straight") {#X585:4 %t2991:p};
// %t2992 = $GROUND @ATTACH &vss => @PLACE(40, -1819);
// &vss @WIRE(mode="straight") {#X585:5 %t2992:p};
// %t2993 = $IO_PORT @ATTACH &n830 => @PLACE(70, -1806) => @ORIENT("R0");
// %t2993 @TEXT("n830", key="name", size=0.75);
// &n830 @WIRE(mode="straight") {#X586:1 %t2993:p};
// %t2994 = $IO_PORT @ATTACH &n727 => @PLACE(70, -1810) => @ORIENT("R0");
// %t2994 @TEXT("n727", key="name", size=0.75);
// &n727 @WIRE(mode="straight") {#X586:2 %t2994:p};
// %t2995 = $IO_PORT @ATTACH &n832 => @PLACE(90, -1808) => @ORIENT("MY");
// %t2995 @TEXT("n832", key="name", size=0.75);
// &n832 @WIRE(mode="straight") {#X586:3 %t2995:p};
// %t2996 = $SUPPLY @ATTACH &vdd => @PLACE(80, -1797);
// &vdd @WIRE(mode="straight") {#X586:4 %t2996:p};
// %t2997 = $GROUND @ATTACH &vss => @PLACE(80, -1819);
// &vss @WIRE(mode="straight") {#X586:5 %t2997:p};
// %t2998 = $IO_PORT @ATTACH &n833 => @PLACE(110, -1806) => @ORIENT("R0");
// %t2998 @TEXT("n833", key="name", size=0.75);
// &n833 @WIRE(mode="straight") {#X587:1 %t2998:p};
// %t2999 = $IO_PORT @ATTACH &n834 => @PLACE(110, -1810) => @ORIENT("R0");
// %t2999 @TEXT("n834", key="name", size=0.75);
// &n834 @WIRE(mode="straight") {#X587:2 %t2999:p};
// %t3000 = $IO_PORT @ATTACH &n822 => @PLACE(130, -1808) => @ORIENT("MY");
// %t3000 @TEXT("n822", key="name", size=0.75);
// &n822 @WIRE(mode="straight") {#X587:3 %t3000:p};
// %t3001 = $SUPPLY @ATTACH &vdd => @PLACE(120, -1797);
// &vdd @WIRE(mode="straight") {#X587:4 %t3001:p};
// %t3002 = $GROUND @ATTACH &vss => @PLACE(120, -1819);
// &vss @WIRE(mode="straight") {#X587:5 %t3002:p};
// %t3003 = $IO_PORT @ATTACH &n569 => @PLACE(-11, -1837) => @ORIENT("R0");
// %t3003 @TEXT("n569", key="name", size=0.75);
// &n569 @WIRE(mode="straight") {#X588:1 %t3003:p};
// %t3004 = $IO_PORT @ATTACH &n704 => @PLACE(-11, -1841) => @ORIENT("R0");
// %t3004 @TEXT("n704", key="name", size=0.75);
// &n704 @WIRE(mode="straight") {#X588:2 %t3004:p};
// %t3005 = $IO_PORT @ATTACH &n834 => @PLACE(10, -1839) => @ORIENT("MY");
// %t3005 @TEXT("n834", key="name", size=0.75);
// &n834 @WIRE(mode="straight") {#X588:3 %t3005:p};
// %t3006 = $SUPPLY @ATTACH &vdd => @PLACE(0, -1828);
// &vdd @WIRE(mode="straight") {#X588:4 %t3006:p};
// %t3007 = $GROUND @ATTACH &vss => @PLACE(0, -1850);
// &vss @WIRE(mode="straight") {#X588:5 %t3007:p};
// %t3008 = $IO_PORT @ATTACH &n504 => @PLACE(30, -1837) => @ORIENT("R0");
// %t3008 @TEXT("n504", key="name", size=0.75);
// &n504 @WIRE(mode="straight") {#X589:1 %t3008:p};
// %t3009 = $IO_PORT @ATTACH &n820 => @PLACE(30, -1841) => @ORIENT("R0");
// %t3009 @TEXT("n820", key="name", size=0.75);
// &n820 @WIRE(mode="straight") {#X589:2 %t3009:p};
// %t3010 = $IO_PORT @ATTACH &n723 => @PLACE(50, -1839) => @ORIENT("MY");
// %t3010 @TEXT("n723", key="name", size=0.75);
// &n723 @WIRE(mode="straight") {#X589:3 %t3010:p};
// %t3011 = $SUPPLY @ATTACH &vdd => @PLACE(40, -1828);
// &vdd @WIRE(mode="straight") {#X589:4 %t3011:p};
// %t3012 = $GROUND @ATTACH &vss => @PLACE(40, -1850);
// &vss @WIRE(mode="straight") {#X589:5 %t3012:p};
// %t3013 = $IO_PORT @ATTACH &n333 => @PLACE(70, -1837) => @ORIENT("R0");
// %t3013 @TEXT("n333", key="name", size=0.75);
// &n333 @WIRE(mode="straight") {#X590:1 %t3013:p};
// %t3014 = $IO_PORT @ATTACH &n520 => @PLACE(70, -1841) => @ORIENT("R0");
// %t3014 @TEXT("n520", key="name", size=0.75);
// &n520 @WIRE(mode="straight") {#X590:2 %t3014:p};
// %t3015 = $IO_PORT @ATTACH &n523 => @PLACE(90, -1839) => @ORIENT("MY");
// %t3015 @TEXT("n523", key="name", size=0.75);
// &n523 @WIRE(mode="straight") {#X590:3 %t3015:p};
// %t3016 = $SUPPLY @ATTACH &vdd => @PLACE(80, -1828);
// &vdd @WIRE(mode="straight") {#X590:4 %t3016:p};
// %t3017 = $GROUND @ATTACH &vss => @PLACE(80, -1850);
// &vss @WIRE(mode="straight") {#X590:5 %t3017:p};
// %t3018 = $IO_PORT @ATTACH &n329 => @PLACE(110, -1837) => @ORIENT("R0");
// %t3018 @TEXT("n329", key="name", size=0.75);
// &n329 @WIRE(mode="straight") {#X591:1 %t3018:p};
// %t3019 = $IO_PORT @ATTACH &n516 => @PLACE(110, -1841) => @ORIENT("R0");
// %t3019 @TEXT("n516", key="name", size=0.75);
// &n516 @WIRE(mode="straight") {#X591:2 %t3019:p};
// %t3020 = $IO_PORT @ATTACH &n518 => @PLACE(130, -1839) => @ORIENT("MY");
// %t3020 @TEXT("n518", key="name", size=0.75);
// &n518 @WIRE(mode="straight") {#X591:3 %t3020:p};
// %t3021 = $SUPPLY @ATTACH &vdd => @PLACE(120, -1828);
// &vdd @WIRE(mode="straight") {#X591:4 %t3021:p};
// %t3022 = $GROUND @ATTACH &vss => @PLACE(120, -1850);
// &vss @WIRE(mode="straight") {#X591:5 %t3022:p};
// %t3023 = $IO_PORT @ATTACH &n325 => @PLACE(-11, -1868) => @ORIENT("R0");
// %t3023 @TEXT("n325", key="name", size=0.75);
// &n325 @WIRE(mode="straight") {#X592:1 %t3023:p};
// %t3024 = $IO_PORT @ATTACH &n251 => @PLACE(-11, -1872) => @ORIENT("R0");
// %t3024 @TEXT("n251", key="name", size=0.75);
// &n251 @WIRE(mode="straight") {#X592:2 %t3024:p};
// %t3025 = $IO_PORT @ATTACH &n514 => @PLACE(10, -1870) => @ORIENT("MY");
// %t3025 @TEXT("n514", key="name", size=0.75);
// &n514 @WIRE(mode="straight") {#X592:3 %t3025:p};
// %t3026 = $SUPPLY @ATTACH &vdd => @PLACE(0, -1859);
// &vdd @WIRE(mode="straight") {#X592:4 %t3026:p};
// %t3027 = $GROUND @ATTACH &vss => @PLACE(0, -1881);
// &vss @WIRE(mode="straight") {#X592:5 %t3027:p};
// %t3028 = $IO_PORT @ATTACH &n835 => @PLACE(30, -1868) => @ORIENT("R0");
// %t3028 @TEXT("n835", key="name", size=0.75);
// &n835 @WIRE(mode="straight") {#X593:1 %t3028:p};
// %t3029 = $IO_PORT @ATTACH &n516 => @PLACE(30, -1872) => @ORIENT("R0");
// %t3029 @TEXT("n516", key="name", size=0.75);
// &n516 @WIRE(mode="straight") {#X593:2 %t3029:p};
// %t3030 = $IO_PORT @ATTACH &n249 => @PLACE(50, -1870) => @ORIENT("MY");
// %t3030 @TEXT("n249", key="name", size=0.75);
// &n249 @WIRE(mode="straight") {#X593:3 %t3030:p};
// %t3031 = $SUPPLY @ATTACH &vdd => @PLACE(40, -1859);
// &vdd @WIRE(mode="straight") {#X593:4 %t3031:p};
// %t3032 = $GROUND @ATTACH &vss => @PLACE(40, -1881);
// &vss @WIRE(mode="straight") {#X593:5 %t3032:p};
// %t3033 = $IO_PORT @ATTACH &n836 => @PLACE(70, -1868) => @ORIENT("R0");
// %t3033 @TEXT("n836", key="name", size=0.75);
// &n836 @WIRE(mode="straight") {#X594:1 %t3033:p};
// %t3034 = $IO_PORT @ATTACH &n251 => @PLACE(70, -1872) => @ORIENT("R0");
// %t3034 @TEXT("n251", key="name", size=0.75);
// &n251 @WIRE(mode="straight") {#X594:2 %t3034:p};
// %t3035 = $IO_PORT @ATTACH &n516 => @PLACE(90, -1870) => @ORIENT("MY");
// %t3035 @TEXT("n516", key="name", size=0.75);
// &n516 @WIRE(mode="straight") {#X594:3 %t3035:p};
// %t3036 = $SUPPLY @ATTACH &vdd => @PLACE(80, -1859);
// &vdd @WIRE(mode="straight") {#X594:4 %t3036:p};
// %t3037 = $GROUND @ATTACH &vss => @PLACE(80, -1881);
// &vss @WIRE(mode="straight") {#X594:5 %t3037:p};
// %t3038 = $IO_PORT @ATTACH &n522 => @PLACE(110, -1868) => @ORIENT("R0");
// %t3038 @TEXT("n522", key="name", size=0.75);
// &n522 @WIRE(mode="straight") {#X595:1 %t3038:p};
// %t3039 = $IO_PORT @ATTACH &n333 => @PLACE(110, -1872) => @ORIENT("R0");
// %t3039 @TEXT("n333", key="name", size=0.75);
// &n333 @WIRE(mode="straight") {#X595:2 %t3039:p};
// %t3040 = $IO_PORT @ATTACH &n837 => @PLACE(130, -1870) => @ORIENT("MY");
// %t3040 @TEXT("n837", key="name", size=0.75);
// &n837 @WIRE(mode="straight") {#X595:3 %t3040:p};
// %t3041 = $SUPPLY @ATTACH &vdd => @PLACE(120, -1859);
// &vdd @WIRE(mode="straight") {#X595:4 %t3041:p};
// %t3042 = $GROUND @ATTACH &vss => @PLACE(120, -1881);
// &vss @WIRE(mode="straight") {#X595:5 %t3042:p};
// %t3043 = $IO_PORT @ATTACH &n327 => @PLACE(-11, -1899) => @ORIENT("R0");
// %t3043 @TEXT("n327", key="name", size=0.75);
// &n327 @WIRE(mode="straight") {#X596:1 %t3043:p};
// %t3044 = $IO_PORT @ATTACH &n325 => @PLACE(-11, -1903) => @ORIENT("R0");
// %t3044 @TEXT("n325", key="name", size=0.75);
// &n325 @WIRE(mode="straight") {#X596:2 %t3044:p};
// %t3045 = $IO_PORT @ATTACH &n836 => @PLACE(10, -1901) => @ORIENT("MY");
// %t3045 @TEXT("n836", key="name", size=0.75);
// &n836 @WIRE(mode="straight") {#X596:3 %t3045:p};
// %t3046 = $SUPPLY @ATTACH &vdd => @PLACE(0, -1890);
// &vdd @WIRE(mode="straight") {#X596:4 %t3046:p};
// %t3047 = $GROUND @ATTACH &vss => @PLACE(0, -1912);
// &vss @WIRE(mode="straight") {#X596:5 %t3047:p};
// %t3048 = $IO_PORT @ATTACH &n838 => @PLACE(30, -1899) => @ORIENT("R0");
// %t3048 @TEXT("n838", key="name", size=0.75);
// &n838 @WIRE(mode="straight") {#X597:1 %t3048:p};
// %t3049 = $IO_PORT @ATTACH &n516 => @PLACE(30, -1903) => @ORIENT("R0");
// %t3049 @TEXT("n516", key="name", size=0.75);
// &n516 @WIRE(mode="straight") {#X597:2 %t3049:p};
// %t3050 = $IO_PORT @ATTACH &n520 => @PLACE(50, -1901) => @ORIENT("MY");
// %t3050 @TEXT("n520", key="name", size=0.75);
// &n520 @WIRE(mode="straight") {#X597:3 %t3050:p};
// %t3051 = $SUPPLY @ATTACH &vdd => @PLACE(40, -1890);
// &vdd @WIRE(mode="straight") {#X597:4 %t3051:p};
// %t3052 = $GROUND @ATTACH &vss => @PLACE(40, -1912);
// &vss @WIRE(mode="straight") {#X597:5 %t3052:p};
// %t3053 = $IO_PORT @ATTACH &coarse2 => @PLACE(70, -1899) => @ORIENT("R0");
// %t3053 @TEXT("coarse2", key="name", size=0.75);
// &coarse2 @WIRE(mode="straight") {#X598:1 %t3053:p};
// %t3054 = $IO_PORT @ATTACH &n526 => @PLACE(70, -1903) => @ORIENT("R0");
// %t3054 @TEXT("n526", key="name", size=0.75);
// &n526 @WIRE(mode="straight") {#X598:2 %t3054:p};
// %t3055 = $IO_PORT @ATTACH &n528 => @PLACE(90, -1901) => @ORIENT("MY");
// %t3055 @TEXT("n528", key="name", size=0.75);
// &n528 @WIRE(mode="straight") {#X598:3 %t3055:p};
// %t3056 = $SUPPLY @ATTACH &vdd => @PLACE(80, -1890);
// &vdd @WIRE(mode="straight") {#X598:4 %t3056:p};
// %t3057 = $GROUND @ATTACH &vss => @PLACE(80, -1912);
// &vss @WIRE(mode="straight") {#X598:5 %t3057:p};
// %t3058 = $IO_PORT @ATTACH &coarse4 => @PLACE(110, -1899) => @ORIENT("R0");
// %t3058 @TEXT("coarse4", key="name", size=0.75);
// &coarse4 @WIRE(mode="straight") {#X599:1 %t3058:p};
// %t3059 = $IO_PORT @ATTACH &n530 => @PLACE(110, -1903) => @ORIENT("R0");
// %t3059 @TEXT("n530", key="name", size=0.75);
// &n530 @WIRE(mode="straight") {#X599:2 %t3059:p};
// %t3060 = $IO_PORT @ATTACH &n532 => @PLACE(130, -1901) => @ORIENT("MY");
// %t3060 @TEXT("n532", key="name", size=0.75);
// &n532 @WIRE(mode="straight") {#X599:3 %t3060:p};
// %t3061 = $SUPPLY @ATTACH &vdd => @PLACE(120, -1890);
// &vdd @WIRE(mode="straight") {#X599:4 %t3061:p};
// %t3062 = $GROUND @ATTACH &vss => @PLACE(120, -1912);
// &vss @WIRE(mode="straight") {#X599:5 %t3062:p};
// %t3063 = $IO_PORT @ATTACH &n839 => @PLACE(158, -1744) => @ORIENT("R0");
// %t3063 @TEXT("n839", key="name", size=0.75);
// &n839 @WIRE(mode="straight") {#X600:1 %t3063:p};
// %t3064 = $IO_PORT @ATTACH &n530 => @PLACE(158, -1748) => @ORIENT("R0");
// %t3064 @TEXT("n530", key="name", size=0.75);
// &n530 @WIRE(mode="straight") {#X600:2 %t3064:p};
// %t3065 = $IO_PORT @ATTACH &n534 => @PLACE(178, -1746) => @ORIENT("MY");
// %t3065 @TEXT("n534", key="name", size=0.75);
// &n534 @WIRE(mode="straight") {#X600:3 %t3065:p};
// %t3066 = $SUPPLY @ATTACH &vdd => @PLACE(168, -1735);
// &vdd @WIRE(mode="straight") {#X600:4 %t3066:p};
// %t3067 = $GROUND @ATTACH &vss => @PLACE(168, -1757);
// &vss @WIRE(mode="straight") {#X600:5 %t3067:p};
// %t3068 = $IO_PORT @ATTACH &coarse6 => @PLACE(198, -1744) => @ORIENT("R0");
// %t3068 @TEXT("coarse6", key="name", size=0.75);
// &coarse6 @WIRE(mode="straight") {#X601:1 %t3068:p};
// %t3069 = $IO_PORT @ATTACH &n534 => @PLACE(198, -1748) => @ORIENT("R0");
// %t3069 @TEXT("n534", key="name", size=0.75);
// &n534 @WIRE(mode="straight") {#X601:2 %t3069:p};
// %t3070 = $IO_PORT @ATTACH &n536 => @PLACE(218, -1746) => @ORIENT("MY");
// %t3070 @TEXT("n536", key="name", size=0.75);
// &n536 @WIRE(mode="straight") {#X601:3 %t3070:p};
// %t3071 = $SUPPLY @ATTACH &vdd => @PLACE(208, -1735);
// &vdd @WIRE(mode="straight") {#X601:4 %t3071:p};
// %t3072 = $GROUND @ATTACH &vss => @PLACE(208, -1757);
// &vss @WIRE(mode="straight") {#X601:5 %t3072:p};
// %t3073 = $IO_PORT @ATTACH &n840 => @PLACE(238, -1744) => @ORIENT("R0");
// %t3073 @TEXT("n840", key="name", size=0.75);
// &n840 @WIRE(mode="straight") {#X602:1 %t3073:p};
// %t3074 = $IO_PORT @ATTACH &n526 => @PLACE(238, -1748) => @ORIENT("R0");
// %t3074 @TEXT("n526", key="name", size=0.75);
// &n526 @WIRE(mode="straight") {#X602:2 %t3074:p};
// %t3075 = $IO_PORT @ATTACH &n530 => @PLACE(258, -1746) => @ORIENT("MY");
// %t3075 @TEXT("n530", key="name", size=0.75);
// &n530 @WIRE(mode="straight") {#X602:3 %t3075:p};
// %t3076 = $SUPPLY @ATTACH &vdd => @PLACE(248, -1735);
// &vdd @WIRE(mode="straight") {#X602:4 %t3076:p};
// %t3077 = $GROUND @ATTACH &vss => @PLACE(248, -1757);
// &vss @WIRE(mode="straight") {#X602:5 %t3077:p};
// %t3078 = $IO_PORT @ATTACH &coarse5 => @PLACE(278, -1744) => @ORIENT("R0");
// %t3078 @TEXT("coarse5", key="name", size=0.75);
// &coarse5 @WIRE(mode="straight") {#X603:1 %t3078:p};
// %t3079 = $IO_PORT @ATTACH &coarse4 => @PLACE(278, -1748) => @ORIENT("R0");
// %t3079 @TEXT("coarse4", key="name", size=0.75);
// &coarse4 @WIRE(mode="straight") {#X603:2 %t3079:p};
// %t3080 = $IO_PORT @ATTACH &n839 => @PLACE(298, -1746) => @ORIENT("MY");
// %t3080 @TEXT("n839", key="name", size=0.75);
// &n839 @WIRE(mode="straight") {#X603:3 %t3080:p};
// %t3081 = $SUPPLY @ATTACH &vdd => @PLACE(288, -1735);
// &vdd @WIRE(mode="straight") {#X603:4 %t3081:p};
// %t3082 = $GROUND @ATTACH &vss => @PLACE(288, -1757);
// &vss @WIRE(mode="straight") {#X603:5 %t3082:p};
// %t3083 = $IO_PORT @ATTACH &coarse3 => @PLACE(158, -1775) => @ORIENT("R0");
// %t3083 @TEXT("coarse3", key="name", size=0.75);
// &coarse3 @WIRE(mode="straight") {#X604:1 %t3083:p};
// %t3084 = $IO_PORT @ATTACH &coarse2 => @PLACE(158, -1779) => @ORIENT("R0");
// %t3084 @TEXT("coarse2", key="name", size=0.75);
// &coarse2 @WIRE(mode="straight") {#X604:2 %t3084:p};
// %t3085 = $IO_PORT @ATTACH &n840 => @PLACE(178, -1777) => @ORIENT("MY");
// %t3085 @TEXT("n840", key="name", size=0.75);
// &n840 @WIRE(mode="straight") {#X604:3 %t3085:p};
// %t3086 = $SUPPLY @ATTACH &vdd => @PLACE(168, -1766);
// &vdd @WIRE(mode="straight") {#X604:4 %t3086:p};
// %t3087 = $GROUND @ATTACH &vss => @PLACE(168, -1788);
// &vss @WIRE(mode="straight") {#X604:5 %t3087:p};
// %t3088 = $IO_PORT @ATTACH &coarse1 => @PLACE(198, -1775) => @ORIENT("R0");
// %t3088 @TEXT("coarse1", key="name", size=0.75);
// &coarse1 @WIRE(mode="straight") {#X605:1 %t3088:p};
// %t3089 = $IO_PORT @ATTACH &coarse0 => @PLACE(198, -1779) => @ORIENT("R0");
// %t3089 @TEXT("coarse0", key="name", size=0.75);
// &coarse0 @WIRE(mode="straight") {#X605:2 %t3089:p};
// %t3090 = $IO_PORT @ATTACH &n526 => @PLACE(218, -1777) => @ORIENT("MY");
// %t3090 @TEXT("n526", key="name", size=0.75);
// &n526 @WIRE(mode="straight") {#X605:3 %t3090:p};
// %t3091 = $SUPPLY @ATTACH &vdd => @PLACE(208, -1766);
// &vdd @WIRE(mode="straight") {#X605:4 %t3091:p};
// %t3092 = $GROUND @ATTACH &vss => @PLACE(208, -1788);
// &vss @WIRE(mode="straight") {#X605:5 %t3092:p};
// %t3093 = $IO_PORT @ATTACH &coarse2 => @PLACE(238, -1775) => @ORIENT("R0");
// %t3093 @TEXT("coarse2", key="name", size=0.75);
// &coarse2 @WIRE(mode="straight") {#X606:1 %t3093:p};
// %t3094 = $IO_PORT @ATTACH &n841 => @PLACE(238, -1779) => @ORIENT("R0");
// %t3094 @TEXT("n841", key="name", size=0.75);
// &n841 @WIRE(mode="straight") {#X606:2 %t3094:p};
// %t3095 = $IO_PORT @ATTACH &n544 => @PLACE(258, -1777) => @ORIENT("MY");
// %t3095 @TEXT("n544", key="name", size=0.75);
// &n544 @WIRE(mode="straight") {#X606:3 %t3095:p};
// %t3096 = $SUPPLY @ATTACH &vdd => @PLACE(248, -1766);
// &vdd @WIRE(mode="straight") {#X606:4 %t3096:p};
// %t3097 = $GROUND @ATTACH &vss => @PLACE(248, -1788);
// &vss @WIRE(mode="straight") {#X606:5 %t3097:p};
// %t3098 = $IO_PORT @ATTACH &n540 => @PLACE(278, -1775) => @ORIENT("R0");
// %t3098 @TEXT("n540", key="name", size=0.75);
// &n540 @WIRE(mode="straight") {#X607:1 %t3098:p};
// %t3099 = $IO_PORT @ATTACH &n541 => @PLACE(278, -1779) => @ORIENT("R0");
// %t3099 @TEXT("n541", key="name", size=0.75);
// &n541 @WIRE(mode="straight") {#X607:2 %t3099:p};
// %t3100 = $IO_PORT @ATTACH &n841 => @PLACE(298, -1777) => @ORIENT("MY");
// %t3100 @TEXT("n841", key="name", size=0.75);
// &n841 @WIRE(mode="straight") {#X607:3 %t3100:p};
// %t3101 = $SUPPLY @ATTACH &vdd => @PLACE(288, -1766);
// &vdd @WIRE(mode="straight") {#X607:4 %t3101:p};
// %t3102 = $GROUND @ATTACH &vss => @PLACE(288, -1788);
// &vss @WIRE(mode="straight") {#X607:5 %t3102:p};
// %t3103 = $IO_PORT @ATTACH &n546 => @PLACE(158, -1806) => @ORIENT("R0");
// %t3103 @TEXT("n546", key="name", size=0.75);
// &n546 @WIRE(mode="straight") {#X608:1 %t3103:p};
// %t3104 = $IO_PORT @ATTACH &n547 => @PLACE(158, -1810) => @ORIENT("R0");
// %t3104 @TEXT("n547", key="name", size=0.75);
// &n547 @WIRE(mode="straight") {#X608:2 %t3104:p};
// %t3105 = $IO_PORT @ATTACH &n842 => @PLACE(178, -1808) => @ORIENT("MY");
// %t3105 @TEXT("n842", key="name", size=0.75);
// &n842 @WIRE(mode="straight") {#X608:3 %t3105:p};
// %t3106 = $SUPPLY @ATTACH &vdd => @PLACE(168, -1797);
// &vdd @WIRE(mode="straight") {#X608:4 %t3106:p};
// %t3107 = $GROUND @ATTACH &vss => @PLACE(168, -1819);
// &vss @WIRE(mode="straight") {#X608:5 %t3107:p};
// %t3108 = $IO_PORT @ATTACH &n843 => @PLACE(198, -1806) => @ORIENT("R0");
// %t3108 @TEXT("n843", key="name", size=0.75);
// &n843 @WIRE(mode="straight") {#X609:1 %t3108:p};
// %t3109 = $IO_PORT @ATTACH &n844 => @PLACE(198, -1810) => @ORIENT("R0");
// %t3109 @TEXT("n844", key="name", size=0.75);
// &n844 @WIRE(mode="straight") {#X609:2 %t3109:p};
// %t3110 = $IO_PORT @ATTACH &n553 => @PLACE(218, -1808) => @ORIENT("MY");
// %t3110 @TEXT("n553", key="name", size=0.75);
// &n553 @WIRE(mode="straight") {#X609:3 %t3110:p};
// %t3111 = $SUPPLY @ATTACH &vdd => @PLACE(208, -1797);
// &vdd @WIRE(mode="straight") {#X609:4 %t3111:p};
// %t3112 = $GROUND @ATTACH &vss => @PLACE(208, -1819);
// &vss @WIRE(mode="straight") {#X609:5 %t3112:p};
// %t3113 = $IO_PORT @ATTACH &n845 => @PLACE(238, -1806) => @ORIENT("R0");
// %t3113 @TEXT("n845", key="name", size=0.75);
// &n845 @WIRE(mode="straight") {#X610:1 %t3113:p};
// %t3114 = $IO_PORT @ATTACH &n547 => @PLACE(238, -1810) => @ORIENT("R0");
// %t3114 @TEXT("n547", key="name", size=0.75);
// &n547 @WIRE(mode="straight") {#X610:2 %t3114:p};
// %t3115 = $IO_PORT @ATTACH &n844 => @PLACE(258, -1808) => @ORIENT("MY");
// %t3115 @TEXT("n844", key="name", size=0.75);
// &n844 @WIRE(mode="straight") {#X610:3 %t3115:p};
// %t3116 = $SUPPLY @ATTACH &vdd => @PLACE(248, -1797);
// &vdd @WIRE(mode="straight") {#X610:4 %t3116:p};
// %t3117 = $GROUND @ATTACH &vss => @PLACE(248, -1819);
// &vss @WIRE(mode="straight") {#X610:5 %t3117:p};
// %t3118 = $IO_PORT @ATTACH &n552 => @PLACE(278, -1806) => @ORIENT("R0");
// %t3118 @TEXT("n552", key="name", size=0.75);
// &n552 @WIRE(mode="straight") {#X611:1 %t3118:p};
// %t3119 = $IO_PORT @ATTACH &n553 => @PLACE(278, -1810) => @ORIENT("R0");
// %t3119 @TEXT("n553", key="name", size=0.75);
// &n553 @WIRE(mode="straight") {#X611:2 %t3119:p};
// %t3120 = $IO_PORT @ATTACH &n846 => @PLACE(298, -1808) => @ORIENT("MY");
// %t3120 @TEXT("n846", key="name", size=0.75);
// &n846 @WIRE(mode="straight") {#X611:3 %t3120:p};
// %t3121 = $SUPPLY @ATTACH &vdd => @PLACE(288, -1797);
// &vdd @WIRE(mode="straight") {#X611:4 %t3121:p};
// %t3122 = $GROUND @ATTACH &vss => @PLACE(288, -1819);
// &vss @WIRE(mode="straight") {#X611:5 %t3122:p};
// %t3123 = $IO_PORT @ATTACH &coarse6 => @PLACE(158, -1837) => @ORIENT("R0");
// %t3123 @TEXT("coarse6", key="name", size=0.75);
// &coarse6 @WIRE(mode="straight") {#X612:1 %t3123:p};
// %t3124 = $IO_PORT @ATTACH &n846 => @PLACE(158, -1841) => @ORIENT("R0");
// %t3124 @TEXT("n846", key="name", size=0.75);
// &n846 @WIRE(mode="straight") {#X612:2 %t3124:p};
// %t3125 = $IO_PORT @ATTACH &n555 => @PLACE(178, -1839) => @ORIENT("MY");
// %t3125 @TEXT("n555", key="name", size=0.75);
// &n555 @WIRE(mode="straight") {#X612:3 %t3125:p};
// %t3126 = $SUPPLY @ATTACH &vdd => @PLACE(168, -1828);
// &vdd @WIRE(mode="straight") {#X612:4 %t3126:p};
// %t3127 = $GROUND @ATTACH &vss => @PLACE(168, -1850);
// &vss @WIRE(mode="straight") {#X612:5 %t3127:p};
// %t3128 = $IO_PORT @ATTACH &n847 => @PLACE(198, -1837) => @ORIENT("R0");
// %t3128 @TEXT("n847", key="name", size=0.75);
// &n847 @WIRE(mode="straight") {#X613:1 %t3128:p};
// %t3129 = $IO_PORT @ATTACH &n848 => @PLACE(198, -1841) => @ORIENT("R0");
// %t3129 @TEXT("n848", key="name", size=0.75);
// &n848 @WIRE(mode="straight") {#X613:2 %t3129:p};
// %t3130 = $IO_PORT @ATTACH &n547 => @PLACE(218, -1839) => @ORIENT("MY");
// %t3130 @TEXT("n547", key="name", size=0.75);
// &n547 @WIRE(mode="straight") {#X613:3 %t3130:p};
// %t3131 = $SUPPLY @ATTACH &vdd => @PLACE(208, -1828);
// &vdd @WIRE(mode="straight") {#X613:4 %t3131:p};
// %t3132 = $GROUND @ATTACH &vss => @PLACE(208, -1850);
// &vss @WIRE(mode="straight") {#X613:5 %t3132:p};
// %t3133 = $IO_PORT @ATTACH &n849 => @PLACE(238, -1837) => @ORIENT("R0");
// %t3133 @TEXT("n849", key="name", size=0.75);
// &n849 @WIRE(mode="straight") {#X614:1 %t3133:p};
// %t3134 = $IO_PORT @ATTACH &n541 => @PLACE(238, -1841) => @ORIENT("R0");
// %t3134 @TEXT("n541", key="name", size=0.75);
// &n541 @WIRE(mode="straight") {#X614:2 %t3134:p};
// %t3135 = $IO_PORT @ATTACH &n848 => @PLACE(258, -1839) => @ORIENT("MY");
// %t3135 @TEXT("n848", key="name", size=0.75);
// &n848 @WIRE(mode="straight") {#X614:3 %t3135:p};
// %t3136 = $SUPPLY @ATTACH &vdd => @PLACE(248, -1828);
// &vdd @WIRE(mode="straight") {#X614:4 %t3136:p};
// %t3137 = $GROUND @ATTACH &vss => @PLACE(248, -1850);
// &vss @WIRE(mode="straight") {#X614:5 %t3137:p};
// %t3138 = $IO_PORT @ATTACH &n549 => @PLACE(278, -1837) => @ORIENT("R0");
// %t3138 @TEXT("n549", key="name", size=0.75);
// &n549 @WIRE(mode="straight") {#X615:1 %t3138:p};
// %t3139 = $IO_PORT @ATTACH &n546 => @PLACE(278, -1841) => @ORIENT("R0");
// %t3139 @TEXT("n546", key="name", size=0.75);
// &n546 @WIRE(mode="straight") {#X615:2 %t3139:p};
// %t3140 = $IO_PORT @ATTACH &n845 => @PLACE(298, -1839) => @ORIENT("MY");
// %t3140 @TEXT("n845", key="name", size=0.75);
// &n845 @WIRE(mode="straight") {#X615:3 %t3140:p};
// %t3141 = $SUPPLY @ATTACH &vdd => @PLACE(288, -1828);
// &vdd @WIRE(mode="straight") {#X615:4 %t3141:p};
// %t3142 = $GROUND @ATTACH &vss => @PLACE(288, -1850);
// &vss @WIRE(mode="straight") {#X615:5 %t3142:p};
// %t3143 = $IO_PORT @ATTACH &coarse5 => @PLACE(158, -1868) => @ORIENT("R0");
// %t3143 @TEXT("coarse5", key="name", size=0.75);
// &coarse5 @WIRE(mode="straight") {#X616:1 %t3143:p};
// %t3144 = $IO_PORT @ATTACH &n850 => @PLACE(158, -1872) => @ORIENT("R0");
// %t3144 @TEXT("n850", key="name", size=0.75);
// &n850 @WIRE(mode="straight") {#X616:2 %t3144:p};
// %t3145 = $IO_PORT @ATTACH &n843 => @PLACE(178, -1870) => @ORIENT("MY");
// %t3145 @TEXT("n843", key="name", size=0.75);
// &n843 @WIRE(mode="straight") {#X616:3 %t3145:p};
// %t3146 = $SUPPLY @ATTACH &vdd => @PLACE(168, -1859);
// &vdd @WIRE(mode="straight") {#X616:4 %t3146:p};
// %t3147 = $GROUND @ATTACH &vss => @PLACE(168, -1881);
// &vss @WIRE(mode="straight") {#X616:5 %t3147:p};
// %t3148 = $IO_PORT @ATTACH &n549 => @PLACE(198, -1868) => @ORIENT("R0");
// %t3148 @TEXT("n549", key="name", size=0.75);
// &n549 @WIRE(mode="straight") {#X617:1 %t3148:p};
// %t3149 = $IO_PORT @ATTACH &coarse4 => @PLACE(198, -1872) => @ORIENT("R0");
// %t3149 @TEXT("coarse4", key="name", size=0.75);
// &coarse4 @WIRE(mode="straight") {#X617:2 %t3149:p};
// %t3150 = $IO_PORT @ATTACH &n850 => @PLACE(218, -1870) => @ORIENT("MY");
// %t3150 @TEXT("n850", key="name", size=0.75);
// &n850 @WIRE(mode="straight") {#X617:3 %t3150:p};
// %t3151 = $SUPPLY @ATTACH &vdd => @PLACE(208, -1859);
// &vdd @WIRE(mode="straight") {#X617:4 %t3151:p};
// %t3152 = $GROUND @ATTACH &vss => @PLACE(208, -1881);
// &vss @WIRE(mode="straight") {#X617:5 %t3152:p};
// %t3153 = $IO_PORT @ATTACH &n543 => @PLACE(238, -1868) => @ORIENT("R0");
// %t3153 @TEXT("n543", key="name", size=0.75);
// &n543 @WIRE(mode="straight") {#X618:1 %t3153:p};
// %t3154 = $IO_PORT @ATTACH &n540 => @PLACE(238, -1872) => @ORIENT("R0");
// %t3154 @TEXT("n540", key="name", size=0.75);
// &n540 @WIRE(mode="straight") {#X618:2 %t3154:p};
// %t3155 = $IO_PORT @ATTACH &n849 => @PLACE(258, -1870) => @ORIENT("MY");
// %t3155 @TEXT("n849", key="name", size=0.75);
// &n849 @WIRE(mode="straight") {#X618:3 %t3155:p};
// %t3156 = $SUPPLY @ATTACH &vdd => @PLACE(248, -1859);
// &vdd @WIRE(mode="straight") {#X618:4 %t3156:p};
// %t3157 = $GROUND @ATTACH &vss => @PLACE(248, -1881);
// &vss @WIRE(mode="straight") {#X618:5 %t3157:p};
// %t3158 = $IO_PORT @ATTACH &coarse3 => @PLACE(278, -1868) => @ORIENT("R0");
// %t3158 @TEXT("coarse3", key="name", size=0.75);
// &coarse3 @WIRE(mode="straight") {#X619:1 %t3158:p};
// %t3159 = $IO_PORT @ATTACH &n851 => @PLACE(278, -1872) => @ORIENT("R0");
// %t3159 @TEXT("n851", key="name", size=0.75);
// &n851 @WIRE(mode="straight") {#X619:2 %t3159:p};
// %t3160 = $IO_PORT @ATTACH &n847 => @PLACE(298, -1870) => @ORIENT("MY");
// %t3160 @TEXT("n847", key="name", size=0.75);
// &n847 @WIRE(mode="straight") {#X619:3 %t3160:p};
// %t3161 = $SUPPLY @ATTACH &vdd => @PLACE(288, -1859);
// &vdd @WIRE(mode="straight") {#X619:4 %t3161:p};
// %t3162 = $GROUND @ATTACH &vss => @PLACE(288, -1881);
// &vss @WIRE(mode="straight") {#X619:5 %t3162:p};
// %t3163 = $IO_PORT @ATTACH &n543 => @PLACE(158, -1899) => @ORIENT("R0");
// %t3163 @TEXT("n543", key="name", size=0.75);
// &n543 @WIRE(mode="straight") {#X620:1 %t3163:p};
// %t3164 = $IO_PORT @ATTACH &coarse2 => @PLACE(158, -1903) => @ORIENT("R0");
// %t3164 @TEXT("coarse2", key="name", size=0.75);
// &coarse2 @WIRE(mode="straight") {#X620:2 %t3164:p};
// %t3165 = $IO_PORT @ATTACH &n851 => @PLACE(178, -1901) => @ORIENT("MY");
// %t3165 @TEXT("n851", key="name", size=0.75);
// &n851 @WIRE(mode="straight") {#X620:3 %t3165:p};
// %t3166 = $SUPPLY @ATTACH &vdd => @PLACE(168, -1890);
// &vdd @WIRE(mode="straight") {#X620:4 %t3166:p};
// %t3167 = $GROUND @ATTACH &vss => @PLACE(168, -1912);
// &vss @WIRE(mode="straight") {#X620:5 %t3167:p};
// %t3168 = $IO_PORT @ATTACH &coarse4 => @PLACE(198, -1899) => @ORIENT("R0");
// %t3168 @TEXT("coarse4", key="name", size=0.75);
// &coarse4 @WIRE(mode="straight") {#X621:1 %t3168:p};
// %t3169 = $IO_PORT @ATTACH &n842 => @PLACE(198, -1903) => @ORIENT("R0");
// %t3169 @TEXT("n842", key="name", size=0.75);
// &n842 @WIRE(mode="straight") {#X621:2 %t3169:p};
// %t3170 = $IO_PORT @ATTACH &n550 => @PLACE(218, -1901) => @ORIENT("MY");
// %t3170 @TEXT("n550", key="name", size=0.75);
// &n550 @WIRE(mode="straight") {#X621:3 %t3170:p};
// %t3171 = $SUPPLY @ATTACH &vdd => @PLACE(208, -1890);
// &vdd @WIRE(mode="straight") {#X621:4 %t3171:p};
// %t3172 = $GROUND @ATTACH &vss => @PLACE(208, -1912);
// &vss @WIRE(mode="straight") {#X621:5 %t3172:p};
// %t3173 = $IO_PORT @ATTACH &coarse1 => @PLACE(238, -1899) => @ORIENT("R0");
// %t3173 @TEXT("coarse1", key="name", size=0.75);
// &coarse1 @WIRE(mode="straight") {#X622:1 %t3173:p};
// %t3174 = $IO_PORT @ATTACH &n852 => @PLACE(238, -1903) => @ORIENT("R0");
// %t3174 @TEXT("n852", key="name", size=0.75);
// &n852 @WIRE(mode="straight") {#X622:2 %t3174:p};
// %t3175 = $IO_PORT @ATTACH &n541 => @PLACE(258, -1901) => @ORIENT("MY");
// %t3175 @TEXT("n541", key="name", size=0.75);
// &n541 @WIRE(mode="straight") {#X622:3 %t3175:p};
// %t3176 = $SUPPLY @ATTACH &vdd => @PLACE(248, -1890);
// &vdd @WIRE(mode="straight") {#X622:4 %t3176:p};
// %t3177 = $GROUND @ATTACH &vss => @PLACE(248, -1912);
// &vss @WIRE(mode="straight") {#X622:5 %t3177:p};
// %t3178 = $IO_PORT @ATTACH &n538 => @PLACE(278, -1899) => @ORIENT("R0");
// %t3178 @TEXT("n538", key="name", size=0.75);
// &n538 @WIRE(mode="straight") {#X623:1 %t3178:p};
// %t3179 = $IO_PORT @ATTACH &coarse0 => @PLACE(278, -1903) => @ORIENT("R0");
// %t3179 @TEXT("coarse0", key="name", size=0.75);
// &coarse0 @WIRE(mode="straight") {#X623:2 %t3179:p};
// %t3180 = $IO_PORT @ATTACH &n852 => @PLACE(298, -1901) => @ORIENT("MY");
// %t3180 @TEXT("n852", key="name", size=0.75);
// &n852 @WIRE(mode="straight") {#X623:3 %t3180:p};
// %t3181 = $SUPPLY @ATTACH &vdd => @PLACE(288, -1890);
// &vdd @WIRE(mode="straight") {#X623:4 %t3181:p};
// %t3182 = $GROUND @ATTACH &vss => @PLACE(288, -1912);
// &vss @WIRE(mode="straight") {#X623:5 %t3182:p};
// %t3183 = $IO_PORT @ATTACH &n95 => @PLACE(326, -1744) => @ORIENT("R0");
// %t3183 @TEXT("n95", key="name", size=0.75);
// &n95 @WIRE(mode="straight") {#X624:1 %t3183:p};
// %t3184 = $IO_PORT @ATTACH &n93 => @PLACE(326, -1748) => @ORIENT("R0");
// %t3184 @TEXT("n93", key="name", size=0.75);
// &n93 @WIRE(mode="straight") {#X624:2 %t3184:p};
// %t3185 = $IO_PORT @ATTACH &n558 => @PLACE(346, -1746) => @ORIENT("MY");
// %t3185 @TEXT("n558", key="name", size=0.75);
// &n558 @WIRE(mode="straight") {#X624:3 %t3185:p};
// %t3186 = $SUPPLY @ATTACH &vdd => @PLACE(336, -1735);
// &vdd @WIRE(mode="straight") {#X624:4 %t3186:p};
// %t3187 = $GROUND @ATTACH &vss => @PLACE(336, -1757);
// &vss @WIRE(mode="straight") {#X624:5 %t3187:p};
// %t3188 = $IO_PORT @ATTACH &n853 => @PLACE(366, -1744) => @ORIENT("R0");
// %t3188 @TEXT("n853", key="name", size=0.75);
// &n853 @WIRE(mode="straight") {#X625:1 %t3188:p};
// %t3189 = $IO_PORT @ATTACH &n854 => @PLACE(366, -1748) => @ORIENT("R0");
// %t3189 @TEXT("n854", key="name", size=0.75);
// &n854 @WIRE(mode="straight") {#X625:2 %t3189:p};
// %t3190 = $IO_PORT @ATTACH &n247 => @PLACE(386, -1746) => @ORIENT("MY");
// %t3190 @TEXT("n247", key="name", size=0.75);
// &n247 @WIRE(mode="straight") {#X625:3 %t3190:p};
// %t3191 = $SUPPLY @ATTACH &vdd => @PLACE(376, -1735);
// &vdd @WIRE(mode="straight") {#X625:4 %t3191:p};
// %t3192 = $GROUND @ATTACH &vss => @PLACE(376, -1757);
// &vss @WIRE(mode="straight") {#X625:5 %t3192:p};
// %t3193 = $IO_PORT @ATTACH &n855 => @PLACE(406, -1744) => @ORIENT("R0");
// %t3193 @TEXT("n855", key="name", size=0.75);
// &n855 @WIRE(mode="straight") {#X626:1 %t3193:p};
// %t3194 = $IO_PORT @ATTACH &n856 => @PLACE(406, -1748) => @ORIENT("R0");
// %t3194 @TEXT("n856", key="name", size=0.75);
// &n856 @WIRE(mode="straight") {#X626:2 %t3194:p};
// %t3195 = $IO_PORT @ATTACH &n854 => @PLACE(426, -1746) => @ORIENT("MY");
// %t3195 @TEXT("n854", key="name", size=0.75);
// &n854 @WIRE(mode="straight") {#X626:3 %t3195:p};
// %t3196 = $SUPPLY @ATTACH &vdd => @PLACE(416, -1735);
// &vdd @WIRE(mode="straight") {#X626:4 %t3196:p};
// %t3197 = $GROUND @ATTACH &vss => @PLACE(416, -1757);
// &vss @WIRE(mode="straight") {#X626:5 %t3197:p};
// %t3198 = $IO_PORT @ATTACH &n857 => @PLACE(446, -1744) => @ORIENT("R0");
// %t3198 @TEXT("n857", key="name", size=0.75);
// &n857 @WIRE(mode="straight") {#X627:1 %t3198:p};
// %t3199 = $IO_PORT @ATTACH &n858 => @PLACE(446, -1748) => @ORIENT("R0");
// %t3199 @TEXT("n858", key="name", size=0.75);
// &n858 @WIRE(mode="straight") {#X627:2 %t3199:p};
// %t3200 = $IO_PORT @ATTACH &n853 => @PLACE(466, -1746) => @ORIENT("MY");
// %t3200 @TEXT("n853", key="name", size=0.75);
// &n853 @WIRE(mode="straight") {#X627:3 %t3200:p};
// %t3201 = $SUPPLY @ATTACH &vdd => @PLACE(456, -1735);
// &vdd @WIRE(mode="straight") {#X627:4 %t3201:p};
// %t3202 = $GROUND @ATTACH &vss => @PLACE(456, -1757);
// &vss @WIRE(mode="straight") {#X627:5 %t3202:p};
// %t3203 = $IO_PORT @ATTACH &n859 => @PLACE(326, -1775) => @ORIENT("R0");
// %t3203 @TEXT("n859", key="name", size=0.75);
// &n859 @WIRE(mode="straight") {#X628:1 %t3203:p};
// %t3204 = $IO_PORT @ATTACH &n860 => @PLACE(326, -1779) => @ORIENT("R0");
// %t3204 @TEXT("n860", key="name", size=0.75);
// &n860 @WIRE(mode="straight") {#X628:2 %t3204:p};
// %t3205 = $IO_PORT @ATTACH &n858 => @PLACE(346, -1777) => @ORIENT("MY");
// %t3205 @TEXT("n858", key="name", size=0.75);
// &n858 @WIRE(mode="straight") {#X628:3 %t3205:p};
// %t3206 = $SUPPLY @ATTACH &vdd => @PLACE(336, -1766);
// &vdd @WIRE(mode="straight") {#X628:4 %t3206:p};
// %t3207 = $GROUND @ATTACH &vss => @PLACE(336, -1788);
// &vss @WIRE(mode="straight") {#X628:5 %t3207:p};
// %t3208 = $IO_PORT @ATTACH &n861 => @PLACE(366, -1775) => @ORIENT("R0");
// %t3208 @TEXT("n861", key="name", size=0.75);
// &n861 @WIRE(mode="straight") {#X629:1 %t3208:p};
// %t3209 = $IO_PORT @ATTACH &n862 => @PLACE(366, -1779) => @ORIENT("R0");
// %t3209 @TEXT("n862", key="name", size=0.75);
// &n862 @WIRE(mode="straight") {#X629:2 %t3209:p};
// %t3210 = $IO_PORT @ATTACH &n856 => @PLACE(386, -1777) => @ORIENT("MY");
// %t3210 @TEXT("n856", key="name", size=0.75);
// &n856 @WIRE(mode="straight") {#X629:3 %t3210:p};
// %t3211 = $SUPPLY @ATTACH &vdd => @PLACE(376, -1766);
// &vdd @WIRE(mode="straight") {#X629:4 %t3211:p};
// %t3212 = $GROUND @ATTACH &vss => @PLACE(376, -1788);
// &vss @WIRE(mode="straight") {#X629:5 %t3212:p};
// %t3213 = $IO_PORT @ATTACH &n863 => @PLACE(406, -1775) => @ORIENT("R0");
// %t3213 @TEXT("n863", key="name", size=0.75);
// &n863 @WIRE(mode="straight") {#X630:1 %t3213:p};
// %t3214 = $IO_PORT @ATTACH &n864 => @PLACE(406, -1779) => @ORIENT("R0");
// %t3214 @TEXT("n864", key="name", size=0.75);
// &n864 @WIRE(mode="straight") {#X630:2 %t3214:p};
// %t3215 = $IO_PORT @ATTACH &n862 => @PLACE(426, -1777) => @ORIENT("MY");
// %t3215 @TEXT("n862", key="name", size=0.75);
// &n862 @WIRE(mode="straight") {#X630:3 %t3215:p};
// %t3216 = $SUPPLY @ATTACH &vdd => @PLACE(416, -1766);
// &vdd @WIRE(mode="straight") {#X630:4 %t3216:p};
// %t3217 = $GROUND @ATTACH &vss => @PLACE(416, -1788);
// &vss @WIRE(mode="straight") {#X630:5 %t3217:p};
// %t3218 = $IO_PORT @ATTACH &n865 => @PLACE(446, -1775) => @ORIENT("R0");
// %t3218 @TEXT("n865", key="name", size=0.75);
// &n865 @WIRE(mode="straight") {#X631:1 %t3218:p};
// %t3219 = $IO_PORT @ATTACH &n866 => @PLACE(446, -1779) => @ORIENT("R0");
// %t3219 @TEXT("n866", key="name", size=0.75);
// &n866 @WIRE(mode="straight") {#X631:2 %t3219:p};
// %t3220 = $IO_PORT @ATTACH &n860 => @PLACE(466, -1777) => @ORIENT("MY");
// %t3220 @TEXT("n860", key="name", size=0.75);
// &n860 @WIRE(mode="straight") {#X631:3 %t3220:p};
// %t3221 = $SUPPLY @ATTACH &vdd => @PLACE(456, -1766);
// &vdd @WIRE(mode="straight") {#X631:4 %t3221:p};
// %t3222 = $GROUND @ATTACH &vss => @PLACE(456, -1788);
// &vss @WIRE(mode="straight") {#X631:5 %t3222:p};
// %t3223 = $IO_PORT @ATTACH &n867 => @PLACE(326, -1806) => @ORIENT("R0");
// %t3223 @TEXT("n867", key="name", size=0.75);
// &n867 @WIRE(mode="straight") {#X632:1 %t3223:p};
// %t3224 = $IO_PORT @ATTACH &n868 => @PLACE(326, -1810) => @ORIENT("R0");
// %t3224 @TEXT("n868", key="name", size=0.75);
// &n868 @WIRE(mode="straight") {#X632:2 %t3224:p};
// %t3225 = $IO_PORT @ATTACH &n866 => @PLACE(346, -1808) => @ORIENT("MY");
// %t3225 @TEXT("n866", key="name", size=0.75);
// &n866 @WIRE(mode="straight") {#X632:3 %t3225:p};
// %t3226 = $SUPPLY @ATTACH &vdd => @PLACE(336, -1797);
// &vdd @WIRE(mode="straight") {#X632:4 %t3226:p};
// %t3227 = $GROUND @ATTACH &vss => @PLACE(336, -1819);
// &vss @WIRE(mode="straight") {#X632:5 %t3227:p};
// %t3228 = $IO_PORT @ATTACH &n869 => @PLACE(366, -1806) => @ORIENT("R0");
// %t3228 @TEXT("n869", key="name", size=0.75);
// &n869 @WIRE(mode="straight") {#X633:1 %t3228:p};
// %t3229 = $IO_PORT @ATTACH &n870 => @PLACE(366, -1810) => @ORIENT("R0");
// %t3229 @TEXT("n870", key="name", size=0.75);
// &n870 @WIRE(mode="straight") {#X633:2 %t3229:p};
// %t3230 = $IO_PORT @ATTACH &n861 => @PLACE(386, -1808) => @ORIENT("MY");
// %t3230 @TEXT("n861", key="name", size=0.75);
// &n861 @WIRE(mode="straight") {#X633:3 %t3230:p};
// %t3231 = $SUPPLY @ATTACH &vdd => @PLACE(376, -1797);
// &vdd @WIRE(mode="straight") {#X633:4 %t3231:p};
// %t3232 = $GROUND @ATTACH &vss => @PLACE(376, -1819);
// &vss @WIRE(mode="straight") {#X633:5 %t3232:p};
// %t3233 = $IO_PORT @ATTACH &n871 => @PLACE(406, -1806) => @ORIENT("R0");
// %t3233 @TEXT("n871", key="name", size=0.75);
// &n871 @WIRE(mode="straight") {#X634:1 %t3233:p};
// %t3234 = $IO_PORT @ATTACH &n872 => @PLACE(406, -1810) => @ORIENT("R0");
// %t3234 @TEXT("n872", key="name", size=0.75);
// &n872 @WIRE(mode="straight") {#X634:2 %t3234:p};
// %t3235 = $IO_PORT @ATTACH &n870 => @PLACE(426, -1808) => @ORIENT("MY");
// %t3235 @TEXT("n870", key="name", size=0.75);
// &n870 @WIRE(mode="straight") {#X634:3 %t3235:p};
// %t3236 = $SUPPLY @ATTACH &vdd => @PLACE(416, -1797);
// &vdd @WIRE(mode="straight") {#X634:4 %t3236:p};
// %t3237 = $GROUND @ATTACH &vss => @PLACE(416, -1819);
// &vss @WIRE(mode="straight") {#X634:5 %t3237:p};
// %t3238 = $IO_PORT @ATTACH &n873 => @PLACE(446, -1806) => @ORIENT("R0");
// %t3238 @TEXT("n873", key="name", size=0.75);
// &n873 @WIRE(mode="straight") {#X635:1 %t3238:p};
// %t3239 = $IO_PORT @ATTACH &n874 => @PLACE(446, -1810) => @ORIENT("R0");
// %t3239 @TEXT("n874", key="name", size=0.75);
// &n874 @WIRE(mode="straight") {#X635:2 %t3239:p};
// %t3240 = $IO_PORT @ATTACH &n864 => @PLACE(466, -1808) => @ORIENT("MY");
// %t3240 @TEXT("n864", key="name", size=0.75);
// &n864 @WIRE(mode="straight") {#X635:3 %t3240:p};
// %t3241 = $SUPPLY @ATTACH &vdd => @PLACE(456, -1797);
// &vdd @WIRE(mode="straight") {#X635:4 %t3241:p};
// %t3242 = $GROUND @ATTACH &vss => @PLACE(456, -1819);
// &vss @WIRE(mode="straight") {#X635:5 %t3242:p};
// %t3243 = $IO_PORT @ATTACH &n875 => @PLACE(326, -1837) => @ORIENT("R0");
// %t3243 @TEXT("n875", key="name", size=0.75);
// &n875 @WIRE(mode="straight") {#X636:1 %t3243:p};
// %t3244 = $IO_PORT @ATTACH &n876 => @PLACE(326, -1841) => @ORIENT("R0");
// %t3244 @TEXT("n876", key="name", size=0.75);
// &n876 @WIRE(mode="straight") {#X636:2 %t3244:p};
// %t3245 = $IO_PORT @ATTACH &n874 => @PLACE(346, -1839) => @ORIENT("MY");
// %t3245 @TEXT("n874", key="name", size=0.75);
// &n874 @WIRE(mode="straight") {#X636:3 %t3245:p};
// %t3246 = $SUPPLY @ATTACH &vdd => @PLACE(336, -1828);
// &vdd @WIRE(mode="straight") {#X636:4 %t3246:p};
// %t3247 = $GROUND @ATTACH &vss => @PLACE(336, -1850);
// &vss @WIRE(mode="straight") {#X636:5 %t3247:p};
// %t3248 = $IO_PORT @ATTACH &n271 => @PLACE(366, -1837) => @ORIENT("R0");
// %t3248 @TEXT("n271", key="name", size=0.75);
// &n271 @WIRE(mode="straight") {#X637:1 %t3248:p};
// %t3249 = $IO_PORT @ATTACH &n877 => @PLACE(366, -1841) => @ORIENT("R0");
// %t3249 @TEXT("n877", key="name", size=0.75);
// &n877 @WIRE(mode="straight") {#X637:2 %t3249:p};
// %t3250 = $IO_PORT @ATTACH &n857 => @PLACE(386, -1839) => @ORIENT("MY");
// %t3250 @TEXT("n857", key="name", size=0.75);
// &n857 @WIRE(mode="straight") {#X637:3 %t3250:p};
// %t3251 = $SUPPLY @ATTACH &vdd => @PLACE(376, -1828);
// &vdd @WIRE(mode="straight") {#X637:4 %t3251:p};
// %t3252 = $GROUND @ATTACH &vss => @PLACE(376, -1850);
// &vss @WIRE(mode="straight") {#X637:5 %t3252:p};
// %t3253 = $IO_PORT @ATTACH &n272 => @PLACE(406, -1837) => @ORIENT("R0");
// %t3253 @TEXT("n272", key="name", size=0.75);
// &n272 @WIRE(mode="straight") {#X638:1 %t3253:p};
// %t3254 = $IO_PORT @ATTACH &n273 => @PLACE(406, -1841) => @ORIENT("R0");
// %t3254 @TEXT("n273", key="name", size=0.75);
// &n273 @WIRE(mode="straight") {#X638:2 %t3254:p};
// %t3255 = $IO_PORT @ATTACH &n877 => @PLACE(426, -1839) => @ORIENT("MY");
// %t3255 @TEXT("n877", key="name", size=0.75);
// &n877 @WIRE(mode="straight") {#X638:3 %t3255:p};
// %t3256 = $SUPPLY @ATTACH &vdd => @PLACE(416, -1828);
// &vdd @WIRE(mode="straight") {#X638:4 %t3256:p};
// %t3257 = $GROUND @ATTACH &vss => @PLACE(416, -1850);
// &vss @WIRE(mode="straight") {#X638:5 %t3257:p};
// %t3258 = $IO_PORT @ATTACH &n275 => @PLACE(446, -1837) => @ORIENT("R0");
// %t3258 @TEXT("n275", key="name", size=0.75);
// &n275 @WIRE(mode="straight") {#X639:1 %t3258:p};
// %t3259 = $IO_PORT @ATTACH &n878 => @PLACE(446, -1841) => @ORIENT("R0");
// %t3259 @TEXT("n878", key="name", size=0.75);
// &n878 @WIRE(mode="straight") {#X639:2 %t3259:p};
// %t3260 = $IO_PORT @ATTACH &n865 => @PLACE(466, -1839) => @ORIENT("MY");
// %t3260 @TEXT("n865", key="name", size=0.75);
// &n865 @WIRE(mode="straight") {#X639:3 %t3260:p};
// %t3261 = $SUPPLY @ATTACH &vdd => @PLACE(456, -1828);
// &vdd @WIRE(mode="straight") {#X639:4 %t3261:p};
// %t3262 = $GROUND @ATTACH &vss => @PLACE(456, -1850);
// &vss @WIRE(mode="straight") {#X639:5 %t3262:p};
// %t3263 = $IO_PORT @ATTACH &n276 => @PLACE(326, -1868) => @ORIENT("R0");
// %t3263 @TEXT("n276", key="name", size=0.75);
// &n276 @WIRE(mode="straight") {#X640:1 %t3263:p};
// %t3264 = $IO_PORT @ATTACH &n277 => @PLACE(326, -1872) => @ORIENT("R0");
// %t3264 @TEXT("n277", key="name", size=0.75);
// &n277 @WIRE(mode="straight") {#X640:2 %t3264:p};
// %t3265 = $IO_PORT @ATTACH &n878 => @PLACE(346, -1870) => @ORIENT("MY");
// %t3265 @TEXT("n878", key="name", size=0.75);
// &n878 @WIRE(mode="straight") {#X640:3 %t3265:p};
// %t3266 = $SUPPLY @ATTACH &vdd => @PLACE(336, -1859);
// &vdd @WIRE(mode="straight") {#X640:4 %t3266:p};
// %t3267 = $GROUND @ATTACH &vss => @PLACE(336, -1881);
// &vss @WIRE(mode="straight") {#X640:5 %t3267:p};
// %t3268 = $IO_PORT @ATTACH &n280 => @PLACE(366, -1868) => @ORIENT("R0");
// %t3268 @TEXT("n280", key="name", size=0.75);
// &n280 @WIRE(mode="straight") {#X641:1 %t3268:p};
// %t3269 = $IO_PORT @ATTACH &n282 => @PLACE(366, -1872) => @ORIENT("R0");
// %t3269 @TEXT("n282", key="name", size=0.75);
// &n282 @WIRE(mode="straight") {#X641:2 %t3269:p};
// %t3270 = $IO_PORT @ATTACH &n879 => @PLACE(386, -1870) => @ORIENT("MY");
// %t3270 @TEXT("n879", key="name", size=0.75);
// &n879 @WIRE(mode="straight") {#X641:3 %t3270:p};
// %t3271 = $SUPPLY @ATTACH &vdd => @PLACE(376, -1859);
// &vdd @WIRE(mode="straight") {#X641:4 %t3271:p};
// %t3272 = $GROUND @ATTACH &vss => @PLACE(376, -1881);
// &vss @WIRE(mode="straight") {#X641:5 %t3272:p};
// %t3273 = $IO_PORT @ATTACH &n279 => @PLACE(406, -1868) => @ORIENT("R0");
// %t3273 @TEXT("n279", key="name", size=0.75);
// &n279 @WIRE(mode="straight") {#X642:1 %t3273:p};
// %t3274 = $IO_PORT @ATTACH &n880 => @PLACE(406, -1872) => @ORIENT("R0");
// %t3274 @TEXT("n880", key="name", size=0.75);
// &n880 @WIRE(mode="straight") {#X642:2 %t3274:p};
// %t3275 = $IO_PORT @ATTACH &n868 => @PLACE(426, -1870) => @ORIENT("MY");
// %t3275 @TEXT("n868", key="name", size=0.75);
// &n868 @WIRE(mode="straight") {#X642:3 %t3275:p};
// %t3276 = $SUPPLY @ATTACH &vdd => @PLACE(416, -1859);
// &vdd @WIRE(mode="straight") {#X642:4 %t3276:p};
// %t3277 = $GROUND @ATTACH &vss => @PLACE(416, -1881);
// &vss @WIRE(mode="straight") {#X642:5 %t3277:p};
// %t3278 = $IO_PORT @ATTACH &n280 => @PLACE(446, -1868) => @ORIENT("R0");
// %t3278 @TEXT("n280", key="name", size=0.75);
// &n280 @WIRE(mode="straight") {#X643:1 %t3278:p};
// %t3279 = $IO_PORT @ATTACH &n281 => @PLACE(446, -1872) => @ORIENT("R0");
// %t3279 @TEXT("n281", key="name", size=0.75);
// &n281 @WIRE(mode="straight") {#X643:2 %t3279:p};
// %t3280 = $IO_PORT @ATTACH &n880 => @PLACE(466, -1870) => @ORIENT("MY");
// %t3280 @TEXT("n880", key="name", size=0.75);
// &n880 @WIRE(mode="straight") {#X643:3 %t3280:p};
// %t3281 = $SUPPLY @ATTACH &vdd => @PLACE(456, -1859);
// &vdd @WIRE(mode="straight") {#X643:4 %t3281:p};
// %t3282 = $GROUND @ATTACH &vss => @PLACE(456, -1881);
// &vss @WIRE(mode="straight") {#X643:5 %t3282:p};
// %t3283 = $IO_PORT @ATTACH &n283 => @PLACE(326, -1899) => @ORIENT("R0");
// %t3283 @TEXT("n283", key="name", size=0.75);
// &n283 @WIRE(mode="straight") {#X644:1 %t3283:p};
// %t3284 = $IO_PORT @ATTACH &n881 => @PLACE(326, -1903) => @ORIENT("R0");
// %t3284 @TEXT("n881", key="name", size=0.75);
// &n881 @WIRE(mode="straight") {#X644:2 %t3284:p};
// %t3285 = $IO_PORT @ATTACH &n869 => @PLACE(346, -1901) => @ORIENT("MY");
// %t3285 @TEXT("n869", key="name", size=0.75);
// &n869 @WIRE(mode="straight") {#X644:3 %t3285:p};
// %t3286 = $SUPPLY @ATTACH &vdd => @PLACE(336, -1890);
// &vdd @WIRE(mode="straight") {#X644:4 %t3286:p};
// %t3287 = $GROUND @ATTACH &vss => @PLACE(336, -1912);
// &vss @WIRE(mode="straight") {#X644:5 %t3287:p};
// %t3288 = $IO_PORT @ATTACH &n284 => @PLACE(366, -1899) => @ORIENT("R0");
// %t3288 @TEXT("n284", key="name", size=0.75);
// &n284 @WIRE(mode="straight") {#X645:1 %t3288:p};
// %t3289 = $IO_PORT @ATTACH &n285 => @PLACE(366, -1903) => @ORIENT("R0");
// %t3289 @TEXT("n285", key="name", size=0.75);
// &n285 @WIRE(mode="straight") {#X645:2 %t3289:p};
// %t3290 = $IO_PORT @ATTACH &n881 => @PLACE(386, -1901) => @ORIENT("MY");
// %t3290 @TEXT("n881", key="name", size=0.75);
// &n881 @WIRE(mode="straight") {#X645:3 %t3290:p};
// %t3291 = $SUPPLY @ATTACH &vdd => @PLACE(376, -1890);
// &vdd @WIRE(mode="straight") {#X645:4 %t3291:p};
// %t3292 = $GROUND @ATTACH &vss => @PLACE(376, -1912);
// &vss @WIRE(mode="straight") {#X645:5 %t3292:p};
// %t3293 = $IO_PORT @ATTACH &n287 => @PLACE(406, -1899) => @ORIENT("R0");
// %t3293 @TEXT("n287", key="name", size=0.75);
// &n287 @WIRE(mode="straight") {#X646:1 %t3293:p};
// %t3294 = $IO_PORT @ATTACH &n882 => @PLACE(406, -1903) => @ORIENT("R0");
// %t3294 @TEXT("n882", key="name", size=0.75);
// &n882 @WIRE(mode="straight") {#X646:2 %t3294:p};
// %t3295 = $IO_PORT @ATTACH &n872 => @PLACE(426, -1901) => @ORIENT("MY");
// %t3295 @TEXT("n872", key="name", size=0.75);
// &n872 @WIRE(mode="straight") {#X646:3 %t3295:p};
// %t3296 = $SUPPLY @ATTACH &vdd => @PLACE(416, -1890);
// &vdd @WIRE(mode="straight") {#X646:4 %t3296:p};
// %t3297 = $GROUND @ATTACH &vss => @PLACE(416, -1912);
// &vss @WIRE(mode="straight") {#X646:5 %t3297:p};
// %t3298 = $IO_PORT @ATTACH &n288 => @PLACE(446, -1899) => @ORIENT("R0");
// %t3298 @TEXT("n288", key="name", size=0.75);
// &n288 @WIRE(mode="straight") {#X647:1 %t3298:p};
// %t3299 = $IO_PORT @ATTACH &n289 => @PLACE(446, -1903) => @ORIENT("R0");
// %t3299 @TEXT("n289", key="name", size=0.75);
// &n289 @WIRE(mode="straight") {#X647:2 %t3299:p};
// %t3300 = $IO_PORT @ATTACH &n882 => @PLACE(466, -1901) => @ORIENT("MY");
// %t3300 @TEXT("n882", key="name", size=0.75);
// &n882 @WIRE(mode="straight") {#X647:3 %t3300:p};
// %t3301 = $SUPPLY @ATTACH &vdd => @PLACE(456, -1890);
// &vdd @WIRE(mode="straight") {#X647:4 %t3301:p};
// %t3302 = $GROUND @ATTACH &vss => @PLACE(456, -1912);
// &vss @WIRE(mode="straight") {#X647:5 %t3302:p};
// %t3303 = $IO_PORT @ATTACH &n292 => @PLACE(494, -1744) => @ORIENT("R0");
// %t3303 @TEXT("n292", key="name", size=0.75);
// &n292 @WIRE(mode="straight") {#X648:1 %t3303:p};
// %t3304 = $IO_PORT @ATTACH &n294 => @PLACE(494, -1748) => @ORIENT("R0");
// %t3304 @TEXT("n294", key="name", size=0.75);
// &n294 @WIRE(mode="straight") {#X648:2 %t3304:p};
// %t3305 = $IO_PORT @ATTACH &n875 => @PLACE(514, -1746) => @ORIENT("MY");
// %t3305 @TEXT("n875", key="name", size=0.75);
// &n875 @WIRE(mode="straight") {#X648:3 %t3305:p};
// %t3306 = $SUPPLY @ATTACH &vdd => @PLACE(504, -1735);
// &vdd @WIRE(mode="straight") {#X648:4 %t3306:p};
// %t3307 = $GROUND @ATTACH &vss => @PLACE(504, -1757);
// &vss @WIRE(mode="straight") {#X648:5 %t3307:p};
// %t3308 = $IO_PORT @ATTACH &n291 => @PLACE(534, -1744) => @ORIENT("R0");
// %t3308 @TEXT("n291", key="name", size=0.75);
// &n291 @WIRE(mode="straight") {#X649:1 %t3308:p};
// %t3309 = $IO_PORT @ATTACH &n883 => @PLACE(534, -1748) => @ORIENT("R0");
// %t3309 @TEXT("n883", key="name", size=0.75);
// &n883 @WIRE(mode="straight") {#X649:2 %t3309:p};
// %t3310 = $IO_PORT @ATTACH &n873 => @PLACE(554, -1746) => @ORIENT("MY");
// %t3310 @TEXT("n873", key="name", size=0.75);
// &n873 @WIRE(mode="straight") {#X649:3 %t3310:p};
// %t3311 = $SUPPLY @ATTACH &vdd => @PLACE(544, -1735);
// &vdd @WIRE(mode="straight") {#X649:4 %t3311:p};
// %t3312 = $GROUND @ATTACH &vss => @PLACE(544, -1757);
// &vss @WIRE(mode="straight") {#X649:5 %t3312:p};
// %t3313 = $IO_PORT @ATTACH &n292 => @PLACE(574, -1744) => @ORIENT("R0");
// %t3313 @TEXT("n292", key="name", size=0.75);
// &n292 @WIRE(mode="straight") {#X650:1 %t3313:p};
// %t3314 = $IO_PORT @ATTACH &n293 => @PLACE(574, -1748) => @ORIENT("R0");
// %t3314 @TEXT("n293", key="name", size=0.75);
// &n293 @WIRE(mode="straight") {#X650:2 %t3314:p};
// %t3315 = $IO_PORT @ATTACH &n883 => @PLACE(594, -1746) => @ORIENT("MY");
// %t3315 @TEXT("n883", key="name", size=0.75);
// &n883 @WIRE(mode="straight") {#X650:3 %t3315:p};
// %t3316 = $SUPPLY @ATTACH &vdd => @PLACE(584, -1735);
// &vdd @WIRE(mode="straight") {#X650:4 %t3316:p};
// %t3317 = $GROUND @ATTACH &vss => @PLACE(584, -1757);
// &vss @WIRE(mode="straight") {#X650:5 %t3317:p};
// %t3318 = $IO_PORT @ATTACH &n269 => @PLACE(614, -1744) => @ORIENT("R0");
// %t3318 @TEXT("n269", key="name", size=0.75);
// &n269 @WIRE(mode="straight") {#X651:1 %t3318:p};
// %t3319 = $IO_PORT @ATTACH &n884 => @PLACE(614, -1748) => @ORIENT("R0");
// %t3319 @TEXT("n884", key="name", size=0.75);
// &n884 @WIRE(mode="straight") {#X651:2 %t3319:p};
// %t3320 = $IO_PORT @ATTACH &n876 => @PLACE(635, -1746) => @ORIENT("MY");
// %t3320 @TEXT("n876", key="name", size=0.75);
// &n876 @WIRE(mode="straight") {#X651:3 %t3320:p};
// %t3321 = $SUPPLY @ATTACH &vdd => @PLACE(624, -1735);
// &vdd @WIRE(mode="straight") {#X651:4 %t3321:p};
// %t3322 = $GROUND @ATTACH &vss => @PLACE(624, -1757);
// &vss @WIRE(mode="straight") {#X651:5 %t3322:p};
// %t3323 = $IO_PORT @ATTACH &n270 => @PLACE(494, -1775) => @ORIENT("R0");
// %t3323 @TEXT("n270", key="name", size=0.75);
// &n270 @WIRE(mode="straight") {#X652:1 %t3323:p};
// %t3324 = $IO_PORT @ATTACH &measured0 => @PLACE(494, -1779) => @ORIENT("R0");
// %t3324 @TEXT("measured0", key="name", size=0.75);
// &measured0 @WIRE(mode="straight") {#X652:2 %t3324:p};
// %t3325 = $IO_PORT @ATTACH &n884 => @PLACE(514, -1777) => @ORIENT("MY");
// %t3325 @TEXT("n884", key="name", size=0.75);
// &n884 @WIRE(mode="straight") {#X652:3 %t3325:p};
// %t3326 = $SUPPLY @ATTACH &vdd => @PLACE(504, -1766);
// &vdd @WIRE(mode="straight") {#X652:4 %t3326:p};
// %t3327 = $GROUND @ATTACH &vss => @PLACE(504, -1788);
// &vss @WIRE(mode="straight") {#X652:5 %t3327:p};
// %t3328 = $IO_PORT @ATTACH &measured6 => @PLACE(534, -1775) => @ORIENT("R0");
// %t3328 @TEXT("measured6", key="name", size=0.75);
// &measured6 @WIRE(mode="straight") {#X653:1 %t3328:p};
// %t3329 = $IO_PORT @ATTACH &n885 => @PLACE(534, -1779) => @ORIENT("R0");
// %t3329 @TEXT("n885", key="name", size=0.75);
// &n885 @WIRE(mode="straight") {#X653:2 %t3329:p};
// %t3330 = $IO_PORT @ATTACH &n820 => @PLACE(554, -1777) => @ORIENT("MY");
// %t3330 @TEXT("n820", key="name", size=0.75);
// &n820 @WIRE(mode="straight") {#X653:3 %t3330:p};
// %t3331 = $SUPPLY @ATTACH &vdd => @PLACE(544, -1766);
// &vdd @WIRE(mode="straight") {#X653:4 %t3331:p};
// %t3332 = $GROUND @ATTACH &vss => @PLACE(544, -1788);
// &vss @WIRE(mode="straight") {#X653:5 %t3332:p};
// %t3333 = $IO_PORT @ATTACH &measured7 => @PLACE(574, -1775) => @ORIENT("R0");
// %t3333 @TEXT("measured7", key="name", size=0.75);
// &measured7 @WIRE(mode="straight") {#X654:1 %t3333:p};
// %t3334 = $IO_PORT @ATTACH &n699 => @PLACE(574, -1779) => @ORIENT("R0");
// %t3334 @TEXT("n699", key="name", size=0.75);
// &n699 @WIRE(mode="straight") {#X654:2 %t3334:p};
// %t3335 = $IO_PORT @ATTACH &n722 => @PLACE(594, -1777) => @ORIENT("MY");
// %t3335 @TEXT("n722", key="name", size=0.75);
// &n722 @WIRE(mode="straight") {#X654:3 %t3335:p};
// %t3336 = $SUPPLY @ATTACH &vdd => @PLACE(584, -1766);
// &vdd @WIRE(mode="straight") {#X654:4 %t3336:p};
// %t3337 = $GROUND @ATTACH &vss => @PLACE(584, -1788);
// &vss @WIRE(mode="straight") {#X654:5 %t3337:p};
// %t3338 = $IO_PORT @ATTACH &measured13 => @PLACE(614, -1775) => @ORIENT("R0");
// %t3338 @TEXT("measured13", key="name", size=0.75);
// &measured13 @WIRE(mode="straight") {#X655:1 %t3338:p};
// %t3339 = $IO_PORT @ATTACH &n886 => @PLACE(614, -1779) => @ORIENT("R0");
// %t3339 @TEXT("n886", key="name", size=0.75);
// &n886 @WIRE(mode="straight") {#X655:2 %t3339:p};
// %t3340 = $IO_PORT @ATTACH &n833 => @PLACE(635, -1777) => @ORIENT("MY");
// %t3340 @TEXT("n833", key="name", size=0.75);
// &n833 @WIRE(mode="straight") {#X655:3 %t3340:p};
// %t3341 = $SUPPLY @ATTACH &vdd => @PLACE(624, -1766);
// &vdd @WIRE(mode="straight") {#X655:4 %t3341:p};
// %t3342 = $GROUND @ATTACH &vss => @PLACE(624, -1788);
// &vss @WIRE(mode="straight") {#X655:5 %t3342:p};
// %t3343 = $IO_PORT @ATTACH &measured4 => @PLACE(494, -1806) => @ORIENT("R0");
// %t3343 @TEXT("measured4", key="name", size=0.75);
// &measured4 @WIRE(mode="straight") {#X656:1 %t3343:p};
// %t3344 = $IO_PORT @ATTACH &n696 => @PLACE(494, -1810) => @ORIENT("R0");
// %t3344 @TEXT("n696", key="name", size=0.75);
// &n696 @WIRE(mode="straight") {#X656:2 %t3344:p};
// %t3345 = $IO_PORT @ATTACH &n439 => @PLACE(514, -1808) => @ORIENT("MY");
// %t3345 @TEXT("n439", key="name", size=0.75);
// &n439 @WIRE(mode="straight") {#X656:3 %t3345:p};
// %t3346 = $SUPPLY @ATTACH &vdd => @PLACE(504, -1797);
// &vdd @WIRE(mode="straight") {#X656:4 %t3346:p};
// %t3347 = $GROUND @ATTACH &vss => @PLACE(504, -1819);
// &vss @WIRE(mode="straight") {#X656:5 %t3347:p};
// %t3348 = $IO_PORT @ATTACH &measured6 => @PLACE(534, -1806) => @ORIENT("R0");
// %t3348 @TEXT("measured6", key="name", size=0.75);
// &measured6 @WIRE(mode="straight") {#X657:1 %t3348:p};
// %t3349 = $IO_PORT @ATTACH &n885 => @PLACE(534, -1810) => @ORIENT("R0");
// %t3349 @TEXT("n885", key="name", size=0.75);
// &n885 @WIRE(mode="straight") {#X657:2 %t3349:p};
// %t3350 = $IO_PORT @ATTACH &n445 => @PLACE(554, -1808) => @ORIENT("MY");
// %t3350 @TEXT("n445", key="name", size=0.75);
// &n445 @WIRE(mode="straight") {#X657:3 %t3350:p};
// %t3351 = $SUPPLY @ATTACH &vdd => @PLACE(544, -1797);
// &vdd @WIRE(mode="straight") {#X657:4 %t3351:p};
// %t3352 = $GROUND @ATTACH &vss => @PLACE(544, -1819);
// &vss @WIRE(mode="straight") {#X657:5 %t3352:p};
// %t3353 = $IO_PORT @ATTACH &measured9 => @PLACE(574, -1806) => @ORIENT("R0");
// %t3353 @TEXT("measured9", key="name", size=0.75);
// &measured9 @WIRE(mode="straight") {#X658:1 %t3353:p};
// %t3354 = $IO_PORT @ATTACH &n817 => @PLACE(574, -1810) => @ORIENT("R0");
// %t3354 @TEXT("n817", key="name", size=0.75);
// &n817 @WIRE(mode="straight") {#X658:2 %t3354:p};
// %t3355 = $IO_PORT @ATTACH &n563 => @PLACE(594, -1808) => @ORIENT("MY");
// %t3355 @TEXT("n563", key="name", size=0.75);
// &n563 @WIRE(mode="straight") {#X658:3 %t3355:p};
// %t3356 = $SUPPLY @ATTACH &vdd => @PLACE(584, -1797);
// &vdd @WIRE(mode="straight") {#X658:4 %t3356:p};
// %t3357 = $GROUND @ATTACH &vss => @PLACE(584, -1819);
// &vss @WIRE(mode="straight") {#X658:5 %t3357:p};
// %t3358 = $IO_PORT @ATTACH &measured13 => @PLACE(614, -1806) => @ORIENT("R0");
// %t3358 @TEXT("measured13", key="name", size=0.75);
// &measured13 @WIRE(mode="straight") {#X659:1 %t3358:p};
// %t3359 = $IO_PORT @ATTACH &n886 => @PLACE(614, -1810) => @ORIENT("R0");
// %t3359 @TEXT("n886", key="name", size=0.75);
// &n886 @WIRE(mode="straight") {#X659:2 %t3359:p};
// %t3360 = $IO_PORT @ATTACH &n569 => @PLACE(635, -1808) => @ORIENT("MY");
// %t3360 @TEXT("n569", key="name", size=0.75);
// &n569 @WIRE(mode="straight") {#X659:3 %t3360:p};
// %t3361 = $SUPPLY @ATTACH &vdd => @PLACE(624, -1797);
// &vdd @WIRE(mode="straight") {#X659:4 %t3361:p};
// %t3362 = $GROUND @ATTACH &vss => @PLACE(624, -1819);
// &vss @WIRE(mode="straight") {#X659:5 %t3362:p};
// %t3363 = $IO_PORT @ATTACH &n439 => @PLACE(494, -1837) => @ORIENT("R0");
// %t3363 @TEXT("n439", key="name", size=0.75);
// &n439 @WIRE(mode="straight") {#X660:1 %t3363:p};
// %t3364 = $IO_PORT @ATTACH &n440 => @PLACE(494, -1841) => @ORIENT("R0");
// %t3364 @TEXT("n440", key="name", size=0.75);
// &n440 @WIRE(mode="straight") {#X660:2 %t3364:p};
// %t3365 = $IO_PORT @ATTACH &n819 => @PLACE(514, -1839) => @ORIENT("MY");
// %t3365 @TEXT("n819", key="name", size=0.75);
// &n819 @WIRE(mode="straight") {#X660:3 %t3365:p};
// %t3366 = $SUPPLY @ATTACH &vdd => @PLACE(504, -1828);
// &vdd @WIRE(mode="straight") {#X660:4 %t3366:p};
// %t3367 = $GROUND @ATTACH &vss => @PLACE(504, -1850);
// &vss @WIRE(mode="straight") {#X660:5 %t3367:p};
// %t3368 = $IO_PORT @ATTACH &n445 => @PLACE(534, -1837) => @ORIENT("R0");
// %t3368 @TEXT("n445", key="name", size=0.75);
// &n445 @WIRE(mode="straight") {#X661:1 %t3368:p};
// %t3369 = $IO_PORT @ATTACH &n446 => @PLACE(534, -1841) => @ORIENT("R0");
// %t3369 @TEXT("n446", key="name", size=0.75);
// &n446 @WIRE(mode="straight") {#X661:2 %t3369:p};
// %t3370 = $IO_PORT @ATTACH &n821 => @PLACE(554, -1839) => @ORIENT("MY");
// %t3370 @TEXT("n821", key="name", size=0.75);
// &n821 @WIRE(mode="straight") {#X661:3 %t3370:p};
// %t3371 = $SUPPLY @ATTACH &vdd => @PLACE(544, -1828);
// &vdd @WIRE(mode="straight") {#X661:4 %t3371:p};
// %t3372 = $GROUND @ATTACH &vss => @PLACE(544, -1850);
// &vss @WIRE(mode="straight") {#X661:5 %t3372:p};
// %t3373 = $IO_PORT @ATTACH &n829 => @PLACE(574, -1837) => @ORIENT("R0");
// %t3373 @TEXT("n829", key="name", size=0.75);
// &n829 @WIRE(mode="straight") {#X662:1 %t3373:p};
// %t3374 = $IO_PORT @ATTACH &n887 => @PLACE(574, -1841) => @ORIENT("R0");
// %t3374 @TEXT("n887", key="name", size=0.75);
// &n887 @WIRE(mode="straight") {#X662:2 %t3374:p};
// %t3375 = $IO_PORT @ATTACH &n567 => @PLACE(594, -1839) => @ORIENT("MY");
// %t3375 @TEXT("n567", key="name", size=0.75);
// &n567 @WIRE(mode="straight") {#X662:3 %t3375:p};
// %t3376 = $SUPPLY @ATTACH &vdd => @PLACE(584, -1828);
// &vdd @WIRE(mode="straight") {#X662:4 %t3376:p};
// %t3377 = $GROUND @ATTACH &vss => @PLACE(584, -1850);
// &vss @WIRE(mode="straight") {#X662:5 %t3377:p};
// %t3378 = $IO_PORT @ATTACH &n827 => @PLACE(614, -1837) => @ORIENT("R0");
// %t3378 @TEXT("n827", key="name", size=0.75);
// &n827 @WIRE(mode="straight") {#X663:1 %t3378:p};
// %t3379 = $IO_PORT @ATTACH &n561 => @PLACE(614, -1841) => @ORIENT("R0");
// %t3379 @TEXT("n561", key="name", size=0.75);
// &n561 @WIRE(mode="straight") {#X663:2 %t3379:p};
// %t3380 = $IO_PORT @ATTACH &n887 => @PLACE(635, -1839) => @ORIENT("MY");
// %t3380 @TEXT("n887", key="name", size=0.75);
// &n887 @WIRE(mode="straight") {#X663:3 %t3380:p};
// %t3381 = $SUPPLY @ATTACH &vdd => @PLACE(624, -1828);
// &vdd @WIRE(mode="straight") {#X663:4 %t3381:p};
// %t3382 = $GROUND @ATTACH &vss => @PLACE(624, -1850);
// &vss @WIRE(mode="straight") {#X663:5 %t3382:p};
// %t3383 = $IO_PORT @ATTACH &n831 => @PLACE(494, -1868) => @ORIENT("R0");
// %t3383 @TEXT("n831", key="name", size=0.75);
// &n831 @WIRE(mode="straight") {#X664:1 %t3383:p};
// %t3384 = $IO_PORT @ATTACH &n440 => @PLACE(494, -1872) => @ORIENT("R0");
// %t3384 @TEXT("n440", key="name", size=0.75);
// &n440 @WIRE(mode="straight") {#X664:2 %t3384:p};
// %t3385 = $IO_PORT @ATTACH &n713 => @PLACE(514, -1870) => @ORIENT("MY");
// %t3385 @TEXT("n713", key="name", size=0.75);
// &n713 @WIRE(mode="straight") {#X664:3 %t3385:p};
// %t3386 = $SUPPLY @ATTACH &vdd => @PLACE(504, -1859);
// &vdd @WIRE(mode="straight") {#X664:4 %t3386:p};
// %t3387 = $GROUND @ATTACH &vss => @PLACE(504, -1881);
// &vss @WIRE(mode="straight") {#X664:5 %t3387:p};
// %t3388 = $IO_PORT @ATTACH &n724 => @PLACE(534, -1868) => @ORIENT("R0");
// %t3388 @TEXT("n724", key="name", size=0.75);
// &n724 @WIRE(mode="straight") {#X665:1 %t3388:p};
// %t3389 = $IO_PORT @ATTACH &n832 => @PLACE(534, -1872) => @ORIENT("R0");
// %t3389 @TEXT("n832", key="name", size=0.75);
// &n832 @WIRE(mode="straight") {#X665:2 %t3389:p};
// %t3390 = $IO_PORT @ATTACH &n712 => @PLACE(554, -1870) => @ORIENT("MY");
// %t3390 @TEXT("n712", key="name", size=0.75);
// &n712 @WIRE(mode="straight") {#X665:3 %t3390:p};
// %t3391 = $SUPPLY @ATTACH &vdd => @PLACE(544, -1859);
// &vdd @WIRE(mode="straight") {#X665:4 %t3391:p};
// %t3392 = $GROUND @ATTACH &vss => @PLACE(544, -1881);
// &vss @WIRE(mode="straight") {#X665:5 %t3392:p};
// %t3393 = $IO_PORT @ATTACH &n510 => @PLACE(574, -1868) => @ORIENT("R0");
// %t3393 @TEXT("n510", key="name", size=0.75);
// &n510 @WIRE(mode="straight") {#X666:1 %t3393:p};
// %t3394 = $IO_PORT @ATTACH &n507 => @PLACE(574, -1872) => @ORIENT("R0");
// %t3394 @TEXT("n507", key="name", size=0.75);
// &n507 @WIRE(mode="straight") {#X666:2 %t3394:p};
// %t3395 = $IO_PORT @ATTACH &n826 => @PLACE(594, -1870) => @ORIENT("MY");
// %t3395 @TEXT("n826", key="name", size=0.75);
// &n826 @WIRE(mode="straight") {#X666:3 %t3395:p};
// %t3396 = $SUPPLY @ATTACH &vdd => @PLACE(584, -1859);
// &vdd @WIRE(mode="straight") {#X666:4 %t3396:p};
// %t3397 = $GROUND @ATTACH &vss => @PLACE(584, -1881);
// &vss @WIRE(mode="straight") {#X666:5 %t3397:p};
// %t3398 = $IO_PORT @ATTACH &n510 => @PLACE(614, -1868) => @ORIENT("R0");
// %t3398 @TEXT("n510", key="name", size=0.75);
// &n510 @WIRE(mode="straight") {#X667:1 %t3398:p};
// %t3399 = $IO_PORT @ATTACH &n709 => @PLACE(614, -1872) => @ORIENT("R0");
// %t3399 @TEXT("n709", key="name", size=0.75);
// &n709 @WIRE(mode="straight") {#X667:2 %t3399:p};
// %t3400 = $IO_PORT @ATTACH &n717 => @PLACE(635, -1870) => @ORIENT("MY");
// %t3400 @TEXT("n717", key="name", size=0.75);
// &n717 @WIRE(mode="straight") {#X667:3 %t3400:p};
// %t3401 = $SUPPLY @ATTACH &vdd => @PLACE(624, -1859);
// &vdd @WIRE(mode="straight") {#X667:4 %t3401:p};
// %t3402 = $GROUND @ATTACH &vss => @PLACE(624, -1881);
// &vss @WIRE(mode="straight") {#X667:5 %t3402:p};
// %t3403 = $IO_PORT @ATTACH &n563 => @PLACE(494, -1899) => @ORIENT("R0");
// %t3403 @TEXT("n563", key="name", size=0.75);
// &n563 @WIRE(mode="straight") {#X668:1 %t3403:p};
// %t3404 = $IO_PORT @ATTACH &n705 => @PLACE(494, -1903) => @ORIENT("R0");
// %t3404 @TEXT("n705", key="name", size=0.75);
// &n705 @WIRE(mode="straight") {#X668:2 %t3404:p};
// %t3405 = $IO_PORT @ATTACH &n721 => @PLACE(514, -1901) => @ORIENT("MY");
// %t3405 @TEXT("n721", key="name", size=0.75);
// &n721 @WIRE(mode="straight") {#X668:3 %t3405:p};
// %t3406 = $SUPPLY @ATTACH &vdd => @PLACE(504, -1890);
// &vdd @WIRE(mode="straight") {#X668:4 %t3406:p};
// %t3407 = $GROUND @ATTACH &vss => @PLACE(504, -1912);
// &vss @WIRE(mode="straight") {#X668:5 %t3407:p};
// %t3408 = $IO_PORT @ATTACH &n504 => @PLACE(534, -1899) => @ORIENT("R0");
// %t3408 @TEXT("n504", key="name", size=0.75);
// &n504 @WIRE(mode="straight") {#X669:1 %t3408:p};
// %t3409 = $IO_PORT @ATTACH &n445 => @PLACE(534, -1903) => @ORIENT("R0");
// %t3409 @TEXT("n445", key="name", size=0.75);
// &n445 @WIRE(mode="straight") {#X669:2 %t3409:p};
// %t3410 = $IO_PORT @ATTACH &n830 => @PLACE(554, -1901) => @ORIENT("MY");
// %t3410 @TEXT("n830", key="name", size=0.75);
// &n830 @WIRE(mode="straight") {#X669:3 %t3410:p};
// %t3411 = $SUPPLY @ATTACH &vdd => @PLACE(544, -1890);
// &vdd @WIRE(mode="straight") {#X669:4 %t3411:p};
// %t3412 = $GROUND @ATTACH &vss => @PLACE(544, -1912);
// &vss @WIRE(mode="straight") {#X669:5 %t3412:p};
// %t3413 = $IO_PORT @ATTACH &n442 => @PLACE(574, -1899) => @ORIENT("R0");
// %t3413 @TEXT("n442", key="name", size=0.75);
// &n442 @WIRE(mode="straight") {#X670:1 %t3413:p};
// %t3414 = $IO_PORT @ATTACH &n697 => @PLACE(574, -1903) => @ORIENT("R0");
// %t3414 @TEXT("n697", key="name", size=0.75);
// &n697 @WIRE(mode="straight") {#X670:2 %t3414:p};
// %t3415 = $IO_PORT @ATTACH &n726 => @PLACE(594, -1901) => @ORIENT("MY");
// %t3415 @TEXT("n726", key="name", size=0.75);
// &n726 @WIRE(mode="straight") {#X670:3 %t3415:p};
// %t3416 = $SUPPLY @ATTACH &vdd => @PLACE(584, -1890);
// &vdd @WIRE(mode="straight") {#X670:4 %t3416:p};
// %t3417 = $GROUND @ATTACH &vss => @PLACE(584, -1912);
// &vss @WIRE(mode="straight") {#X670:5 %t3417:p};
// %t3418 = $IO_PORT @ATTACH &measured3 => @PLACE(614, -1899) => @ORIENT("R0");
// %t3418 @TEXT("measured3", key="name", size=0.75);
// &measured3 @WIRE(mode="straight") {#X671:1 %t3418:p};
// %t3419 = $IO_PORT @ATTACH &n728 => @PLACE(614, -1903) => @ORIENT("R0");
// %t3419 @TEXT("n728", key="name", size=0.75);
// &n728 @WIRE(mode="straight") {#X671:2 %t3419:p};
// %t3420 = $IO_PORT @ATTACH &n714 => @PLACE(635, -1901) => @ORIENT("MY");
// %t3420 @TEXT("n714", key="name", size=0.75);
// &n714 @WIRE(mode="straight") {#X671:3 %t3420:p};
// %t3421 = $SUPPLY @ATTACH &vdd => @PLACE(624, -1890);
// &vdd @WIRE(mode="straight") {#X671:4 %t3421:p};
// %t3422 = $GROUND @ATTACH &vss => @PLACE(624, -1912);
// &vss @WIRE(mode="straight") {#X671:5 %t3422:p};
// %t3423 = $IO_PORT @ATTACH &dac0 => @PLACE(-11, -1942) => @ORIENT("R0");
// %t3423 @TEXT("dac0", key="name", size=0.75);
// &dac0 @WIRE(mode="straight") {#X672:1 %t3423:p};
// %t3424 = $IO_PORT @ATTACH &n888 => @PLACE(-11, -1946) => @ORIENT("R0");
// %t3424 @TEXT("n888", key="name", size=0.75);
// &n888 @WIRE(mode="straight") {#X672:2 %t3424:p};
// %t3425 = $IO_PORT @ATTACH &n889 => @PLACE(10, -1944) => @ORIENT("MY");
// %t3425 @TEXT("n889", key="name", size=0.75);
// &n889 @WIRE(mode="straight") {#X672:3 %t3425:p};
// %t3426 = $SUPPLY @ATTACH &vdd => @PLACE(0, -1933);
// &vdd @WIRE(mode="straight") {#X672:4 %t3426:p};
// %t3427 = $GROUND @ATTACH &vss => @PLACE(0, -1955);
// &vss @WIRE(mode="straight") {#X672:5 %t3427:p};
// %t3428 = $IO_PORT @ATTACH &dac1 => @PLACE(30, -1942) => @ORIENT("R0");
// %t3428 @TEXT("dac1", key="name", size=0.75);
// &dac1 @WIRE(mode="straight") {#X673:1 %t3428:p};
// %t3429 = $IO_PORT @ATTACH &n890 => @PLACE(30, -1946) => @ORIENT("R0");
// %t3429 @TEXT("n890", key="name", size=0.75);
// &n890 @WIRE(mode="straight") {#X673:2 %t3429:p};
// %t3430 = $IO_PORT @ATTACH &n891 => @PLACE(50, -1944) => @ORIENT("MY");
// %t3430 @TEXT("n891", key="name", size=0.75);
// &n891 @WIRE(mode="straight") {#X673:3 %t3430:p};
// %t3431 = $SUPPLY @ATTACH &vdd => @PLACE(40, -1933);
// &vdd @WIRE(mode="straight") {#X673:4 %t3431:p};
// %t3432 = $GROUND @ATTACH &vss => @PLACE(40, -1955);
// &vss @WIRE(mode="straight") {#X673:5 %t3432:p};
// %t3433 = $IO_PORT @ATTACH &dac2 => @PLACE(70, -1942) => @ORIENT("R0");
// %t3433 @TEXT("dac2", key="name", size=0.75);
// &dac2 @WIRE(mode="straight") {#X674:1 %t3433:p};
// %t3434 = $IO_PORT @ATTACH &n892 => @PLACE(70, -1946) => @ORIENT("R0");
// %t3434 @TEXT("n892", key="name", size=0.75);
// &n892 @WIRE(mode="straight") {#X674:2 %t3434:p};
// %t3435 = $IO_PORT @ATTACH &n893 => @PLACE(90, -1944) => @ORIENT("MY");
// %t3435 @TEXT("n893", key="name", size=0.75);
// &n893 @WIRE(mode="straight") {#X674:3 %t3435:p};
// %t3436 = $SUPPLY @ATTACH &vdd => @PLACE(80, -1933);
// &vdd @WIRE(mode="straight") {#X674:4 %t3436:p};
// %t3437 = $GROUND @ATTACH &vss => @PLACE(80, -1955);
// &vss @WIRE(mode="straight") {#X674:5 %t3437:p};
// %t3438 = $IO_PORT @ATTACH &dac3 => @PLACE(110, -1942) => @ORIENT("R0");
// %t3438 @TEXT("dac3", key="name", size=0.75);
// &dac3 @WIRE(mode="straight") {#X675:1 %t3438:p};
// %t3439 = $IO_PORT @ATTACH &n894 => @PLACE(110, -1946) => @ORIENT("R0");
// %t3439 @TEXT("n894", key="name", size=0.75);
// &n894 @WIRE(mode="straight") {#X675:2 %t3439:p};
// %t3440 = $IO_PORT @ATTACH &n895 => @PLACE(130, -1944) => @ORIENT("MY");
// %t3440 @TEXT("n895", key="name", size=0.75);
// &n895 @WIRE(mode="straight") {#X675:3 %t3440:p};
// %t3441 = $SUPPLY @ATTACH &vdd => @PLACE(120, -1933);
// &vdd @WIRE(mode="straight") {#X675:4 %t3441:p};
// %t3442 = $GROUND @ATTACH &vss => @PLACE(120, -1955);
// &vss @WIRE(mode="straight") {#X675:5 %t3442:p};
// %t3443 = $IO_PORT @ATTACH &dac4 => @PLACE(-11, -1973) => @ORIENT("R0");
// %t3443 @TEXT("dac4", key="name", size=0.75);
// &dac4 @WIRE(mode="straight") {#X676:1 %t3443:p};
// %t3444 = $IO_PORT @ATTACH &n896 => @PLACE(-11, -1977) => @ORIENT("R0");
// %t3444 @TEXT("n896", key="name", size=0.75);
// &n896 @WIRE(mode="straight") {#X676:2 %t3444:p};
// %t3445 = $IO_PORT @ATTACH &n897 => @PLACE(10, -1975) => @ORIENT("MY");
// %t3445 @TEXT("n897", key="name", size=0.75);
// &n897 @WIRE(mode="straight") {#X676:3 %t3445:p};
// %t3446 = $SUPPLY @ATTACH &vdd => @PLACE(0, -1964);
// &vdd @WIRE(mode="straight") {#X676:4 %t3446:p};
// %t3447 = $GROUND @ATTACH &vss => @PLACE(0, -1986);
// &vss @WIRE(mode="straight") {#X676:5 %t3447:p};
// %t3448 = $IO_PORT @ATTACH &dac5 => @PLACE(30, -1973) => @ORIENT("R0");
// %t3448 @TEXT("dac5", key="name", size=0.75);
// &dac5 @WIRE(mode="straight") {#X677:1 %t3448:p};
// %t3449 = $IO_PORT @ATTACH &n898 => @PLACE(30, -1977) => @ORIENT("R0");
// %t3449 @TEXT("n898", key="name", size=0.75);
// &n898 @WIRE(mode="straight") {#X677:2 %t3449:p};
// %t3450 = $IO_PORT @ATTACH &n899 => @PLACE(50, -1975) => @ORIENT("MY");
// %t3450 @TEXT("n899", key="name", size=0.75);
// &n899 @WIRE(mode="straight") {#X677:3 %t3450:p};
// %t3451 = $SUPPLY @ATTACH &vdd => @PLACE(40, -1964);
// &vdd @WIRE(mode="straight") {#X677:4 %t3451:p};
// %t3452 = $GROUND @ATTACH &vss => @PLACE(40, -1986);
// &vss @WIRE(mode="straight") {#X677:5 %t3452:p};
// %t3453 = $IO_PORT @ATTACH &dac0 => @PLACE(70, -1973) => @ORIENT("R0");
// %t3453 @TEXT("dac0", key="name", size=0.75);
// &dac0 @WIRE(mode="straight") {#X678:1 %t3453:p};
// %t3454 = $IO_PORT @ATTACH &n888 => @PLACE(70, -1977) => @ORIENT("R0");
// %t3454 @TEXT("n888", key="name", size=0.75);
// &n888 @WIRE(mode="straight") {#X678:2 %t3454:p};
// %t3455 = $IO_PORT @ATTACH &n900 => @PLACE(90, -1975) => @ORIENT("MY");
// %t3455 @TEXT("n900", key="name", size=0.75);
// &n900 @WIRE(mode="straight") {#X678:3 %t3455:p};
// %t3456 = $SUPPLY @ATTACH &vdd => @PLACE(80, -1964);
// &vdd @WIRE(mode="straight") {#X678:4 %t3456:p};
// %t3457 = $GROUND @ATTACH &vss => @PLACE(80, -1986);
// &vss @WIRE(mode="straight") {#X678:5 %t3457:p};
// %t3458 = $IO_PORT @ATTACH &dac1 => @PLACE(110, -1973) => @ORIENT("R0");
// %t3458 @TEXT("dac1", key="name", size=0.75);
// &dac1 @WIRE(mode="straight") {#X679:1 %t3458:p};
// %t3459 = $IO_PORT @ATTACH &n890 => @PLACE(110, -1977) => @ORIENT("R0");
// %t3459 @TEXT("n890", key="name", size=0.75);
// &n890 @WIRE(mode="straight") {#X679:2 %t3459:p};
// %t3460 = $IO_PORT @ATTACH &n901 => @PLACE(130, -1975) => @ORIENT("MY");
// %t3460 @TEXT("n901", key="name", size=0.75);
// &n901 @WIRE(mode="straight") {#X679:3 %t3460:p};
// %t3461 = $SUPPLY @ATTACH &vdd => @PLACE(120, -1964);
// &vdd @WIRE(mode="straight") {#X679:4 %t3461:p};
// %t3462 = $GROUND @ATTACH &vss => @PLACE(120, -1986);
// &vss @WIRE(mode="straight") {#X679:5 %t3462:p};
// %t3463 = $IO_PORT @ATTACH &dac2 => @PLACE(-11, -2004) => @ORIENT("R0");
// %t3463 @TEXT("dac2", key="name", size=0.75);
// &dac2 @WIRE(mode="straight") {#X680:1 %t3463:p};
// %t3464 = $IO_PORT @ATTACH &n892 => @PLACE(-11, -2008) => @ORIENT("R0");
// %t3464 @TEXT("n892", key="name", size=0.75);
// &n892 @WIRE(mode="straight") {#X680:2 %t3464:p};
// %t3465 = $IO_PORT @ATTACH &n902 => @PLACE(10, -2006) => @ORIENT("MY");
// %t3465 @TEXT("n902", key="name", size=0.75);
// &n902 @WIRE(mode="straight") {#X680:3 %t3465:p};
// %t3466 = $SUPPLY @ATTACH &vdd => @PLACE(0, -1995);
// &vdd @WIRE(mode="straight") {#X680:4 %t3466:p};
// %t3467 = $GROUND @ATTACH &vss => @PLACE(0, -2017);
// &vss @WIRE(mode="straight") {#X680:5 %t3467:p};
// %t3468 = $IO_PORT @ATTACH &dac3 => @PLACE(30, -2004) => @ORIENT("R0");
// %t3468 @TEXT("dac3", key="name", size=0.75);
// &dac3 @WIRE(mode="straight") {#X681:1 %t3468:p};
// %t3469 = $IO_PORT @ATTACH &n894 => @PLACE(30, -2008) => @ORIENT("R0");
// %t3469 @TEXT("n894", key="name", size=0.75);
// &n894 @WIRE(mode="straight") {#X681:2 %t3469:p};
// %t3470 = $IO_PORT @ATTACH &n903 => @PLACE(50, -2006) => @ORIENT("MY");
// %t3470 @TEXT("n903", key="name", size=0.75);
// &n903 @WIRE(mode="straight") {#X681:3 %t3470:p};
// %t3471 = $SUPPLY @ATTACH &vdd => @PLACE(40, -1995);
// &vdd @WIRE(mode="straight") {#X681:4 %t3471:p};
// %t3472 = $GROUND @ATTACH &vss => @PLACE(40, -2017);
// &vss @WIRE(mode="straight") {#X681:5 %t3472:p};
// %t3473 = $IO_PORT @ATTACH &dac4 => @PLACE(70, -2004) => @ORIENT("R0");
// %t3473 @TEXT("dac4", key="name", size=0.75);
// &dac4 @WIRE(mode="straight") {#X682:1 %t3473:p};
// %t3474 = $IO_PORT @ATTACH &n896 => @PLACE(70, -2008) => @ORIENT("R0");
// %t3474 @TEXT("n896", key="name", size=0.75);
// &n896 @WIRE(mode="straight") {#X682:2 %t3474:p};
// %t3475 = $IO_PORT @ATTACH &n904 => @PLACE(90, -2006) => @ORIENT("MY");
// %t3475 @TEXT("n904", key="name", size=0.75);
// &n904 @WIRE(mode="straight") {#X682:3 %t3475:p};
// %t3476 = $SUPPLY @ATTACH &vdd => @PLACE(80, -1995);
// &vdd @WIRE(mode="straight") {#X682:4 %t3476:p};
// %t3477 = $GROUND @ATTACH &vss => @PLACE(80, -2017);
// &vss @WIRE(mode="straight") {#X682:5 %t3477:p};
// %t3478 = $IO_PORT @ATTACH &dac5 => @PLACE(110, -2004) => @ORIENT("R0");
// %t3478 @TEXT("dac5", key="name", size=0.75);
// &dac5 @WIRE(mode="straight") {#X683:1 %t3478:p};
// %t3479 = $IO_PORT @ATTACH &n898 => @PLACE(110, -2008) => @ORIENT("R0");
// %t3479 @TEXT("n898", key="name", size=0.75);
// &n898 @WIRE(mode="straight") {#X683:2 %t3479:p};
// %t3480 = $IO_PORT @ATTACH &n905 => @PLACE(130, -2006) => @ORIENT("MY");
// %t3480 @TEXT("n905", key="name", size=0.75);
// &n905 @WIRE(mode="straight") {#X683:3 %t3480:p};
// %t3481 = $SUPPLY @ATTACH &vdd => @PLACE(120, -1995);
// &vdd @WIRE(mode="straight") {#X683:4 %t3481:p};
// %t3482 = $GROUND @ATTACH &vss => @PLACE(120, -2017);
// &vss @WIRE(mode="straight") {#X683:5 %t3482:p};
// %t3483 = $IO_PORT @ATTACH &n906 => @PLACE(-11, -2035) => @ORIENT("R0");
// %t3483 @TEXT("n906", key="name", size=0.75);
// &n906 @WIRE(mode="straight") {#X684:1 %t3483:p};
// %t3484 = $IO_PORT @ATTACH &n907 => @PLACE(-11, -2039) => @ORIENT("R0");
// %t3484 @TEXT("n907", key="name", size=0.75);
// &n907 @WIRE(mode="straight") {#X684:2 %t3484:p};
// %t3485 = $IO_PORT @ATTACH &n908 => @PLACE(10, -2037) => @ORIENT("MY");
// %t3485 @TEXT("n908", key="name", size=0.75);
// &n908 @WIRE(mode="straight") {#X684:3 %t3485:p};
// %t3486 = $SUPPLY @ATTACH &vdd => @PLACE(0, -2026);
// &vdd @WIRE(mode="straight") {#X684:4 %t3486:p};
// %t3487 = $GROUND @ATTACH &vss => @PLACE(0, -2048);
// &vss @WIRE(mode="straight") {#X684:5 %t3487:p};
// %t3488 = $IO_PORT @ATTACH &n909 => @PLACE(30, -2035) => @ORIENT("R0");
// %t3488 @TEXT("n909", key="name", size=0.75);
// &n909 @WIRE(mode="straight") {#X685:1 %t3488:p};
// %t3489 = $IO_PORT @ATTACH &n910 => @PLACE(30, -2039) => @ORIENT("R0");
// %t3489 @TEXT("n910", key="name", size=0.75);
// &n910 @WIRE(mode="straight") {#X685:2 %t3489:p};
// %t3490 = $IO_PORT @ATTACH &n907 => @PLACE(50, -2037) => @ORIENT("MY");
// %t3490 @TEXT("n907", key="name", size=0.75);
// &n907 @WIRE(mode="straight") {#X685:3 %t3490:p};
// %t3491 = $SUPPLY @ATTACH &vdd => @PLACE(40, -2026);
// &vdd @WIRE(mode="straight") {#X685:4 %t3491:p};
// %t3492 = $GROUND @ATTACH &vss => @PLACE(40, -2048);
// &vss @WIRE(mode="straight") {#X685:5 %t3492:p};
// %t3493 = $IO_PORT @ATTACH &n911 => @PLACE(70, -2035) => @ORIENT("R0");
// %t3493 @TEXT("n911", key="name", size=0.75);
// &n911 @WIRE(mode="straight") {#X686:1 %t3493:p};
// %t3494 = $IO_PORT @ATTACH &n912 => @PLACE(70, -2039) => @ORIENT("R0");
// %t3494 @TEXT("n912", key="name", size=0.75);
// &n912 @WIRE(mode="straight") {#X686:2 %t3494:p};
// %t3495 = $IO_PORT @ATTACH &n910 => @PLACE(90, -2037) => @ORIENT("MY");
// %t3495 @TEXT("n910", key="name", size=0.75);
// &n910 @WIRE(mode="straight") {#X686:3 %t3495:p};
// %t3496 = $SUPPLY @ATTACH &vdd => @PLACE(80, -2026);
// &vdd @WIRE(mode="straight") {#X686:4 %t3496:p};
// %t3497 = $GROUND @ATTACH &vss => @PLACE(80, -2048);
// &vss @WIRE(mode="straight") {#X686:5 %t3497:p};
// %t3498 = $IO_PORT @ATTACH &n913 => @PLACE(110, -2035) => @ORIENT("R0");
// %t3498 @TEXT("n913", key="name", size=0.75);
// &n913 @WIRE(mode="straight") {#X687:1 %t3498:p};
// %t3499 = $IO_PORT @ATTACH &n914 => @PLACE(110, -2039) => @ORIENT("R0");
// %t3499 @TEXT("n914", key="name", size=0.75);
// &n914 @WIRE(mode="straight") {#X687:2 %t3499:p};
// %t3500 = $IO_PORT @ATTACH &n912 => @PLACE(130, -2037) => @ORIENT("MY");
// %t3500 @TEXT("n912", key="name", size=0.75);
// &n912 @WIRE(mode="straight") {#X687:3 %t3500:p};
// %t3501 = $SUPPLY @ATTACH &vdd => @PLACE(120, -2026);
// &vdd @WIRE(mode="straight") {#X687:4 %t3501:p};
// %t3502 = $GROUND @ATTACH &vss => @PLACE(120, -2048);
// &vss @WIRE(mode="straight") {#X687:5 %t3502:p};
// %t3503 = $IO_PORT @ATTACH &n905 => @PLACE(-11, -2066) => @ORIENT("R0");
// %t3503 @TEXT("n905", key="name", size=0.75);
// &n905 @WIRE(mode="straight") {#X688:1 %t3503:p};
// %t3504 = $IO_PORT @ATTACH &n904 => @PLACE(-11, -2070) => @ORIENT("R0");
// %t3504 @TEXT("n904", key="name", size=0.75);
// &n904 @WIRE(mode="straight") {#X688:2 %t3504:p};
// %t3505 = $IO_PORT @ATTACH &n909 => @PLACE(10, -2068) => @ORIENT("MY");
// %t3505 @TEXT("n909", key="name", size=0.75);
// &n909 @WIRE(mode="straight") {#X688:3 %t3505:p};
// %t3506 = $SUPPLY @ATTACH &vdd => @PLACE(0, -2057);
// &vdd @WIRE(mode="straight") {#X688:4 %t3506:p};
// %t3507 = $GROUND @ATTACH &vss => @PLACE(0, -2079);
// &vss @WIRE(mode="straight") {#X688:5 %t3507:p};
// %t3508 = $IO_PORT @ATTACH &n899 => @PLACE(30, -2066) => @ORIENT("R0");
// %t3508 @TEXT("n899", key="name", size=0.75);
// &n899 @WIRE(mode="straight") {#X689:1 %t3508:p};
// %t3509 = $IO_PORT @ATTACH &n915 => @PLACE(30, -2070) => @ORIENT("R0");
// %t3509 @TEXT("n915", key="name", size=0.75);
// &n915 @WIRE(mode="straight") {#X689:2 %t3509:p};
// %t3510 = $IO_PORT @ATTACH &n906 => @PLACE(50, -2068) => @ORIENT("MY");
// %t3510 @TEXT("n906", key="name", size=0.75);
// &n906 @WIRE(mode="straight") {#X689:3 %t3510:p};
// %t3511 = $SUPPLY @ATTACH &vdd => @PLACE(40, -2057);
// &vdd @WIRE(mode="straight") {#X689:4 %t3511:p};
// %t3512 = $GROUND @ATTACH &vss => @PLACE(40, -2079);
// &vss @WIRE(mode="straight") {#X689:5 %t3512:p};
// %t3513 = $IO_PORT @ATTACH &n905 => @PLACE(70, -2066) => @ORIENT("R0");
// %t3513 @TEXT("n905", key="name", size=0.75);
// &n905 @WIRE(mode="straight") {#X690:1 %t3513:p};
// %t3514 = $IO_PORT @ATTACH &n897 => @PLACE(70, -2070) => @ORIENT("R0");
// %t3514 @TEXT("n897", key="name", size=0.75);
// &n897 @WIRE(mode="straight") {#X690:2 %t3514:p};
// %t3515 = $IO_PORT @ATTACH &n915 => @PLACE(90, -2068) => @ORIENT("MY");
// %t3515 @TEXT("n915", key="name", size=0.75);
// &n915 @WIRE(mode="straight") {#X690:3 %t3515:p};
// %t3516 = $SUPPLY @ATTACH &vdd => @PLACE(80, -2057);
// &vdd @WIRE(mode="straight") {#X690:4 %t3516:p};
// %t3517 = $GROUND @ATTACH &vss => @PLACE(80, -2079);
// &vss @WIRE(mode="straight") {#X690:5 %t3517:p};
// %t3518 = $IO_PORT @ATTACH &n895 => @PLACE(110, -2066) => @ORIENT("R0");
// %t3518 @TEXT("n895", key="name", size=0.75);
// &n895 @WIRE(mode="straight") {#X691:1 %t3518:p};
// %t3519 = $IO_PORT @ATTACH &n916 => @PLACE(110, -2070) => @ORIENT("R0");
// %t3519 @TEXT("n916", key="name", size=0.75);
// &n916 @WIRE(mode="straight") {#X691:2 %t3519:p};
// %t3520 = $IO_PORT @ATTACH &n911 => @PLACE(130, -2068) => @ORIENT("MY");
// %t3520 @TEXT("n911", key="name", size=0.75);
// &n911 @WIRE(mode="straight") {#X691:3 %t3520:p};
// %t3521 = $SUPPLY @ATTACH &vdd => @PLACE(120, -2057);
// &vdd @WIRE(mode="straight") {#X691:4 %t3521:p};
// %t3522 = $GROUND @ATTACH &vss => @PLACE(120, -2079);
// &vss @WIRE(mode="straight") {#X691:5 %t3522:p};
// %t3523 = $IO_PORT @ATTACH &n903 => @PLACE(-11, -2097) => @ORIENT("R0");
// %t3523 @TEXT("n903", key="name", size=0.75);
// &n903 @WIRE(mode="straight") {#X692:1 %t3523:p};
// %t3524 = $IO_PORT @ATTACH &n893 => @PLACE(-11, -2101) => @ORIENT("R0");
// %t3524 @TEXT("n893", key="name", size=0.75);
// &n893 @WIRE(mode="straight") {#X692:2 %t3524:p};
// %t3525 = $IO_PORT @ATTACH &n916 => @PLACE(10, -2099) => @ORIENT("MY");
// %t3525 @TEXT("n916", key="name", size=0.75);
// &n916 @WIRE(mode="straight") {#X692:3 %t3525:p};
// %t3526 = $SUPPLY @ATTACH &vdd => @PLACE(0, -2088);
// &vdd @WIRE(mode="straight") {#X692:4 %t3526:p};
// %t3527 = $GROUND @ATTACH &vss => @PLACE(0, -2110);
// &vss @WIRE(mode="straight") {#X692:5 %t3527:p};
// %t3528 = $IO_PORT @ATTACH &n891 => @PLACE(30, -2097) => @ORIENT("R0");
// %t3528 @TEXT("n891", key="name", size=0.75);
// &n891 @WIRE(mode="straight") {#X693:1 %t3528:p};
// %t3529 = $IO_PORT @ATTACH &n917 => @PLACE(30, -2101) => @ORIENT("R0");
// %t3529 @TEXT("n917", key="name", size=0.75);
// &n917 @WIRE(mode="straight") {#X693:2 %t3529:p};
// %t3530 = $IO_PORT @ATTACH &n914 => @PLACE(50, -2099) => @ORIENT("MY");
// %t3530 @TEXT("n914", key="name", size=0.75);
// &n914 @WIRE(mode="straight") {#X693:3 %t3530:p};
// %t3531 = $SUPPLY @ATTACH &vdd => @PLACE(40, -2088);
// &vdd @WIRE(mode="straight") {#X693:4 %t3531:p};
// %t3532 = $GROUND @ATTACH &vss => @PLACE(40, -2110);
// &vss @WIRE(mode="straight") {#X693:5 %t3532:p};
// %t3533 = $IO_PORT @ATTACH &n901 => @PLACE(70, -2097) => @ORIENT("R0");
// %t3533 @TEXT("n901", key="name", size=0.75);
// &n901 @WIRE(mode="straight") {#X694:1 %t3533:p};
// %t3534 = $IO_PORT @ATTACH &n918 => @PLACE(70, -2101) => @ORIENT("R0");
// %t3534 @TEXT("n918", key="name", size=0.75);
// &n918 @WIRE(mode="straight") {#X694:2 %t3534:p};
// %t3535 = $IO_PORT @ATTACH &n917 => @PLACE(90, -2099) => @ORIENT("MY");
// %t3535 @TEXT("n917", key="name", size=0.75);
// &n917 @WIRE(mode="straight") {#X694:3 %t3535:p};
// %t3536 = $SUPPLY @ATTACH &vdd => @PLACE(80, -2088);
// &vdd @WIRE(mode="straight") {#X694:4 %t3536:p};
// %t3537 = $GROUND @ATTACH &vss => @PLACE(80, -2110);
// &vss @WIRE(mode="straight") {#X694:5 %t3537:p};
// %t3538 = $IO_PORT @ATTACH &n889 => @PLACE(110, -2097) => @ORIENT("R0");
// %t3538 @TEXT("n889", key="name", size=0.75);
// &n889 @WIRE(mode="straight") {#X695:1 %t3538:p};
// %t3539 = $IO_PORT @ATTACH &n900 => @PLACE(110, -2101) => @ORIENT("R0");
// %t3539 @TEXT("n900", key="name", size=0.75);
// &n900 @WIRE(mode="straight") {#X695:2 %t3539:p};
// %t3540 = $IO_PORT @ATTACH &n918 => @PLACE(130, -2099) => @ORIENT("MY");
// %t3540 @TEXT("n918", key="name", size=0.75);
// &n918 @WIRE(mode="straight") {#X695:3 %t3540:p};
// %t3541 = $SUPPLY @ATTACH &vdd => @PLACE(120, -2088);
// &vdd @WIRE(mode="straight") {#X695:4 %t3541:p};
// %t3542 = $GROUND @ATTACH &vss => @PLACE(120, -2110);
// &vss @WIRE(mode="straight") {#X695:5 %t3542:p};
// %t3543 = $IO_PORT @ATTACH &n575 => @PLACE(158, -1942) => @ORIENT("R0");
// %t3543 @TEXT("n575", key="name", size=0.75);
// &n575 @WIRE(mode="straight") {#X696:1 %t3543:p};
// %t3544 = $IO_PORT @ATTACH &n576 => @PLACE(158, -1946) => @ORIENT("R0");
// %t3544 @TEXT("n576", key="name", size=0.75);
// &n576 @WIRE(mode="straight") {#X696:2 %t3544:p};
// %t3545 = $IO_PORT @ATTACH &n919 => @PLACE(178, -1944) => @ORIENT("MY");
// %t3545 @TEXT("n919", key="name", size=0.75);
// &n919 @WIRE(mode="straight") {#X696:3 %t3545:p};
// %t3546 = $SUPPLY @ATTACH &vdd => @PLACE(168, -1933);
// &vdd @WIRE(mode="straight") {#X696:4 %t3546:p};
// %t3547 = $GROUND @ATTACH &vss => @PLACE(168, -1955);
// &vss @WIRE(mode="straight") {#X696:5 %t3547:p};
// %t3548 = $IO_PORT @ATTACH &dac4 => @PLACE(198, -1942) => @ORIENT("R0");
// %t3548 @TEXT("dac4", key="name", size=0.75);
// &dac4 @WIRE(mode="straight") {#X697:1 %t3548:p};
// %t3549 = $IO_PORT @ATTACH &n919 => @PLACE(198, -1946) => @ORIENT("R0");
// %t3549 @TEXT("n919", key="name", size=0.75);
// &n919 @WIRE(mode="straight") {#X697:2 %t3549:p};
// %t3550 = $IO_PORT @ATTACH &n579 => @PLACE(218, -1944) => @ORIENT("MY");
// %t3550 @TEXT("n579", key="name", size=0.75);
// &n579 @WIRE(mode="straight") {#X697:3 %t3550:p};
// %t3551 = $SUPPLY @ATTACH &vdd => @PLACE(208, -1933);
// &vdd @WIRE(mode="straight") {#X697:4 %t3551:p};
// %t3552 = $GROUND @ATTACH &vss => @PLACE(208, -1955);
// &vss @WIRE(mode="straight") {#X697:5 %t3552:p};
// %t3553 = $IO_PORT @ATTACH &n920 => @PLACE(238, -1942) => @ORIENT("R0");
// %t3553 @TEXT("n920", key="name", size=0.75);
// &n920 @WIRE(mode="straight") {#X698:1 %t3553:p};
// %t3554 = $IO_PORT @ATTACH &n815 => @PLACE(238, -1946) => @ORIENT("R0");
// %t3554 @TEXT("n815", key="name", size=0.75);
// &n815 @WIRE(mode="straight") {#X698:2 %t3554:p};
// %t3555 = $IO_PORT @ATTACH &n576 => @PLACE(258, -1944) => @ORIENT("MY");
// %t3555 @TEXT("n576", key="name", size=0.75);
// &n576 @WIRE(mode="straight") {#X698:3 %t3555:p};
// %t3556 = $SUPPLY @ATTACH &vdd => @PLACE(248, -1933);
// &vdd @WIRE(mode="straight") {#X698:4 %t3556:p};
// %t3557 = $GROUND @ATTACH &vss => @PLACE(248, -1955);
// &vss @WIRE(mode="straight") {#X698:5 %t3557:p};
// %t3558 = $IO_PORT @ATTACH &dac3 => @PLACE(278, -1942) => @ORIENT("R0");
// %t3558 @TEXT("dac3", key="name", size=0.75);
// &dac3 @WIRE(mode="straight") {#X699:1 %t3558:p};
// %t3559 = $IO_PORT @ATTACH &n921 => @PLACE(278, -1946) => @ORIENT("R0");
// %t3559 @TEXT("n921", key="name", size=0.75);
// &n921 @WIRE(mode="straight") {#X699:2 %t3559:p};
// %t3560 = $IO_PORT @ATTACH &n920 => @PLACE(298, -1944) => @ORIENT("MY");
// %t3560 @TEXT("n920", key="name", size=0.75);
// &n920 @WIRE(mode="straight") {#X699:3 %t3560:p};
// %t3561 = $SUPPLY @ATTACH &vdd => @PLACE(288, -1933);
// &vdd @WIRE(mode="straight") {#X699:4 %t3561:p};
// %t3562 = $GROUND @ATTACH &vss => @PLACE(288, -1955);
// &vss @WIRE(mode="straight") {#X699:5 %t3562:p};
// %t3563 = $IO_PORT @ATTACH &n211 => @PLACE(158, -1973) => @ORIENT("R0");
// %t3563 @TEXT("n211", key="name", size=0.75);
// &n211 @WIRE(mode="straight") {#X700:1 %t3563:p};
// %t3564 = $IO_PORT @ATTACH &dac2 => @PLACE(158, -1977) => @ORIENT("R0");
// %t3564 @TEXT("dac2", key="name", size=0.75);
// &dac2 @WIRE(mode="straight") {#X700:2 %t3564:p};
// %t3565 = $IO_PORT @ATTACH &n921 => @PLACE(178, -1975) => @ORIENT("MY");
// %t3565 @TEXT("n921", key="name", size=0.75);
// &n921 @WIRE(mode="straight") {#X700:3 %t3565:p};
// %t3566 = $SUPPLY @ATTACH &vdd => @PLACE(168, -1964);
// &vdd @WIRE(mode="straight") {#X700:4 %t3566:p};
// %t3567 = $GROUND @ATTACH &vss => @PLACE(168, -1986);
// &vss @WIRE(mode="straight") {#X700:5 %t3567:p};
// %t3568 = $IO_PORT @ATTACH &dac2 => @PLACE(198, -1973) => @ORIENT("R0");
// %t3568 @TEXT("dac2", key="name", size=0.75);
// &dac2 @WIRE(mode="straight") {#X701:1 %t3568:p};
// %t3569 = $IO_PORT @ATTACH &n812 => @PLACE(198, -1977) => @ORIENT("R0");
// %t3569 @TEXT("n812", key="name", size=0.75);
// &n812 @WIRE(mode="straight") {#X701:2 %t3569:p};
// %t3570 = $IO_PORT @ATTACH &n502 => @PLACE(218, -1975) => @ORIENT("MY");
// %t3570 @TEXT("n502", key="name", size=0.75);
// &n502 @WIRE(mode="straight") {#X701:3 %t3570:p};
// %t3571 = $SUPPLY @ATTACH &vdd => @PLACE(208, -1964);
// &vdd @WIRE(mode="straight") {#X701:4 %t3571:p};
// %t3572 = $GROUND @ATTACH &vss => @PLACE(208, -1986);
// &vss @WIRE(mode="straight") {#X701:5 %t3572:p};
// %t3573 = $IO_PORT @ATTACH &dac1 => @PLACE(238, -1973) => @ORIENT("R0");
// %t3573 @TEXT("dac1", key="name", size=0.75);
// &dac1 @WIRE(mode="straight") {#X702:1 %t3573:p};
// %t3574 = $IO_PORT @ATTACH &n922 => @PLACE(238, -1977) => @ORIENT("R0");
// %t3574 @TEXT("n922", key="name", size=0.75);
// &n922 @WIRE(mode="straight") {#X702:2 %t3574:p};
// %t3575 = $IO_PORT @ATTACH &n573 => @PLACE(258, -1975) => @ORIENT("MY");
// %t3575 @TEXT("n573", key="name", size=0.75);
// &n573 @WIRE(mode="straight") {#X702:3 %t3575:p};
// %t3576 = $SUPPLY @ATTACH &vdd => @PLACE(248, -1964);
// &vdd @WIRE(mode="straight") {#X702:4 %t3576:p};
// %t3577 = $GROUND @ATTACH &vss => @PLACE(248, -1986);
// &vss @WIRE(mode="straight") {#X702:5 %t3577:p};
// %t3578 = $IO_PORT @ATTACH &n500 => @PLACE(278, -1973) => @ORIENT("R0");
// %t3578 @TEXT("n500", key="name", size=0.75);
// &n500 @WIRE(mode="straight") {#X703:1 %t3578:p};
// %t3579 = $IO_PORT @ATTACH &dac0 => @PLACE(278, -1977) => @ORIENT("R0");
// %t3579 @TEXT("dac0", key="name", size=0.75);
// &dac0 @WIRE(mode="straight") {#X703:2 %t3579:p};
// %t3580 = $IO_PORT @ATTACH &n922 => @PLACE(298, -1975) => @ORIENT("MY");
// %t3580 @TEXT("n922", key="name", size=0.75);
// &n922 @WIRE(mode="straight") {#X703:3 %t3580:p};
// %t3581 = $SUPPLY @ATTACH &vdd => @PLACE(288, -1964);
// &vdd @WIRE(mode="straight") {#X703:4 %t3581:p};
// %t3582 = $GROUND @ATTACH &vss => @PLACE(288, -1986);
// &vss @WIRE(mode="straight") {#X703:5 %t3582:p};
// %t3583 = $IO_PORT @ATTACH &dac0 => @PLACE(158, -2004) => @ORIENT("R0");
// %t3583 @TEXT("dac0", key="name", size=0.75);
// &dac0 @WIRE(mode="straight") {#X704:1 %t3583:p};
// %t3584 = $IO_PORT @ATTACH &n923 => @PLACE(158, -2008) => @ORIENT("R0");
// %t3584 @TEXT("n923", key="name", size=0.75);
// &n923 @WIRE(mode="straight") {#X704:2 %t3584:p};
// %t3585 = $IO_PORT @ATTACH &n924 => @PLACE(178, -2006) => @ORIENT("MY");
// %t3585 @TEXT("n924", key="name", size=0.75);
// &n924 @WIRE(mode="straight") {#X704:3 %t3585:p};
// %t3586 = $SUPPLY @ATTACH &vdd => @PLACE(168, -1995);
// &vdd @WIRE(mode="straight") {#X704:4 %t3586:p};
// %t3587 = $GROUND @ATTACH &vss => @PLACE(168, -2017);
// &vss @WIRE(mode="straight") {#X704:5 %t3587:p};
// %t3588 = $IO_PORT @ATTACH &dac1 => @PLACE(198, -2004) => @ORIENT("R0");
// %t3588 @TEXT("dac1", key="name", size=0.75);
// &dac1 @WIRE(mode="straight") {#X705:1 %t3588:p};
// %t3589 = $IO_PORT @ATTACH &n925 => @PLACE(198, -2008) => @ORIENT("R0");
// %t3589 @TEXT("n925", key="name", size=0.75);
// &n925 @WIRE(mode="straight") {#X705:2 %t3589:p};
// %t3590 = $IO_PORT @ATTACH &n926 => @PLACE(218, -2006) => @ORIENT("MY");
// %t3590 @TEXT("n926", key="name", size=0.75);
// &n926 @WIRE(mode="straight") {#X705:3 %t3590:p};
// %t3591 = $SUPPLY @ATTACH &vdd => @PLACE(208, -1995);
// &vdd @WIRE(mode="straight") {#X705:4 %t3591:p};
// %t3592 = $GROUND @ATTACH &vss => @PLACE(208, -2017);
// &vss @WIRE(mode="straight") {#X705:5 %t3592:p};
// %t3593 = $IO_PORT @ATTACH &dac2 => @PLACE(238, -2004) => @ORIENT("R0");
// %t3593 @TEXT("dac2", key="name", size=0.75);
// &dac2 @WIRE(mode="straight") {#X706:1 %t3593:p};
// %t3594 = $IO_PORT @ATTACH &n927 => @PLACE(238, -2008) => @ORIENT("R0");
// %t3594 @TEXT("n927", key="name", size=0.75);
// &n927 @WIRE(mode="straight") {#X706:2 %t3594:p};
// %t3595 = $IO_PORT @ATTACH &n928 => @PLACE(258, -2006) => @ORIENT("MY");
// %t3595 @TEXT("n928", key="name", size=0.75);
// &n928 @WIRE(mode="straight") {#X706:3 %t3595:p};
// %t3596 = $SUPPLY @ATTACH &vdd => @PLACE(248, -1995);
// &vdd @WIRE(mode="straight") {#X706:4 %t3596:p};
// %t3597 = $GROUND @ATTACH &vss => @PLACE(248, -2017);
// &vss @WIRE(mode="straight") {#X706:5 %t3597:p};
// %t3598 = $IO_PORT @ATTACH &dac3 => @PLACE(278, -2004) => @ORIENT("R0");
// %t3598 @TEXT("dac3", key="name", size=0.75);
// &dac3 @WIRE(mode="straight") {#X707:1 %t3598:p};
// %t3599 = $IO_PORT @ATTACH &n929 => @PLACE(278, -2008) => @ORIENT("R0");
// %t3599 @TEXT("n929", key="name", size=0.75);
// &n929 @WIRE(mode="straight") {#X707:2 %t3599:p};
// %t3600 = $IO_PORT @ATTACH &n930 => @PLACE(298, -2006) => @ORIENT("MY");
// %t3600 @TEXT("n930", key="name", size=0.75);
// &n930 @WIRE(mode="straight") {#X707:3 %t3600:p};
// %t3601 = $SUPPLY @ATTACH &vdd => @PLACE(288, -1995);
// &vdd @WIRE(mode="straight") {#X707:4 %t3601:p};
// %t3602 = $GROUND @ATTACH &vss => @PLACE(288, -2017);
// &vss @WIRE(mode="straight") {#X707:5 %t3602:p};
// %t3603 = $IO_PORT @ATTACH &dac4 => @PLACE(158, -2035) => @ORIENT("R0");
// %t3603 @TEXT("dac4", key="name", size=0.75);
// &dac4 @WIRE(mode="straight") {#X708:1 %t3603:p};
// %t3604 = $IO_PORT @ATTACH &n931 => @PLACE(158, -2039) => @ORIENT("R0");
// %t3604 @TEXT("n931", key="name", size=0.75);
// &n931 @WIRE(mode="straight") {#X708:2 %t3604:p};
// %t3605 = $IO_PORT @ATTACH &n932 => @PLACE(178, -2037) => @ORIENT("MY");
// %t3605 @TEXT("n932", key="name", size=0.75);
// &n932 @WIRE(mode="straight") {#X708:3 %t3605:p};
// %t3606 = $SUPPLY @ATTACH &vdd => @PLACE(168, -2026);
// &vdd @WIRE(mode="straight") {#X708:4 %t3606:p};
// %t3607 = $GROUND @ATTACH &vss => @PLACE(168, -2048);
// &vss @WIRE(mode="straight") {#X708:5 %t3607:p};
// %t3608 = $IO_PORT @ATTACH &dac5 => @PLACE(198, -2035) => @ORIENT("R0");
// %t3608 @TEXT("dac5", key="name", size=0.75);
// &dac5 @WIRE(mode="straight") {#X709:1 %t3608:p};
// %t3609 = $IO_PORT @ATTACH &n933 => @PLACE(198, -2039) => @ORIENT("R0");
// %t3609 @TEXT("n933", key="name", size=0.75);
// &n933 @WIRE(mode="straight") {#X709:2 %t3609:p};
// %t3610 = $IO_PORT @ATTACH &n934 => @PLACE(218, -2037) => @ORIENT("MY");
// %t3610 @TEXT("n934", key="name", size=0.75);
// &n934 @WIRE(mode="straight") {#X709:3 %t3610:p};
// %t3611 = $SUPPLY @ATTACH &vdd => @PLACE(208, -2026);
// &vdd @WIRE(mode="straight") {#X709:4 %t3611:p};
// %t3612 = $GROUND @ATTACH &vss => @PLACE(208, -2048);
// &vss @WIRE(mode="straight") {#X709:5 %t3612:p};
// %t3613 = $IO_PORT @ATTACH &dac0 => @PLACE(238, -2035) => @ORIENT("R0");
// %t3613 @TEXT("dac0", key="name", size=0.75);
// &dac0 @WIRE(mode="straight") {#X710:1 %t3613:p};
// %t3614 = $IO_PORT @ATTACH &n923 => @PLACE(238, -2039) => @ORIENT("R0");
// %t3614 @TEXT("n923", key="name", size=0.75);
// &n923 @WIRE(mode="straight") {#X710:2 %t3614:p};
// %t3615 = $IO_PORT @ATTACH &n935 => @PLACE(258, -2037) => @ORIENT("MY");
// %t3615 @TEXT("n935", key="name", size=0.75);
// &n935 @WIRE(mode="straight") {#X710:3 %t3615:p};
// %t3616 = $SUPPLY @ATTACH &vdd => @PLACE(248, -2026);
// &vdd @WIRE(mode="straight") {#X710:4 %t3616:p};
// %t3617 = $GROUND @ATTACH &vss => @PLACE(248, -2048);
// &vss @WIRE(mode="straight") {#X710:5 %t3617:p};
// %t3618 = $IO_PORT @ATTACH &dac1 => @PLACE(278, -2035) => @ORIENT("R0");
// %t3618 @TEXT("dac1", key="name", size=0.75);
// &dac1 @WIRE(mode="straight") {#X711:1 %t3618:p};
// %t3619 = $IO_PORT @ATTACH &n925 => @PLACE(278, -2039) => @ORIENT("R0");
// %t3619 @TEXT("n925", key="name", size=0.75);
// &n925 @WIRE(mode="straight") {#X711:2 %t3619:p};
// %t3620 = $IO_PORT @ATTACH &n936 => @PLACE(298, -2037) => @ORIENT("MY");
// %t3620 @TEXT("n936", key="name", size=0.75);
// &n936 @WIRE(mode="straight") {#X711:3 %t3620:p};
// %t3621 = $SUPPLY @ATTACH &vdd => @PLACE(288, -2026);
// &vdd @WIRE(mode="straight") {#X711:4 %t3621:p};
// %t3622 = $GROUND @ATTACH &vss => @PLACE(288, -2048);
// &vss @WIRE(mode="straight") {#X711:5 %t3622:p};
// %t3623 = $IO_PORT @ATTACH &dac2 => @PLACE(158, -2066) => @ORIENT("R0");
// %t3623 @TEXT("dac2", key="name", size=0.75);
// &dac2 @WIRE(mode="straight") {#X712:1 %t3623:p};
// %t3624 = $IO_PORT @ATTACH &n927 => @PLACE(158, -2070) => @ORIENT("R0");
// %t3624 @TEXT("n927", key="name", size=0.75);
// &n927 @WIRE(mode="straight") {#X712:2 %t3624:p};
// %t3625 = $IO_PORT @ATTACH &n937 => @PLACE(178, -2068) => @ORIENT("MY");
// %t3625 @TEXT("n937", key="name", size=0.75);
// &n937 @WIRE(mode="straight") {#X712:3 %t3625:p};
// %t3626 = $SUPPLY @ATTACH &vdd => @PLACE(168, -2057);
// &vdd @WIRE(mode="straight") {#X712:4 %t3626:p};
// %t3627 = $GROUND @ATTACH &vss => @PLACE(168, -2079);
// &vss @WIRE(mode="straight") {#X712:5 %t3627:p};
// %t3628 = $IO_PORT @ATTACH &dac3 => @PLACE(198, -2066) => @ORIENT("R0");
// %t3628 @TEXT("dac3", key="name", size=0.75);
// &dac3 @WIRE(mode="straight") {#X713:1 %t3628:p};
// %t3629 = $IO_PORT @ATTACH &n929 => @PLACE(198, -2070) => @ORIENT("R0");
// %t3629 @TEXT("n929", key="name", size=0.75);
// &n929 @WIRE(mode="straight") {#X713:2 %t3629:p};
// %t3630 = $IO_PORT @ATTACH &n938 => @PLACE(218, -2068) => @ORIENT("MY");
// %t3630 @TEXT("n938", key="name", size=0.75);
// &n938 @WIRE(mode="straight") {#X713:3 %t3630:p};
// %t3631 = $SUPPLY @ATTACH &vdd => @PLACE(208, -2057);
// &vdd @WIRE(mode="straight") {#X713:4 %t3631:p};
// %t3632 = $GROUND @ATTACH &vss => @PLACE(208, -2079);
// &vss @WIRE(mode="straight") {#X713:5 %t3632:p};
// %t3633 = $IO_PORT @ATTACH &dac4 => @PLACE(238, -2066) => @ORIENT("R0");
// %t3633 @TEXT("dac4", key="name", size=0.75);
// &dac4 @WIRE(mode="straight") {#X714:1 %t3633:p};
// %t3634 = $IO_PORT @ATTACH &n931 => @PLACE(238, -2070) => @ORIENT("R0");
// %t3634 @TEXT("n931", key="name", size=0.75);
// &n931 @WIRE(mode="straight") {#X714:2 %t3634:p};
// %t3635 = $IO_PORT @ATTACH &n939 => @PLACE(258, -2068) => @ORIENT("MY");
// %t3635 @TEXT("n939", key="name", size=0.75);
// &n939 @WIRE(mode="straight") {#X714:3 %t3635:p};
// %t3636 = $SUPPLY @ATTACH &vdd => @PLACE(248, -2057);
// &vdd @WIRE(mode="straight") {#X714:4 %t3636:p};
// %t3637 = $GROUND @ATTACH &vss => @PLACE(248, -2079);
// &vss @WIRE(mode="straight") {#X714:5 %t3637:p};
// %t3638 = $IO_PORT @ATTACH &dac5 => @PLACE(278, -2066) => @ORIENT("R0");
// %t3638 @TEXT("dac5", key="name", size=0.75);
// &dac5 @WIRE(mode="straight") {#X715:1 %t3638:p};
// %t3639 = $IO_PORT @ATTACH &n933 => @PLACE(278, -2070) => @ORIENT("R0");
// %t3639 @TEXT("n933", key="name", size=0.75);
// &n933 @WIRE(mode="straight") {#X715:2 %t3639:p};
// %t3640 = $IO_PORT @ATTACH &n940 => @PLACE(298, -2068) => @ORIENT("MY");
// %t3640 @TEXT("n940", key="name", size=0.75);
// &n940 @WIRE(mode="straight") {#X715:3 %t3640:p};
// %t3641 = $SUPPLY @ATTACH &vdd => @PLACE(288, -2057);
// &vdd @WIRE(mode="straight") {#X715:4 %t3641:p};
// %t3642 = $GROUND @ATTACH &vss => @PLACE(288, -2079);
// &vss @WIRE(mode="straight") {#X715:5 %t3642:p};
// %t3643 = $IO_PORT @ATTACH &n941 => @PLACE(158, -2097) => @ORIENT("R0");
// %t3643 @TEXT("n941", key="name", size=0.75);
// &n941 @WIRE(mode="straight") {#X716:1 %t3643:p};
// %t3644 = $IO_PORT @ATTACH &n942 => @PLACE(158, -2101) => @ORIENT("R0");
// %t3644 @TEXT("n942", key="name", size=0.75);
// &n942 @WIRE(mode="straight") {#X716:2 %t3644:p};
// %t3645 = $IO_PORT @ATTACH &n943 => @PLACE(178, -2099) => @ORIENT("MY");
// %t3645 @TEXT("n943", key="name", size=0.75);
// &n943 @WIRE(mode="straight") {#X716:3 %t3645:p};
// %t3646 = $SUPPLY @ATTACH &vdd => @PLACE(168, -2088);
// &vdd @WIRE(mode="straight") {#X716:4 %t3646:p};
// %t3647 = $GROUND @ATTACH &vss => @PLACE(168, -2110);
// &vss @WIRE(mode="straight") {#X716:5 %t3647:p};
// %t3648 = $IO_PORT @ATTACH &n944 => @PLACE(198, -2097) => @ORIENT("R0");
// %t3648 @TEXT("n944", key="name", size=0.75);
// &n944 @WIRE(mode="straight") {#X717:1 %t3648:p};
// %t3649 = $IO_PORT @ATTACH &n945 => @PLACE(198, -2101) => @ORIENT("R0");
// %t3649 @TEXT("n945", key="name", size=0.75);
// &n945 @WIRE(mode="straight") {#X717:2 %t3649:p};
// %t3650 = $IO_PORT @ATTACH &n942 => @PLACE(218, -2099) => @ORIENT("MY");
// %t3650 @TEXT("n942", key="name", size=0.75);
// &n942 @WIRE(mode="straight") {#X717:3 %t3650:p};
// %t3651 = $SUPPLY @ATTACH &vdd => @PLACE(208, -2088);
// &vdd @WIRE(mode="straight") {#X717:4 %t3651:p};
// %t3652 = $GROUND @ATTACH &vss => @PLACE(208, -2110);
// &vss @WIRE(mode="straight") {#X717:5 %t3652:p};
// %t3653 = $IO_PORT @ATTACH &n946 => @PLACE(238, -2097) => @ORIENT("R0");
// %t3653 @TEXT("n946", key="name", size=0.75);
// &n946 @WIRE(mode="straight") {#X718:1 %t3653:p};
// %t3654 = $IO_PORT @ATTACH &n947 => @PLACE(238, -2101) => @ORIENT("R0");
// %t3654 @TEXT("n947", key="name", size=0.75);
// &n947 @WIRE(mode="straight") {#X718:2 %t3654:p};
// %t3655 = $IO_PORT @ATTACH &n945 => @PLACE(258, -2099) => @ORIENT("MY");
// %t3655 @TEXT("n945", key="name", size=0.75);
// &n945 @WIRE(mode="straight") {#X718:3 %t3655:p};
// %t3656 = $SUPPLY @ATTACH &vdd => @PLACE(248, -2088);
// &vdd @WIRE(mode="straight") {#X718:4 %t3656:p};
// %t3657 = $GROUND @ATTACH &vss => @PLACE(248, -2110);
// &vss @WIRE(mode="straight") {#X718:5 %t3657:p};
// %t3658 = $IO_PORT @ATTACH &n948 => @PLACE(278, -2097) => @ORIENT("R0");
// %t3658 @TEXT("n948", key="name", size=0.75);
// &n948 @WIRE(mode="straight") {#X719:1 %t3658:p};
// %t3659 = $IO_PORT @ATTACH &n949 => @PLACE(278, -2101) => @ORIENT("R0");
// %t3659 @TEXT("n949", key="name", size=0.75);
// &n949 @WIRE(mode="straight") {#X719:2 %t3659:p};
// %t3660 = $IO_PORT @ATTACH &n947 => @PLACE(298, -2099) => @ORIENT("MY");
// %t3660 @TEXT("n947", key="name", size=0.75);
// &n947 @WIRE(mode="straight") {#X719:3 %t3660:p};
// %t3661 = $SUPPLY @ATTACH &vdd => @PLACE(288, -2088);
// &vdd @WIRE(mode="straight") {#X719:4 %t3661:p};
// %t3662 = $GROUND @ATTACH &vss => @PLACE(288, -2110);
// &vss @WIRE(mode="straight") {#X719:5 %t3662:p};
// %t3663 = $IO_PORT @ATTACH &n940 => @PLACE(326, -1942) => @ORIENT("R0");
// %t3663 @TEXT("n940", key="name", size=0.75);
// &n940 @WIRE(mode="straight") {#X720:1 %t3663:p};
// %t3664 = $IO_PORT @ATTACH &n939 => @PLACE(326, -1946) => @ORIENT("R0");
// %t3664 @TEXT("n939", key="name", size=0.75);
// &n939 @WIRE(mode="straight") {#X720:2 %t3664:p};
// %t3665 = $IO_PORT @ATTACH &n944 => @PLACE(346, -1944) => @ORIENT("MY");
// %t3665 @TEXT("n944", key="name", size=0.75);
// &n944 @WIRE(mode="straight") {#X720:3 %t3665:p};
// %t3666 = $SUPPLY @ATTACH &vdd => @PLACE(336, -1933);
// &vdd @WIRE(mode="straight") {#X720:4 %t3666:p};
// %t3667 = $GROUND @ATTACH &vss => @PLACE(336, -1955);
// &vss @WIRE(mode="straight") {#X720:5 %t3667:p};
// %t3668 = $IO_PORT @ATTACH &n934 => @PLACE(366, -1942) => @ORIENT("R0");
// %t3668 @TEXT("n934", key="name", size=0.75);
// &n934 @WIRE(mode="straight") {#X721:1 %t3668:p};
// %t3669 = $IO_PORT @ATTACH &n950 => @PLACE(366, -1946) => @ORIENT("R0");
// %t3669 @TEXT("n950", key="name", size=0.75);
// &n950 @WIRE(mode="straight") {#X721:2 %t3669:p};
// %t3670 = $IO_PORT @ATTACH &n941 => @PLACE(386, -1944) => @ORIENT("MY");
// %t3670 @TEXT("n941", key="name", size=0.75);
// &n941 @WIRE(mode="straight") {#X721:3 %t3670:p};
// %t3671 = $SUPPLY @ATTACH &vdd => @PLACE(376, -1933);
// &vdd @WIRE(mode="straight") {#X721:4 %t3671:p};
// %t3672 = $GROUND @ATTACH &vss => @PLACE(376, -1955);
// &vss @WIRE(mode="straight") {#X721:5 %t3672:p};
// %t3673 = $IO_PORT @ATTACH &n940 => @PLACE(406, -1942) => @ORIENT("R0");
// %t3673 @TEXT("n940", key="name", size=0.75);
// &n940 @WIRE(mode="straight") {#X722:1 %t3673:p};
// %t3674 = $IO_PORT @ATTACH &n932 => @PLACE(406, -1946) => @ORIENT("R0");
// %t3674 @TEXT("n932", key="name", size=0.75);
// &n932 @WIRE(mode="straight") {#X722:2 %t3674:p};
// %t3675 = $IO_PORT @ATTACH &n950 => @PLACE(426, -1944) => @ORIENT("MY");
// %t3675 @TEXT("n950", key="name", size=0.75);
// &n950 @WIRE(mode="straight") {#X722:3 %t3675:p};
// %t3676 = $SUPPLY @ATTACH &vdd => @PLACE(416, -1933);
// &vdd @WIRE(mode="straight") {#X722:4 %t3676:p};
// %t3677 = $GROUND @ATTACH &vss => @PLACE(416, -1955);
// &vss @WIRE(mode="straight") {#X722:5 %t3677:p};
// %t3678 = $IO_PORT @ATTACH &n938 => @PLACE(446, -1942) => @ORIENT("R0");
// %t3678 @TEXT("n938", key="name", size=0.75);
// &n938 @WIRE(mode="straight") {#X723:1 %t3678:p};
// %t3679 = $IO_PORT @ATTACH &n937 => @PLACE(446, -1946) => @ORIENT("R0");
// %t3679 @TEXT("n937", key="name", size=0.75);
// &n937 @WIRE(mode="straight") {#X723:2 %t3679:p};
// %t3680 = $IO_PORT @ATTACH &n948 => @PLACE(466, -1944) => @ORIENT("MY");
// %t3680 @TEXT("n948", key="name", size=0.75);
// &n948 @WIRE(mode="straight") {#X723:3 %t3680:p};
// %t3681 = $SUPPLY @ATTACH &vdd => @PLACE(456, -1933);
// &vdd @WIRE(mode="straight") {#X723:4 %t3681:p};
// %t3682 = $GROUND @ATTACH &vss => @PLACE(456, -1955);
// &vss @WIRE(mode="straight") {#X723:5 %t3682:p};
// %t3683 = $IO_PORT @ATTACH &n930 => @PLACE(326, -1973) => @ORIENT("R0");
// %t3683 @TEXT("n930", key="name", size=0.75);
// &n930 @WIRE(mode="straight") {#X724:1 %t3683:p};
// %t3684 = $IO_PORT @ATTACH &n951 => @PLACE(326, -1977) => @ORIENT("R0");
// %t3684 @TEXT("n951", key="name", size=0.75);
// &n951 @WIRE(mode="straight") {#X724:2 %t3684:p};
// %t3685 = $IO_PORT @ATTACH &n946 => @PLACE(346, -1975) => @ORIENT("MY");
// %t3685 @TEXT("n946", key="name", size=0.75);
// &n946 @WIRE(mode="straight") {#X724:3 %t3685:p};
// %t3686 = $SUPPLY @ATTACH &vdd => @PLACE(336, -1964);
// &vdd @WIRE(mode="straight") {#X724:4 %t3686:p};
// %t3687 = $GROUND @ATTACH &vss => @PLACE(336, -1986);
// &vss @WIRE(mode="straight") {#X724:5 %t3687:p};
// %t3688 = $IO_PORT @ATTACH &n938 => @PLACE(366, -1973) => @ORIENT("R0");
// %t3688 @TEXT("n938", key="name", size=0.75);
// &n938 @WIRE(mode="straight") {#X725:1 %t3688:p};
// %t3689 = $IO_PORT @ATTACH &n928 => @PLACE(366, -1977) => @ORIENT("R0");
// %t3689 @TEXT("n928", key="name", size=0.75);
// &n928 @WIRE(mode="straight") {#X725:2 %t3689:p};
// %t3690 = $IO_PORT @ATTACH &n951 => @PLACE(386, -1975) => @ORIENT("MY");
// %t3690 @TEXT("n951", key="name", size=0.75);
// &n951 @WIRE(mode="straight") {#X725:3 %t3690:p};
// %t3691 = $SUPPLY @ATTACH &vdd => @PLACE(376, -1964);
// &vdd @WIRE(mode="straight") {#X725:4 %t3691:p};
// %t3692 = $GROUND @ATTACH &vss => @PLACE(376, -1986);
// &vss @WIRE(mode="straight") {#X725:5 %t3692:p};
// %t3693 = $IO_PORT @ATTACH &n926 => @PLACE(406, -1973) => @ORIENT("R0");
// %t3693 @TEXT("n926", key="name", size=0.75);
// &n926 @WIRE(mode="straight") {#X726:1 %t3693:p};
// %t3694 = $IO_PORT @ATTACH &n952 => @PLACE(406, -1977) => @ORIENT("R0");
// %t3694 @TEXT("n952", key="name", size=0.75);
// &n952 @WIRE(mode="straight") {#X726:2 %t3694:p};
// %t3695 = $IO_PORT @ATTACH &n949 => @PLACE(426, -1975) => @ORIENT("MY");
// %t3695 @TEXT("n949", key="name", size=0.75);
// &n949 @WIRE(mode="straight") {#X726:3 %t3695:p};
// %t3696 = $SUPPLY @ATTACH &vdd => @PLACE(416, -1964);
// &vdd @WIRE(mode="straight") {#X726:4 %t3696:p};
// %t3697 = $GROUND @ATTACH &vss => @PLACE(416, -1986);
// &vss @WIRE(mode="straight") {#X726:5 %t3697:p};
// %t3698 = $IO_PORT @ATTACH &n936 => @PLACE(446, -1973) => @ORIENT("R0");
// %t3698 @TEXT("n936", key="name", size=0.75);
// &n936 @WIRE(mode="straight") {#X727:1 %t3698:p};
// %t3699 = $IO_PORT @ATTACH &n953 => @PLACE(446, -1977) => @ORIENT("R0");
// %t3699 @TEXT("n953", key="name", size=0.75);
// &n953 @WIRE(mode="straight") {#X727:2 %t3699:p};
// %t3700 = $IO_PORT @ATTACH &n952 => @PLACE(466, -1975) => @ORIENT("MY");
// %t3700 @TEXT("n952", key="name", size=0.75);
// &n952 @WIRE(mode="straight") {#X727:3 %t3700:p};
// %t3701 = $SUPPLY @ATTACH &vdd => @PLACE(456, -1964);
// &vdd @WIRE(mode="straight") {#X727:4 %t3701:p};
// %t3702 = $GROUND @ATTACH &vss => @PLACE(456, -1986);
// &vss @WIRE(mode="straight") {#X727:5 %t3702:p};
// %t3703 = $IO_PORT @ATTACH &n924 => @PLACE(326, -2004) => @ORIENT("R0");
// %t3703 @TEXT("n924", key="name", size=0.75);
// &n924 @WIRE(mode="straight") {#X728:1 %t3703:p};
// %t3704 = $IO_PORT @ATTACH &n935 => @PLACE(326, -2008) => @ORIENT("R0");
// %t3704 @TEXT("n935", key="name", size=0.75);
// &n935 @WIRE(mode="straight") {#X728:2 %t3704:p};
// %t3705 = $IO_PORT @ATTACH &n953 => @PLACE(346, -2006) => @ORIENT("MY");
// %t3705 @TEXT("n953", key="name", size=0.75);
// &n953 @WIRE(mode="straight") {#X728:3 %t3705:p};
// %t3706 = $SUPPLY @ATTACH &vdd => @PLACE(336, -1995);
// &vdd @WIRE(mode="straight") {#X728:4 %t3706:p};
// %t3707 = $GROUND @ATTACH &vss => @PLACE(336, -2017);
// &vss @WIRE(mode="straight") {#X728:5 %t3707:p};
// %t3708 = $IO_PORT @ATTACH &dac2 => @PLACE(366, -2004) => @ORIENT("R0");
// %t3708 @TEXT("dac2", key="name", size=0.75);
// &dac2 @WIRE(mode="straight") {#X729:1 %t3708:p};
// %t3709 = $IO_PORT @ATTACH &n356 => @PLACE(366, -2008) => @ORIENT("R0");
// %t3709 @TEXT("n356", key="name", size=0.75);
// &n356 @WIRE(mode="straight") {#X729:2 %t3709:p};
// %t3710 = $IO_PORT @ATTACH &n581 => @PLACE(386, -2006) => @ORIENT("MY");
// %t3710 @TEXT("n581", key="name", size=0.75);
// &n581 @WIRE(mode="straight") {#X729:3 %t3710:p};
// %t3711 = $SUPPLY @ATTACH &vdd => @PLACE(376, -1995);
// &vdd @WIRE(mode="straight") {#X729:4 %t3711:p};
// %t3712 = $GROUND @ATTACH &vss => @PLACE(376, -2017);
// &vss @WIRE(mode="straight") {#X729:5 %t3712:p};
// %t3713 = $IO_PORT @ATTACH &n813 => @PLACE(406, -2004) => @ORIENT("R0");
// %t3713 @TEXT("n813", key="name", size=0.75);
// &n813 @WIRE(mode="straight") {#X730:1 %t3713:p};
// %t3714 = $IO_PORT @ATTACH &n358 => @PLACE(406, -2008) => @ORIENT("R0");
// %t3714 @TEXT("n358", key="name", size=0.75);
// &n358 @WIRE(mode="straight") {#X730:2 %t3714:p};
// %t3715 = $IO_PORT @ATTACH &n377 => @PLACE(426, -2006) => @ORIENT("MY");
// %t3715 @TEXT("n377", key="name", size=0.75);
// &n377 @WIRE(mode="straight") {#X730:3 %t3715:p};
// %t3716 = $SUPPLY @ATTACH &vdd => @PLACE(416, -1995);
// &vdd @WIRE(mode="straight") {#X730:4 %t3716:p};
// %t3717 = $GROUND @ATTACH &vss => @PLACE(416, -2017);
// &vss @WIRE(mode="straight") {#X730:5 %t3717:p};
// %t3718 = $IO_PORT @ATTACH &dac3 => @PLACE(446, -2004) => @ORIENT("R0");
// %t3718 @TEXT("dac3", key="name", size=0.75);
// &dac3 @WIRE(mode="straight") {#X731:1 %t3718:p};
// %t3719 = $IO_PORT @ATTACH &dac2 => @PLACE(446, -2008) => @ORIENT("R0");
// %t3719 @TEXT("dac2", key="name", size=0.75);
// &dac2 @WIRE(mode="straight") {#X731:2 %t3719:p};
// %t3720 = $IO_PORT @ATTACH &n596 => @PLACE(466, -2006) => @ORIENT("MY");
// %t3720 @TEXT("n596", key="name", size=0.75);
// &n596 @WIRE(mode="straight") {#X731:3 %t3720:p};
// %t3721 = $SUPPLY @ATTACH &vdd => @PLACE(456, -1995);
// &vdd @WIRE(mode="straight") {#X731:4 %t3721:p};
// %t3722 = $GROUND @ATTACH &vss => @PLACE(456, -2017);
// &vss @WIRE(mode="straight") {#X731:5 %t3722:p};
// %t3723 = $IO_PORT @ATTACH &dac1 => @PLACE(326, -2035) => @ORIENT("R0");
// %t3723 @TEXT("dac1", key="name", size=0.75);
// &dac1 @WIRE(mode="straight") {#X732:1 %t3723:p};
// %t3724 = $IO_PORT @ATTACH &dac0 => @PLACE(326, -2039) => @ORIENT("R0");
// %t3724 @TEXT("dac0", key="name", size=0.75);
// &dac0 @WIRE(mode="straight") {#X732:2 %t3724:p};
// %t3725 = $IO_PORT @ATTACH &n356 => @PLACE(346, -2037) => @ORIENT("MY");
// %t3725 @TEXT("n356", key="name", size=0.75);
// &n356 @WIRE(mode="straight") {#X732:3 %t3725:p};
// %t3726 = $SUPPLY @ATTACH &vdd => @PLACE(336, -2026);
// &vdd @WIRE(mode="straight") {#X732:4 %t3726:p};
// %t3727 = $GROUND @ATTACH &vss => @PLACE(336, -2048);
// &vss @WIRE(mode="straight") {#X732:5 %t3727:p};
// %t3728 = $IO_PORT @ATTACH &n103 => @PLACE(366, -2035) => @ORIENT("R0");
// %t3728 @TEXT("n103", key="name", size=0.75);
// &n103 @WIRE(mode="straight") {#X733:1 %t3728:p};
// %t3729 = $IO_PORT @ATTACH &n584 => @PLACE(366, -2039) => @ORIENT("R0");
// %t3729 @TEXT("n584", key="name", size=0.75);
// &n584 @WIRE(mode="straight") {#X733:2 %t3729:p};
// %t3730 = $IO_PORT @ATTACH &n586 => @PLACE(386, -2037) => @ORIENT("MY");
// %t3730 @TEXT("n586", key="name", size=0.75);
// &n586 @WIRE(mode="straight") {#X733:3 %t3730:p};
// %t3731 = $SUPPLY @ATTACH &vdd => @PLACE(376, -2026);
// &vdd @WIRE(mode="straight") {#X733:4 %t3731:p};
// %t3732 = $GROUND @ATTACH &vss => @PLACE(376, -2048);
// &vss @WIRE(mode="straight") {#X733:5 %t3732:p};
// %t3733 = $IO_PORT @ATTACH &n107 => @PLACE(406, -2035) => @ORIENT("R0");
// %t3733 @TEXT("n107", key="name", size=0.75);
// &n107 @WIRE(mode="straight") {#X734:1 %t3733:p};
// %t3734 = $IO_PORT @ATTACH &n588 => @PLACE(406, -2039) => @ORIENT("R0");
// %t3734 @TEXT("n588", key="name", size=0.75);
// &n588 @WIRE(mode="straight") {#X734:2 %t3734:p};
// %t3735 = $IO_PORT @ATTACH &n590 => @PLACE(426, -2037) => @ORIENT("MY");
// %t3735 @TEXT("n590", key="name", size=0.75);
// &n590 @WIRE(mode="straight") {#X734:3 %t3735:p};
// %t3736 = $SUPPLY @ATTACH &vdd => @PLACE(416, -2026);
// &vdd @WIRE(mode="straight") {#X734:4 %t3736:p};
// %t3737 = $GROUND @ATTACH &vss => @PLACE(416, -2048);
// &vss @WIRE(mode="straight") {#X734:5 %t3737:p};
// %t3738 = $IO_PORT @ATTACH &n954 => @PLACE(446, -2035) => @ORIENT("R0");
// %t3738 @TEXT("n954", key="name", size=0.75);
// &n954 @WIRE(mode="straight") {#X735:1 %t3738:p};
// %t3739 = $IO_PORT @ATTACH &n588 => @PLACE(446, -2039) => @ORIENT("R0");
// %t3739 @TEXT("n588", key="name", size=0.75);
// &n588 @WIRE(mode="straight") {#X735:2 %t3739:p};
// %t3740 = $IO_PORT @ATTACH &n592 => @PLACE(466, -2037) => @ORIENT("MY");
// %t3740 @TEXT("n592", key="name", size=0.75);
// &n592 @WIRE(mode="straight") {#X735:3 %t3740:p};
// %t3741 = $SUPPLY @ATTACH &vdd => @PLACE(456, -2026);
// &vdd @WIRE(mode="straight") {#X735:4 %t3741:p};
// %t3742 = $GROUND @ATTACH &vss => @PLACE(456, -2048);
// &vss @WIRE(mode="straight") {#X735:5 %t3742:p};
// %t3743 = $IO_PORT @ATTACH &n111 => @PLACE(326, -2066) => @ORIENT("R0");
// %t3743 @TEXT("n111", key="name", size=0.75);
// &n111 @WIRE(mode="straight") {#X736:1 %t3743:p};
// %t3744 = $IO_PORT @ATTACH &n592 => @PLACE(326, -2070) => @ORIENT("R0");
// %t3744 @TEXT("n592", key="name", size=0.75);
// &n592 @WIRE(mode="straight") {#X736:2 %t3744:p};
// %t3745 = $IO_PORT @ATTACH &n594 => @PLACE(346, -2068) => @ORIENT("MY");
// %t3745 @TEXT("n594", key="name", size=0.75);
// &n594 @WIRE(mode="straight") {#X736:3 %t3745:p};
// %t3746 = $SUPPLY @ATTACH &vdd => @PLACE(336, -2057);
// &vdd @WIRE(mode="straight") {#X736:4 %t3746:p};
// %t3747 = $GROUND @ATTACH &vss => @PLACE(336, -2079);
// &vss @WIRE(mode="straight") {#X736:5 %t3747:p};
// %t3748 = $IO_PORT @ATTACH &n955 => @PLACE(366, -2066) => @ORIENT("R0");
// %t3748 @TEXT("n955", key="name", size=0.75);
// &n955 @WIRE(mode="straight") {#X737:1 %t3748:p};
// %t3749 = $IO_PORT @ATTACH &n584 => @PLACE(366, -2070) => @ORIENT("R0");
// %t3749 @TEXT("n584", key="name", size=0.75);
// &n584 @WIRE(mode="straight") {#X737:2 %t3749:p};
// %t3750 = $IO_PORT @ATTACH &n588 => @PLACE(386, -2068) => @ORIENT("MY");
// %t3750 @TEXT("n588", key="name", size=0.75);
// &n588 @WIRE(mode="straight") {#X737:3 %t3750:p};
// %t3751 = $SUPPLY @ATTACH &vdd => @PLACE(376, -2057);
// &vdd @WIRE(mode="straight") {#X737:4 %t3751:p};
// %t3752 = $GROUND @ATTACH &vss => @PLACE(376, -2079);
// &vss @WIRE(mode="straight") {#X737:5 %t3752:p};
// %t3753 = $IO_PORT @ATTACH &n109 => @PLACE(406, -2066) => @ORIENT("R0");
// %t3753 @TEXT("n109", key="name", size=0.75);
// &n109 @WIRE(mode="straight") {#X738:1 %t3753:p};
// %t3754 = $IO_PORT @ATTACH &n107 => @PLACE(406, -2070) => @ORIENT("R0");
// %t3754 @TEXT("n107", key="name", size=0.75);
// &n107 @WIRE(mode="straight") {#X738:2 %t3754:p};
// %t3755 = $IO_PORT @ATTACH &n954 => @PLACE(426, -2068) => @ORIENT("MY");
// %t3755 @TEXT("n954", key="name", size=0.75);
// &n954 @WIRE(mode="straight") {#X738:3 %t3755:p};
// %t3756 = $SUPPLY @ATTACH &vdd => @PLACE(416, -2057);
// &vdd @WIRE(mode="straight") {#X738:4 %t3756:p};
// %t3757 = $GROUND @ATTACH &vss => @PLACE(416, -2079);
// &vss @WIRE(mode="straight") {#X738:5 %t3757:p};
// %t3758 = $IO_PORT @ATTACH &n105 => @PLACE(446, -2066) => @ORIENT("R0");
// %t3758 @TEXT("n105", key="name", size=0.75);
// &n105 @WIRE(mode="straight") {#X739:1 %t3758:p};
// %t3759 = $IO_PORT @ATTACH &n103 => @PLACE(446, -2070) => @ORIENT("R0");
// %t3759 @TEXT("n103", key="name", size=0.75);
// &n103 @WIRE(mode="straight") {#X739:2 %t3759:p};
// %t3760 = $IO_PORT @ATTACH &n955 => @PLACE(466, -2068) => @ORIENT("MY");
// %t3760 @TEXT("n955", key="name", size=0.75);
// &n955 @WIRE(mode="straight") {#X739:3 %t3760:p};
// %t3761 = $SUPPLY @ATTACH &vdd => @PLACE(456, -2057);
// &vdd @WIRE(mode="straight") {#X739:4 %t3761:p};
// %t3762 = $GROUND @ATTACH &vss => @PLACE(456, -2079);
// &vss @WIRE(mode="straight") {#X739:5 %t3762:p};
// %t3763 = $IO_PORT @ATTACH &n101 => @PLACE(326, -2097) => @ORIENT("R0");
// %t3763 @TEXT("n101", key="name", size=0.75);
// &n101 @WIRE(mode="straight") {#X740:1 %t3763:p};
// %t3764 = $IO_PORT @ATTACH &n99 => @PLACE(326, -2101) => @ORIENT("R0");
// %t3764 @TEXT("n99", key="name", size=0.75);
// &n99 @WIRE(mode="straight") {#X740:2 %t3764:p};
// %t3765 = $IO_PORT @ATTACH &n584 => @PLACE(346, -2099) => @ORIENT("MY");
// %t3765 @TEXT("n584", key="name", size=0.75);
// &n584 @WIRE(mode="straight") {#X740:3 %t3765:p};
// %t3766 = $SUPPLY @ATTACH &vdd => @PLACE(336, -2088);
// &vdd @WIRE(mode="straight") {#X740:4 %t3766:p};
// %t3767 = $GROUND @ATTACH &vss => @PLACE(336, -2110);
// &vss @WIRE(mode="straight") {#X740:5 %t3767:p};
// %t3768 = $IO_PORT @ATTACH &n956 => @PLACE(366, -2097) => @ORIENT("R0");
// %t3768 @TEXT("n956", key="name", size=0.75);
// &n956 @WIRE(mode="straight") {#X741:1 %t3768:p};
// %t3769 = $IO_PORT @ATTACH &n957 => @PLACE(366, -2101) => @ORIENT("R0");
// %t3769 @TEXT("n957", key="name", size=0.75);
// &n957 @WIRE(mode="straight") {#X741:2 %t3769:p};
// %t3770 = $IO_PORT @ATTACH &n958 => @PLACE(386, -2099) => @ORIENT("MY");
// %t3770 @TEXT("n958", key="name", size=0.75);
// &n958 @WIRE(mode="straight") {#X741:3 %t3770:p};
// %t3771 = $SUPPLY @ATTACH &vdd => @PLACE(376, -2088);
// &vdd @WIRE(mode="straight") {#X741:4 %t3771:p};
// %t3772 = $GROUND @ATTACH &vss => @PLACE(376, -2110);
// &vss @WIRE(mode="straight") {#X741:5 %t3772:p};
// %t3773 = $IO_PORT @ATTACH &n956 => @PLACE(406, -2097) => @ORIENT("R0");
// %t3773 @TEXT("n956", key="name", size=0.75);
// &n956 @WIRE(mode="straight") {#X742:1 %t3773:p};
// %t3774 = $IO_PORT @ATTACH &n237 => @PLACE(406, -2101) => @ORIENT("R0");
// %t3774 @TEXT("n237", key="name", size=0.75);
// &n237 @WIRE(mode="straight") {#X742:2 %t3774:p};
// %t3775 = $IO_PORT @ATTACH &n959 => @PLACE(426, -2099) => @ORIENT("MY");
// %t3775 @TEXT("n959", key="name", size=0.75);
// &n959 @WIRE(mode="straight") {#X742:3 %t3775:p};
// %t3776 = $SUPPLY @ATTACH &vdd => @PLACE(416, -2088);
// &vdd @WIRE(mode="straight") {#X742:4 %t3776:p};
// %t3777 = $GROUND @ATTACH &vss => @PLACE(416, -2110);
// &vss @WIRE(mode="straight") {#X742:5 %t3777:p};
// %t3778 = $IO_PORT @ATTACH &n956 => @PLACE(446, -2097) => @ORIENT("R0");
// %t3778 @TEXT("n956", key="name", size=0.75);
// &n956 @WIRE(mode="straight") {#X743:1 %t3778:p};
// %t3779 = $IO_PORT @ATTACH &n960 => @PLACE(446, -2101) => @ORIENT("R0");
// %t3779 @TEXT("n960", key="name", size=0.75);
// &n960 @WIRE(mode="straight") {#X743:2 %t3779:p};
// %t3780 = $IO_PORT @ATTACH &n961 => @PLACE(466, -2099) => @ORIENT("MY");
// %t3780 @TEXT("n961", key="name", size=0.75);
// &n961 @WIRE(mode="straight") {#X743:3 %t3780:p};
// %t3781 = $SUPPLY @ATTACH &vdd => @PLACE(456, -2088);
// &vdd @WIRE(mode="straight") {#X743:4 %t3781:p};
// %t3782 = $GROUND @ATTACH &vss => @PLACE(456, -2110);
// &vss @WIRE(mode="straight") {#X743:5 %t3782:p};
// %t3783 = $IO_PORT @ATTACH &n242 => @PLACE(494, -1942) => @ORIENT("R0");
// %t3783 @TEXT("n242", key="name", size=0.75);
// &n242 @WIRE(mode="straight") {#X744:1 %t3783:p};
// %t3784 = $IO_PORT @ATTACH &n265 => @PLACE(494, -1946) => @ORIENT("R0");
// %t3784 @TEXT("n265", key="name", size=0.75);
// &n265 @WIRE(mode="straight") {#X744:2 %t3784:p};
// %t3785 = $IO_PORT @ATTACH &n962 => @PLACE(514, -1944) => @ORIENT("MY");
// %t3785 @TEXT("n962", key="name", size=0.75);
// &n962 @WIRE(mode="straight") {#X744:3 %t3785:p};
// %t3786 = $SUPPLY @ATTACH &vdd => @PLACE(504, -1933);
// &vdd @WIRE(mode="straight") {#X744:4 %t3786:p};
// %t3787 = $GROUND @ATTACH &vss => @PLACE(504, -1955);
// &vss @WIRE(mode="straight") {#X744:5 %t3787:p};
// %t3788 = $IO_PORT @ATTACH &n231 => @PLACE(534, -1942) => @ORIENT("R0");
// %t3788 @TEXT("n231", key="name", size=0.75);
// &n231 @WIRE(mode="straight") {#X745:1 %t3788:p};
// %t3789 = $IO_PORT @ATTACH &n238 => @PLACE(534, -1946) => @ORIENT("R0");
// %t3789 @TEXT("n238", key="name", size=0.75);
// &n238 @WIRE(mode="straight") {#X745:2 %t3789:p};
// %t3790 = $IO_PORT @ATTACH &n963 => @PLACE(554, -1944) => @ORIENT("MY");
// %t3790 @TEXT("n963", key="name", size=0.75);
// &n963 @WIRE(mode="straight") {#X745:3 %t3790:p};
// %t3791 = $SUPPLY @ATTACH &vdd => @PLACE(544, -1933);
// &vdd @WIRE(mode="straight") {#X745:4 %t3791:p};
// %t3792 = $GROUND @ATTACH &vss => @PLACE(544, -1955);
// &vss @WIRE(mode="straight") {#X745:5 %t3792:p};
// %t3793 = $IO_PORT @ATTACH &n962 => @PLACE(574, -1942) => @ORIENT("R0");
// %t3793 @TEXT("n962", key="name", size=0.75);
// &n962 @WIRE(mode="straight") {#X746:1 %t3793:p};
// %t3794 = $IO_PORT @ATTACH &n963 => @PLACE(574, -1946) => @ORIENT("R0");
// %t3794 @TEXT("n963", key="name", size=0.75);
// &n963 @WIRE(mode="straight") {#X746:2 %t3794:p};
// %t3795 = $IO_PORT @ATTACH &n956 => @PLACE(594, -1944) => @ORIENT("MY");
// %t3795 @TEXT("n956", key="name", size=0.75);
// &n956 @WIRE(mode="straight") {#X746:3 %t3795:p};
// %t3796 = $SUPPLY @ATTACH &vdd => @PLACE(584, -1933);
// &vdd @WIRE(mode="straight") {#X746:4 %t3796:p};
// %t3797 = $GROUND @ATTACH &vss => @PLACE(584, -1955);
// &vss @WIRE(mode="straight") {#X746:5 %t3797:p};
// %t3798 = $IO_PORT @ATTACH &n956 => @PLACE(614, -1942) => @ORIENT("R0");
// %t3798 @TEXT("n956", key="name", size=0.75);
// &n956 @WIRE(mode="straight") {#X747:1 %t3798:p};
// %t3799 = $IO_PORT @ATTACH &n235 => @PLACE(614, -1946) => @ORIENT("R0");
// %t3799 @TEXT("n235", key="name", size=0.75);
// &n235 @WIRE(mode="straight") {#X747:2 %t3799:p};
// %t3800 = $IO_PORT @ATTACH &n964 => @PLACE(635, -1944) => @ORIENT("MY");
// %t3800 @TEXT("n964", key="name", size=0.75);
// &n964 @WIRE(mode="straight") {#X747:3 %t3800:p};
// %t3801 = $SUPPLY @ATTACH &vdd => @PLACE(624, -1933);
// &vdd @WIRE(mode="straight") {#X747:4 %t3801:p};
// %t3802 = $GROUND @ATTACH &vss => @PLACE(624, -1955);
// &vss @WIRE(mode="straight") {#X747:5 %t3802:p};
// %t3803 = $IO_PORT @ATTACH &n117 => @PLACE(494, -1973) => @ORIENT("R0");
// %t3803 @TEXT("n117", key="name", size=0.75);
// &n117 @WIRE(mode="straight") {#X748:1 %t3803:p};
// %t3804 = $IO_PORT @ATTACH &n265 => @PLACE(494, -1977) => @ORIENT("R0");
// %t3804 @TEXT("n265", key="name", size=0.75);
// &n265 @WIRE(mode="straight") {#X748:2 %t3804:p};
// %t3805 = $IO_PORT @ATTACH &n965 => @PLACE(514, -1975) => @ORIENT("MY");
// %t3805 @TEXT("n965", key="name", size=0.75);
// &n965 @WIRE(mode="straight") {#X748:3 %t3805:p};
// %t3806 = $SUPPLY @ATTACH &vdd => @PLACE(504, -1964);
// &vdd @WIRE(mode="straight") {#X748:4 %t3806:p};
// %t3807 = $GROUND @ATTACH &vss => @PLACE(504, -1986);
// &vss @WIRE(mode="straight") {#X748:5 %t3807:p};
// %t3808 = $IO_PORT @ATTACH &n965 => @PLACE(534, -1973) => @ORIENT("R0");
// %t3808 @TEXT("n965", key="name", size=0.75);
// &n965 @WIRE(mode="straight") {#X749:1 %t3808:p};
// %t3809 = $IO_PORT @ATTACH &n966 => @PLACE(534, -1977) => @ORIENT("R0");
// %t3809 @TEXT("n966", key="name", size=0.75);
// &n966 @WIRE(mode="straight") {#X749:2 %t3809:p};
// %t3810 = $IO_PORT @ATTACH &n967 => @PLACE(554, -1975) => @ORIENT("MY");
// %t3810 @TEXT("n967", key="name", size=0.75);
// &n967 @WIRE(mode="straight") {#X749:3 %t3810:p};
// %t3811 = $SUPPLY @ATTACH &vdd => @PLACE(544, -1964);
// &vdd @WIRE(mode="straight") {#X749:4 %t3811:p};
// %t3812 = $GROUND @ATTACH &vss => @PLACE(544, -1986);
// &vss @WIRE(mode="straight") {#X749:5 %t3812:p};
// %t3813 = $IO_PORT @ATTACH &n233 => @PLACE(574, -1973) => @ORIENT("R0");
// %t3813 @TEXT("n233", key="name", size=0.75);
// &n233 @WIRE(mode="straight") {#X750:1 %t3813:p};
// %t3814 = $IO_PORT @ATTACH &n117 => @PLACE(574, -1977) => @ORIENT("R0");
// %t3814 @TEXT("n117", key="name", size=0.75);
// &n117 @WIRE(mode="straight") {#X750:2 %t3814:p};
// %t3815 = $IO_PORT @ATTACH &n968 => @PLACE(594, -1975) => @ORIENT("MY");
// %t3815 @TEXT("n968", key="name", size=0.75);
// &n968 @WIRE(mode="straight") {#X750:3 %t3815:p};
// %t3816 = $SUPPLY @ATTACH &vdd => @PLACE(584, -1964);
// &vdd @WIRE(mode="straight") {#X750:4 %t3816:p};
// %t3817 = $GROUND @ATTACH &vss => @PLACE(584, -1986);
// &vss @WIRE(mode="straight") {#X750:5 %t3817:p};
// %t3818 = $IO_PORT @ATTACH &n238 => @PLACE(614, -1973) => @ORIENT("R0");
// %t3818 @TEXT("n238", key="name", size=0.75);
// &n238 @WIRE(mode="straight") {#X751:1 %t3818:p};
// %t3819 = $IO_PORT @ATTACH &n184 => @PLACE(614, -1977) => @ORIENT("R0");
// %t3819 @TEXT("n184", key="name", size=0.75);
// &n184 @WIRE(mode="straight") {#X751:2 %t3819:p};
// %t3820 = $IO_PORT @ATTACH &n969 => @PLACE(635, -1975) => @ORIENT("MY");
// %t3820 @TEXT("n969", key="name", size=0.75);
// &n969 @WIRE(mode="straight") {#X751:3 %t3820:p};
// %t3821 = $SUPPLY @ATTACH &vdd => @PLACE(624, -1964);
// &vdd @WIRE(mode="straight") {#X751:4 %t3821:p};
// %t3822 = $GROUND @ATTACH &vss => @PLACE(624, -1986);
// &vss @WIRE(mode="straight") {#X751:5 %t3822:p};
// %t3823 = $IO_PORT @ATTACH &n968 => @PLACE(494, -2004) => @ORIENT("R0");
// %t3823 @TEXT("n968", key="name", size=0.75);
// &n968 @WIRE(mode="straight") {#X752:1 %t3823:p};
// %t3824 = $IO_PORT @ATTACH &n970 => @PLACE(494, -2008) => @ORIENT("R0");
// %t3824 @TEXT("n970", key="name", size=0.75);
// &n970 @WIRE(mode="straight") {#X752:2 %t3824:p};
// %t3825 = $IO_PORT @ATTACH &n971 => @PLACE(514, -2006) => @ORIENT("MY");
// %t3825 @TEXT("n971", key="name", size=0.75);
// &n971 @WIRE(mode="straight") {#X752:3 %t3825:p};
// %t3826 = $SUPPLY @ATTACH &vdd => @PLACE(504, -1995);
// &vdd @WIRE(mode="straight") {#X752:4 %t3826:p};
// %t3827 = $GROUND @ATTACH &vss => @PLACE(504, -2017);
// &vss @WIRE(mode="straight") {#X752:5 %t3827:p};
// %t3828 = $IO_PORT @ATTACH &n971 => @PLACE(534, -2004) => @ORIENT("R0");
// %t3828 @TEXT("n971", key="name", size=0.75);
// &n971 @WIRE(mode="straight") {#X753:1 %t3828:p};
// %t3829 = $IO_PORT @ATTACH &n969 => @PLACE(534, -2008) => @ORIENT("R0");
// %t3829 @TEXT("n969", key="name", size=0.75);
// &n969 @WIRE(mode="straight") {#X753:2 %t3829:p};
// %t3830 = $IO_PORT @ATTACH &n187 => @PLACE(554, -2006) => @ORIENT("MY");
// %t3830 @TEXT("n187", key="name", size=0.75);
// &n187 @WIRE(mode="straight") {#X753:3 %t3830:p};
// %t3831 = $SUPPLY @ATTACH &vdd => @PLACE(544, -1995);
// &vdd @WIRE(mode="straight") {#X753:4 %t3831:p};
// %t3832 = $GROUND @ATTACH &vss => @PLACE(544, -2017);
// &vss @WIRE(mode="straight") {#X753:5 %t3832:p};
// %t3833 = $IO_PORT @ATTACH &n972 => @PLACE(574, -2004) => @ORIENT("R0");
// %t3833 @TEXT("n972", key="name", size=0.75);
// &n972 @WIRE(mode="straight") {#X754:1 %t3833:p};
// %t3834 = $IO_PORT @ATTACH &n973 => @PLACE(574, -2008) => @ORIENT("R0");
// %t3834 @TEXT("n973", key="name", size=0.75);
// &n973 @WIRE(mode="straight") {#X754:2 %t3834:p};
// %t3835 = $IO_PORT @ATTACH &n974 => @PLACE(594, -2006) => @ORIENT("MY");
// %t3835 @TEXT("n974", key="name", size=0.75);
// &n974 @WIRE(mode="straight") {#X754:3 %t3835:p};
// %t3836 = $SUPPLY @ATTACH &vdd => @PLACE(584, -1995);
// &vdd @WIRE(mode="straight") {#X754:4 %t3836:p};
// %t3837 = $GROUND @ATTACH &vss => @PLACE(584, -2017);
// &vss @WIRE(mode="straight") {#X754:5 %t3837:p};
// %t3838 = $IO_PORT @ATTACH &n974 => @PLACE(614, -2004) => @ORIENT("R0");
// %t3838 @TEXT("n974", key="name", size=0.75);
// &n974 @WIRE(mode="straight") {#X755:1 %t3838:p};
// %t3839 = $IO_PORT @ATTACH &n184 => @PLACE(614, -2008) => @ORIENT("R0");
// %t3839 @TEXT("n184", key="name", size=0.75);
// &n184 @WIRE(mode="straight") {#X755:2 %t3839:p};
// %t3840 = $IO_PORT @ATTACH &n151 => @PLACE(635, -2006) => @ORIENT("MY");
// %t3840 @TEXT("n151", key="name", size=0.75);
// &n151 @WIRE(mode="straight") {#X755:3 %t3840:p};
// %t3841 = $SUPPLY @ATTACH &vdd => @PLACE(624, -1995);
// &vdd @WIRE(mode="straight") {#X755:4 %t3841:p};
// %t3842 = $GROUND @ATTACH &vss => @PLACE(624, -2017);
// &vss @WIRE(mode="straight") {#X755:5 %t3842:p};
// %t3843 = $IO_PORT @ATTACH &n966 => @PLACE(494, -2035) => @ORIENT("R0");
// %t3843 @TEXT("n966", key="name", size=0.75);
// &n966 @WIRE(mode="straight") {#X756:1 %t3843:p};
// %t3844 = $IO_PORT @ATTACH &n242 => @PLACE(494, -2039) => @ORIENT("R0");
// %t3844 @TEXT("n242", key="name", size=0.75);
// &n242 @WIRE(mode="straight") {#X756:2 %t3844:p};
// %t3845 = $IO_PORT @ATTACH &n975 => @PLACE(514, -2037) => @ORIENT("MY");
// %t3845 @TEXT("n975", key="name", size=0.75);
// &n975 @WIRE(mode="straight") {#X756:3 %t3845:p};
// %t3846 = $SUPPLY @ATTACH &vdd => @PLACE(504, -2026);
// &vdd @WIRE(mode="straight") {#X756:4 %t3846:p};
// %t3847 = $GROUND @ATTACH &vss => @PLACE(504, -2048);
// &vss @WIRE(mode="straight") {#X756:5 %t3847:p};
// %t3848 = $IO_PORT @ATTACH &n265 => @PLACE(534, -2035) => @ORIENT("R0");
// %t3848 @TEXT("n265", key="name", size=0.75);
// &n265 @WIRE(mode="straight") {#X757:1 %t3848:p};
// %t3849 = $IO_PORT @ATTACH &n88 => @PLACE(534, -2039) => @ORIENT("R0");
// %t3849 @TEXT("n88", key="name", size=0.75);
// &n88 @WIRE(mode="straight") {#X757:2 %t3849:p};
// %t3850 = $IO_PORT @ATTACH &n976 => @PLACE(554, -2037) => @ORIENT("MY");
// %t3850 @TEXT("n976", key="name", size=0.75);
// &n976 @WIRE(mode="straight") {#X757:3 %t3850:p};
// %t3851 = $SUPPLY @ATTACH &vdd => @PLACE(544, -2026);
// &vdd @WIRE(mode="straight") {#X757:4 %t3851:p};
// %t3852 = $GROUND @ATTACH &vss => @PLACE(544, -2048);
// &vss @WIRE(mode="straight") {#X757:5 %t3852:p};
// %t3853 = $IO_PORT @ATTACH &n975 => @PLACE(574, -2035) => @ORIENT("R0");
// %t3853 @TEXT("n975", key="name", size=0.75);
// &n975 @WIRE(mode="straight") {#X758:1 %t3853:p};
// %t3854 = $IO_PORT @ATTACH &n976 => @PLACE(574, -2039) => @ORIENT("R0");
// %t3854 @TEXT("n976", key="name", size=0.75);
// &n976 @WIRE(mode="straight") {#X758:2 %t3854:p};
// %t3855 = $IO_PORT @ATTACH &n977 => @PLACE(594, -2037) => @ORIENT("MY");
// %t3855 @TEXT("n977", key="name", size=0.75);
// &n977 @WIRE(mode="straight") {#X758:3 %t3855:p};
// %t3856 = $SUPPLY @ATTACH &vdd => @PLACE(584, -2026);
// &vdd @WIRE(mode="straight") {#X758:4 %t3856:p};
// %t3857 = $GROUND @ATTACH &vss => @PLACE(584, -2048);
// &vss @WIRE(mode="straight") {#X758:5 %t3857:p};
// %t3858 = $IO_PORT @ATTACH &n977 => @PLACE(614, -2035) => @ORIENT("R0");
// %t3858 @TEXT("n977", key="name", size=0.75);
// &n977 @WIRE(mode="straight") {#X759:1 %t3858:p};
// %t3859 = $IO_PORT @ATTACH &n978 => @PLACE(614, -2039) => @ORIENT("R0");
// %t3859 @TEXT("n978", key="name", size=0.75);
// &n978 @WIRE(mode="straight") {#X759:2 %t3859:p};
// %t3860 = $IO_PORT @ATTACH &n979 => @PLACE(635, -2037) => @ORIENT("MY");
// %t3860 @TEXT("n979", key="name", size=0.75);
// &n979 @WIRE(mode="straight") {#X759:3 %t3860:p};
// %t3861 = $SUPPLY @ATTACH &vdd => @PLACE(624, -2026);
// &vdd @WIRE(mode="straight") {#X759:4 %t3861:p};
// %t3862 = $GROUND @ATTACH &vss => @PLACE(624, -2048);
// &vss @WIRE(mode="straight") {#X759:5 %t3862:p};
// %t3863 = $IO_PORT @ATTACH &n979 => @PLACE(494, -2066) => @ORIENT("R0");
// %t3863 @TEXT("n979", key="name", size=0.75);
// &n979 @WIRE(mode="straight") {#X760:1 %t3863:p};
// %t3864 = $IO_PORT @ATTACH &n159 => @PLACE(494, -2070) => @ORIENT("R0");
// %t3864 @TEXT("n159", key="name", size=0.75);
// &n159 @WIRE(mode="straight") {#X760:2 %t3864:p};
// %t3865 = $IO_PORT @ATTACH &n183 => @PLACE(514, -2068) => @ORIENT("MY");
// %t3865 @TEXT("n183", key="name", size=0.75);
// &n183 @WIRE(mode="straight") {#X760:3 %t3865:p};
// %t3866 = $SUPPLY @ATTACH &vdd => @PLACE(504, -2057);
// &vdd @WIRE(mode="straight") {#X760:4 %t3866:p};
// %t3867 = $GROUND @ATTACH &vss => @PLACE(504, -2079);
// &vss @WIRE(mode="straight") {#X760:5 %t3867:p};
// %t3868 = $IO_PORT @ATTACH &n962 => @PLACE(534, -2066) => @ORIENT("R0");
// %t3868 @TEXT("n962", key="name", size=0.75);
// &n962 @WIRE(mode="straight") {#X761:1 %t3868:p};
// %t3869 = $IO_PORT @ATTACH &n980 => @PLACE(534, -2070) => @ORIENT("R0");
// %t3869 @TEXT("n980", key="name", size=0.75);
// &n980 @WIRE(mode="straight") {#X761:2 %t3869:p};
// %t3870 = $IO_PORT @ATTACH &n972 => @PLACE(554, -2068) => @ORIENT("MY");
// %t3870 @TEXT("n972", key="name", size=0.75);
// &n972 @WIRE(mode="straight") {#X761:3 %t3870:p};
// %t3871 = $SUPPLY @ATTACH &vdd => @PLACE(544, -2057);
// &vdd @WIRE(mode="straight") {#X761:4 %t3871:p};
// %t3872 = $GROUND @ATTACH &vss => @PLACE(544, -2079);
// &vss @WIRE(mode="straight") {#X761:5 %t3872:p};
// %t3873 = $IO_PORT @ATTACH &n962 => @PLACE(574, -2066) => @ORIENT("R0");
// %t3873 @TEXT("n962", key="name", size=0.75);
// &n962 @WIRE(mode="straight") {#X762:1 %t3873:p};
// %t3874 = $IO_PORT @ATTACH &n231 => @PLACE(574, -2070) => @ORIENT("R0");
// %t3874 @TEXT("n231", key="name", size=0.75);
// &n231 @WIRE(mode="straight") {#X762:2 %t3874:p};
// %t3875 = $IO_PORT @ATTACH &n973 => @PLACE(594, -2068) => @ORIENT("MY");
// %t3875 @TEXT("n973", key="name", size=0.75);
// &n973 @WIRE(mode="straight") {#X762:3 %t3875:p};
// %t3876 = $SUPPLY @ATTACH &vdd => @PLACE(584, -2057);
// &vdd @WIRE(mode="straight") {#X762:4 %t3876:p};
// %t3877 = $GROUND @ATTACH &vss => @PLACE(584, -2079);
// &vss @WIRE(mode="straight") {#X762:5 %t3877:p};
// %t3878 = $IO_PORT @ATTACH &n981 => @PLACE(614, -2066) => @ORIENT("R0");
// %t3878 @TEXT("n981", key="name", size=0.75);
// &n981 @WIRE(mode="straight") {#X763:1 %t3878:p};
// %t3879 = $IO_PORT @ATTACH &n982 => @PLACE(614, -2070) => @ORIENT("R0");
// %t3879 @TEXT("n982", key="name", size=0.75);
// &n982 @WIRE(mode="straight") {#X763:2 %t3879:p};
// %t3880 = $IO_PORT @ATTACH &n983 => @PLACE(635, -2068) => @ORIENT("MY");
// %t3880 @TEXT("n983", key="name", size=0.75);
// &n983 @WIRE(mode="straight") {#X763:3 %t3880:p};
// %t3881 = $SUPPLY @ATTACH &vdd => @PLACE(624, -2057);
// &vdd @WIRE(mode="straight") {#X763:4 %t3881:p};
// %t3882 = $GROUND @ATTACH &vss => @PLACE(624, -2079);
// &vss @WIRE(mode="straight") {#X763:5 %t3882:p};
// %t3883 = $IO_PORT @ATTACH &n984 => @PLACE(494, -2097) => @ORIENT("R0");
// %t3883 @TEXT("n984", key="name", size=0.75);
// &n984 @WIRE(mode="straight") {#X764:1 %t3883:p};
// %t3884 = $IO_PORT @ATTACH &n985 => @PLACE(494, -2101) => @ORIENT("R0");
// %t3884 @TEXT("n985", key="name", size=0.75);
// &n985 @WIRE(mode="straight") {#X764:2 %t3884:p};
// %t3885 = $IO_PORT @ATTACH &n986 => @PLACE(514, -2099) => @ORIENT("MY");
// %t3885 @TEXT("n986", key="name", size=0.75);
// &n986 @WIRE(mode="straight") {#X764:3 %t3885:p};
// %t3886 = $SUPPLY @ATTACH &vdd => @PLACE(504, -2088);
// &vdd @WIRE(mode="straight") {#X764:4 %t3886:p};
// %t3887 = $GROUND @ATTACH &vss => @PLACE(504, -2110);
// &vss @WIRE(mode="straight") {#X764:5 %t3887:p};
// %t3888 = $IO_PORT @ATTACH &n987 => @PLACE(534, -2097) => @ORIENT("R0");
// %t3888 @TEXT("n987", key="name", size=0.75);
// &n987 @WIRE(mode="straight") {#X765:1 %t3888:p};
// %t3889 = $IO_PORT @ATTACH &n988 => @PLACE(534, -2101) => @ORIENT("R0");
// %t3889 @TEXT("n988", key="name", size=0.75);
// &n988 @WIRE(mode="straight") {#X765:2 %t3889:p};
// %t3890 = $IO_PORT @ATTACH &n989 => @PLACE(554, -2099) => @ORIENT("MY");
// %t3890 @TEXT("n989", key="name", size=0.75);
// &n989 @WIRE(mode="straight") {#X765:3 %t3890:p};
// %t3891 = $SUPPLY @ATTACH &vdd => @PLACE(544, -2088);
// &vdd @WIRE(mode="straight") {#X765:4 %t3891:p};
// %t3892 = $GROUND @ATTACH &vss => @PLACE(544, -2110);
// &vss @WIRE(mode="straight") {#X765:5 %t3892:p};
// %t3893 = $IO_PORT @ATTACH &n990 => @PLACE(574, -2097) => @ORIENT("R0");
// %t3893 @TEXT("n990", key="name", size=0.75);
// &n990 @WIRE(mode="straight") {#X766:1 %t3893:p};
// %t3894 = $IO_PORT @ATTACH &n991 => @PLACE(574, -2101) => @ORIENT("R0");
// %t3894 @TEXT("n991", key="name", size=0.75);
// &n991 @WIRE(mode="straight") {#X766:2 %t3894:p};
// %t3895 = $IO_PORT @ATTACH &n992 => @PLACE(594, -2099) => @ORIENT("MY");
// %t3895 @TEXT("n992", key="name", size=0.75);
// &n992 @WIRE(mode="straight") {#X766:3 %t3895:p};
// %t3896 = $SUPPLY @ATTACH &vdd => @PLACE(584, -2088);
// &vdd @WIRE(mode="straight") {#X766:4 %t3896:p};
// %t3897 = $GROUND @ATTACH &vss => @PLACE(584, -2110);
// &vss @WIRE(mode="straight") {#X766:5 %t3897:p};
// %t3898 = $IO_PORT @ATTACH &n993 => @PLACE(614, -2097) => @ORIENT("R0");
// %t3898 @TEXT("n993", key="name", size=0.75);
// &n993 @WIRE(mode="straight") {#X767:1 %t3898:p};
// %t3899 = $IO_PORT @ATTACH &n994 => @PLACE(614, -2101) => @ORIENT("R0");
// %t3899 @TEXT("n994", key="name", size=0.75);
// &n994 @WIRE(mode="straight") {#X767:2 %t3899:p};
// %t3900 = $IO_PORT @ATTACH &n995 => @PLACE(635, -2099) => @ORIENT("MY");
// %t3900 @TEXT("n995", key="name", size=0.75);
// &n995 @WIRE(mode="straight") {#X767:3 %t3900:p};
// %t3901 = $SUPPLY @ATTACH &vdd => @PLACE(624, -2088);
// &vdd @WIRE(mode="straight") {#X767:4 %t3901:p};
// %t3902 = $GROUND @ATTACH &vss => @PLACE(624, -2110);
// &vss @WIRE(mode="straight") {#X767:5 %t3902:p};
// %t3903 = $IO_PORT @ATTACH &n983 => @PLACE(-11, -2140) => @ORIENT("R0");
// %t3903 @TEXT("n983", key="name", size=0.75);
// &n983 @WIRE(mode="straight") {#X768:1 %t3903:p};
// %t3904 = $IO_PORT @ATTACH &n986 => @PLACE(-11, -2144) => @ORIENT("R0");
// %t3904 @TEXT("n986", key="name", size=0.75);
// &n986 @WIRE(mode="straight") {#X768:2 %t3904:p};
// %t3905 = $IO_PORT @ATTACH &n996 => @PLACE(10, -2142) => @ORIENT("MY");
// %t3905 @TEXT("n996", key="name", size=0.75);
// &n996 @WIRE(mode="straight") {#X768:3 %t3905:p};
// %t3906 = $SUPPLY @ATTACH &vdd => @PLACE(0, -2131);
// &vdd @WIRE(mode="straight") {#X768:4 %t3906:p};
// %t3907 = $GROUND @ATTACH &vss => @PLACE(0, -2153);
// &vss @WIRE(mode="straight") {#X768:5 %t3907:p};
// %t3908 = $IO_PORT @ATTACH &n989 => @PLACE(30, -2140) => @ORIENT("R0");
// %t3908 @TEXT("n989", key="name", size=0.75);
// &n989 @WIRE(mode="straight") {#X769:1 %t3908:p};
// %t3909 = $IO_PORT @ATTACH &n992 => @PLACE(30, -2144) => @ORIENT("R0");
// %t3909 @TEXT("n992", key="name", size=0.75);
// &n992 @WIRE(mode="straight") {#X769:2 %t3909:p};
// %t3910 = $IO_PORT @ATTACH &n997 => @PLACE(50, -2142) => @ORIENT("MY");
// %t3910 @TEXT("n997", key="name", size=0.75);
// &n997 @WIRE(mode="straight") {#X769:3 %t3910:p};
// %t3911 = $SUPPLY @ATTACH &vdd => @PLACE(40, -2131);
// &vdd @WIRE(mode="straight") {#X769:4 %t3911:p};
// %t3912 = $GROUND @ATTACH &vss => @PLACE(40, -2153);
// &vss @WIRE(mode="straight") {#X769:5 %t3912:p};
// %t3913 = $IO_PORT @ATTACH &n996 => @PLACE(70, -2140) => @ORIENT("R0");
// %t3913 @TEXT("n996", key="name", size=0.75);
// &n996 @WIRE(mode="straight") {#X770:1 %t3913:p};
// %t3914 = $IO_PORT @ATTACH &n997 => @PLACE(70, -2144) => @ORIENT("R0");
// %t3914 @TEXT("n997", key="name", size=0.75);
// &n997 @WIRE(mode="straight") {#X770:2 %t3914:p};
// %t3915 = $IO_PORT @ATTACH &n998 => @PLACE(90, -2142) => @ORIENT("MY");
// %t3915 @TEXT("n998", key="name", size=0.75);
// &n998 @WIRE(mode="straight") {#X770:3 %t3915:p};
// %t3916 = $SUPPLY @ATTACH &vdd => @PLACE(80, -2131);
// &vdd @WIRE(mode="straight") {#X770:4 %t3916:p};
// %t3917 = $GROUND @ATTACH &vss => @PLACE(80, -2153);
// &vss @WIRE(mode="straight") {#X770:5 %t3917:p};
// %t3918 = $IO_PORT @ATTACH &n998 => @PLACE(110, -2140) => @ORIENT("R0");
// %t3918 @TEXT("n998", key="name", size=0.75);
// &n998 @WIRE(mode="straight") {#X771:1 %t3918:p};
// %t3919 = $IO_PORT @ATTACH &n995 => @PLACE(110, -2144) => @ORIENT("R0");
// %t3919 @TEXT("n995", key="name", size=0.75);
// &n995 @WIRE(mode="straight") {#X771:2 %t3919:p};
// %t3920 = $IO_PORT @ATTACH &n192 => @PLACE(130, -2142) => @ORIENT("MY");
// %t3920 @TEXT("n192", key="name", size=0.75);
// &n192 @WIRE(mode="straight") {#X771:3 %t3920:p};
// %t3921 = $SUPPLY @ATTACH &vdd => @PLACE(120, -2131);
// &vdd @WIRE(mode="straight") {#X771:4 %t3921:p};
// %t3922 = $GROUND @ATTACH &vss => @PLACE(120, -2153);
// &vss @WIRE(mode="straight") {#X771:5 %t3922:p};
// %t3923 = $IO_PORT @ATTACH &n999 => @PLACE(-11, -2171) => @ORIENT("R0");
// %t3923 @TEXT("n999", key="name", size=0.75);
// &n999 @WIRE(mode="straight") {#X772:1 %t3923:p};
// %t3924 = $IO_PORT @ATTACH &n1000 => @PLACE(-11, -2175) => @ORIENT("R0");
// %t3924 @TEXT("n1000", key="name", size=0.75);
// &n1000 @WIRE(mode="straight") {#X772:2 %t3924:p};
// %t3925 = $IO_PORT @ATTACH &n994 => @PLACE(10, -2173) => @ORIENT("MY");
// %t3925 @TEXT("n994", key="name", size=0.75);
// &n994 @WIRE(mode="straight") {#X772:3 %t3925:p};
// %t3926 = $SUPPLY @ATTACH &vdd => @PLACE(0, -2162);
// &vdd @WIRE(mode="straight") {#X772:4 %t3926:p};
// %t3927 = $GROUND @ATTACH &vss => @PLACE(0, -2184);
// &vss @WIRE(mode="straight") {#X772:5 %t3927:p};
// %t3928 = $IO_PORT @ATTACH &n1001 => @PLACE(30, -2171) => @ORIENT("R0");
// %t3928 @TEXT("n1001", key="name", size=0.75);
// &n1001 @WIRE(mode="straight") {#X773:1 %t3928:p};
// %t3929 = $IO_PORT @ATTACH &n1002 => @PLACE(30, -2175) => @ORIENT("R0");
// %t3929 @TEXT("n1002", key="name", size=0.75);
// &n1002 @WIRE(mode="straight") {#X773:2 %t3929:p};
// %t3930 = $IO_PORT @ATTACH &n982 => @PLACE(50, -2173) => @ORIENT("MY");
// %t3930 @TEXT("n982", key="name", size=0.75);
// &n982 @WIRE(mode="straight") {#X773:3 %t3930:p};
// %t3931 = $SUPPLY @ATTACH &vdd => @PLACE(40, -2162);
// &vdd @WIRE(mode="straight") {#X773:4 %t3931:p};
// %t3932 = $GROUND @ATTACH &vss => @PLACE(40, -2184);
// &vss @WIRE(mode="straight") {#X773:5 %t3932:p};
// %t3933 = $IO_PORT @ATTACH &n351 => @PLACE(70, -2171) => @ORIENT("R0");
// %t3933 @TEXT("n351", key="name", size=0.75);
// &n351 @WIRE(mode="straight") {#X774:1 %t3933:p};
// %t3934 = $IO_PORT @ATTACH &n243 => @PLACE(70, -2175) => @ORIENT("R0");
// %t3934 @TEXT("n243", key="name", size=0.75);
// &n243 @WIRE(mode="straight") {#X774:2 %t3934:p};
// %t3935 = $IO_PORT @ATTACH &n1003 => @PLACE(90, -2173) => @ORIENT("MY");
// %t3935 @TEXT("n1003", key="name", size=0.75);
// &n1003 @WIRE(mode="straight") {#X774:3 %t3935:p};
// %t3936 = $SUPPLY @ATTACH &vdd => @PLACE(80, -2162);
// &vdd @WIRE(mode="straight") {#X774:4 %t3936:p};
// %t3937 = $GROUND @ATTACH &vss => @PLACE(80, -2184);
// &vss @WIRE(mode="straight") {#X774:5 %t3937:p};
// %t3938 = $IO_PORT @ATTACH &n1004 => @PLACE(110, -2171) => @ORIENT("R0");
// %t3938 @TEXT("n1004", key="name", size=0.75);
// &n1004 @WIRE(mode="straight") {#X775:1 %t3938:p};
// %t3939 = $IO_PORT @ATTACH &n1002 => @PLACE(110, -2175) => @ORIENT("R0");
// %t3939 @TEXT("n1002", key="name", size=0.75);
// &n1002 @WIRE(mode="straight") {#X775:2 %t3939:p};
// %t3940 = $IO_PORT @ATTACH &n984 => @PLACE(130, -2173) => @ORIENT("MY");
// %t3940 @TEXT("n984", key="name", size=0.75);
// &n984 @WIRE(mode="straight") {#X775:3 %t3940:p};
// %t3941 = $SUPPLY @ATTACH &vdd => @PLACE(120, -2162);
// &vdd @WIRE(mode="straight") {#X775:4 %t3941:p};
// %t3942 = $GROUND @ATTACH &vss => @PLACE(120, -2184);
// &vss @WIRE(mode="straight") {#X775:5 %t3942:p};
// %t3943 = $IO_PORT @ATTACH &n1005 => @PLACE(-11, -2202) => @ORIENT("R0");
// %t3943 @TEXT("n1005", key="name", size=0.75);
// &n1005 @WIRE(mode="straight") {#X776:1 %t3943:p};
// %t3944 = $IO_PORT @ATTACH &n1002 => @PLACE(-11, -2206) => @ORIENT("R0");
// %t3944 @TEXT("n1002", key="name", size=0.75);
// &n1002 @WIRE(mode="straight") {#X776:2 %t3944:p};
// %t3945 = $IO_PORT @ATTACH &n985 => @PLACE(10, -2204) => @ORIENT("MY");
// %t3945 @TEXT("n985", key="name", size=0.75);
// &n985 @WIRE(mode="straight") {#X776:3 %t3945:p};
// %t3946 = $SUPPLY @ATTACH &vdd => @PLACE(0, -2193);
// &vdd @WIRE(mode="straight") {#X776:4 %t3946:p};
// %t3947 = $GROUND @ATTACH &vss => @PLACE(0, -2215);
// &vss @WIRE(mode="straight") {#X776:5 %t3947:p};
// %t3948 = $IO_PORT @ATTACH &n237 => @PLACE(30, -2202) => @ORIENT("R0");
// %t3948 @TEXT("n237", key="name", size=0.75);
// &n237 @WIRE(mode="straight") {#X777:1 %t3948:p};
// %t3949 = $IO_PORT @ATTACH &n1002 => @PLACE(30, -2206) => @ORIENT("R0");
// %t3949 @TEXT("n1002", key="name", size=0.75);
// &n1002 @WIRE(mode="straight") {#X777:2 %t3949:p};
// %t3950 = $IO_PORT @ATTACH &n1006 => @PLACE(50, -2204) => @ORIENT("MY");
// %t3950 @TEXT("n1006", key="name", size=0.75);
// &n1006 @WIRE(mode="straight") {#X777:3 %t3950:p};
// %t3951 = $SUPPLY @ATTACH &vdd => @PLACE(40, -2193);
// &vdd @WIRE(mode="straight") {#X777:4 %t3951:p};
// %t3952 = $GROUND @ATTACH &vss => @PLACE(40, -2215);
// &vss @WIRE(mode="straight") {#X777:5 %t3952:p};
// %t3953 = $IO_PORT @ATTACH &n1007 => @PLACE(70, -2202) => @ORIENT("R0");
// %t3953 @TEXT("n1007", key="name", size=0.75);
// &n1007 @WIRE(mode="straight") {#X778:1 %t3953:p};
// %t3954 = $IO_PORT @ATTACH &n1006 => @PLACE(70, -2206) => @ORIENT("R0");
// %t3954 @TEXT("n1006", key="name", size=0.75);
// &n1006 @WIRE(mode="straight") {#X778:2 %t3954:p};
// %t3955 = $IO_PORT @ATTACH &n987 => @PLACE(90, -2204) => @ORIENT("MY");
// %t3955 @TEXT("n987", key="name", size=0.75);
// &n987 @WIRE(mode="straight") {#X778:3 %t3955:p};
// %t3956 = $SUPPLY @ATTACH &vdd => @PLACE(80, -2193);
// &vdd @WIRE(mode="straight") {#X778:4 %t3956:p};
// %t3957 = $GROUND @ATTACH &vss => @PLACE(80, -2215);
// &vss @WIRE(mode="straight") {#X778:5 %t3957:p};
// %t3958 = $IO_PORT @ATTACH &n1008 => @PLACE(110, -2202) => @ORIENT("R0");
// %t3958 @TEXT("n1008", key="name", size=0.75);
// &n1008 @WIRE(mode="straight") {#X779:1 %t3958:p};
// %t3959 = $IO_PORT @ATTACH &n1002 => @PLACE(110, -2206) => @ORIENT("R0");
// %t3959 @TEXT("n1002", key="name", size=0.75);
// &n1002 @WIRE(mode="straight") {#X779:2 %t3959:p};
// %t3960 = $IO_PORT @ATTACH &n988 => @PLACE(130, -2204) => @ORIENT("MY");
// %t3960 @TEXT("n988", key="name", size=0.75);
// &n988 @WIRE(mode="straight") {#X779:3 %t3960:p};
// %t3961 = $SUPPLY @ATTACH &vdd => @PLACE(120, -2193);
// &vdd @WIRE(mode="straight") {#X779:4 %t3961:p};
// %t3962 = $GROUND @ATTACH &vss => @PLACE(120, -2215);
// &vss @WIRE(mode="straight") {#X779:5 %t3962:p};
// %t3963 = $IO_PORT @ATTACH &n88 => @PLACE(-11, -2233) => @ORIENT("R0");
// %t3963 @TEXT("n88", key="name", size=0.75);
// &n88 @WIRE(mode="straight") {#X780:1 %t3963:p};
// %t3964 = $IO_PORT @ATTACH &n1002 => @PLACE(-11, -2237) => @ORIENT("R0");
// %t3964 @TEXT("n1002", key="name", size=0.75);
// &n1002 @WIRE(mode="straight") {#X780:2 %t3964:p};
// %t3965 = $IO_PORT @ATTACH &n990 => @PLACE(10, -2235) => @ORIENT("MY");
// %t3965 @TEXT("n990", key="name", size=0.75);
// &n990 @WIRE(mode="straight") {#X780:3 %t3965:p};
// %t3966 = $SUPPLY @ATTACH &vdd => @PLACE(0, -2224);
// &vdd @WIRE(mode="straight") {#X780:4 %t3966:p};
// %t3967 = $GROUND @ATTACH &vss => @PLACE(0, -2246);
// &vss @WIRE(mode="straight") {#X780:5 %t3967:p};
// %t3968 = $IO_PORT @ATTACH &n51 => @PLACE(30, -2233) => @ORIENT("R0");
// %t3968 @TEXT("n51", key="name", size=0.75);
// &n51 @WIRE(mode="straight") {#X781:1 %t3968:p};
// %t3969 = $IO_PORT @ATTACH &n1002 => @PLACE(30, -2237) => @ORIENT("R0");
// %t3969 @TEXT("n1002", key="name", size=0.75);
// &n1002 @WIRE(mode="straight") {#X781:2 %t3969:p};
// %t3970 = $IO_PORT @ATTACH &n991 => @PLACE(50, -2235) => @ORIENT("MY");
// %t3970 @TEXT("n991", key="name", size=0.75);
// &n991 @WIRE(mode="straight") {#X781:3 %t3970:p};
// %t3971 = $SUPPLY @ATTACH &vdd => @PLACE(40, -2224);
// &vdd @WIRE(mode="straight") {#X781:4 %t3971:p};
// %t3972 = $GROUND @ATTACH &vss => @PLACE(40, -2246);
// &vss @WIRE(mode="straight") {#X781:5 %t3972:p};
// %t3973 = $IO_PORT @ATTACH &n117 => @PLACE(70, -2233) => @ORIENT("R0");
// %t3973 @TEXT("n117", key="name", size=0.75);
// &n117 @WIRE(mode="straight") {#X782:1 %t3973:p};
// %t3974 = $IO_PORT @ATTACH &n1002 => @PLACE(70, -2237) => @ORIENT("R0");
// %t3974 @TEXT("n1002", key="name", size=0.75);
// &n1002 @WIRE(mode="straight") {#X782:2 %t3974:p};
// %t3975 = $IO_PORT @ATTACH &n993 => @PLACE(90, -2235) => @ORIENT("MY");
// %t3975 @TEXT("n993", key="name", size=0.75);
// &n993 @WIRE(mode="straight") {#X782:3 %t3975:p};
// %t3976 = $SUPPLY @ATTACH &vdd => @PLACE(80, -2224);
// &vdd @WIRE(mode="straight") {#X782:4 %t3976:p};
// %t3977 = $GROUND @ATTACH &vss => @PLACE(80, -2246);
// &vss @WIRE(mode="straight") {#X782:5 %t3977:p};
// %t3978 = $IO_PORT @ATTACH &n1009 => @PLACE(110, -2233) => @ORIENT("R0");
// %t3978 @TEXT("n1009", key="name", size=0.75);
// &n1009 @WIRE(mode="straight") {#X783:1 %t3978:p};
// %t3979 = $IO_PORT @ATTACH &n1010 => @PLACE(110, -2237) => @ORIENT("R0");
// %t3979 @TEXT("n1010", key="name", size=0.75);
// &n1010 @WIRE(mode="straight") {#X783:2 %t3979:p};
// %t3980 = $IO_PORT @ATTACH &n1011 => @PLACE(130, -2235) => @ORIENT("MY");
// %t3980 @TEXT("n1011", key="name", size=0.75);
// &n1011 @WIRE(mode="straight") {#X783:3 %t3980:p};
// %t3981 = $SUPPLY @ATTACH &vdd => @PLACE(120, -2224);
// &vdd @WIRE(mode="straight") {#X783:4 %t3981:p};
// %t3982 = $GROUND @ATTACH &vss => @PLACE(120, -2246);
// &vss @WIRE(mode="straight") {#X783:5 %t3982:p};
// %t3983 = $IO_PORT @ATTACH &n1012 => @PLACE(-11, -2264) => @ORIENT("R0");
// %t3983 @TEXT("n1012", key="name", size=0.75);
// &n1012 @WIRE(mode="straight") {#X784:1 %t3983:p};
// %t3984 = $IO_PORT @ATTACH &n1013 => @PLACE(-11, -2268) => @ORIENT("R0");
// %t3984 @TEXT("n1013", key="name", size=0.75);
// &n1013 @WIRE(mode="straight") {#X784:2 %t3984:p};
// %t3985 = $IO_PORT @ATTACH &n1014 => @PLACE(10, -2266) => @ORIENT("MY");
// %t3985 @TEXT("n1014", key="name", size=0.75);
// &n1014 @WIRE(mode="straight") {#X784:3 %t3985:p};
// %t3986 = $SUPPLY @ATTACH &vdd => @PLACE(0, -2255);
// &vdd @WIRE(mode="straight") {#X784:4 %t3986:p};
// %t3987 = $GROUND @ATTACH &vss => @PLACE(0, -2277);
// &vss @WIRE(mode="straight") {#X784:5 %t3987:p};
// %t3988 = $IO_PORT @ATTACH &n1011 => @PLACE(30, -2264) => @ORIENT("R0");
// %t3988 @TEXT("n1011", key="name", size=0.75);
// &n1011 @WIRE(mode="straight") {#X785:1 %t3988:p};
// %t3989 = $IO_PORT @ATTACH &n1014 => @PLACE(30, -2268) => @ORIENT("R0");
// %t3989 @TEXT("n1014", key="name", size=0.75);
// &n1014 @WIRE(mode="straight") {#X785:2 %t3989:p};
// %t3990 = $IO_PORT @ATTACH &n1015 => @PLACE(50, -2266) => @ORIENT("MY");
// %t3990 @TEXT("n1015", key="name", size=0.75);
// &n1015 @WIRE(mode="straight") {#X785:3 %t3990:p};
// %t3991 = $SUPPLY @ATTACH &vdd => @PLACE(40, -2255);
// &vdd @WIRE(mode="straight") {#X785:4 %t3991:p};
// %t3992 = $GROUND @ATTACH &vss => @PLACE(40, -2277);
// &vss @WIRE(mode="straight") {#X785:5 %t3992:p};
// %t3993 = $IO_PORT @ATTACH &n1015 => @PLACE(70, -2264) => @ORIENT("R0");
// %t3993 @TEXT("n1015", key="name", size=0.75);
// &n1015 @WIRE(mode="straight") {#X786:1 %t3993:p};
// %t3994 = $IO_PORT @ATTACH &n1016 => @PLACE(70, -2268) => @ORIENT("R0");
// %t3994 @TEXT("n1016", key="name", size=0.75);
// &n1016 @WIRE(mode="straight") {#X786:2 %t3994:p};
// %t3995 = $IO_PORT @ATTACH &n1017 => @PLACE(90, -2266) => @ORIENT("MY");
// %t3995 @TEXT("n1017", key="name", size=0.75);
// &n1017 @WIRE(mode="straight") {#X786:3 %t3995:p};
// %t3996 = $SUPPLY @ATTACH &vdd => @PLACE(80, -2255);
// &vdd @WIRE(mode="straight") {#X786:4 %t3996:p};
// %t3997 = $GROUND @ATTACH &vss => @PLACE(80, -2277);
// &vss @WIRE(mode="straight") {#X786:5 %t3997:p};
// %t3998 = $IO_PORT @ATTACH &n1017 => @PLACE(110, -2264) => @ORIENT("R0");
// %t3998 @TEXT("n1017", key="name", size=0.75);
// &n1017 @WIRE(mode="straight") {#X787:1 %t3998:p};
// %t3999 = $IO_PORT @ATTACH &n1018 => @PLACE(110, -2268) => @ORIENT("R0");
// %t3999 @TEXT("n1018", key="name", size=0.75);
// &n1018 @WIRE(mode="straight") {#X787:2 %t3999:p};
// %t4000 = $IO_PORT @ATTACH &n145 => @PLACE(130, -2266) => @ORIENT("MY");
// %t4000 @TEXT("n145", key="name", size=0.75);
// &n145 @WIRE(mode="straight") {#X787:3 %t4000:p};
// %t4001 = $SUPPLY @ATTACH &vdd => @PLACE(120, -2255);
// &vdd @WIRE(mode="straight") {#X787:4 %t4001:p};
// %t4002 = $GROUND @ATTACH &vss => @PLACE(120, -2277);
// &vss @WIRE(mode="straight") {#X787:5 %t4002:p};
// %t4003 = $IO_PORT @ATTACH &n1019 => @PLACE(-11, -2295) => @ORIENT("R0");
// %t4003 @TEXT("n1019", key="name", size=0.75);
// &n1019 @WIRE(mode="straight") {#X788:1 %t4003:p};
// %t4004 = $IO_PORT @ATTACH &n233 => @PLACE(-11, -2299) => @ORIENT("R0");
// %t4004 @TEXT("n233", key="name", size=0.75);
// &n233 @WIRE(mode="straight") {#X788:2 %t4004:p};
// %t4005 = $IO_PORT @ATTACH &n1013 => @PLACE(10, -2297) => @ORIENT("MY");
// %t4005 @TEXT("n1013", key="name", size=0.75);
// &n1013 @WIRE(mode="straight") {#X788:3 %t4005:p};
// %t4006 = $SUPPLY @ATTACH &vdd => @PLACE(0, -2286);
// &vdd @WIRE(mode="straight") {#X788:4 %t4006:p};
// %t4007 = $GROUND @ATTACH &vss => @PLACE(0, -2308);
// &vss @WIRE(mode="straight") {#X788:5 %t4007:p};
// %t4008 = $IO_PORT @ATTACH &n963 => @PLACE(30, -2295) => @ORIENT("R0");
// %t4008 @TEXT("n963", key="name", size=0.75);
// &n963 @WIRE(mode="straight") {#X789:1 %t4008:p};
// %t4009 = $IO_PORT @ATTACH &n241 => @PLACE(30, -2299) => @ORIENT("R0");
// %t4009 @TEXT("n241", key="name", size=0.75);
// &n241 @WIRE(mode="straight") {#X789:2 %t4009:p};
// %t4010 = $IO_PORT @ATTACH &n1009 => @PLACE(50, -2297) => @ORIENT("MY");
// %t4010 @TEXT("n1009", key="name", size=0.75);
// &n1009 @WIRE(mode="straight") {#X789:3 %t4010:p};
// %t4011 = $SUPPLY @ATTACH &vdd => @PLACE(40, -2286);
// &vdd @WIRE(mode="straight") {#X789:4 %t4011:p};
// %t4012 = $GROUND @ATTACH &vss => @PLACE(40, -2308);
// &vss @WIRE(mode="straight") {#X789:5 %t4012:p};
// %t4013 = $IO_PORT @ATTACH &n963 => @PLACE(70, -2295) => @ORIENT("R0");
// %t4013 @TEXT("n963", key="name", size=0.75);
// &n963 @WIRE(mode="straight") {#X790:1 %t4013:p};
// %t4014 = $IO_PORT @ATTACH &n351 => @PLACE(70, -2299) => @ORIENT("R0");
// %t4014 @TEXT("n351", key="name", size=0.75);
// &n351 @WIRE(mode="straight") {#X790:2 %t4014:p};
// %t4015 = $IO_PORT @ATTACH &n1010 => @PLACE(90, -2297) => @ORIENT("MY");
// %t4015 @TEXT("n1010", key="name", size=0.75);
// &n1010 @WIRE(mode="straight") {#X790:3 %t4015:p};
// %t4016 = $SUPPLY @ATTACH &vdd => @PLACE(80, -2286);
// &vdd @WIRE(mode="straight") {#X790:4 %t4016:p};
// %t4017 = $GROUND @ATTACH &vss => @PLACE(80, -2308);
// &vss @WIRE(mode="straight") {#X790:5 %t4017:p};
// %t4018 = $IO_PORT @ATTACH &n963 => @PLACE(110, -2295) => @ORIENT("R0");
// %t4018 @TEXT("n963", key="name", size=0.75);
// &n963 @WIRE(mode="straight") {#X791:1 %t4018:p};
// %t4019 = $IO_PORT @ATTACH &n237 => @PLACE(110, -2299) => @ORIENT("R0");
// %t4019 @TEXT("n237", key="name", size=0.75);
// &n237 @WIRE(mode="straight") {#X791:2 %t4019:p};
// %t4020 = $IO_PORT @ATTACH &n1012 => @PLACE(130, -2297) => @ORIENT("MY");
// %t4020 @TEXT("n1012", key="name", size=0.75);
// &n1012 @WIRE(mode="straight") {#X791:3 %t4020:p};
// %t4021 = $SUPPLY @ATTACH &vdd => @PLACE(120, -2286);
// &vdd @WIRE(mode="straight") {#X791:4 %t4021:p};
// %t4022 = $GROUND @ATTACH &vss => @PLACE(120, -2308);
// &vss @WIRE(mode="straight") {#X791:5 %t4022:p};
// %t4023 = $IO_PORT @ATTACH &n963 => @PLACE(158, -2140) => @ORIENT("R0");
// %t4023 @TEXT("n963", key="name", size=0.75);
// &n963 @WIRE(mode="straight") {#X792:1 %t4023:p};
// %t4024 = $IO_PORT @ATTACH &n960 => @PLACE(158, -2144) => @ORIENT("R0");
// %t4024 @TEXT("n960", key="name", size=0.75);
// &n960 @WIRE(mode="straight") {#X792:2 %t4024:p};
// %t4025 = $IO_PORT @ATTACH &n1020 => @PLACE(178, -2142) => @ORIENT("MY");
// %t4025 @TEXT("n1020", key="name", size=0.75);
// &n1020 @WIRE(mode="straight") {#X792:3 %t4025:p};
// %t4026 = $SUPPLY @ATTACH &vdd => @PLACE(168, -2131);
// &vdd @WIRE(mode="straight") {#X792:4 %t4026:p};
// %t4027 = $GROUND @ATTACH &vss => @PLACE(168, -2153);
// &vss @WIRE(mode="straight") {#X792:5 %t4027:p};
// %t4028 = $IO_PORT @ATTACH &n963 => @PLACE(198, -2140) => @ORIENT("R0");
// %t4028 @TEXT("n963", key="name", size=0.75);
// &n963 @WIRE(mode="straight") {#X793:1 %t4028:p};
// %t4029 = $IO_PORT @ATTACH &n235 => @PLACE(198, -2144) => @ORIENT("R0");
// %t4029 @TEXT("n235", key="name", size=0.75);
// &n235 @WIRE(mode="straight") {#X793:2 %t4029:p};
// %t4030 = $IO_PORT @ATTACH &n1021 => @PLACE(218, -2142) => @ORIENT("MY");
// %t4030 @TEXT("n1021", key="name", size=0.75);
// &n1021 @WIRE(mode="straight") {#X793:3 %t4030:p};
// %t4031 = $SUPPLY @ATTACH &vdd => @PLACE(208, -2131);
// &vdd @WIRE(mode="straight") {#X793:4 %t4031:p};
// %t4032 = $GROUND @ATTACH &vss => @PLACE(208, -2153);
// &vss @WIRE(mode="straight") {#X793:5 %t4032:p};
// %t4033 = $IO_PORT @ATTACH &n88 => @PLACE(238, -2140) => @ORIENT("R0");
// %t4033 @TEXT("n88", key="name", size=0.75);
// &n88 @WIRE(mode="straight") {#X794:1 %t4033:p};
// %t4034 = $IO_PORT @ATTACH &n966 => @PLACE(238, -2144) => @ORIENT("R0");
// %t4034 @TEXT("n966", key="name", size=0.75);
// &n966 @WIRE(mode="straight") {#X794:2 %t4034:p};
// %t4035 = $IO_PORT @ATTACH &n1022 => @PLACE(258, -2142) => @ORIENT("MY");
// %t4035 @TEXT("n1022", key="name", size=0.75);
// &n1022 @WIRE(mode="straight") {#X794:3 %t4035:p};
// %t4036 = $SUPPLY @ATTACH &vdd => @PLACE(248, -2131);
// &vdd @WIRE(mode="straight") {#X794:4 %t4036:p};
// %t4037 = $GROUND @ATTACH &vss => @PLACE(248, -2153);
// &vss @WIRE(mode="straight") {#X794:5 %t4037:p};
// %t4038 = $IO_PORT @ATTACH &n1001 => @PLACE(278, -2140) => @ORIENT("R0");
// %t4038 @TEXT("n1001", key="name", size=0.75);
// &n1001 @WIRE(mode="straight") {#X795:1 %t4038:p};
// %t4039 = $IO_PORT @ATTACH &n1004 => @PLACE(278, -2144) => @ORIENT("R0");
// %t4039 @TEXT("n1004", key="name", size=0.75);
// &n1004 @WIRE(mode="straight") {#X795:2 %t4039:p};
// %t4040 = $IO_PORT @ATTACH &n1023 => @PLACE(298, -2142) => @ORIENT("MY");
// %t4040 @TEXT("n1023", key="name", size=0.75);
// &n1023 @WIRE(mode="straight") {#X795:3 %t4040:p};
// %t4041 = $SUPPLY @ATTACH &vdd => @PLACE(288, -2131);
// &vdd @WIRE(mode="straight") {#X795:4 %t4041:p};
// %t4042 = $GROUND @ATTACH &vss => @PLACE(288, -2153);
// &vss @WIRE(mode="straight") {#X795:5 %t4042:p};
// %t4043 = $IO_PORT @ATTACH &n1005 => @PLACE(158, -2171) => @ORIENT("R0");
// %t4043 @TEXT("n1005", key="name", size=0.75);
// &n1005 @WIRE(mode="straight") {#X796:1 %t4043:p};
// %t4044 = $IO_PORT @ATTACH &n1024 => @PLACE(158, -2175) => @ORIENT("R0");
// %t4044 @TEXT("n1024", key="name", size=0.75);
// &n1024 @WIRE(mode="straight") {#X796:2 %t4044:p};
// %t4045 = $IO_PORT @ATTACH &n1025 => @PLACE(178, -2173) => @ORIENT("MY");
// %t4045 @TEXT("n1025", key="name", size=0.75);
// &n1025 @WIRE(mode="straight") {#X796:3 %t4045:p};
// %t4046 = $SUPPLY @ATTACH &vdd => @PLACE(168, -2162);
// &vdd @WIRE(mode="straight") {#X796:4 %t4046:p};
// %t4047 = $GROUND @ATTACH &vss => @PLACE(168, -2184);
// &vss @WIRE(mode="straight") {#X796:5 %t4047:p};
// %t4048 = $IO_PORT @ATTACH &n1008 => @PLACE(198, -2171) => @ORIENT("R0");
// %t4048 @TEXT("n1008", key="name", size=0.75);
// &n1008 @WIRE(mode="straight") {#X797:1 %t4048:p};
// %t4049 = $IO_PORT @ATTACH &n117 => @PLACE(198, -2175) => @ORIENT("R0");
// %t4049 @TEXT("n117", key="name", size=0.75);
// &n117 @WIRE(mode="straight") {#X797:2 %t4049:p};
// %t4050 = $IO_PORT @ATTACH &n1026 => @PLACE(218, -2173) => @ORIENT("MY");
// %t4050 @TEXT("n1026", key="name", size=0.75);
// &n1026 @WIRE(mode="straight") {#X797:3 %t4050:p};
// %t4051 = $SUPPLY @ATTACH &vdd => @PLACE(208, -2162);
// &vdd @WIRE(mode="straight") {#X797:4 %t4051:p};
// %t4052 = $GROUND @ATTACH &vss => @PLACE(208, -2184);
// &vss @WIRE(mode="straight") {#X797:5 %t4052:p};
// %t4053 = $IO_PORT @ATTACH &n51 => @PLACE(238, -2171) => @ORIENT("R0");
// %t4053 @TEXT("n51", key="name", size=0.75);
// &n51 @WIRE(mode="straight") {#X798:1 %t4053:p};
// %t4054 = $IO_PORT @ATTACH &n88 => @PLACE(238, -2175) => @ORIENT("R0");
// %t4054 @TEXT("n88", key="name", size=0.75);
// &n88 @WIRE(mode="straight") {#X798:2 %t4054:p};
// %t4055 = $IO_PORT @ATTACH &n970 => @PLACE(258, -2173) => @ORIENT("MY");
// %t4055 @TEXT("n970", key="name", size=0.75);
// &n970 @WIRE(mode="straight") {#X798:3 %t4055:p};
// %t4056 = $SUPPLY @ATTACH &vdd => @PLACE(248, -2162);
// &vdd @WIRE(mode="straight") {#X798:4 %t4056:p};
// %t4057 = $GROUND @ATTACH &vss => @PLACE(248, -2184);
// &vss @WIRE(mode="straight") {#X798:5 %t4057:p};
// %t4058 = $IO_PORT @ATTACH &n1023 => @PLACE(278, -2171) => @ORIENT("R0");
// %t4058 @TEXT("n1023", key="name", size=0.75);
// &n1023 @WIRE(mode="straight") {#X799:1 %t4058:p};
// %t4059 = $IO_PORT @ATTACH &n1025 => @PLACE(278, -2175) => @ORIENT("R0");
// %t4059 @TEXT("n1025", key="name", size=0.75);
// &n1025 @WIRE(mode="straight") {#X799:2 %t4059:p};
// %t4060 = $IO_PORT @ATTACH &n1027 => @PLACE(298, -2173) => @ORIENT("MY");
// %t4060 @TEXT("n1027", key="name", size=0.75);
// &n1027 @WIRE(mode="straight") {#X799:3 %t4060:p};
// %t4061 = $SUPPLY @ATTACH &vdd => @PLACE(288, -2162);
// &vdd @WIRE(mode="straight") {#X799:4 %t4061:p};
// %t4062 = $GROUND @ATTACH &vss => @PLACE(288, -2184);
// &vss @WIRE(mode="straight") {#X799:5 %t4062:p};
// %t4063 = $IO_PORT @ATTACH &n1026 => @PLACE(158, -2202) => @ORIENT("R0");
// %t4063 @TEXT("n1026", key="name", size=0.75);
// &n1026 @WIRE(mode="straight") {#X800:1 %t4063:p};
// %t4064 = $IO_PORT @ATTACH &n970 => @PLACE(158, -2206) => @ORIENT("R0");
// %t4064 @TEXT("n970", key="name", size=0.75);
// &n970 @WIRE(mode="straight") {#X800:2 %t4064:p};
// %t4065 = $IO_PORT @ATTACH &n1028 => @PLACE(178, -2204) => @ORIENT("MY");
// %t4065 @TEXT("n1028", key="name", size=0.75);
// &n1028 @WIRE(mode="straight") {#X800:3 %t4065:p};
// %t4066 = $SUPPLY @ATTACH &vdd => @PLACE(168, -2193);
// &vdd @WIRE(mode="straight") {#X800:4 %t4066:p};
// %t4067 = $GROUND @ATTACH &vss => @PLACE(168, -2215);
// &vss @WIRE(mode="straight") {#X800:5 %t4067:p};
// %t4068 = $IO_PORT @ATTACH &n1027 => @PLACE(198, -2202) => @ORIENT("R0");
// %t4068 @TEXT("n1027", key="name", size=0.75);
// &n1027 @WIRE(mode="straight") {#X801:1 %t4068:p};
// %t4069 = $IO_PORT @ATTACH &n1028 => @PLACE(198, -2206) => @ORIENT("R0");
// %t4069 @TEXT("n1028", key="name", size=0.75);
// &n1028 @WIRE(mode="straight") {#X801:2 %t4069:p};
// %t4070 = $IO_PORT @ATTACH &n1029 => @PLACE(218, -2204) => @ORIENT("MY");
// %t4070 @TEXT("n1029", key="name", size=0.75);
// &n1029 @WIRE(mode="straight") {#X801:3 %t4070:p};
// %t4071 = $SUPPLY @ATTACH &vdd => @PLACE(208, -2193);
// &vdd @WIRE(mode="straight") {#X801:4 %t4071:p};
// %t4072 = $GROUND @ATTACH &vss => @PLACE(208, -2215);
// &vss @WIRE(mode="straight") {#X801:5 %t4072:p};
// %t4073 = $IO_PORT @ATTACH &n1029 => @PLACE(238, -2202) => @ORIENT("R0");
// %t4073 @TEXT("n1029", key="name", size=0.75);
// &n1029 @WIRE(mode="straight") {#X802:1 %t4073:p};
// %t4074 = $IO_PORT @ATTACH &n184 => @PLACE(238, -2206) => @ORIENT("R0");
// %t4074 @TEXT("n184", key="name", size=0.75);
// &n184 @WIRE(mode="straight") {#X802:2 %t4074:p};
// %t4075 = $IO_PORT @ATTACH &n195 => @PLACE(258, -2204) => @ORIENT("MY");
// %t4075 @TEXT("n195", key="name", size=0.75);
// &n195 @WIRE(mode="straight") {#X802:3 %t4075:p};
// %t4076 = $SUPPLY @ATTACH &vdd => @PLACE(248, -2193);
// &vdd @WIRE(mode="straight") {#X802:4 %t4076:p};
// %t4077 = $GROUND @ATTACH &vss => @PLACE(248, -2215);
// &vss @WIRE(mode="straight") {#X802:5 %t4077:p};
// %t4078 = $IO_PORT @ATTACH &n239 => @PLACE(278, -2202) => @ORIENT("R0");
// %t4078 @TEXT("n239", key="name", size=0.75);
// &n239 @WIRE(mode="straight") {#X803:1 %t4078:p};
// %t4079 = $IO_PORT @ATTACH &n232 => @PLACE(278, -2206) => @ORIENT("R0");
// %t4079 @TEXT("n232", key="name", size=0.75);
// &n232 @WIRE(mode="straight") {#X803:2 %t4079:p};
// %t4080 = $IO_PORT @ATTACH &n1001 => @PLACE(298, -2204) => @ORIENT("MY");
// %t4080 @TEXT("n1001", key="name", size=0.75);
// &n1001 @WIRE(mode="straight") {#X803:3 %t4080:p};
// %t4081 = $SUPPLY @ATTACH &vdd => @PLACE(288, -2193);
// &vdd @WIRE(mode="straight") {#X803:4 %t4081:p};
// %t4082 = $GROUND @ATTACH &vss => @PLACE(288, -2215);
// &vss @WIRE(mode="straight") {#X803:5 %t4082:p};
// %t4083 = $IO_PORT @ATTACH &n1007 => @PLACE(158, -2233) => @ORIENT("R0");
// %t4083 @TEXT("n1007", key="name", size=0.75);
// &n1007 @WIRE(mode="straight") {#X804:1 %t4083:p};
// %t4084 = $IO_PORT @ATTACH &n1003 => @PLACE(158, -2237) => @ORIENT("R0");
// %t4084 @TEXT("n1003", key="name", size=0.75);
// &n1003 @WIRE(mode="straight") {#X804:2 %t4084:p};
// %t4085 = $IO_PORT @ATTACH &n1004 => @PLACE(178, -2235) => @ORIENT("MY");
// %t4085 @TEXT("n1004", key="name", size=0.75);
// &n1004 @WIRE(mode="straight") {#X804:3 %t4085:p};
// %t4086 = $SUPPLY @ATTACH &vdd => @PLACE(168, -2224);
// &vdd @WIRE(mode="straight") {#X804:4 %t4086:p};
// %t4087 = $GROUND @ATTACH &vss => @PLACE(168, -2246);
// &vss @WIRE(mode="straight") {#X804:5 %t4087:p};
// %t4088 = $IO_PORT @ATTACH &n238 => @PLACE(198, -2233) => @ORIENT("R0");
// %t4088 @TEXT("n238", key="name", size=0.75);
// &n238 @WIRE(mode="straight") {#X805:1 %t4088:p};
// %t4089 = $IO_PORT @ATTACH &n1030 => @PLACE(198, -2237) => @ORIENT("R0");
// %t4089 @TEXT("n1030", key="name", size=0.75);
// &n1030 @WIRE(mode="straight") {#X805:2 %t4089:p};
// %t4090 = $IO_PORT @ATTACH &n1007 => @PLACE(218, -2235) => @ORIENT("MY");
// %t4090 @TEXT("n1007", key="name", size=0.75);
// &n1007 @WIRE(mode="straight") {#X805:3 %t4090:p};
// %t4091 = $SUPPLY @ATTACH &vdd => @PLACE(208, -2224);
// &vdd @WIRE(mode="straight") {#X805:4 %t4091:p};
// %t4092 = $GROUND @ATTACH &vss => @PLACE(208, -2246);
// &vss @WIRE(mode="straight") {#X805:5 %t4092:p};
// %t4093 = $IO_PORT @ATTACH &n1031 => @PLACE(238, -2233) => @ORIENT("R0");
// %t4093 @TEXT("n1031", key="name", size=0.75);
// &n1031 @WIRE(mode="straight") {#X806:1 %t4093:p};
// %t4094 = $IO_PORT @ATTACH &n240 => @PLACE(238, -2237) => @ORIENT("R0");
// %t4094 @TEXT("n240", key="name", size=0.75);
// &n240 @WIRE(mode="straight") {#X806:2 %t4094:p};
// %t4095 = $IO_PORT @ATTACH &n1032 => @PLACE(258, -2235) => @ORIENT("MY");
// %t4095 @TEXT("n1032", key="name", size=0.75);
// &n1032 @WIRE(mode="straight") {#X806:3 %t4095:p};
// %t4096 = $SUPPLY @ATTACH &vdd => @PLACE(248, -2224);
// &vdd @WIRE(mode="straight") {#X806:4 %t4096:p};
// %t4097 = $GROUND @ATTACH &vss => @PLACE(248, -2246);
// &vss @WIRE(mode="straight") {#X806:5 %t4097:p};
// %t4098 = $IO_PORT @ATTACH &n1007 => @PLACE(278, -2233) => @ORIENT("R0");
// %t4098 @TEXT("n1007", key="name", size=0.75);
// &n1007 @WIRE(mode="straight") {#X807:1 %t4098:p};
// %t4099 = $IO_PORT @ATTACH &n1032 => @PLACE(278, -2237) => @ORIENT("R0");
// %t4099 @TEXT("n1032", key="name", size=0.75);
// &n1032 @WIRE(mode="straight") {#X807:2 %t4099:p};
// %t4100 = $IO_PORT @ATTACH &n1005 => @PLACE(298, -2235) => @ORIENT("MY");
// %t4100 @TEXT("n1005", key="name", size=0.75);
// &n1005 @WIRE(mode="straight") {#X807:3 %t4100:p};
// %t4101 = $SUPPLY @ATTACH &vdd => @PLACE(288, -2224);
// &vdd @WIRE(mode="straight") {#X807:4 %t4101:p};
// %t4102 = $GROUND @ATTACH &vss => @PLACE(288, -2246);
// &vss @WIRE(mode="straight") {#X807:5 %t4102:p};
// %t4103 = $IO_PORT @ATTACH &n1007 => @PLACE(158, -2264) => @ORIENT("R0");
// %t4103 @TEXT("n1007", key="name", size=0.75);
// &n1007 @WIRE(mode="straight") {#X808:1 %t4103:p};
// %t4104 = $IO_PORT @ATTACH &n237 => @PLACE(158, -2268) => @ORIENT("R0");
// %t4104 @TEXT("n237", key="name", size=0.75);
// &n237 @WIRE(mode="straight") {#X808:2 %t4104:p};
// %t4105 = $IO_PORT @ATTACH &n1024 => @PLACE(178, -2266) => @ORIENT("MY");
// %t4105 @TEXT("n1024", key="name", size=0.75);
// &n1024 @WIRE(mode="straight") {#X808:3 %t4105:p};
// %t4106 = $SUPPLY @ATTACH &vdd => @PLACE(168, -2255);
// &vdd @WIRE(mode="straight") {#X808:4 %t4106:p};
// %t4107 = $GROUND @ATTACH &vss => @PLACE(168, -2277);
// &vss @WIRE(mode="straight") {#X808:5 %t4107:p};
// %t4108 = $IO_PORT @ATTACH &n238 => @PLACE(198, -2264) => @ORIENT("R0");
// %t4108 @TEXT("n238", key="name", size=0.75);
// &n238 @WIRE(mode="straight") {#X809:1 %t4108:p};
// %t4109 = $IO_PORT @ATTACH &n235 => @PLACE(198, -2268) => @ORIENT("R0");
// %t4109 @TEXT("n235", key="name", size=0.75);
// &n235 @WIRE(mode="straight") {#X809:2 %t4109:p};
// %t4110 = $IO_PORT @ATTACH &n1008 => @PLACE(218, -2266) => @ORIENT("MY");
// %t4110 @TEXT("n1008", key="name", size=0.75);
// &n1008 @WIRE(mode="straight") {#X809:3 %t4110:p};
// %t4111 = $SUPPLY @ATTACH &vdd => @PLACE(208, -2255);
// &vdd @WIRE(mode="straight") {#X809:4 %t4111:p};
// %t4112 = $GROUND @ATTACH &vss => @PLACE(208, -2277);
// &vss @WIRE(mode="straight") {#X809:5 %t4112:p};
// %t4113 = $IO_PORT @ATTACH &n1033 => @PLACE(238, -2264) => @ORIENT("R0");
// %t4113 @TEXT("n1033", key="name", size=0.75);
// &n1033 @WIRE(mode="straight") {#X810:1 %t4113:p};
// %t4114 = $IO_PORT @ATTACH &n994 => @PLACE(238, -2268) => @ORIENT("R0");
// %t4114 @TEXT("n994", key="name", size=0.75);
// &n994 @WIRE(mode="straight") {#X810:2 %t4114:p};
// %t4115 = $IO_PORT @ATTACH &n1034 => @PLACE(258, -2266) => @ORIENT("MY");
// %t4115 @TEXT("n1034", key="name", size=0.75);
// &n1034 @WIRE(mode="straight") {#X810:3 %t4115:p};
// %t4116 = $SUPPLY @ATTACH &vdd => @PLACE(248, -2255);
// &vdd @WIRE(mode="straight") {#X810:4 %t4116:p};
// %t4117 = $GROUND @ATTACH &vss => @PLACE(248, -2277);
// &vss @WIRE(mode="straight") {#X810:5 %t4117:p};
// %t4118 = $IO_PORT @ATTACH &n1035 => @PLACE(278, -2264) => @ORIENT("R0");
// %t4118 @TEXT("n1035", key="name", size=0.75);
// &n1035 @WIRE(mode="straight") {#X811:1 %t4118:p};
// %t4119 = $IO_PORT @ATTACH &n1036 => @PLACE(278, -2268) => @ORIENT("R0");
// %t4119 @TEXT("n1036", key="name", size=0.75);
// &n1036 @WIRE(mode="straight") {#X811:2 %t4119:p};
// %t4120 = $IO_PORT @ATTACH &n1037 => @PLACE(298, -2266) => @ORIENT("MY");
// %t4120 @TEXT("n1037", key="name", size=0.75);
// &n1037 @WIRE(mode="straight") {#X811:3 %t4120:p};
// %t4121 = $SUPPLY @ATTACH &vdd => @PLACE(288, -2255);
// &vdd @WIRE(mode="straight") {#X811:4 %t4121:p};
// %t4122 = $GROUND @ATTACH &vss => @PLACE(288, -2277);
// &vss @WIRE(mode="straight") {#X811:5 %t4122:p};
// %t4123 = $IO_PORT @ATTACH &n1034 => @PLACE(158, -2295) => @ORIENT("R0");
// %t4123 @TEXT("n1034", key="name", size=0.75);
// &n1034 @WIRE(mode="straight") {#X812:1 %t4123:p};
// %t4124 = $IO_PORT @ATTACH &n1037 => @PLACE(158, -2299) => @ORIENT("R0");
// %t4124 @TEXT("n1037", key="name", size=0.75);
// &n1037 @WIRE(mode="straight") {#X812:2 %t4124:p};
// %t4125 = $IO_PORT @ATTACH &n1038 => @PLACE(178, -2297) => @ORIENT("MY");
// %t4125 @TEXT("n1038", key="name", size=0.75);
// &n1038 @WIRE(mode="straight") {#X812:3 %t4125:p};
// %t4126 = $SUPPLY @ATTACH &vdd => @PLACE(168, -2286);
// &vdd @WIRE(mode="straight") {#X812:4 %t4126:p};
// %t4127 = $GROUND @ATTACH &vss => @PLACE(168, -2308);
// &vss @WIRE(mode="straight") {#X812:5 %t4127:p};
// %t4128 = $IO_PORT @ATTACH &n1038 => @PLACE(198, -2295) => @ORIENT("R0");
// %t4128 @TEXT("n1038", key="name", size=0.75);
// &n1038 @WIRE(mode="straight") {#X813:1 %t4128:p};
// %t4129 = $IO_PORT @ATTACH &n1039 => @PLACE(198, -2299) => @ORIENT("R0");
// %t4129 @TEXT("n1039", key="name", size=0.75);
// &n1039 @WIRE(mode="straight") {#X813:2 %t4129:p};
// %t4130 = $IO_PORT @ATTACH &n142 => @PLACE(218, -2297) => @ORIENT("MY");
// %t4130 @TEXT("n142", key="name", size=0.75);
// &n142 @WIRE(mode="straight") {#X813:3 %t4130:p};
// %t4131 = $SUPPLY @ATTACH &vdd => @PLACE(208, -2286);
// &vdd @WIRE(mode="straight") {#X813:4 %t4131:p};
// %t4132 = $GROUND @ATTACH &vss => @PLACE(208, -2308);
// &vss @WIRE(mode="straight") {#X813:5 %t4132:p};
// %t4133 = $IO_PORT @ATTACH &n1040 => @PLACE(238, -2295) => @ORIENT("R0");
// %t4133 @TEXT("n1040", key="name", size=0.75);
// &n1040 @WIRE(mode="straight") {#X814:1 %t4133:p};
// %t4134 = $IO_PORT @ATTACH &n1041 => @PLACE(238, -2299) => @ORIENT("R0");
// %t4134 @TEXT("n1041", key="name", size=0.75);
// &n1041 @WIRE(mode="straight") {#X814:2 %t4134:p};
// %t4135 = $IO_PORT @ATTACH &n1035 => @PLACE(258, -2297) => @ORIENT("MY");
// %t4135 @TEXT("n1035", key="name", size=0.75);
// &n1035 @WIRE(mode="straight") {#X814:3 %t4135:p};
// %t4136 = $SUPPLY @ATTACH &vdd => @PLACE(248, -2286);
// &vdd @WIRE(mode="straight") {#X814:4 %t4136:p};
// %t4137 = $GROUND @ATTACH &vss => @PLACE(248, -2308);
// &vss @WIRE(mode="straight") {#X814:5 %t4137:p};
// %t4138 = $IO_PORT @ATTACH &n1042 => @PLACE(278, -2295) => @ORIENT("R0");
// %t4138 @TEXT("n1042", key="name", size=0.75);
// &n1042 @WIRE(mode="straight") {#X815:1 %t4138:p};
// %t4139 = $IO_PORT @ATTACH &n1043 => @PLACE(278, -2299) => @ORIENT("R0");
// %t4139 @TEXT("n1043", key="name", size=0.75);
// &n1043 @WIRE(mode="straight") {#X815:2 %t4139:p};
// %t4140 = $IO_PORT @ATTACH &n1036 => @PLACE(298, -2297) => @ORIENT("MY");
// %t4140 @TEXT("n1036", key="name", size=0.75);
// &n1036 @WIRE(mode="straight") {#X815:3 %t4140:p};
// %t4141 = $SUPPLY @ATTACH &vdd => @PLACE(288, -2286);
// &vdd @WIRE(mode="straight") {#X815:4 %t4141:p};
// %t4142 = $GROUND @ATTACH &vss => @PLACE(288, -2308);
// &vss @WIRE(mode="straight") {#X815:5 %t4142:p};
// %t4143 = $IO_PORT @ATTACH &n1044 => @PLACE(326, -2140) => @ORIENT("R0");
// %t4143 @TEXT("n1044", key="name", size=0.75);
// &n1044 @WIRE(mode="straight") {#X816:1 %t4143:p};
// %t4144 = $IO_PORT @ATTACH &n1045 => @PLACE(326, -2144) => @ORIENT("R0");
// %t4144 @TEXT("n1045", key="name", size=0.75);
// &n1045 @WIRE(mode="straight") {#X816:2 %t4144:p};
// %t4145 = $IO_PORT @ATTACH &n1039 => @PLACE(346, -2142) => @ORIENT("MY");
// %t4145 @TEXT("n1039", key="name", size=0.75);
// &n1039 @WIRE(mode="straight") {#X816:3 %t4145:p};
// %t4146 = $SUPPLY @ATTACH &vdd => @PLACE(336, -2131);
// &vdd @WIRE(mode="straight") {#X816:4 %t4146:p};
// %t4147 = $GROUND @ATTACH &vss => @PLACE(336, -2153);
// &vss @WIRE(mode="straight") {#X816:5 %t4147:p};
// %t4148 = $IO_PORT @ATTACH &n1013 => @PLACE(366, -2140) => @ORIENT("R0");
// %t4148 @TEXT("n1013", key="name", size=0.75);
// &n1013 @WIRE(mode="straight") {#X817:1 %t4148:p};
// %t4149 = $IO_PORT @ATTACH &n1020 => @PLACE(366, -2144) => @ORIENT("R0");
// %t4149 @TEXT("n1020", key="name", size=0.75);
// &n1020 @WIRE(mode="straight") {#X817:2 %t4149:p};
// %t4150 = $IO_PORT @ATTACH &n1046 => @PLACE(386, -2142) => @ORIENT("MY");
// %t4150 @TEXT("n1046", key="name", size=0.75);
// &n1046 @WIRE(mode="straight") {#X817:3 %t4150:p};
// %t4151 = $SUPPLY @ATTACH &vdd => @PLACE(376, -2131);
// &vdd @WIRE(mode="straight") {#X817:4 %t4151:p};
// %t4152 = $GROUND @ATTACH &vss => @PLACE(376, -2153);
// &vss @WIRE(mode="straight") {#X817:5 %t4152:p};
// %t4153 = $IO_PORT @ATTACH &n1021 => @PLACE(406, -2140) => @ORIENT("R0");
// %t4153 @TEXT("n1021", key="name", size=0.75);
// &n1021 @WIRE(mode="straight") {#X818:1 %t4153:p};
// %t4154 = $IO_PORT @ATTACH &n1022 => @PLACE(406, -2144) => @ORIENT("R0");
// %t4154 @TEXT("n1022", key="name", size=0.75);
// &n1022 @WIRE(mode="straight") {#X818:2 %t4154:p};
// %t4155 = $IO_PORT @ATTACH &n1047 => @PLACE(426, -2142) => @ORIENT("MY");
// %t4155 @TEXT("n1047", key="name", size=0.75);
// &n1047 @WIRE(mode="straight") {#X818:3 %t4155:p};
// %t4156 = $SUPPLY @ATTACH &vdd => @PLACE(416, -2131);
// &vdd @WIRE(mode="straight") {#X818:4 %t4156:p};
// %t4157 = $GROUND @ATTACH &vss => @PLACE(416, -2153);
// &vss @WIRE(mode="straight") {#X818:5 %t4157:p};
// %t4158 = $IO_PORT @ATTACH &n117 => @PLACE(446, -2140) => @ORIENT("R0");
// %t4158 @TEXT("n117", key="name", size=0.75);
// &n117 @WIRE(mode="straight") {#X819:1 %t4158:p};
// %t4159 = $IO_PORT @ATTACH &n51 => @PLACE(446, -2144) => @ORIENT("R0");
// %t4159 @TEXT("n51", key="name", size=0.75);
// &n51 @WIRE(mode="straight") {#X819:2 %t4159:p};
// %t4160 = $IO_PORT @ATTACH &n1048 => @PLACE(466, -2142) => @ORIENT("MY");
// %t4160 @TEXT("n1048", key="name", size=0.75);
// &n1048 @WIRE(mode="straight") {#X819:3 %t4160:p};
// %t4161 = $SUPPLY @ATTACH &vdd => @PLACE(456, -2131);
// &vdd @WIRE(mode="straight") {#X819:4 %t4161:p};
// %t4162 = $GROUND @ATTACH &vss => @PLACE(456, -2153);
// &vss @WIRE(mode="straight") {#X819:5 %t4162:p};
// %t4163 = $IO_PORT @ATTACH &n1046 => @PLACE(326, -2171) => @ORIENT("R0");
// %t4163 @TEXT("n1046", key="name", size=0.75);
// &n1046 @WIRE(mode="straight") {#X820:1 %t4163:p};
// %t4164 = $IO_PORT @ATTACH &n1047 => @PLACE(326, -2175) => @ORIENT("R0");
// %t4164 @TEXT("n1047", key="name", size=0.75);
// &n1047 @WIRE(mode="straight") {#X820:2 %t4164:p};
// %t4165 = $IO_PORT @ATTACH &n1049 => @PLACE(346, -2173) => @ORIENT("MY");
// %t4165 @TEXT("n1049", key="name", size=0.75);
// &n1049 @WIRE(mode="straight") {#X820:3 %t4165:p};
// %t4166 = $SUPPLY @ATTACH &vdd => @PLACE(336, -2162);
// &vdd @WIRE(mode="straight") {#X820:4 %t4166:p};
// %t4167 = $GROUND @ATTACH &vss => @PLACE(336, -2184);
// &vss @WIRE(mode="straight") {#X820:5 %t4167:p};
// %t4168 = $IO_PORT @ATTACH &n1048 => @PLACE(366, -2171) => @ORIENT("R0");
// %t4168 @TEXT("n1048", key="name", size=0.75);
// &n1048 @WIRE(mode="straight") {#X821:1 %t4168:p};
// %t4169 = $IO_PORT @ATTACH &n184 => @PLACE(366, -2175) => @ORIENT("R0");
// %t4169 @TEXT("n184", key="name", size=0.75);
// &n184 @WIRE(mode="straight") {#X821:2 %t4169:p};
// %t4170 = $IO_PORT @ATTACH &n197 => @PLACE(386, -2173) => @ORIENT("MY");
// %t4170 @TEXT("n197", key="name", size=0.75);
// &n197 @WIRE(mode="straight") {#X821:3 %t4170:p};
// %t4171 = $SUPPLY @ATTACH &vdd => @PLACE(376, -2162);
// &vdd @WIRE(mode="straight") {#X821:4 %t4171:p};
// %t4172 = $GROUND @ATTACH &vss => @PLACE(376, -2184);
// &vss @WIRE(mode="straight") {#X821:5 %t4172:p};
// %t4173 = $IO_PORT @ATTACH &n1049 => @PLACE(406, -2171) => @ORIENT("R0");
// %t4173 @TEXT("n1049", key="name", size=0.75);
// &n1049 @WIRE(mode="straight") {#X822:1 %t4173:p};
// %t4174 = $IO_PORT @ATTACH &n197 => @PLACE(406, -2175) => @ORIENT("R0");
// %t4174 @TEXT("n197", key="name", size=0.75);
// &n197 @WIRE(mode="straight") {#X822:2 %t4174:p};
// %t4175 = $IO_PORT @ATTACH &n139 => @PLACE(426, -2173) => @ORIENT("MY");
// %t4175 @TEXT("n139", key="name", size=0.75);
// &n139 @WIRE(mode="straight") {#X822:3 %t4175:p};
// %t4176 = $SUPPLY @ATTACH &vdd => @PLACE(416, -2162);
// &vdd @WIRE(mode="straight") {#X822:4 %t4176:p};
// %t4177 = $GROUND @ATTACH &vss => @PLACE(416, -2184);
// &vss @WIRE(mode="straight") {#X822:5 %t4177:p};
// %t4178 = $IO_PORT @ATTACH &n1020 => @PLACE(446, -2171) => @ORIENT("R0");
// %t4178 @TEXT("n1020", key="name", size=0.75);
// &n1020 @WIRE(mode="straight") {#X823:1 %t4178:p};
// %t4179 = $IO_PORT @ATTACH &n1021 => @PLACE(446, -2175) => @ORIENT("R0");
// %t4179 @TEXT("n1021", key="name", size=0.75);
// &n1021 @WIRE(mode="straight") {#X823:2 %t4179:p};
// %t4180 = $IO_PORT @ATTACH &n1050 => @PLACE(466, -2173) => @ORIENT("MY");
// %t4180 @TEXT("n1050", key="name", size=0.75);
// &n1050 @WIRE(mode="straight") {#X823:3 %t4180:p};
// %t4181 = $SUPPLY @ATTACH &vdd => @PLACE(456, -2162);
// &vdd @WIRE(mode="straight") {#X823:4 %t4181:p};
// %t4182 = $GROUND @ATTACH &vss => @PLACE(456, -2184);
// &vss @WIRE(mode="straight") {#X823:5 %t4182:p};
// %t4183 = $IO_PORT @ATTACH &n1022 => @PLACE(326, -2202) => @ORIENT("R0");
// %t4183 @TEXT("n1022", key="name", size=0.75);
// &n1022 @WIRE(mode="straight") {#X824:1 %t4183:p};
// %t4184 = $IO_PORT @ATTACH &n117 => @PLACE(326, -2206) => @ORIENT("R0");
// %t4184 @TEXT("n117", key="name", size=0.75);
// &n117 @WIRE(mode="straight") {#X824:2 %t4184:p};
// %t4185 = $IO_PORT @ATTACH &n1051 => @PLACE(346, -2204) => @ORIENT("MY");
// %t4185 @TEXT("n1051", key="name", size=0.75);
// &n1051 @WIRE(mode="straight") {#X824:3 %t4185:p};
// %t4186 = $SUPPLY @ATTACH &vdd => @PLACE(336, -2193);
// &vdd @WIRE(mode="straight") {#X824:4 %t4186:p};
// %t4187 = $GROUND @ATTACH &vss => @PLACE(336, -2215);
// &vss @WIRE(mode="straight") {#X824:5 %t4187:p};
// %t4188 = $IO_PORT @ATTACH &n51 => @PLACE(366, -2202) => @ORIENT("R0");
// %t4188 @TEXT("n51", key="name", size=0.75);
// &n51 @WIRE(mode="straight") {#X825:1 %t4188:p};
// %t4189 = $IO_PORT @ATTACH &n184 => @PLACE(366, -2206) => @ORIENT("R0");
// %t4189 @TEXT("n184", key="name", size=0.75);
// &n184 @WIRE(mode="straight") {#X825:2 %t4189:p};
// %t4190 = $IO_PORT @ATTACH &n1018 => @PLACE(386, -2204) => @ORIENT("MY");
// %t4190 @TEXT("n1018", key="name", size=0.75);
// &n1018 @WIRE(mode="straight") {#X825:3 %t4190:p};
// %t4191 = $SUPPLY @ATTACH &vdd => @PLACE(376, -2193);
// &vdd @WIRE(mode="straight") {#X825:4 %t4191:p};
// %t4192 = $GROUND @ATTACH &vss => @PLACE(376, -2215);
// &vss @WIRE(mode="straight") {#X825:5 %t4192:p};
// %t4193 = $IO_PORT @ATTACH &n1050 => @PLACE(406, -2202) => @ORIENT("R0");
// %t4193 @TEXT("n1050", key="name", size=0.75);
// &n1050 @WIRE(mode="straight") {#X826:1 %t4193:p};
// %t4194 = $IO_PORT @ATTACH &n1051 => @PLACE(406, -2206) => @ORIENT("R0");
// %t4194 @TEXT("n1051", key="name", size=0.75);
// &n1051 @WIRE(mode="straight") {#X826:2 %t4194:p};
// %t4195 = $IO_PORT @ATTACH &n1016 => @PLACE(426, -2204) => @ORIENT("MY");
// %t4195 @TEXT("n1016", key="name", size=0.75);
// &n1016 @WIRE(mode="straight") {#X826:3 %t4195:p};
// %t4196 = $SUPPLY @ATTACH &vdd => @PLACE(416, -2193);
// &vdd @WIRE(mode="straight") {#X826:4 %t4196:p};
// %t4197 = $GROUND @ATTACH &vss => @PLACE(416, -2215);
// &vss @WIRE(mode="straight") {#X826:5 %t4197:p};
// %t4198 = $IO_PORT @ATTACH &n1016 => @PLACE(446, -2202) => @ORIENT("R0");
// %t4198 @TEXT("n1016", key="name", size=0.75);
// &n1016 @WIRE(mode="straight") {#X827:1 %t4198:p};
// %t4199 = $IO_PORT @ATTACH &n1018 => @PLACE(446, -2206) => @ORIENT("R0");
// %t4199 @TEXT("n1018", key="name", size=0.75);
// &n1018 @WIRE(mode="straight") {#X827:2 %t4199:p};
// %t4200 = $IO_PORT @ATTACH &n201 => @PLACE(466, -2204) => @ORIENT("MY");
// %t4200 @TEXT("n201", key="name", size=0.75);
// &n201 @WIRE(mode="straight") {#X827:3 %t4200:p};
// %t4201 = $SUPPLY @ATTACH &vdd => @PLACE(456, -2193);
// &vdd @WIRE(mode="straight") {#X827:4 %t4201:p};
// %t4202 = $GROUND @ATTACH &vss => @PLACE(456, -2215);
// &vss @WIRE(mode="straight") {#X827:5 %t4202:p};
// %t4203 = $IO_PORT @ATTACH &n184 => @PLACE(326, -2233) => @ORIENT("R0");
// %t4203 @TEXT("n184", key="name", size=0.75);
// &n184 @WIRE(mode="straight") {#X828:1 %t4203:p};
// %t4204 = $IO_PORT @ATTACH &n1052 => @PLACE(326, -2237) => @ORIENT("R0");
// %t4204 @TEXT("n1052", key="name", size=0.75);
// &n1052 @WIRE(mode="straight") {#X828:2 %t4204:p};
// %t4205 = $IO_PORT @ATTACH &n203 => @PLACE(346, -2235) => @ORIENT("MY");
// %t4205 @TEXT("n203", key="name", size=0.75);
// &n203 @WIRE(mode="straight") {#X828:3 %t4205:p};
// %t4206 = $SUPPLY @ATTACH &vdd => @PLACE(336, -2224);
// &vdd @WIRE(mode="straight") {#X828:4 %t4206:p};
// %t4207 = $GROUND @ATTACH &vss => @PLACE(336, -2246);
// &vss @WIRE(mode="straight") {#X828:5 %t4207:p};
// %t4208 = $IO_PORT @ATTACH &n1052 => @PLACE(366, -2233) => @ORIENT("R0");
// %t4208 @TEXT("n1052", key="name", size=0.75);
// &n1052 @WIRE(mode="straight") {#X829:1 %t4208:p};
// %t4209 = $IO_PORT @ATTACH &n1053 => @PLACE(366, -2237) => @ORIENT("R0");
// %t4209 @TEXT("n1053", key="name", size=0.75);
// &n1053 @WIRE(mode="straight") {#X829:2 %t4209:p};
// %t4210 = $IO_PORT @ATTACH &n1054 => @PLACE(386, -2235) => @ORIENT("MY");
// %t4210 @TEXT("n1054", key="name", size=0.75);
// &n1054 @WIRE(mode="straight") {#X829:3 %t4210:p};
// %t4211 = $SUPPLY @ATTACH &vdd => @PLACE(376, -2224);
// &vdd @WIRE(mode="straight") {#X829:4 %t4211:p};
// %t4212 = $GROUND @ATTACH &vss => @PLACE(376, -2246);
// &vss @WIRE(mode="straight") {#X829:5 %t4212:p};
// %t4213 = $IO_PORT @ATTACH &n1054 => @PLACE(406, -2233) => @ORIENT("R0");
// %t4213 @TEXT("n1054", key="name", size=0.75);
// &n1054 @WIRE(mode="straight") {#X830:1 %t4213:p};
// %t4214 = $IO_PORT @ATTACH &n1055 => @PLACE(406, -2237) => @ORIENT("R0");
// %t4214 @TEXT("n1055", key="name", size=0.75);
// &n1055 @WIRE(mode="straight") {#X830:2 %t4214:p};
// %t4215 = $IO_PORT @ATTACH &n1056 => @PLACE(426, -2235) => @ORIENT("MY");
// %t4215 @TEXT("n1056", key="name", size=0.75);
// &n1056 @WIRE(mode="straight") {#X830:3 %t4215:p};
// %t4216 = $SUPPLY @ATTACH &vdd => @PLACE(416, -2224);
// &vdd @WIRE(mode="straight") {#X830:4 %t4216:p};
// %t4217 = $GROUND @ATTACH &vss => @PLACE(416, -2246);
// &vss @WIRE(mode="straight") {#X830:5 %t4217:p};
// %t4218 = $IO_PORT @ATTACH &n224 => @PLACE(446, -2233) => @ORIENT("R0");
// %t4218 @TEXT("n224", key="name", size=0.75);
// &n224 @WIRE(mode="straight") {#X831:1 %t4218:p};
// %t4219 = $IO_PORT @ATTACH &target_k1 => @PLACE(446, -2237) => @ORIENT("R0");
// %t4219 @TEXT("target_k1", key="name", size=0.75);
// &target_k1 @WIRE(mode="straight") {#X831:2 %t4219:p};
// %t4220 = $IO_PORT @ATTACH &n1057 => @PLACE(466, -2235) => @ORIENT("MY");
// %t4220 @TEXT("n1057", key="name", size=0.75);
// &n1057 @WIRE(mode="straight") {#X831:3 %t4220:p};
// %t4221 = $SUPPLY @ATTACH &vdd => @PLACE(456, -2224);
// &vdd @WIRE(mode="straight") {#X831:4 %t4221:p};
// %t4222 = $GROUND @ATTACH &vss => @PLACE(456, -2246);
// &vss @WIRE(mode="straight") {#X831:5 %t4222:p};
// %t4223 = $IO_PORT @ATTACH &target_k2 => @PLACE(326, -2264) => @ORIENT("R0");
// %t4223 @TEXT("target_k2", key="name", size=0.75);
// &target_k2 @WIRE(mode="straight") {#X832:1 %t4223:p};
// %t4224 = $IO_PORT @ATTACH &n754 => @PLACE(326, -2268) => @ORIENT("R0");
// %t4224 @TEXT("n754", key="name", size=0.75);
// &n754 @WIRE(mode="straight") {#X832:2 %t4224:p};
// %t4225 = $IO_PORT @ATTACH &n1058 => @PLACE(346, -2266) => @ORIENT("MY");
// %t4225 @TEXT("n1058", key="name", size=0.75);
// &n1058 @WIRE(mode="straight") {#X832:3 %t4225:p};
// %t4226 = $SUPPLY @ATTACH &vdd => @PLACE(336, -2255);
// &vdd @WIRE(mode="straight") {#X832:4 %t4226:p};
// %t4227 = $GROUND @ATTACH &vss => @PLACE(336, -2277);
// &vss @WIRE(mode="straight") {#X832:5 %t4227:p};
// %t4228 = $IO_PORT @ATTACH &target_k4 => @PLACE(366, -2264) => @ORIENT("R0");
// %t4228 @TEXT("target_k4", key="name", size=0.75);
// &target_k4 @WIRE(mode="straight") {#X833:1 %t4228:p};
// %t4229 = $IO_PORT @ATTACH &target_k5 => @PLACE(366, -2268) => @ORIENT("R0");
// %t4229 @TEXT("target_k5", key="name", size=0.75);
// &target_k5 @WIRE(mode="straight") {#X833:2 %t4229:p};
// %t4230 = $IO_PORT @ATTACH &n1059 => @PLACE(386, -2266) => @ORIENT("MY");
// %t4230 @TEXT("n1059", key="name", size=0.75);
// &n1059 @WIRE(mode="straight") {#X833:3 %t4230:p};
// %t4231 = $SUPPLY @ATTACH &vdd => @PLACE(376, -2255);
// &vdd @WIRE(mode="straight") {#X833:4 %t4231:p};
// %t4232 = $GROUND @ATTACH &vss => @PLACE(376, -2277);
// &vss @WIRE(mode="straight") {#X833:5 %t4232:p};
// %t4233 = $IO_PORT @ATTACH &n1057 => @PLACE(406, -2264) => @ORIENT("R0");
// %t4233 @TEXT("n1057", key="name", size=0.75);
// &n1057 @WIRE(mode="straight") {#X834:1 %t4233:p};
// %t4234 = $IO_PORT @ATTACH &n1058 => @PLACE(406, -2268) => @ORIENT("R0");
// %t4234 @TEXT("n1058", key="name", size=0.75);
// &n1058 @WIRE(mode="straight") {#X834:2 %t4234:p};
// %t4235 = $IO_PORT @ATTACH &n1060 => @PLACE(426, -2266) => @ORIENT("MY");
// %t4235 @TEXT("n1060", key="name", size=0.75);
// &n1060 @WIRE(mode="straight") {#X834:3 %t4235:p};
// %t4236 = $SUPPLY @ATTACH &vdd => @PLACE(416, -2255);
// &vdd @WIRE(mode="straight") {#X834:4 %t4236:p};
// %t4237 = $GROUND @ATTACH &vss => @PLACE(416, -2277);
// &vss @WIRE(mode="straight") {#X834:5 %t4237:p};
// %t4238 = $IO_PORT @ATTACH &n1060 => @PLACE(446, -2264) => @ORIENT("R0");
// %t4238 @TEXT("n1060", key="name", size=0.75);
// &n1060 @WIRE(mode="straight") {#X835:1 %t4238:p};
// %t4239 = $IO_PORT @ATTACH &n1059 => @PLACE(446, -2268) => @ORIENT("R0");
// %t4239 @TEXT("n1059", key="name", size=0.75);
// &n1059 @WIRE(mode="straight") {#X835:2 %t4239:p};
// %t4240 = $IO_PORT @ATTACH &n1061 => @PLACE(466, -2266) => @ORIENT("MY");
// %t4240 @TEXT("n1061", key="name", size=0.75);
// &n1061 @WIRE(mode="straight") {#X835:3 %t4240:p};
// %t4241 = $SUPPLY @ATTACH &vdd => @PLACE(456, -2255);
// &vdd @WIRE(mode="straight") {#X835:4 %t4241:p};
// %t4242 = $GROUND @ATTACH &vss => @PLACE(456, -2277);
// &vss @WIRE(mode="straight") {#X835:5 %t4242:p};
// %t4243 = $IO_PORT @ATTACH &n1062 => @PLACE(326, -2295) => @ORIENT("R0");
// %t4243 @TEXT("n1062", key="name", size=0.75);
// &n1062 @WIRE(mode="straight") {#X836:1 %t4243:p};
// %t4244 = $IO_PORT @ATTACH &n318 => @PLACE(326, -2299) => @ORIENT("R0");
// %t4244 @TEXT("n318", key="name", size=0.75);
// &n318 @WIRE(mode="straight") {#X836:2 %t4244:p};
// %t4245 = $IO_PORT @ATTACH &n1063 => @PLACE(346, -2297) => @ORIENT("MY");
// %t4245 @TEXT("n1063", key="name", size=0.75);
// &n1063 @WIRE(mode="straight") {#X836:3 %t4245:p};
// %t4246 = $SUPPLY @ATTACH &vdd => @PLACE(336, -2286);
// &vdd @WIRE(mode="straight") {#X836:4 %t4246:p};
// %t4247 = $GROUND @ATTACH &vss => @PLACE(336, -2308);
// &vss @WIRE(mode="straight") {#X836:5 %t4247:p};
// %t4248 = $IO_PORT @ATTACH &n319 => @PLACE(366, -2295) => @ORIENT("R0");
// %t4248 @TEXT("n319", key="name", size=0.75);
// &n319 @WIRE(mode="straight") {#X837:1 %t4248:p};
// %t4249 = $IO_PORT @ATTACH &n109 => @PLACE(366, -2299) => @ORIENT("R0");
// %t4249 @TEXT("n109", key="name", size=0.75);
// &n109 @WIRE(mode="straight") {#X837:2 %t4249:p};
// %t4250 = $IO_PORT @ATTACH &n1064 => @PLACE(386, -2297) => @ORIENT("MY");
// %t4250 @TEXT("n1064", key="name", size=0.75);
// &n1064 @WIRE(mode="straight") {#X837:3 %t4250:p};
// %t4251 = $SUPPLY @ATTACH &vdd => @PLACE(376, -2286);
// &vdd @WIRE(mode="straight") {#X837:4 %t4251:p};
// %t4252 = $GROUND @ATTACH &vss => @PLACE(376, -2308);
// &vss @WIRE(mode="straight") {#X837:5 %t4252:p};
// %t4253 = $IO_PORT @ATTACH &n1065 => @PLACE(406, -2295) => @ORIENT("R0");
// %t4253 @TEXT("n1065", key="name", size=0.75);
// &n1065 @WIRE(mode="straight") {#X838:1 %t4253:p};
// %t4254 = $IO_PORT @ATTACH &n1063 => @PLACE(406, -2299) => @ORIENT("R0");
// %t4254 @TEXT("n1063", key="name", size=0.75);
// &n1063 @WIRE(mode="straight") {#X838:2 %t4254:p};
// %t4255 = $IO_PORT @ATTACH &n1066 => @PLACE(426, -2297) => @ORIENT("MY");
// %t4255 @TEXT("n1066", key="name", size=0.75);
// &n1066 @WIRE(mode="straight") {#X838:3 %t4255:p};
// %t4256 = $SUPPLY @ATTACH &vdd => @PLACE(416, -2286);
// &vdd @WIRE(mode="straight") {#X838:4 %t4256:p};
// %t4257 = $GROUND @ATTACH &vss => @PLACE(416, -2308);
// &vss @WIRE(mode="straight") {#X838:5 %t4257:p};
// %t4258 = $IO_PORT @ATTACH &n1064 => @PLACE(446, -2295) => @ORIENT("R0");
// %t4258 @TEXT("n1064", key="name", size=0.75);
// &n1064 @WIRE(mode="straight") {#X839:1 %t4258:p};
// %t4259 = $IO_PORT @ATTACH &n1067 => @PLACE(446, -2299) => @ORIENT("R0");
// %t4259 @TEXT("n1067", key="name", size=0.75);
// &n1067 @WIRE(mode="straight") {#X839:2 %t4259:p};
// %t4260 = $IO_PORT @ATTACH &n1068 => @PLACE(466, -2297) => @ORIENT("MY");
// %t4260 @TEXT("n1068", key="name", size=0.75);
// &n1068 @WIRE(mode="straight") {#X839:3 %t4260:p};
// %t4261 = $SUPPLY @ATTACH &vdd => @PLACE(456, -2286);
// &vdd @WIRE(mode="straight") {#X839:4 %t4261:p};
// %t4262 = $GROUND @ATTACH &vss => @PLACE(456, -2308);
// &vss @WIRE(mode="straight") {#X839:5 %t4262:p};
// %t4263 = $IO_PORT @ATTACH &n1066 => @PLACE(494, -2140) => @ORIENT("R0");
// %t4263 @TEXT("n1066", key="name", size=0.75);
// &n1066 @WIRE(mode="straight") {#X840:1 %t4263:p};
// %t4264 = $IO_PORT @ATTACH &n1068 => @PLACE(494, -2144) => @ORIENT("R0");
// %t4264 @TEXT("n1068", key="name", size=0.75);
// &n1068 @WIRE(mode="straight") {#X840:2 %t4264:p};
// %t4265 = $IO_PORT @ATTACH &n1069 => @PLACE(514, -2142) => @ORIENT("MY");
// %t4265 @TEXT("n1069", key="name", size=0.75);
// &n1069 @WIRE(mode="straight") {#X840:3 %t4265:p};
// %t4266 = $SUPPLY @ATTACH &vdd => @PLACE(504, -2131);
// &vdd @WIRE(mode="straight") {#X840:4 %t4266:p};
// %t4267 = $GROUND @ATTACH &vss => @PLACE(504, -2153);
// &vss @WIRE(mode="straight") {#X840:5 %t4267:p};
// %t4268 = $IO_PORT @ATTACH &n230 => @PLACE(534, -2140) => @ORIENT("R0");
// %t4268 @TEXT("n230", key="name", size=0.75);
// &n230 @WIRE(mode="straight") {#X841:1 %t4268:p};
// %t4269 = $IO_PORT @ATTACH &n320 => @PLACE(534, -2144) => @ORIENT("R0");
// %t4269 @TEXT("n320", key="name", size=0.75);
// &n320 @WIRE(mode="straight") {#X841:2 %t4269:p};
// %t4270 = $IO_PORT @ATTACH &n1070 => @PLACE(554, -2142) => @ORIENT("MY");
// %t4270 @TEXT("n1070", key="name", size=0.75);
// &n1070 @WIRE(mode="straight") {#X841:3 %t4270:p};
// %t4271 = $SUPPLY @ATTACH &vdd => @PLACE(544, -2131);
// &vdd @WIRE(mode="straight") {#X841:4 %t4271:p};
// %t4272 = $GROUND @ATTACH &vss => @PLACE(544, -2153);
// &vss @WIRE(mode="straight") {#X841:5 %t4272:p};
// %t4273 = $IO_PORT @ATTACH &n321 => @PLACE(574, -2140) => @ORIENT("R0");
// %t4273 @TEXT("n321", key="name", size=0.75);
// &n321 @WIRE(mode="straight") {#X842:1 %t4273:p};
// %t4274 = $IO_PORT @ATTACH &n113 => @PLACE(574, -2144) => @ORIENT("R0");
// %t4274 @TEXT("n113", key="name", size=0.75);
// &n113 @WIRE(mode="straight") {#X842:2 %t4274:p};
// %t4275 = $IO_PORT @ATTACH &n1071 => @PLACE(594, -2142) => @ORIENT("MY");
// %t4275 @TEXT("n1071", key="name", size=0.75);
// &n1071 @WIRE(mode="straight") {#X842:3 %t4275:p};
// %t4276 = $SUPPLY @ATTACH &vdd => @PLACE(584, -2131);
// &vdd @WIRE(mode="straight") {#X842:4 %t4276:p};
// %t4277 = $GROUND @ATTACH &vss => @PLACE(584, -2153);
// &vss @WIRE(mode="straight") {#X842:5 %t4277:p};
// %t4278 = $IO_PORT @ATTACH &n1070 => @PLACE(614, -2140) => @ORIENT("R0");
// %t4278 @TEXT("n1070", key="name", size=0.75);
// &n1070 @WIRE(mode="straight") {#X843:1 %t4278:p};
// %t4279 = $IO_PORT @ATTACH &n1071 => @PLACE(614, -2144) => @ORIENT("R0");
// %t4279 @TEXT("n1071", key="name", size=0.75);
// &n1071 @WIRE(mode="straight") {#X843:2 %t4279:p};
// %t4280 = $IO_PORT @ATTACH &n1072 => @PLACE(635, -2142) => @ORIENT("MY");
// %t4280 @TEXT("n1072", key="name", size=0.75);
// &n1072 @WIRE(mode="straight") {#X843:3 %t4280:p};
// %t4281 = $SUPPLY @ATTACH &vdd => @PLACE(624, -2131);
// &vdd @WIRE(mode="straight") {#X843:4 %t4281:p};
// %t4282 = $GROUND @ATTACH &vss => @PLACE(624, -2153);
// &vss @WIRE(mode="straight") {#X843:5 %t4282:p};
// %t4283 = $IO_PORT @ATTACH &n1073 => @PLACE(494, -2171) => @ORIENT("R0");
// %t4283 @TEXT("n1073", key="name", size=0.75);
// &n1073 @WIRE(mode="straight") {#X844:1 %t4283:p};
// %t4284 = $IO_PORT @ATTACH &n1072 => @PLACE(494, -2175) => @ORIENT("R0");
// %t4284 @TEXT("n1072", key="name", size=0.75);
// &n1072 @WIRE(mode="straight") {#X844:2 %t4284:p};
// %t4285 = $IO_PORT @ATTACH &n1074 => @PLACE(514, -2173) => @ORIENT("MY");
// %t4285 @TEXT("n1074", key="name", size=0.75);
// &n1074 @WIRE(mode="straight") {#X844:3 %t4285:p};
// %t4286 = $SUPPLY @ATTACH &vdd => @PLACE(504, -2162);
// &vdd @WIRE(mode="straight") {#X844:4 %t4286:p};
// %t4287 = $GROUND @ATTACH &vss => @PLACE(504, -2184);
// &vss @WIRE(mode="straight") {#X844:5 %t4287:p};
// %t4288 = $IO_PORT @ATTACH &n99 => @PLACE(534, -2171) => @ORIENT("R0");
// %t4288 @TEXT("n99", key="name", size=0.75);
// &n99 @WIRE(mode="straight") {#X845:1 %t4288:p};
// %t4289 = $IO_PORT @ATTACH &n1075 => @PLACE(534, -2175) => @ORIENT("R0");
// %t4289 @TEXT("n1075", key="name", size=0.75);
// &n1075 @WIRE(mode="straight") {#X845:2 %t4289:p};
// %t4290 = $IO_PORT @ATTACH &n1076 => @PLACE(554, -2173) => @ORIENT("MY");
// %t4290 @TEXT("n1076", key="name", size=0.75);
// &n1076 @WIRE(mode="straight") {#X845:3 %t4290:p};
// %t4291 = $SUPPLY @ATTACH &vdd => @PLACE(544, -2162);
// &vdd @WIRE(mode="straight") {#X845:4 %t4291:p};
// %t4292 = $GROUND @ATTACH &vss => @PLACE(544, -2184);
// &vss @WIRE(mode="straight") {#X845:5 %t4292:p};
// %t4293 = $IO_PORT @ATTACH &n103 => @PLACE(574, -2171) => @ORIENT("R0");
// %t4293 @TEXT("n103", key="name", size=0.75);
// &n103 @WIRE(mode="straight") {#X846:1 %t4293:p};
// %t4294 = $IO_PORT @ATTACH &n105 => @PLACE(574, -2175) => @ORIENT("R0");
// %t4294 @TEXT("n105", key="name", size=0.75);
// &n105 @WIRE(mode="straight") {#X846:2 %t4294:p};
// %t4295 = $IO_PORT @ATTACH &n1077 => @PLACE(594, -2173) => @ORIENT("MY");
// %t4295 @TEXT("n1077", key="name", size=0.75);
// &n1077 @WIRE(mode="straight") {#X846:3 %t4295:p};
// %t4296 = $SUPPLY @ATTACH &vdd => @PLACE(584, -2162);
// &vdd @WIRE(mode="straight") {#X846:4 %t4296:p};
// %t4297 = $GROUND @ATTACH &vss => @PLACE(584, -2184);
// &vss @WIRE(mode="straight") {#X846:5 %t4297:p};
// %t4298 = $IO_PORT @ATTACH &n107 => @PLACE(614, -2171) => @ORIENT("R0");
// %t4298 @TEXT("n107", key="name", size=0.75);
// &n107 @WIRE(mode="straight") {#X847:1 %t4298:p};
// %t4299 = $IO_PORT @ATTACH &n109 => @PLACE(614, -2175) => @ORIENT("R0");
// %t4299 @TEXT("n109", key="name", size=0.75);
// &n109 @WIRE(mode="straight") {#X847:2 %t4299:p};
// %t4300 = $IO_PORT @ATTACH &n1078 => @PLACE(635, -2173) => @ORIENT("MY");
// %t4300 @TEXT("n1078", key="name", size=0.75);
// &n1078 @WIRE(mode="straight") {#X847:3 %t4300:p};
// %t4301 = $SUPPLY @ATTACH &vdd => @PLACE(624, -2162);
// &vdd @WIRE(mode="straight") {#X847:4 %t4301:p};
// %t4302 = $GROUND @ATTACH &vss => @PLACE(624, -2184);
// &vss @WIRE(mode="straight") {#X847:5 %t4302:p};
// %t4303 = $IO_PORT @ATTACH &n1076 => @PLACE(494, -2202) => @ORIENT("R0");
// %t4303 @TEXT("n1076", key="name", size=0.75);
// &n1076 @WIRE(mode="straight") {#X848:1 %t4303:p};
// %t4304 = $IO_PORT @ATTACH &n1077 => @PLACE(494, -2206) => @ORIENT("R0");
// %t4304 @TEXT("n1077", key="name", size=0.75);
// &n1077 @WIRE(mode="straight") {#X848:2 %t4304:p};
// %t4305 = $IO_PORT @ATTACH &n1079 => @PLACE(514, -2204) => @ORIENT("MY");
// %t4305 @TEXT("n1079", key="name", size=0.75);
// &n1079 @WIRE(mode="straight") {#X848:3 %t4305:p};
// %t4306 = $SUPPLY @ATTACH &vdd => @PLACE(504, -2193);
// &vdd @WIRE(mode="straight") {#X848:4 %t4306:p};
// %t4307 = $GROUND @ATTACH &vss => @PLACE(504, -2215);
// &vss @WIRE(mode="straight") {#X848:5 %t4307:p};
// %t4308 = $IO_PORT @ATTACH &n1078 => @PLACE(534, -2202) => @ORIENT("R0");
// %t4308 @TEXT("n1078", key="name", size=0.75);
// &n1078 @WIRE(mode="straight") {#X849:1 %t4308:p};
// %t4309 = $IO_PORT @ATTACH &n1067 => @PLACE(534, -2206) => @ORIENT("R0");
// %t4309 @TEXT("n1067", key="name", size=0.75);
// &n1067 @WIRE(mode="straight") {#X849:2 %t4309:p};
// %t4310 = $IO_PORT @ATTACH &n1080 => @PLACE(554, -2204) => @ORIENT("MY");
// %t4310 @TEXT("n1080", key="name", size=0.75);
// &n1080 @WIRE(mode="straight") {#X849:3 %t4310:p};
// %t4311 = $SUPPLY @ATTACH &vdd => @PLACE(544, -2193);
// &vdd @WIRE(mode="straight") {#X849:4 %t4311:p};
// %t4312 = $GROUND @ATTACH &vss => @PLACE(544, -2215);
// &vss @WIRE(mode="straight") {#X849:5 %t4312:p};
// %t4313 = $IO_PORT @ATTACH &n1079 => @PLACE(574, -2202) => @ORIENT("R0");
// %t4313 @TEXT("n1079", key="name", size=0.75);
// &n1079 @WIRE(mode="straight") {#X850:1 %t4313:p};
// %t4314 = $IO_PORT @ATTACH &n1080 => @PLACE(574, -2206) => @ORIENT("R0");
// %t4314 @TEXT("n1080", key="name", size=0.75);
// &n1080 @WIRE(mode="straight") {#X850:2 %t4314:p};
// %t4315 = $IO_PORT @ATTACH &n1081 => @PLACE(594, -2204) => @ORIENT("MY");
// %t4315 @TEXT("n1081", key="name", size=0.75);
// &n1081 @WIRE(mode="straight") {#X850:3 %t4315:p};
// %t4316 = $SUPPLY @ATTACH &vdd => @PLACE(584, -2193);
// &vdd @WIRE(mode="straight") {#X850:4 %t4316:p};
// %t4317 = $GROUND @ATTACH &vss => @PLACE(584, -2215);
// &vss @WIRE(mode="straight") {#X850:5 %t4317:p};
// %t4318 = $IO_PORT @ATTACH &n296 => @PLACE(614, -2202) => @ORIENT("R0");
// %t4318 @TEXT("n296", key="name", size=0.75);
// &n296 @WIRE(mode="straight") {#X851:1 %t4318:p};
// %t4319 = $IO_PORT @ATTACH &n538 => @PLACE(614, -2206) => @ORIENT("R0");
// %t4319 @TEXT("n538", key="name", size=0.75);
// &n538 @WIRE(mode="straight") {#X851:2 %t4319:p};
// %t4320 = $IO_PORT @ATTACH &n1082 => @PLACE(635, -2204) => @ORIENT("MY");
// %t4320 @TEXT("n1082", key="name", size=0.75);
// &n1082 @WIRE(mode="straight") {#X851:3 %t4320:p};
// %t4321 = $SUPPLY @ATTACH &vdd => @PLACE(624, -2193);
// &vdd @WIRE(mode="straight") {#X851:4 %t4321:p};
// %t4322 = $GROUND @ATTACH &vss => @PLACE(624, -2215);
// &vss @WIRE(mode="straight") {#X851:5 %t4322:p};
// %t4323 = $IO_PORT @ATTACH &n540 => @PLACE(494, -2233) => @ORIENT("R0");
// %t4323 @TEXT("n540", key="name", size=0.75);
// &n540 @WIRE(mode="straight") {#X852:1 %t4323:p};
// %t4324 = $IO_PORT @ATTACH &n543 => @PLACE(494, -2237) => @ORIENT("R0");
// %t4324 @TEXT("n543", key="name", size=0.75);
// &n543 @WIRE(mode="straight") {#X852:2 %t4324:p};
// %t4325 = $IO_PORT @ATTACH &n1083 => @PLACE(514, -2235) => @ORIENT("MY");
// %t4325 @TEXT("n1083", key="name", size=0.75);
// &n1083 @WIRE(mode="straight") {#X852:3 %t4325:p};
// %t4326 = $SUPPLY @ATTACH &vdd => @PLACE(504, -2224);
// &vdd @WIRE(mode="straight") {#X852:4 %t4326:p};
// %t4327 = $GROUND @ATTACH &vss => @PLACE(504, -2246);
// &vss @WIRE(mode="straight") {#X852:5 %t4327:p};
// %t4328 = $IO_PORT @ATTACH &n546 => @PLACE(534, -2233) => @ORIENT("R0");
// %t4328 @TEXT("n546", key="name", size=0.75);
// &n546 @WIRE(mode="straight") {#X853:1 %t4328:p};
// %t4329 = $IO_PORT @ATTACH &n549 => @PLACE(534, -2237) => @ORIENT("R0");
// %t4329 @TEXT("n549", key="name", size=0.75);
// &n549 @WIRE(mode="straight") {#X853:2 %t4329:p};
// %t4330 = $IO_PORT @ATTACH &n1084 => @PLACE(554, -2235) => @ORIENT("MY");
// %t4330 @TEXT("n1084", key="name", size=0.75);
// &n1084 @WIRE(mode="straight") {#X853:3 %t4330:p};
// %t4331 = $SUPPLY @ATTACH &vdd => @PLACE(544, -2224);
// &vdd @WIRE(mode="straight") {#X853:4 %t4331:p};
// %t4332 = $GROUND @ATTACH &vss => @PLACE(544, -2246);
// &vss @WIRE(mode="straight") {#X853:5 %t4332:p};
// %t4333 = $IO_PORT @ATTACH &n552 => @PLACE(574, -2233) => @ORIENT("R0");
// %t4333 @TEXT("n552", key="name", size=0.75);
// &n552 @WIRE(mode="straight") {#X854:1 %t4333:p};
// %t4334 = $IO_PORT @ATTACH &n295 => @PLACE(574, -2237) => @ORIENT("R0");
// %t4334 @TEXT("n295", key="name", size=0.75);
// &n295 @WIRE(mode="straight") {#X854:2 %t4334:p};
// %t4335 = $IO_PORT @ATTACH &n1085 => @PLACE(594, -2235) => @ORIENT("MY");
// %t4335 @TEXT("n1085", key="name", size=0.75);
// &n1085 @WIRE(mode="straight") {#X854:3 %t4335:p};
// %t4336 = $SUPPLY @ATTACH &vdd => @PLACE(584, -2224);
// &vdd @WIRE(mode="straight") {#X854:4 %t4336:p};
// %t4337 = $GROUND @ATTACH &vss => @PLACE(584, -2246);
// &vss @WIRE(mode="straight") {#X854:5 %t4337:p};
// %t4338 = $IO_PORT @ATTACH &n1082 => @PLACE(614, -2233) => @ORIENT("R0");
// %t4338 @TEXT("n1082", key="name", size=0.75);
// &n1082 @WIRE(mode="straight") {#X855:1 %t4338:p};
// %t4339 = $IO_PORT @ATTACH &n1083 => @PLACE(614, -2237) => @ORIENT("R0");
// %t4339 @TEXT("n1083", key="name", size=0.75);
// &n1083 @WIRE(mode="straight") {#X855:2 %t4339:p};
// %t4340 = $IO_PORT @ATTACH &n1086 => @PLACE(635, -2235) => @ORIENT("MY");
// %t4340 @TEXT("n1086", key="name", size=0.75);
// &n1086 @WIRE(mode="straight") {#X855:3 %t4340:p};
// %t4341 = $SUPPLY @ATTACH &vdd => @PLACE(624, -2224);
// &vdd @WIRE(mode="straight") {#X855:4 %t4341:p};
// %t4342 = $GROUND @ATTACH &vss => @PLACE(624, -2246);
// &vss @WIRE(mode="straight") {#X855:5 %t4342:p};
// %t4343 = $IO_PORT @ATTACH &n1084 => @PLACE(494, -2264) => @ORIENT("R0");
// %t4343 @TEXT("n1084", key="name", size=0.75);
// &n1084 @WIRE(mode="straight") {#X856:1 %t4343:p};
// %t4344 = $IO_PORT @ATTACH &n1085 => @PLACE(494, -2268) => @ORIENT("R0");
// %t4344 @TEXT("n1085", key="name", size=0.75);
// &n1085 @WIRE(mode="straight") {#X856:2 %t4344:p};
// %t4345 = $IO_PORT @ATTACH &n1087 => @PLACE(514, -2266) => @ORIENT("MY");
// %t4345 @TEXT("n1087", key="name", size=0.75);
// &n1087 @WIRE(mode="straight") {#X856:3 %t4345:p};
// %t4346 = $SUPPLY @ATTACH &vdd => @PLACE(504, -2255);
// &vdd @WIRE(mode="straight") {#X856:4 %t4346:p};
// %t4347 = $GROUND @ATTACH &vss => @PLACE(504, -2277);
// &vss @WIRE(mode="straight") {#X856:5 %t4347:p};
// %t4348 = $IO_PORT @ATTACH &n1086 => @PLACE(534, -2264) => @ORIENT("R0");
// %t4348 @TEXT("n1086", key="name", size=0.75);
// &n1086 @WIRE(mode="straight") {#X857:1 %t4348:p};
// %t4349 = $IO_PORT @ATTACH &n1087 => @PLACE(534, -2268) => @ORIENT("R0");
// %t4349 @TEXT("n1087", key="name", size=0.75);
// &n1087 @WIRE(mode="straight") {#X857:2 %t4349:p};
// %t4350 = $IO_PORT @ATTACH &n1088 => @PLACE(554, -2266) => @ORIENT("MY");
// %t4350 @TEXT("n1088", key="name", size=0.75);
// &n1088 @WIRE(mode="straight") {#X857:3 %t4350:p};
// %t4351 = $SUPPLY @ATTACH &vdd => @PLACE(544, -2255);
// &vdd @WIRE(mode="straight") {#X857:4 %t4351:p};
// %t4352 = $GROUND @ATTACH &vss => @PLACE(544, -2277);
// &vss @WIRE(mode="straight") {#X857:5 %t4352:p};
// %t4353 = $IO_PORT @ATTACH &n1089 => @PLACE(574, -2264) => @ORIENT("R0");
// %t4353 @TEXT("n1089", key="name", size=0.75);
// &n1089 @WIRE(mode="straight") {#X858:1 %t4353:p};
// %t4354 = $IO_PORT @ATTACH &n1090 => @PLACE(574, -2268) => @ORIENT("R0");
// %t4354 @TEXT("n1090", key="name", size=0.75);
// &n1090 @WIRE(mode="straight") {#X858:2 %t4354:p};
// %t4355 = $IO_PORT @ATTACH &n1091 => @PLACE(594, -2266) => @ORIENT("MY");
// %t4355 @TEXT("n1091", key="name", size=0.75);
// &n1091 @WIRE(mode="straight") {#X858:3 %t4355:p};
// %t4356 = $SUPPLY @ATTACH &vdd => @PLACE(584, -2255);
// &vdd @WIRE(mode="straight") {#X858:4 %t4356:p};
// %t4357 = $GROUND @ATTACH &vss => @PLACE(584, -2277);
// &vss @WIRE(mode="straight") {#X858:5 %t4357:p};
// %t4358 = $IO_PORT @ATTACH &n1091 => @PLACE(614, -2264) => @ORIENT("R0");
// %t4358 @TEXT("n1091", key="name", size=0.75);
// &n1091 @WIRE(mode="straight") {#X859:1 %t4358:p};
// %t4359 = $IO_PORT @ATTACH &n228 => @PLACE(614, -2268) => @ORIENT("R0");
// %t4359 @TEXT("n228", key="name", size=0.75);
// &n228 @WIRE(mode="straight") {#X859:2 %t4359:p};
// %t4360 = $IO_PORT @ATTACH &n960 => @PLACE(635, -2266) => @ORIENT("MY");
// %t4360 @TEXT("n960", key="name", size=0.75);
// &n960 @WIRE(mode="straight") {#X859:3 %t4360:p};
// %t4361 = $SUPPLY @ATTACH &vdd => @PLACE(624, -2255);
// &vdd @WIRE(mode="straight") {#X859:4 %t4361:p};
// %t4362 = $GROUND @ATTACH &vss => @PLACE(624, -2277);
// &vss @WIRE(mode="straight") {#X859:5 %t4362:p};
// %t4363 = $IO_PORT @ATTACH &n227 => @PLACE(494, -2295) => @ORIENT("R0");
// %t4363 @TEXT("n227", key="name", size=0.75);
// &n227 @WIRE(mode="straight") {#X860:1 %t4363:p};
// %t4364 = $IO_PORT @ATTACH &n60 => @PLACE(494, -2299) => @ORIENT("R0");
// %t4364 @TEXT("n60", key="name", size=0.75);
// &n60 @WIRE(mode="straight") {#X860:2 %t4364:p};
// %t4365 = $IO_PORT @ATTACH &n1092 => @PLACE(514, -2297) => @ORIENT("MY");
// %t4365 @TEXT("n1092", key="name", size=0.75);
// &n1092 @WIRE(mode="straight") {#X860:3 %t4365:p};
// %t4366 = $SUPPLY @ATTACH &vdd => @PLACE(504, -2286);
// &vdd @WIRE(mode="straight") {#X860:4 %t4366:p};
// %t4367 = $GROUND @ATTACH &vss => @PLACE(504, -2308);
// &vss @WIRE(mode="straight") {#X860:5 %t4367:p};
// %t4368 = $IO_PORT @ATTACH &n62 => @PLACE(534, -2295) => @ORIENT("R0");
// %t4368 @TEXT("n62", key="name", size=0.75);
// &n62 @WIRE(mode="straight") {#X861:1 %t4368:p};
// %t4369 = $IO_PORT @ATTACH &n64 => @PLACE(534, -2299) => @ORIENT("R0");
// %t4369 @TEXT("n64", key="name", size=0.75);
// &n64 @WIRE(mode="straight") {#X861:2 %t4369:p};
// %t4370 = $IO_PORT @ATTACH &n1093 => @PLACE(554, -2297) => @ORIENT("MY");
// %t4370 @TEXT("n1093", key="name", size=0.75);
// &n1093 @WIRE(mode="straight") {#X861:3 %t4370:p};
// %t4371 = $SUPPLY @ATTACH &vdd => @PLACE(544, -2286);
// &vdd @WIRE(mode="straight") {#X861:4 %t4371:p};
// %t4372 = $GROUND @ATTACH &vss => @PLACE(544, -2308);
// &vss @WIRE(mode="straight") {#X861:5 %t4372:p};
// %t4373 = $IO_PORT @ATTACH &n66 => @PLACE(574, -2295) => @ORIENT("R0");
// %t4373 @TEXT("n66", key="name", size=0.75);
// &n66 @WIRE(mode="straight") {#X862:1 %t4373:p};
// %t4374 = $IO_PORT @ATTACH &n68 => @PLACE(574, -2299) => @ORIENT("R0");
// %t4374 @TEXT("n68", key="name", size=0.75);
// &n68 @WIRE(mode="straight") {#X862:2 %t4374:p};
// %t4375 = $IO_PORT @ATTACH &n1094 => @PLACE(594, -2297) => @ORIENT("MY");
// %t4375 @TEXT("n1094", key="name", size=0.75);
// &n1094 @WIRE(mode="straight") {#X862:3 %t4375:p};
// %t4376 = $SUPPLY @ATTACH &vdd => @PLACE(584, -2286);
// &vdd @WIRE(mode="straight") {#X862:4 %t4376:p};
// %t4377 = $GROUND @ATTACH &vss => @PLACE(584, -2308);
// &vss @WIRE(mode="straight") {#X862:5 %t4377:p};
// %t4378 = $IO_PORT @ATTACH &n70 => @PLACE(614, -2295) => @ORIENT("R0");
// %t4378 @TEXT("n70", key="name", size=0.75);
// &n70 @WIRE(mode="straight") {#X863:1 %t4378:p};
// %t4379 = $IO_PORT @ATTACH &n72 => @PLACE(614, -2299) => @ORIENT("R0");
// %t4379 @TEXT("n72", key="name", size=0.75);
// &n72 @WIRE(mode="straight") {#X863:2 %t4379:p};
// %t4380 = $IO_PORT @ATTACH &n1095 => @PLACE(635, -2297) => @ORIENT("MY");
// %t4380 @TEXT("n1095", key="name", size=0.75);
// &n1095 @WIRE(mode="straight") {#X863:3 %t4380:p};
// %t4381 = $SUPPLY @ATTACH &vdd => @PLACE(624, -2286);
// &vdd @WIRE(mode="straight") {#X863:4 %t4381:p};
// %t4382 = $GROUND @ATTACH &vss => @PLACE(624, -2308);
// &vss @WIRE(mode="straight") {#X863:5 %t4382:p};
// %t4383 = $IO_PORT @ATTACH &n1092 => @PLACE(-11, -2338) => @ORIENT("R0");
// %t4383 @TEXT("n1092", key="name", size=0.75);
// &n1092 @WIRE(mode="straight") {#X864:1 %t4383:p};
// %t4384 = $IO_PORT @ATTACH &n1093 => @PLACE(-11, -2342) => @ORIENT("R0");
// %t4384 @TEXT("n1093", key="name", size=0.75);
// &n1093 @WIRE(mode="straight") {#X864:2 %t4384:p};
// %t4385 = $IO_PORT @ATTACH &n1096 => @PLACE(10, -2340) => @ORIENT("MY");
// %t4385 @TEXT("n1096", key="name", size=0.75);
// &n1096 @WIRE(mode="straight") {#X864:3 %t4385:p};
// %t4386 = $SUPPLY @ATTACH &vdd => @PLACE(0, -2329);
// &vdd @WIRE(mode="straight") {#X864:4 %t4386:p};
// %t4387 = $GROUND @ATTACH &vss => @PLACE(0, -2351);
// &vss @WIRE(mode="straight") {#X864:5 %t4387:p};
// %t4388 = $IO_PORT @ATTACH &n1094 => @PLACE(30, -2338) => @ORIENT("R0");
// %t4388 @TEXT("n1094", key="name", size=0.75);
// &n1094 @WIRE(mode="straight") {#X865:1 %t4388:p};
// %t4389 = $IO_PORT @ATTACH &n1095 => @PLACE(30, -2342) => @ORIENT("R0");
// %t4389 @TEXT("n1095", key="name", size=0.75);
// &n1095 @WIRE(mode="straight") {#X865:2 %t4389:p};
// %t4390 = $IO_PORT @ATTACH &n1097 => @PLACE(50, -2340) => @ORIENT("MY");
// %t4390 @TEXT("n1097", key="name", size=0.75);
// &n1097 @WIRE(mode="straight") {#X865:3 %t4390:p};
// %t4391 = $SUPPLY @ATTACH &vdd => @PLACE(40, -2329);
// &vdd @WIRE(mode="straight") {#X865:4 %t4391:p};
// %t4392 = $GROUND @ATTACH &vss => @PLACE(40, -2351);
// &vss @WIRE(mode="straight") {#X865:5 %t4392:p};
// %t4393 = $IO_PORT @ATTACH &n1096 => @PLACE(70, -2338) => @ORIENT("R0");
// %t4393 @TEXT("n1096", key="name", size=0.75);
// &n1096 @WIRE(mode="straight") {#X866:1 %t4393:p};
// %t4394 = $IO_PORT @ATTACH &n1097 => @PLACE(70, -2342) => @ORIENT("R0");
// %t4394 @TEXT("n1097", key="name", size=0.75);
// &n1097 @WIRE(mode="straight") {#X866:2 %t4394:p};
// %t4395 = $IO_PORT @ATTACH &n980 => @PLACE(90, -2340) => @ORIENT("MY");
// %t4395 @TEXT("n980", key="name", size=0.75);
// &n980 @WIRE(mode="straight") {#X866:3 %t4395:p};
// %t4396 = $SUPPLY @ATTACH &vdd => @PLACE(80, -2329);
// &vdd @WIRE(mode="straight") {#X866:4 %t4396:p};
// %t4397 = $GROUND @ATTACH &vss => @PLACE(80, -2351);
// &vss @WIRE(mode="straight") {#X866:5 %t4397:p};
// %t4398 = $IO_PORT @ATTACH &n266 => @PLACE(110, -2338) => @ORIENT("R0");
// %t4398 @TEXT("n266", key="name", size=0.75);
// &n266 @WIRE(mode="straight") {#X867:1 %t4398:p};
// %t4399 = $IO_PORT @ATTACH &n1075 => @PLACE(110, -2342) => @ORIENT("R0");
// %t4399 @TEXT("n1075", key="name", size=0.75);
// &n1075 @WIRE(mode="straight") {#X867:2 %t4399:p};
// %t4400 = $IO_PORT @ATTACH &n1065 => @PLACE(130, -2340) => @ORIENT("MY");
// %t4400 @TEXT("n1065", key="name", size=0.75);
// &n1065 @WIRE(mode="straight") {#X867:3 %t4400:p};
// %t4401 = $SUPPLY @ATTACH &vdd => @PLACE(120, -2329);
// &vdd @WIRE(mode="straight") {#X867:4 %t4401:p};
// %t4402 = $GROUND @ATTACH &vss => @PLACE(120, -2351);
// &vss @WIRE(mode="straight") {#X867:5 %t4402:p};
// %t4403 = $IO_PORT @ATTACH &n1062 => @PLACE(-11, -2369) => @ORIENT("R0");
// %t4403 @TEXT("n1062", key="name", size=0.75);
// &n1062 @WIRE(mode="straight") {#X868:1 %t4403:p};
// %t4404 = $IO_PORT @ATTACH &n1098 => @PLACE(-11, -2373) => @ORIENT("R0");
// %t4404 @TEXT("n1098", key="name", size=0.75);
// &n1098 @WIRE(mode="straight") {#X868:2 %t4404:p};
// %t4405 = $IO_PORT @ATTACH &n1099 => @PLACE(10, -2371) => @ORIENT("MY");
// %t4405 @TEXT("n1099", key="name", size=0.75);
// &n1099 @WIRE(mode="straight") {#X868:3 %t4405:p};
// %t4406 = $SUPPLY @ATTACH &vdd => @PLACE(0, -2360);
// &vdd @WIRE(mode="straight") {#X868:4 %t4406:p};
// %t4407 = $GROUND @ATTACH &vss => @PLACE(0, -2382);
// &vss @WIRE(mode="straight") {#X868:5 %t4407:p};
// %t4408 = $IO_PORT @ATTACH &n230 => @PLACE(30, -2369) => @ORIENT("R0");
// %t4408 @TEXT("n230", key="name", size=0.75);
// &n230 @WIRE(mode="straight") {#X869:1 %t4408:p};
// %t4409 = $IO_PORT @ATTACH &n109 => @PLACE(30, -2373) => @ORIENT("R0");
// %t4409 @TEXT("n109", key="name", size=0.75);
// &n109 @WIRE(mode="straight") {#X869:2 %t4409:p};
// %t4410 = $IO_PORT @ATTACH &n1100 => @PLACE(50, -2371) => @ORIENT("MY");
// %t4410 @TEXT("n1100", key="name", size=0.75);
// &n1100 @WIRE(mode="straight") {#X869:3 %t4410:p};
// %t4411 = $SUPPLY @ATTACH &vdd => @PLACE(40, -2360);
// &vdd @WIRE(mode="straight") {#X869:4 %t4411:p};
// %t4412 = $GROUND @ATTACH &vss => @PLACE(40, -2382);
// &vss @WIRE(mode="straight") {#X869:5 %t4412:p};
// %t4413 = $IO_PORT @ATTACH &n111 => @PLACE(70, -2369) => @ORIENT("R0");
// %t4413 @TEXT("n111", key="name", size=0.75);
// &n111 @WIRE(mode="straight") {#X870:1 %t4413:p};
// %t4414 = $IO_PORT @ATTACH &n113 => @PLACE(70, -2373) => @ORIENT("R0");
// %t4414 @TEXT("n113", key="name", size=0.75);
// &n113 @WIRE(mode="straight") {#X870:2 %t4414:p};
// %t4415 = $IO_PORT @ATTACH &n1067 => @PLACE(90, -2371) => @ORIENT("MY");
// %t4415 @TEXT("n1067", key="name", size=0.75);
// &n1067 @WIRE(mode="straight") {#X870:3 %t4415:p};
// %t4416 = $SUPPLY @ATTACH &vdd => @PLACE(80, -2360);
// &vdd @WIRE(mode="straight") {#X870:4 %t4416:p};
// %t4417 = $GROUND @ATTACH &vss => @PLACE(80, -2382);
// &vss @WIRE(mode="straight") {#X870:5 %t4417:p};
// %t4418 = $IO_PORT @ATTACH &n1065 => @PLACE(110, -2369) => @ORIENT("R0");
// %t4418 @TEXT("n1065", key="name", size=0.75);
// &n1065 @WIRE(mode="straight") {#X871:1 %t4418:p};
// %t4419 = $IO_PORT @ATTACH &n1099 => @PLACE(110, -2373) => @ORIENT("R0");
// %t4419 @TEXT("n1099", key="name", size=0.75);
// &n1099 @WIRE(mode="straight") {#X871:2 %t4419:p};
// %t4420 = $IO_PORT @ATTACH &n1073 => @PLACE(130, -2371) => @ORIENT("MY");
// %t4420 @TEXT("n1073", key="name", size=0.75);
// &n1073 @WIRE(mode="straight") {#X871:3 %t4420:p};
// %t4421 = $SUPPLY @ATTACH &vdd => @PLACE(120, -2360);
// &vdd @WIRE(mode="straight") {#X871:4 %t4421:p};
// %t4422 = $GROUND @ATTACH &vss => @PLACE(120, -2382);
// &vss @WIRE(mode="straight") {#X871:5 %t4422:p};
// %t4423 = $IO_PORT @ATTACH &n1100 => @PLACE(-11, -2400) => @ORIENT("R0");
// %t4423 @TEXT("n1100", key="name", size=0.75);
// &n1100 @WIRE(mode="straight") {#X872:1 %t4423:p};
// %t4424 = $IO_PORT @ATTACH &n1067 => @PLACE(-11, -2404) => @ORIENT("R0");
// %t4424 @TEXT("n1067", key="name", size=0.75);
// &n1067 @WIRE(mode="straight") {#X872:2 %t4424:p};
// %t4425 = $IO_PORT @ATTACH &n1101 => @PLACE(10, -2402) => @ORIENT("MY");
// %t4425 @TEXT("n1101", key="name", size=0.75);
// &n1101 @WIRE(mode="straight") {#X872:3 %t4425:p};
// %t4426 = $SUPPLY @ATTACH &vdd => @PLACE(0, -2391);
// &vdd @WIRE(mode="straight") {#X872:4 %t4426:p};
// %t4427 = $GROUND @ATTACH &vss => @PLACE(0, -2413);
// &vss @WIRE(mode="straight") {#X872:5 %t4427:p};
// %t4428 = $IO_PORT @ATTACH &n1073 => @PLACE(30, -2400) => @ORIENT("R0");
// %t4428 @TEXT("n1073", key="name", size=0.75);
// &n1073 @WIRE(mode="straight") {#X873:1 %t4428:p};
// %t4429 = $IO_PORT @ATTACH &n1101 => @PLACE(30, -2404) => @ORIENT("R0");
// %t4429 @TEXT("n1101", key="name", size=0.75);
// &n1101 @WIRE(mode="straight") {#X873:2 %t4429:p};
// %t4430 = $IO_PORT @ATTACH &n1102 => @PLACE(50, -2402) => @ORIENT("MY");
// %t4430 @TEXT("n1102", key="name", size=0.75);
// &n1102 @WIRE(mode="straight") {#X873:3 %t4430:p};
// %t4431 = $SUPPLY @ATTACH &vdd => @PLACE(40, -2391);
// &vdd @WIRE(mode="straight") {#X873:4 %t4431:p};
// %t4432 = $GROUND @ATTACH &vss => @PLACE(40, -2413);
// &vss @WIRE(mode="straight") {#X873:5 %t4432:p};
// %t4433 = $IO_PORT @ATTACH &n1103 => @PLACE(70, -2400) => @ORIENT("R0");
// %t4433 @TEXT("n1103", key="name", size=0.75);
// &n1103 @WIRE(mode="straight") {#X874:1 %t4433:p};
// %t4434 = $IO_PORT @ATTACH &n229 => @PLACE(70, -2404) => @ORIENT("R0");
// %t4434 @TEXT("n229", key="name", size=0.75);
// &n229 @WIRE(mode="straight") {#X874:2 %t4434:p};
// %t4435 = $IO_PORT @ATTACH &n1000 => @PLACE(90, -2402) => @ORIENT("MY");
// %t4435 @TEXT("n1000", key="name", size=0.75);
// &n1000 @WIRE(mode="straight") {#X874:3 %t4435:p};
// %t4436 = $SUPPLY @ATTACH &vdd => @PLACE(80, -2391);
// &vdd @WIRE(mode="straight") {#X874:4 %t4436:p};
// %t4437 = $GROUND @ATTACH &vss => @PLACE(80, -2413);
// &vss @WIRE(mode="straight") {#X874:5 %t4437:p};
// %t4438 = $IO_PORT @ATTACH &n1104 => @PLACE(110, -2400) => @ORIENT("R0");
// %t4438 @TEXT("n1104", key="name", size=0.75);
// &n1104 @WIRE(mode="straight") {#X875:1 %t4438:p};
// %t4439 = $IO_PORT @ATTACH &n229 => @PLACE(110, -2404) => @ORIENT("R0");
// %t4439 @TEXT("n229", key="name", size=0.75);
// &n229 @WIRE(mode="straight") {#X875:2 %t4439:p};
// %t4440 = $IO_PORT @ATTACH &n1033 => @PLACE(130, -2402) => @ORIENT("MY");
// %t4440 @TEXT("n1033", key="name", size=0.75);
// &n1033 @WIRE(mode="straight") {#X875:3 %t4440:p};
// %t4441 = $SUPPLY @ATTACH &vdd => @PLACE(120, -2391);
// &vdd @WIRE(mode="straight") {#X875:4 %t4441:p};
// %t4442 = $GROUND @ATTACH &vss => @PLACE(120, -2413);
// &vss @WIRE(mode="straight") {#X875:5 %t4442:p};
// %t4443 = $IO_PORT @ATTACH &state_out0 => @PLACE(-11, -2431) => @ORIENT("R0");
// %t4443 @TEXT("state_out0", key="name", size=0.75);
// &state_out0 @WIRE(mode="straight") {#X876:1 %t4443:p};
// %t4444 = $IO_PORT @ATTACH &n225 => @PLACE(-11, -2435) => @ORIENT("R0");
// %t4444 @TEXT("n225", key="name", size=0.75);
// &n225 @WIRE(mode="straight") {#X876:2 %t4444:p};
// %t4445 = $IO_PORT @ATTACH &n1105 => @PLACE(10, -2433) => @ORIENT("MY");
// %t4445 @TEXT("n1105", key="name", size=0.75);
// &n1105 @WIRE(mode="straight") {#X876:3 %t4445:p};
// %t4446 = $SUPPLY @ATTACH &vdd => @PLACE(0, -2422);
// &vdd @WIRE(mode="straight") {#X876:4 %t4446:p};
// %t4447 = $GROUND @ATTACH &vss => @PLACE(0, -2444);
// &vss @WIRE(mode="straight") {#X876:5 %t4447:p};
// %t4448 = $IO_PORT @ATTACH &n1105 => @PLACE(30, -2431) => @ORIENT("R0");
// %t4448 @TEXT("n1105", key="name", size=0.75);
// &n1105 @WIRE(mode="straight") {#X877:1 %t4448:p};
// %t4449 = $IO_PORT @ATTACH &state_out2 => @PLACE(30, -2435) => @ORIENT("R0");
// %t4449 @TEXT("state_out2", key="name", size=0.75);
// &state_out2 @WIRE(mode="straight") {#X877:2 %t4449:p};
// %t4450 = $IO_PORT @ATTACH &n1041 => @PLACE(50, -2433) => @ORIENT("MY");
// %t4450 @TEXT("n1041", key="name", size=0.75);
// &n1041 @WIRE(mode="straight") {#X877:3 %t4450:p};
// %t4451 = $SUPPLY @ATTACH &vdd => @PLACE(40, -2422);
// &vdd @WIRE(mode="straight") {#X877:4 %t4451:p};
// %t4452 = $GROUND @ATTACH &vss => @PLACE(40, -2444);
// &vss @WIRE(mode="straight") {#X877:5 %t4452:p};
// %t4453 = $IO_PORT @ATTACH &n226 => @PLACE(70, -2431) => @ORIENT("R0");
// %t4453 @TEXT("n226", key="name", size=0.75);
// &n226 @WIRE(mode="straight") {#X878:1 %t4453:p};
// %t4454 = $IO_PORT @ATTACH &state_out1 => @PLACE(70, -2435) => @ORIENT("R0");
// %t4454 @TEXT("state_out1", key="name", size=0.75);
// &state_out1 @WIRE(mode="straight") {#X878:2 %t4454:p};
// %t4455 = $IO_PORT @ATTACH &n1104 => @PLACE(90, -2433) => @ORIENT("MY");
// %t4455 @TEXT("n1104", key="name", size=0.75);
// &n1104 @WIRE(mode="straight") {#X878:3 %t4455:p};
// %t4456 = $SUPPLY @ATTACH &vdd => @PLACE(80, -2422);
// &vdd @WIRE(mode="straight") {#X878:4 %t4456:p};
// %t4457 = $GROUND @ATTACH &vss => @PLACE(80, -2444);
// &vss @WIRE(mode="straight") {#X878:5 %t4457:p};
// %t4458 = $IO_PORT @ATTACH &n1104 => @PLACE(110, -2431) => @ORIENT("R0");
// %t4458 @TEXT("n1104", key="name", size=0.75);
// &n1104 @WIRE(mode="straight") {#X879:1 %t4458:p};
// %t4459 = $IO_PORT @ATTACH &state_out2 => @PLACE(110, -2435) => @ORIENT("R0");
// %t4459 @TEXT("state_out2", key="name", size=0.75);
// &state_out2 @WIRE(mode="straight") {#X879:2 %t4459:p};
// %t4460 = $IO_PORT @ATTACH &n1043 => @PLACE(130, -2433) => @ORIENT("MY");
// %t4460 @TEXT("n1043", key="name", size=0.75);
// &n1043 @WIRE(mode="straight") {#X879:3 %t4460:p};
// %t4461 = $SUPPLY @ATTACH &vdd => @PLACE(120, -2422);
// &vdd @WIRE(mode="straight") {#X879:4 %t4461:p};
// %t4462 = $GROUND @ATTACH &vss => @PLACE(120, -2444);
// &vss @WIRE(mode="straight") {#X879:5 %t4462:p};
// %t4463 = $IO_PORT @ATTACH &n226 => @PLACE(-11, -2462) => @ORIENT("R0");
// %t4463 @TEXT("n226", key="name", size=0.75);
// &n226 @WIRE(mode="straight") {#X880:1 %t4463:p};
// %t4464 = $IO_PORT @ATTACH &n225 => @PLACE(-11, -2466) => @ORIENT("R0");
// %t4464 @TEXT("n225", key="name", size=0.75);
// &n225 @WIRE(mode="straight") {#X880:2 %t4464:p};
// %t4465 = $IO_PORT @ATTACH &n1106 => @PLACE(10, -2464) => @ORIENT("MY");
// %t4465 @TEXT("n1106", key="name", size=0.75);
// &n1106 @WIRE(mode="straight") {#X880:3 %t4465:p};
// %t4466 = $SUPPLY @ATTACH &vdd => @PLACE(0, -2453);
// &vdd @WIRE(mode="straight") {#X880:4 %t4466:p};
// %t4467 = $GROUND @ATTACH &vss => @PLACE(0, -2475);
// &vss @WIRE(mode="straight") {#X880:5 %t4467:p};
// %t4468 = $IO_PORT @ATTACH &n1106 => @PLACE(30, -2462) => @ORIENT("R0");
// %t4468 @TEXT("n1106", key="name", size=0.75);
// &n1106 @WIRE(mode="straight") {#X881:1 %t4468:p};
// %t4469 = $IO_PORT @ATTACH &state_out2 => @PLACE(30, -2466) => @ORIENT("R0");
// %t4469 @TEXT("state_out2", key="name", size=0.75);
// &state_out2 @WIRE(mode="straight") {#X881:2 %t4469:p};
// %t4470 = $IO_PORT @ATTACH &n1002 => @PLACE(50, -2464) => @ORIENT("MY");
// %t4470 @TEXT("n1002", key="name", size=0.75);
// &n1002 @WIRE(mode="straight") {#X881:3 %t4470:p};
// %t4471 = $SUPPLY @ATTACH &vdd => @PLACE(40, -2453);
// &vdd @WIRE(mode="straight") {#X881:4 %t4471:p};
// %t4472 = $GROUND @ATTACH &vss => @PLACE(40, -2475);
// &vss @WIRE(mode="straight") {#X881:5 %t4472:p};
// %t4473 = $IO_PORT @ATTACH &n1031 => @PLACE(70, -2462) => @ORIENT("R0");
// %t4473 @TEXT("n1031", key="name", size=0.75);
// &n1031 @WIRE(mode="straight") {#X882:1 %t4473:p};
// %t4474 = $IO_PORT @ATTACH &n350 => @PLACE(70, -2466) => @ORIENT("R0");
// %t4474 @TEXT("n350", key="name", size=0.75);
// &n350 @WIRE(mode="straight") {#X882:2 %t4474:p};
// %t4475 = $IO_PORT @ATTACH &n1107 => @PLACE(90, -2464) => @ORIENT("MY");
// %t4475 @TEXT("n1107", key="name", size=0.75);
// &n1107 @WIRE(mode="straight") {#X882:3 %t4475:p};
// %t4476 = $SUPPLY @ATTACH &vdd => @PLACE(80, -2453);
// &vdd @WIRE(mode="straight") {#X882:4 %t4476:p};
// %t4477 = $GROUND @ATTACH &vss => @PLACE(80, -2475);
// &vss @WIRE(mode="straight") {#X882:5 %t4477:p};
// %t4478 = $IO_PORT @ATTACH &n405 => @PLACE(110, -2462) => @ORIENT("R0");
// %t4478 @TEXT("n405", key="name", size=0.75);
// &n405 @WIRE(mode="straight") {#X883:1 %t4478:p};
// %t4479 = $IO_PORT @ATTACH &n715 => @PLACE(110, -2466) => @ORIENT("R0");
// %t4479 @TEXT("n715", key="name", size=0.75);
// &n715 @WIRE(mode="straight") {#X883:2 %t4479:p};
// %t4480 = $IO_PORT @ATTACH &n410 => @PLACE(130, -2464) => @ORIENT("MY");
// %t4480 @TEXT("n410", key="name", size=0.75);
// &n410 @WIRE(mode="straight") {#X883:3 %t4480:p};
// %t4481 = $SUPPLY @ATTACH &vdd => @PLACE(120, -2453);
// &vdd @WIRE(mode="straight") {#X883:4 %t4481:p};
// %t4482 = $GROUND @ATTACH &vss => @PLACE(120, -2475);
// &vss @WIRE(mode="straight") {#X883:5 %t4482:p};
// %t4483 = $IO_PORT @ATTACH &n410 => @PLACE(-11, -2493) => @ORIENT("R0");
// %t4483 @TEXT("n410", key="name", size=0.75);
// &n410 @WIRE(mode="straight") {#X884:1 %t4483:p};
// %t4484 = $IO_PORT @ATTACH &n831 => @PLACE(-11, -2497) => @ORIENT("R0");
// %t4484 @TEXT("n831", key="name", size=0.75);
// &n831 @WIRE(mode="straight") {#X884:2 %t4484:p};
// %t4485 = $IO_PORT @ATTACH &n1108 => @PLACE(10, -2495) => @ORIENT("MY");
// %t4485 @TEXT("n1108", key="name", size=0.75);
// &n1108 @WIRE(mode="straight") {#X884:3 %t4485:p};
// %t4486 = $SUPPLY @ATTACH &vdd => @PLACE(0, -2484);
// &vdd @WIRE(mode="straight") {#X884:4 %t4486:p};
// %t4487 = $GROUND @ATTACH &vss => @PLACE(0, -2506);
// &vss @WIRE(mode="straight") {#X884:5 %t4487:p};
// %t4488 = $IO_PORT @ATTACH &n827 => @PLACE(30, -2493) => @ORIENT("R0");
// %t4488 @TEXT("n827", key="name", size=0.75);
// &n827 @WIRE(mode="straight") {#X885:1 %t4488:p};
// %t4489 = $IO_PORT @ATTACH &n716 => @PLACE(30, -2497) => @ORIENT("R0");
// %t4489 @TEXT("n716", key="name", size=0.75);
// &n716 @WIRE(mode="straight") {#X885:2 %t4489:p};
// %t4490 = $IO_PORT @ATTACH &n1109 => @PLACE(50, -2495) => @ORIENT("MY");
// %t4490 @TEXT("n1109", key="name", size=0.75);
// &n1109 @WIRE(mode="straight") {#X885:3 %t4490:p};
// %t4491 = $SUPPLY @ATTACH &vdd => @PLACE(40, -2484);
// &vdd @WIRE(mode="straight") {#X885:4 %t4491:p};
// %t4492 = $GROUND @ATTACH &vss => @PLACE(40, -2506);
// &vss @WIRE(mode="straight") {#X885:5 %t4492:p};
// %t4493 = $IO_PORT @ATTACH &n264 => @PLACE(70, -2493) => @ORIENT("R0");
// %t4493 @TEXT("n264", key="name", size=0.75);
// &n264 @WIRE(mode="straight") {#X886:1 %t4493:p};
// %t4494 = $IO_PORT @ATTACH &n1110 => @PLACE(70, -2497) => @ORIENT("R0");
// %t4494 @TEXT("n1110", key="name", size=0.75);
// &n1110 @WIRE(mode="straight") {#X886:2 %t4494:p};
// %t4495 = $IO_PORT @ATTACH &n1111 => @PLACE(90, -2495) => @ORIENT("MY");
// %t4495 @TEXT("n1111", key="name", size=0.75);
// &n1111 @WIRE(mode="straight") {#X886:3 %t4495:p};
// %t4496 = $SUPPLY @ATTACH &vdd => @PLACE(80, -2484);
// &vdd @WIRE(mode="straight") {#X886:4 %t4496:p};
// %t4497 = $GROUND @ATTACH &vss => @PLACE(80, -2506);
// &vss @WIRE(mode="straight") {#X886:5 %t4497:p};
// %t4498 = $IO_PORT @ATTACH &n788 => @PLACE(110, -2493) => @ORIENT("R0");
// %t4498 @TEXT("n788", key="name", size=0.75);
// &n788 @WIRE(mode="straight") {#X887:1 %t4498:p};
// %t4499 = $IO_PORT @ATTACH &n745 => @PLACE(110, -2497) => @ORIENT("R0");
// %t4499 @TEXT("n745", key="name", size=0.75);
// &n745 @WIRE(mode="straight") {#X887:2 %t4499:p};
// %t4500 = $IO_PORT @ATTACH &n1110 => @PLACE(130, -2495) => @ORIENT("MY");
// %t4500 @TEXT("n1110", key="name", size=0.75);
// &n1110 @WIRE(mode="straight") {#X887:3 %t4500:p};
// %t4501 = $SUPPLY @ATTACH &vdd => @PLACE(120, -2484);
// &vdd @WIRE(mode="straight") {#X887:4 %t4501:p};
// %t4502 = $GROUND @ATTACH &vss => @PLACE(120, -2506);
// &vss @WIRE(mode="straight") {#X887:5 %t4502:p};
// %t4503 = $IO_PORT @ATTACH &n262 => @PLACE(158, -2338) => @ORIENT("R0");
// %t4503 @TEXT("n262", key="name", size=0.75);
// &n262 @WIRE(mode="straight") {#X888:1 %t4503:p};
// %t4504 = $IO_PORT @ATTACH &n1112 => @PLACE(158, -2342) => @ORIENT("R0");
// %t4504 @TEXT("n1112", key="name", size=0.75);
// &n1112 @WIRE(mode="straight") {#X888:2 %t4504:p};
// %t4505 = $IO_PORT @ATTACH &n1113 => @PLACE(178, -2340) => @ORIENT("MY");
// %t4505 @TEXT("n1113", key="name", size=0.75);
// &n1113 @WIRE(mode="straight") {#X888:3 %t4505:p};
// %t4506 = $SUPPLY @ATTACH &vdd => @PLACE(168, -2329);
// &vdd @WIRE(mode="straight") {#X888:4 %t4506:p};
// %t4507 = $GROUND @ATTACH &vss => @PLACE(168, -2351);
// &vss @WIRE(mode="straight") {#X888:5 %t4507:p};
// %t4508 = $IO_PORT @ATTACH &n224 => @PLACE(198, -2338) => @ORIENT("R0");
// %t4508 @TEXT("n224", key="name", size=0.75);
// &n224 @WIRE(mode="straight") {#X889:1 %t4508:p};
// %t4509 = $IO_PORT @ATTACH &target_k1 => @PLACE(198, -2342) => @ORIENT("R0");
// %t4509 @TEXT("target_k1", key="name", size=0.75);
// &target_k1 @WIRE(mode="straight") {#X889:2 %t4509:p};
// %t4510 = $IO_PORT @ATTACH &n1114 => @PLACE(218, -2340) => @ORIENT("MY");
// %t4510 @TEXT("n1114", key="name", size=0.75);
// &n1114 @WIRE(mode="straight") {#X889:3 %t4510:p};
// %t4511 = $SUPPLY @ATTACH &vdd => @PLACE(208, -2329);
// &vdd @WIRE(mode="straight") {#X889:4 %t4511:p};
// %t4512 = $GROUND @ATTACH &vss => @PLACE(208, -2351);
// &vss @WIRE(mode="straight") {#X889:5 %t4512:p};
// %t4513 = $IO_PORT @ATTACH &n268 => @PLACE(238, -2338) => @ORIENT("R0");
// %t4513 @TEXT("n268", key="name", size=0.75);
// &n268 @WIRE(mode="straight") {#X890:1 %t4513:p};
// %t4514 = $IO_PORT @ATTACH &n754 => @PLACE(238, -2342) => @ORIENT("R0");
// %t4514 @TEXT("n754", key="name", size=0.75);
// &n754 @WIRE(mode="straight") {#X890:2 %t4514:p};
// %t4515 = $IO_PORT @ATTACH &n752 => @PLACE(258, -2340) => @ORIENT("MY");
// %t4515 @TEXT("n752", key="name", size=0.75);
// &n752 @WIRE(mode="straight") {#X890:3 %t4515:p};
// %t4516 = $SUPPLY @ATTACH &vdd => @PLACE(248, -2329);
// &vdd @WIRE(mode="straight") {#X890:4 %t4516:p};
// %t4517 = $GROUND @ATTACH &vss => @PLACE(248, -2351);
// &vss @WIRE(mode="straight") {#X890:5 %t4517:p};
// %t4518 = $IO_PORT @ATTACH &n1114 => @PLACE(278, -2338) => @ORIENT("R0");
// %t4518 @TEXT("n1114", key="name", size=0.75);
// &n1114 @WIRE(mode="straight") {#X891:1 %t4518:p};
// %t4519 = $IO_PORT @ATTACH &n752 => @PLACE(278, -2342) => @ORIENT("R0");
// %t4519 @TEXT("n752", key="name", size=0.75);
// &n752 @WIRE(mode="straight") {#X891:2 %t4519:p};
// %t4520 = $IO_PORT @ATTACH &n1115 => @PLACE(298, -2340) => @ORIENT("MY");
// %t4520 @TEXT("n1115", key="name", size=0.75);
// &n1115 @WIRE(mode="straight") {#X891:3 %t4520:p};
// %t4521 = $SUPPLY @ATTACH &vdd => @PLACE(288, -2329);
// &vdd @WIRE(mode="straight") {#X891:4 %t4521:p};
// %t4522 = $GROUND @ATTACH &vss => @PLACE(288, -2351);
// &vss @WIRE(mode="straight") {#X891:5 %t4522:p};
// %t4523 = $IO_PORT @ATTACH &n1115 => @PLACE(158, -2369) => @ORIENT("R0");
// %t4523 @TEXT("n1115", key="name", size=0.75);
// &n1115 @WIRE(mode="straight") {#X892:1 %t4523:p};
// %t4524 = $IO_PORT @ATTACH &n745 => @PLACE(158, -2373) => @ORIENT("R0");
// %t4524 @TEXT("n745", key="name", size=0.75);
// &n745 @WIRE(mode="straight") {#X892:2 %t4524:p};
// %t4525 = $IO_PORT @ATTACH &n1112 => @PLACE(178, -2371) => @ORIENT("MY");
// %t4525 @TEXT("n1112", key="name", size=0.75);
// &n1112 @WIRE(mode="straight") {#X892:3 %t4525:p};
// %t4526 = $SUPPLY @ATTACH &vdd => @PLACE(168, -2360);
// &vdd @WIRE(mode="straight") {#X892:4 %t4526:p};
// %t4527 = $GROUND @ATTACH &vss => @PLACE(168, -2382);
// &vss @WIRE(mode="straight") {#X892:5 %t4527:p};
// %t4528 = $IO_PORT @ATTACH &n260 => @PLACE(198, -2369) => @ORIENT("R0");
// %t4528 @TEXT("n260", key="name", size=0.75);
// &n260 @WIRE(mode="straight") {#X893:1 %t4528:p};
// %t4529 = $IO_PORT @ATTACH &n1116 => @PLACE(198, -2373) => @ORIENT("R0");
// %t4529 @TEXT("n1116", key="name", size=0.75);
// &n1116 @WIRE(mode="straight") {#X893:2 %t4529:p};
// %t4530 = $IO_PORT @ATTACH &n1117 => @PLACE(218, -2371) => @ORIENT("MY");
// %t4530 @TEXT("n1117", key="name", size=0.75);
// &n1117 @WIRE(mode="straight") {#X893:3 %t4530:p};
// %t4531 = $SUPPLY @ATTACH &vdd => @PLACE(208, -2360);
// &vdd @WIRE(mode="straight") {#X893:4 %t4531:p};
// %t4532 = $GROUND @ATTACH &vss => @PLACE(208, -2382);
// &vss @WIRE(mode="straight") {#X893:5 %t4532:p};
// %t4533 = $IO_PORT @ATTACH &target_k0 => @PLACE(238, -2369) => @ORIENT("R0");
// %t4533 @TEXT("target_k0", key="name", size=0.75);
// &target_k0 @WIRE(mode="straight") {#X894:1 %t4533:p};
// %t4534 = $IO_PORT @ATTACH &n1118 => @PLACE(238, -2373) => @ORIENT("R0");
// %t4534 @TEXT("n1118", key="name", size=0.75);
// &n1118 @WIRE(mode="straight") {#X894:2 %t4534:p};
// %t4535 = $IO_PORT @ATTACH &n774 => @PLACE(258, -2371) => @ORIENT("MY");
// %t4535 @TEXT("n774", key="name", size=0.75);
// &n774 @WIRE(mode="straight") {#X894:3 %t4535:p};
// %t4536 = $SUPPLY @ATTACH &vdd => @PLACE(248, -2360);
// &vdd @WIRE(mode="straight") {#X894:4 %t4536:p};
// %t4537 = $GROUND @ATTACH &vss => @PLACE(248, -2382);
// &vss @WIRE(mode="straight") {#X894:5 %t4537:p};
// %t4538 = $IO_PORT @ATTACH &target_k2 => @PLACE(278, -2369) => @ORIENT("R0");
// %t4538 @TEXT("target_k2", key="name", size=0.75);
// &target_k2 @WIRE(mode="straight") {#X895:1 %t4538:p};
// %t4539 = $IO_PORT @ATTACH &target_k3 => @PLACE(278, -2373) => @ORIENT("R0");
// %t4539 @TEXT("target_k3", key="name", size=0.75);
// &target_k3 @WIRE(mode="straight") {#X895:2 %t4539:p};
// %t4540 = $IO_PORT @ATTACH &n742 => @PLACE(298, -2371) => @ORIENT("MY");
// %t4540 @TEXT("n742", key="name", size=0.75);
// &n742 @WIRE(mode="straight") {#X895:3 %t4540:p};
// %t4541 = $SUPPLY @ATTACH &vdd => @PLACE(288, -2360);
// &vdd @WIRE(mode="straight") {#X895:4 %t4541:p};
// %t4542 = $GROUND @ATTACH &vss => @PLACE(288, -2382);
// &vss @WIRE(mode="straight") {#X895:5 %t4542:p};
// %t4543 = $IO_PORT @ATTACH &n774 => @PLACE(158, -2400) => @ORIENT("R0");
// %t4543 @TEXT("n774", key="name", size=0.75);
// &n774 @WIRE(mode="straight") {#X896:1 %t4543:p};
// %t4544 = $IO_PORT @ATTACH &n742 => @PLACE(158, -2404) => @ORIENT("R0");
// %t4544 @TEXT("n742", key="name", size=0.75);
// &n742 @WIRE(mode="straight") {#X896:2 %t4544:p};
// %t4545 = $IO_PORT @ATTACH &n1119 => @PLACE(178, -2402) => @ORIENT("MY");
// %t4545 @TEXT("n1119", key="name", size=0.75);
// &n1119 @WIRE(mode="straight") {#X896:3 %t4545:p};
// %t4546 = $SUPPLY @ATTACH &vdd => @PLACE(168, -2391);
// &vdd @WIRE(mode="straight") {#X896:4 %t4546:p};
// %t4547 = $GROUND @ATTACH &vss => @PLACE(168, -2413);
// &vss @WIRE(mode="straight") {#X896:5 %t4547:p};
// %t4548 = $IO_PORT @ATTACH &n1119 => @PLACE(198, -2400) => @ORIENT("R0");
// %t4548 @TEXT("n1119", key="name", size=0.75);
// &n1119 @WIRE(mode="straight") {#X897:1 %t4548:p};
// %t4549 = $IO_PORT @ATTACH &n769 => @PLACE(198, -2404) => @ORIENT("R0");
// %t4549 @TEXT("n769", key="name", size=0.75);
// &n769 @WIRE(mode="straight") {#X897:2 %t4549:p};
// %t4550 = $IO_PORT @ATTACH &n1116 => @PLACE(218, -2402) => @ORIENT("MY");
// %t4550 @TEXT("n1116", key="name", size=0.75);
// &n1116 @WIRE(mode="straight") {#X897:3 %t4550:p};
// %t4551 = $SUPPLY @ATTACH &vdd => @PLACE(208, -2391);
// &vdd @WIRE(mode="straight") {#X897:4 %t4551:p};
// %t4552 = $GROUND @ATTACH &vss => @PLACE(208, -2413);
// &vss @WIRE(mode="straight") {#X897:5 %t4552:p};
// %t4553 = $IO_PORT @ATTACH &n258 => @PLACE(238, -2400) => @ORIENT("R0");
// %t4553 @TEXT("n258", key="name", size=0.75);
// &n258 @WIRE(mode="straight") {#X898:1 %t4553:p};
// %t4554 = $IO_PORT @ATTACH &n1120 => @PLACE(238, -2404) => @ORIENT("R0");
// %t4554 @TEXT("n1120", key="name", size=0.75);
// &n1120 @WIRE(mode="straight") {#X898:2 %t4554:p};
// %t4555 = $IO_PORT @ATTACH &n1121 => @PLACE(258, -2402) => @ORIENT("MY");
// %t4555 @TEXT("n1121", key="name", size=0.75);
// &n1121 @WIRE(mode="straight") {#X898:3 %t4555:p};
// %t4556 = $SUPPLY @ATTACH &vdd => @PLACE(248, -2391);
// &vdd @WIRE(mode="straight") {#X898:4 %t4556:p};
// %t4557 = $GROUND @ATTACH &vss => @PLACE(248, -2413);
// &vss @WIRE(mode="straight") {#X898:5 %t4557:p};
// %t4558 = $IO_PORT @ATTACH &n268 => @PLACE(278, -2400) => @ORIENT("R0");
// %t4558 @TEXT("n268", key="name", size=0.75);
// &n268 @WIRE(mode="straight") {#X899:1 %t4558:p};
// %t4559 = $IO_PORT @ATTACH &target_k3 => @PLACE(278, -2404) => @ORIENT("R0");
// %t4559 @TEXT("target_k3", key="name", size=0.75);
// &target_k3 @WIRE(mode="straight") {#X899:2 %t4559:p};
// %t4560 = $IO_PORT @ATTACH &n1122 => @PLACE(298, -2402) => @ORIENT("MY");
// %t4560 @TEXT("n1122", key="name", size=0.75);
// &n1122 @WIRE(mode="straight") {#X899:3 %t4560:p};
// %t4561 = $SUPPLY @ATTACH &vdd => @PLACE(288, -2391);
// &vdd @WIRE(mode="straight") {#X899:4 %t4561:p};
// %t4562 = $GROUND @ATTACH &vss => @PLACE(288, -2413);
// &vss @WIRE(mode="straight") {#X899:5 %t4562:p};
// %t4563 = $IO_PORT @ATTACH &n1123 => @PLACE(158, -2431) => @ORIENT("R0");
// %t4563 @TEXT("n1123", key="name", size=0.75);
// &n1123 @WIRE(mode="straight") {#X900:1 %t4563:p};
// %t4564 = $IO_PORT @ATTACH &n747 => @PLACE(158, -2435) => @ORIENT("R0");
// %t4564 @TEXT("n747", key="name", size=0.75);
// &n747 @WIRE(mode="straight") {#X900:2 %t4564:p};
// %t4565 = $IO_PORT @ATTACH &n769 => @PLACE(178, -2433) => @ORIENT("MY");
// %t4565 @TEXT("n769", key="name", size=0.75);
// &n769 @WIRE(mode="straight") {#X900:3 %t4565:p};
// %t4566 = $SUPPLY @ATTACH &vdd => @PLACE(168, -2422);
// &vdd @WIRE(mode="straight") {#X900:4 %t4566:p};
// %t4567 = $GROUND @ATTACH &vss => @PLACE(168, -2444);
// &vss @WIRE(mode="straight") {#X900:5 %t4567:p};
// %t4568 = $IO_PORT @ATTACH &n449 => @PLACE(198, -2431) => @ORIENT("R0");
// %t4568 @TEXT("n449", key="name", size=0.75);
// &n449 @WIRE(mode="straight") {#X901:1 %t4568:p};
// %t4569 = $IO_PORT @ATTACH &n1122 => @PLACE(198, -2435) => @ORIENT("R0");
// %t4569 @TEXT("n1122", key="name", size=0.75);
// &n1122 @WIRE(mode="straight") {#X901:2 %t4569:p};
// %t4570 = $IO_PORT @ATTACH &n788 => @PLACE(218, -2433) => @ORIENT("MY");
// %t4570 @TEXT("n788", key="name", size=0.75);
// &n788 @WIRE(mode="straight") {#X901:3 %t4570:p};
// %t4571 = $SUPPLY @ATTACH &vdd => @PLACE(208, -2422);
// &vdd @WIRE(mode="straight") {#X901:4 %t4571:p};
// %t4572 = $GROUND @ATTACH &vss => @PLACE(208, -2444);
// &vss @WIRE(mode="straight") {#X901:5 %t4572:p};
// %t4573 = $IO_PORT @ATTACH &n788 => @PLACE(238, -2431) => @ORIENT("R0");
// %t4573 @TEXT("n788", key="name", size=0.75);
// &n788 @WIRE(mode="straight") {#X902:1 %t4573:p};
// %t4574 = $IO_PORT @ATTACH &n769 => @PLACE(238, -2435) => @ORIENT("R0");
// %t4574 @TEXT("n769", key="name", size=0.75);
// &n769 @WIRE(mode="straight") {#X902:2 %t4574:p};
// %t4575 = $IO_PORT @ATTACH &n1120 => @PLACE(258, -2433) => @ORIENT("MY");
// %t4575 @TEXT("n1120", key="name", size=0.75);
// &n1120 @WIRE(mode="straight") {#X902:3 %t4575:p};
// %t4576 = $SUPPLY @ATTACH &vdd => @PLACE(248, -2422);
// &vdd @WIRE(mode="straight") {#X902:4 %t4576:p};
// %t4577 = $GROUND @ATTACH &vss => @PLACE(248, -2444);
// &vss @WIRE(mode="straight") {#X902:5 %t4577:p};
// %t4578 = $IO_PORT @ATTACH &n256 => @PLACE(278, -2431) => @ORIENT("R0");
// %t4578 @TEXT("n256", key="name", size=0.75);
// &n256 @WIRE(mode="straight") {#X903:1 %t4578:p};
// %t4579 = $IO_PORT @ATTACH &n809 => @PLACE(278, -2435) => @ORIENT("R0");
// %t4579 @TEXT("n809", key="name", size=0.75);
// &n809 @WIRE(mode="straight") {#X903:2 %t4579:p};
// %t4580 = $IO_PORT @ATTACH &n1124 => @PLACE(298, -2433) => @ORIENT("MY");
// %t4580 @TEXT("n1124", key="name", size=0.75);
// &n1124 @WIRE(mode="straight") {#X903:3 %t4580:p};
// %t4581 = $SUPPLY @ATTACH &vdd => @PLACE(288, -2422);
// &vdd @WIRE(mode="straight") {#X903:4 %t4581:p};
// %t4582 = $GROUND @ATTACH &vss => @PLACE(288, -2444);
// &vss @WIRE(mode="straight") {#X903:5 %t4582:p};
// %t4583 = $IO_PORT @ATTACH &n572 => @PLACE(158, -2462) => @ORIENT("R0");
// %t4583 @TEXT("n572", key="name", size=0.75);
// &n572 @WIRE(mode="straight") {#X904:1 %t4583:p};
// %t4584 = $IO_PORT @ATTACH &n211 => @PLACE(158, -2466) => @ORIENT("R0");
// %t4584 @TEXT("n211", key="name", size=0.75);
// &n211 @WIRE(mode="straight") {#X904:2 %t4584:p};
// %t4585 = $IO_PORT @ATTACH &n814 => @PLACE(178, -2464) => @ORIENT("MY");
// %t4585 @TEXT("n814", key="name", size=0.75);
// &n814 @WIRE(mode="straight") {#X904:3 %t4585:p};
// %t4586 = $SUPPLY @ATTACH &vdd => @PLACE(168, -2453);
// &vdd @WIRE(mode="straight") {#X904:4 %t4586:p};
// %t4587 = $GROUND @ATTACH &vss => @PLACE(168, -2475);
// &vss @WIRE(mode="straight") {#X904:5 %t4587:p};
// %t4588 = $IO_PORT @ATTACH &n922 => @PLACE(198, -2462) => @ORIENT("R0");
// %t4588 @TEXT("n922", key="name", size=0.75);
// &n922 @WIRE(mode="straight") {#X905:1 %t4588:p};
// %t4589 = $IO_PORT @ATTACH &n814 => @PLACE(198, -2466) => @ORIENT("R0");
// %t4589 @TEXT("n814", key="name", size=0.75);
// &n814 @WIRE(mode="straight") {#X905:2 %t4589:p};
// %t4590 = $IO_PORT @ATTACH &n1125 => @PLACE(218, -2464) => @ORIENT("MY");
// %t4590 @TEXT("n1125", key="name", size=0.75);
// &n1125 @WIRE(mode="straight") {#X905:3 %t4590:p};
// %t4591 = $SUPPLY @ATTACH &vdd => @PLACE(208, -2453);
// &vdd @WIRE(mode="straight") {#X905:4 %t4591:p};
// %t4592 = $GROUND @ATTACH &vss => @PLACE(208, -2475);
// &vss @WIRE(mode="straight") {#X905:5 %t4592:p};
// %t4593 = $IO_PORT @ATTACH &n1125 => @PLACE(238, -2462) => @ORIENT("R0");
// %t4593 @TEXT("n1125", key="name", size=0.75);
// &n1125 @WIRE(mode="straight") {#X906:1 %t4593:p};
// %t4594 = $IO_PORT @ATTACH &n813 => @PLACE(238, -2466) => @ORIENT("R0");
// %t4594 @TEXT("n813", key="name", size=0.75);
// &n813 @WIRE(mode="straight") {#X906:2 %t4594:p};
// %t4595 = $IO_PORT @ATTACH &n345 => @PLACE(258, -2464) => @ORIENT("MY");
// %t4595 @TEXT("n345", key="name", size=0.75);
// &n345 @WIRE(mode="straight") {#X906:3 %t4595:p};
// %t4596 = $SUPPLY @ATTACH &vdd => @PLACE(248, -2453);
// &vdd @WIRE(mode="straight") {#X906:4 %t4596:p};
// %t4597 = $GROUND @ATTACH &vss => @PLACE(248, -2475);
// &vss @WIRE(mode="straight") {#X906:5 %t4597:p};
// %t4598 = $IO_PORT @ATTACH &n1126 => @PLACE(278, -2462) => @ORIENT("R0");
// %t4598 @TEXT("n1126", key="name", size=0.75);
// &n1126 @WIRE(mode="straight") {#X907:1 %t4598:p};
// %t4599 = $IO_PORT @ATTACH &n345 => @PLACE(278, -2466) => @ORIENT("R0");
// %t4599 @TEXT("n345", key="name", size=0.75);
// &n345 @WIRE(mode="straight") {#X907:2 %t4599:p};
// %t4600 = $IO_PORT @ATTACH &n1127 => @PLACE(298, -2464) => @ORIENT("MY");
// %t4600 @TEXT("n1127", key="name", size=0.75);
// &n1127 @WIRE(mode="straight") {#X907:3 %t4600:p};
// %t4601 = $SUPPLY @ATTACH &vdd => @PLACE(288, -2453);
// &vdd @WIRE(mode="straight") {#X907:4 %t4601:p};
// %t4602 = $GROUND @ATTACH &vss => @PLACE(288, -2475);
// &vss @WIRE(mode="straight") {#X907:5 %t4602:p};
// %t4603 = $IO_PORT @ATTACH &n1128 => @PLACE(158, -2493) => @ORIENT("R0");
// %t4603 @TEXT("n1128", key="name", size=0.75);
// &n1128 @WIRE(mode="straight") {#X908:1 %t4603:p};
// %t4604 = $IO_PORT @ATTACH &n251 => @PLACE(158, -2497) => @ORIENT("R0");
// %t4604 @TEXT("n251", key="name", size=0.75);
// &n251 @WIRE(mode="straight") {#X908:2 %t4604:p};
// %t4605 = $IO_PORT @ATTACH &n1129 => @PLACE(178, -2495) => @ORIENT("MY");
// %t4605 @TEXT("n1129", key="name", size=0.75);
// &n1129 @WIRE(mode="straight") {#X908:3 %t4605:p};
// %t4606 = $SUPPLY @ATTACH &vdd => @PLACE(168, -2484);
// &vdd @WIRE(mode="straight") {#X908:4 %t4606:p};
// %t4607 = $GROUND @ATTACH &vss => @PLACE(168, -2506);
// &vss @WIRE(mode="straight") {#X908:5 %t4607:p};
// %t4608 = $IO_PORT @ATTACH &n329 => @PLACE(198, -2493) => @ORIENT("R0");
// %t4608 @TEXT("n329", key="name", size=0.75);
// &n329 @WIRE(mode="straight") {#X909:1 %t4608:p};
// %t4609 = $IO_PORT @ATTACH &n331 => @PLACE(198, -2497) => @ORIENT("R0");
// %t4609 @TEXT("n331", key="name", size=0.75);
// &n331 @WIRE(mode="straight") {#X909:2 %t4609:p};
// %t4610 = $IO_PORT @ATTACH &n838 => @PLACE(218, -2495) => @ORIENT("MY");
// %t4610 @TEXT("n838", key="name", size=0.75);
// &n838 @WIRE(mode="straight") {#X909:3 %t4610:p};
// %t4611 = $SUPPLY @ATTACH &vdd => @PLACE(208, -2484);
// &vdd @WIRE(mode="straight") {#X909:4 %t4611:p};
// %t4612 = $GROUND @ATTACH &vss => @PLACE(208, -2506);
// &vss @WIRE(mode="straight") {#X909:5 %t4612:p};
// %t4613 = $IO_PORT @ATTACH &n1129 => @PLACE(238, -2493) => @ORIENT("R0");
// %t4613 @TEXT("n1129", key="name", size=0.75);
// &n1129 @WIRE(mode="straight") {#X910:1 %t4613:p};
// %t4614 = $IO_PORT @ATTACH &n836 => @PLACE(238, -2497) => @ORIENT("R0");
// %t4614 @TEXT("n836", key="name", size=0.75);
// &n836 @WIRE(mode="straight") {#X910:2 %t4614:p};
// %t4615 = $IO_PORT @ATTACH &n1130 => @PLACE(258, -2495) => @ORIENT("MY");
// %t4615 @TEXT("n1130", key="name", size=0.75);
// &n1130 @WIRE(mode="straight") {#X910:3 %t4615:p};
// %t4616 = $SUPPLY @ATTACH &vdd => @PLACE(248, -2484);
// &vdd @WIRE(mode="straight") {#X910:4 %t4616:p};
// %t4617 = $GROUND @ATTACH &vss => @PLACE(248, -2506);
// &vss @WIRE(mode="straight") {#X910:5 %t4617:p};
// %t4618 = $IO_PORT @ATTACH &n838 => @PLACE(278, -2493) => @ORIENT("R0");
// %t4618 @TEXT("n838", key="name", size=0.75);
// &n838 @WIRE(mode="straight") {#X911:1 %t4618:p};
// %t4619 = $IO_PORT @ATTACH &n837 => @PLACE(278, -2497) => @ORIENT("R0");
// %t4619 @TEXT("n837", key="name", size=0.75);
// &n837 @WIRE(mode="straight") {#X911:2 %t4619:p};
// %t4620 = $IO_PORT @ATTACH &n835 => @PLACE(298, -2495) => @ORIENT("MY");
// %t4620 @TEXT("n835", key="name", size=0.75);
// &n835 @WIRE(mode="straight") {#X911:3 %t4620:p};
// %t4621 = $SUPPLY @ATTACH &vdd => @PLACE(288, -2484);
// &vdd @WIRE(mode="straight") {#X911:4 %t4621:p};
// %t4622 = $GROUND @ATTACH &vss => @PLACE(288, -2506);
// &vss @WIRE(mode="straight") {#X911:5 %t4622:p};
// %t4623 = $IO_PORT @ATTACH &n1130 => @PLACE(326, -2338) => @ORIENT("R0");
// %t4623 @TEXT("n1130", key="name", size=0.75);
// &n1130 @WIRE(mode="straight") {#X912:1 %t4623:p};
// %t4624 = $IO_PORT @ATTACH &n835 => @PLACE(326, -2342) => @ORIENT("R0");
// %t4624 @TEXT("n835", key="name", size=0.75);
// &n835 @WIRE(mode="straight") {#X912:2 %t4624:p};
// %t4625 = $IO_PORT @ATTACH &n347 => @PLACE(346, -2340) => @ORIENT("MY");
// %t4625 @TEXT("n347", key="name", size=0.75);
// &n347 @WIRE(mode="straight") {#X912:3 %t4625:p};
// %t4626 = $SUPPLY @ATTACH &vdd => @PLACE(336, -2329);
// &vdd @WIRE(mode="straight") {#X912:4 %t4626:p};
// %t4627 = $GROUND @ATTACH &vss => @PLACE(336, -2351);
// &vss @WIRE(mode="straight") {#X912:5 %t4627:p};
// %t4628 = $IO_PORT @ATTACH &n1131 => @PLACE(366, -2338) => @ORIENT("R0");
// %t4628 @TEXT("n1131", key="name", size=0.75);
// &n1131 @WIRE(mode="straight") {#X913:1 %t4628:p};
// %t4629 = $IO_PORT @ATTACH &n347 => @PLACE(366, -2342) => @ORIENT("R0");
// %t4629 @TEXT("n347", key="name", size=0.75);
// &n347 @WIRE(mode="straight") {#X913:2 %t4629:p};
// %t4630 = $IO_PORT @ATTACH &n1132 => @PLACE(386, -2340) => @ORIENT("MY");
// %t4630 @TEXT("n1132", key="name", size=0.75);
// &n1132 @WIRE(mode="straight") {#X913:3 %t4630:p};
// %t4631 = $SUPPLY @ATTACH &vdd => @PLACE(376, -2329);
// &vdd @WIRE(mode="straight") {#X913:4 %t4631:p};
// %t4632 = $GROUND @ATTACH &vss => @PLACE(376, -2351);
// &vss @WIRE(mode="straight") {#X913:5 %t4632:p};
// %t4633 = $IO_PORT @ATTACH &n290 => @PLACE(406, -2338) => @ORIENT("R0");
// %t4633 @TEXT("n290", key="name", size=0.75);
// &n290 @WIRE(mode="straight") {#X914:1 %t4633:p};
// %t4634 = $IO_PORT @ATTACH &n288 => @PLACE(406, -2342) => @ORIENT("R0");
// %t4634 @TEXT("n288", key="name", size=0.75);
// &n288 @WIRE(mode="straight") {#X914:2 %t4634:p};
// %t4635 = $IO_PORT @ATTACH &n1133 => @PLACE(426, -2340) => @ORIENT("MY");
// %t4635 @TEXT("n1133", key="name", size=0.75);
// &n1133 @WIRE(mode="straight") {#X914:3 %t4635:p};
// %t4636 = $SUPPLY @ATTACH &vdd => @PLACE(416, -2329);
// &vdd @WIRE(mode="straight") {#X914:4 %t4636:p};
// %t4637 = $GROUND @ATTACH &vss => @PLACE(416, -2351);
// &vss @WIRE(mode="straight") {#X914:5 %t4637:p};
// %t4638 = $IO_PORT @ATTACH &n286 => @PLACE(446, -2338) => @ORIENT("R0");
// %t4638 @TEXT("n286", key="name", size=0.75);
// &n286 @WIRE(mode="straight") {#X915:1 %t4638:p};
// %t4639 = $IO_PORT @ATTACH &n284 => @PLACE(446, -2342) => @ORIENT("R0");
// %t4639 @TEXT("n284", key="name", size=0.75);
// &n284 @WIRE(mode="straight") {#X915:2 %t4639:p};
// %t4640 = $IO_PORT @ATTACH &n871 => @PLACE(466, -2340) => @ORIENT("MY");
// %t4640 @TEXT("n871", key="name", size=0.75);
// &n871 @WIRE(mode="straight") {#X915:3 %t4640:p};
// %t4641 = $SUPPLY @ATTACH &vdd => @PLACE(456, -2329);
// &vdd @WIRE(mode="straight") {#X915:4 %t4641:p};
// %t4642 = $GROUND @ATTACH &vss => @PLACE(456, -2351);
// &vss @WIRE(mode="straight") {#X915:5 %t4642:p};
// %t4643 = $IO_PORT @ATTACH &n278 => @PLACE(326, -2369) => @ORIENT("R0");
// %t4643 @TEXT("n278", key="name", size=0.75);
// &n278 @WIRE(mode="straight") {#X916:1 %t4643:p};
// %t4644 = $IO_PORT @ATTACH &n276 => @PLACE(326, -2373) => @ORIENT("R0");
// %t4644 @TEXT("n276", key="name", size=0.75);
// &n276 @WIRE(mode="straight") {#X916:2 %t4644:p};
// %t4645 = $IO_PORT @ATTACH &n867 => @PLACE(346, -2371) => @ORIENT("MY");
// %t4645 @TEXT("n867", key="name", size=0.75);
// &n867 @WIRE(mode="straight") {#X916:3 %t4645:p};
// %t4646 = $SUPPLY @ATTACH &vdd => @PLACE(336, -2360);
// &vdd @WIRE(mode="straight") {#X916:4 %t4646:p};
// %t4647 = $GROUND @ATTACH &vss => @PLACE(336, -2382);
// &vss @WIRE(mode="straight") {#X916:5 %t4647:p};
// %t4648 = $IO_PORT @ATTACH &n274 => @PLACE(366, -2369) => @ORIENT("R0");
// %t4648 @TEXT("n274", key="name", size=0.75);
// &n274 @WIRE(mode="straight") {#X917:1 %t4648:p};
// %t4649 = $IO_PORT @ATTACH &n272 => @PLACE(366, -2373) => @ORIENT("R0");
// %t4649 @TEXT("n272", key="name", size=0.75);
// &n272 @WIRE(mode="straight") {#X917:2 %t4649:p};
// %t4650 = $IO_PORT @ATTACH &n859 => @PLACE(386, -2371) => @ORIENT("MY");
// %t4650 @TEXT("n859", key="name", size=0.75);
// &n859 @WIRE(mode="straight") {#X917:3 %t4650:p};
// %t4651 = $SUPPLY @ATTACH &vdd => @PLACE(376, -2360);
// &vdd @WIRE(mode="straight") {#X917:4 %t4651:p};
// %t4652 = $GROUND @ATTACH &vss => @PLACE(376, -2382);
// &vss @WIRE(mode="straight") {#X917:5 %t4652:p};
// %t4653 = $IO_PORT @ATTACH &n884 => @PLACE(406, -2369) => @ORIENT("R0");
// %t4653 @TEXT("n884", key="name", size=0.75);
// &n884 @WIRE(mode="straight") {#X918:1 %t4653:p};
// %t4654 = $IO_PORT @ATTACH &n875 => @PLACE(406, -2373) => @ORIENT("R0");
// %t4654 @TEXT("n875", key="name", size=0.75);
// &n875 @WIRE(mode="straight") {#X918:2 %t4654:p};
// %t4655 = $IO_PORT @ATTACH &n1134 => @PLACE(426, -2371) => @ORIENT("MY");
// %t4655 @TEXT("n1134", key="name", size=0.75);
// &n1134 @WIRE(mode="straight") {#X918:3 %t4655:p};
// %t4656 = $SUPPLY @ATTACH &vdd => @PLACE(416, -2360);
// &vdd @WIRE(mode="straight") {#X918:4 %t4656:p};
// %t4657 = $GROUND @ATTACH &vss => @PLACE(416, -2382);
// &vss @WIRE(mode="straight") {#X918:5 %t4657:p};
// %t4658 = $IO_PORT @ATTACH &n1133 => @PLACE(446, -2369) => @ORIENT("R0");
// %t4658 @TEXT("n1133", key="name", size=0.75);
// &n1133 @WIRE(mode="straight") {#X919:1 %t4658:p};
// %t4659 = $IO_PORT @ATTACH &n871 => @PLACE(446, -2373) => @ORIENT("R0");
// %t4659 @TEXT("n871", key="name", size=0.75);
// &n871 @WIRE(mode="straight") {#X919:2 %t4659:p};
// %t4660 = $IO_PORT @ATTACH &n863 => @PLACE(466, -2371) => @ORIENT("MY");
// %t4660 @TEXT("n863", key="name", size=0.75);
// &n863 @WIRE(mode="straight") {#X919:3 %t4660:p};
// %t4661 = $SUPPLY @ATTACH &vdd => @PLACE(456, -2360);
// &vdd @WIRE(mode="straight") {#X919:4 %t4661:p};
// %t4662 = $GROUND @ATTACH &vss => @PLACE(456, -2382);
// &vss @WIRE(mode="straight") {#X919:5 %t4662:p};
// %t4663 = $IO_PORT @ATTACH &n879 => @PLACE(326, -2400) => @ORIENT("R0");
// %t4663 @TEXT("n879", key="name", size=0.75);
// &n879 @WIRE(mode="straight") {#X920:1 %t4663:p};
// %t4664 = $IO_PORT @ATTACH &n867 => @PLACE(326, -2404) => @ORIENT("R0");
// %t4664 @TEXT("n867", key="name", size=0.75);
// &n867 @WIRE(mode="straight") {#X920:2 %t4664:p};
// %t4665 = $IO_PORT @ATTACH &n1135 => @PLACE(346, -2402) => @ORIENT("MY");
// %t4665 @TEXT("n1135", key="name", size=0.75);
// &n1135 @WIRE(mode="straight") {#X920:3 %t4665:p};
// %t4666 = $SUPPLY @ATTACH &vdd => @PLACE(336, -2391);
// &vdd @WIRE(mode="straight") {#X920:4 %t4666:p};
// %t4667 = $GROUND @ATTACH &vss => @PLACE(336, -2413);
// &vss @WIRE(mode="straight") {#X920:5 %t4667:p};
// %t4668 = $IO_PORT @ATTACH &n1134 => @PLACE(366, -2400) => @ORIENT("R0");
// %t4668 @TEXT("n1134", key="name", size=0.75);
// &n1134 @WIRE(mode="straight") {#X921:1 %t4668:p};
// %t4669 = $IO_PORT @ATTACH &n863 => @PLACE(366, -2404) => @ORIENT("R0");
// %t4669 @TEXT("n863", key="name", size=0.75);
// &n863 @WIRE(mode="straight") {#X921:2 %t4669:p};
// %t4670 = $IO_PORT @ATTACH &n1136 => @PLACE(386, -2402) => @ORIENT("MY");
// %t4670 @TEXT("n1136", key="name", size=0.75);
// &n1136 @WIRE(mode="straight") {#X921:3 %t4670:p};
// %t4671 = $SUPPLY @ATTACH &vdd => @PLACE(376, -2391);
// &vdd @WIRE(mode="straight") {#X921:4 %t4671:p};
// %t4672 = $GROUND @ATTACH &vss => @PLACE(376, -2413);
// &vss @WIRE(mode="straight") {#X921:5 %t4672:p};
// %t4673 = $IO_PORT @ATTACH &n1135 => @PLACE(406, -2400) => @ORIENT("R0");
// %t4673 @TEXT("n1135", key="name", size=0.75);
// &n1135 @WIRE(mode="straight") {#X922:1 %t4673:p};
// %t4674 = $IO_PORT @ATTACH &n859 => @PLACE(406, -2404) => @ORIENT("R0");
// %t4674 @TEXT("n859", key="name", size=0.75);
// &n859 @WIRE(mode="straight") {#X922:2 %t4674:p};
// %t4675 = $IO_PORT @ATTACH &n855 => @PLACE(426, -2402) => @ORIENT("MY");
// %t4675 @TEXT("n855", key="name", size=0.75);
// &n855 @WIRE(mode="straight") {#X922:3 %t4675:p};
// %t4676 = $SUPPLY @ATTACH &vdd => @PLACE(416, -2391);
// &vdd @WIRE(mode="straight") {#X922:4 %t4676:p};
// %t4677 = $GROUND @ATTACH &vss => @PLACE(416, -2413);
// &vss @WIRE(mode="straight") {#X922:5 %t4677:p};
// %t4678 = $IO_PORT @ATTACH &n1136 => @PLACE(446, -2400) => @ORIENT("R0");
// %t4678 @TEXT("n1136", key="name", size=0.75);
// &n1136 @WIRE(mode="straight") {#X923:1 %t4678:p};
// %t4679 = $IO_PORT @ATTACH &n855 => @PLACE(446, -2404) => @ORIENT("R0");
// %t4679 @TEXT("n855", key="name", size=0.75);
// &n855 @WIRE(mode="straight") {#X923:2 %t4679:p};
// %t4680 = $IO_PORT @ATTACH &n1137 => @PLACE(466, -2402) => @ORIENT("MY");
// %t4680 @TEXT("n1137", key="name", size=0.75);
// &n1137 @WIRE(mode="straight") {#X923:3 %t4680:p};
// %t4681 = $SUPPLY @ATTACH &vdd => @PLACE(456, -2391);
// &vdd @WIRE(mode="straight") {#X923:4 %t4681:p};
// %t4682 = $GROUND @ATTACH &vss => @PLACE(456, -2413);
// &vss @WIRE(mode="straight") {#X923:5 %t4682:p};
// %t4683 = $IO_PORT @ATTACH &n248 => @PLACE(326, -2431) => @ORIENT("R0");
// %t4683 @TEXT("n248", key="name", size=0.75);
// &n248 @WIRE(mode="straight") {#X924:1 %t4683:p};
// %t4684 = $IO_PORT @ATTACH &n1137 => @PLACE(326, -2435) => @ORIENT("R0");
// %t4684 @TEXT("n1137", key="name", size=0.75);
// &n1137 @WIRE(mode="straight") {#X924:2 %t4684:p};
// %t4685 = $IO_PORT @ATTACH &n236 => @PLACE(346, -2433) => @ORIENT("MY");
// %t4685 @TEXT("n236", key="name", size=0.75);
// &n236 @WIRE(mode="straight") {#X924:3 %t4685:p};
// %t4686 = $SUPPLY @ATTACH &vdd => @PLACE(336, -2422);
// &vdd @WIRE(mode="straight") {#X924:4 %t4686:p};
// %t4687 = $GROUND @ATTACH &vss => @PLACE(336, -2444);
// &vss @WIRE(mode="straight") {#X924:5 %t4687:p};
// %t4688 = $IO_PORT @ATTACH &n403 => @PLACE(366, -2431) => @ORIENT("R0");
// %t4688 @TEXT("n403", key="name", size=0.75);
// &n403 @WIRE(mode="straight") {#X925:1 %t4688:p};
// %t4689 = $IO_PORT @ATTACH &n402 => @PLACE(366, -2435) => @ORIENT("R0");
// %t4689 @TEXT("n402", key="name", size=0.75);
// &n402 @WIRE(mode="straight") {#X925:2 %t4689:p};
// %t4690 = $IO_PORT @ATTACH &n405 => @PLACE(386, -2433) => @ORIENT("MY");
// %t4690 @TEXT("n405", key="name", size=0.75);
// &n405 @WIRE(mode="straight") {#X925:3 %t4690:p};
// %t4691 = $SUPPLY @ATTACH &vdd => @PLACE(376, -2422);
// &vdd @WIRE(mode="straight") {#X925:4 %t4691:p};
// %t4692 = $GROUND @ATTACH &vss => @PLACE(376, -2444);
// &vss @WIRE(mode="straight") {#X925:5 %t4692:p};
// %t4693 = $IO_PORT @ATTACH &n246 => @PLACE(406, -2431) => @ORIENT("R0");
// %t4693 @TEXT("n246", key="name", size=0.75);
// &n246 @WIRE(mode="straight") {#X926:1 %t4693:p};
// %t4694 = $IO_PORT @ATTACH &n245 => @PLACE(406, -2435) => @ORIENT("R0");
// %t4694 @TEXT("n245", key="name", size=0.75);
// &n245 @WIRE(mode="straight") {#X926:2 %t4694:p};
// %t4695 = $IO_PORT @ATTACH &n715 => @PLACE(426, -2433) => @ORIENT("MY");
// %t4695 @TEXT("n715", key="name", size=0.75);
// &n715 @WIRE(mode="straight") {#X926:3 %t4695:p};
// %t4696 = $SUPPLY @ATTACH &vdd => @PLACE(416, -2422);
// &vdd @WIRE(mode="straight") {#X926:4 %t4696:p};
// %t4697 = $GROUND @ATTACH &vss => @PLACE(416, -2444);
// &vss @WIRE(mode="straight") {#X926:5 %t4697:p};
// %t4698 = $IO_PORT @ATTACH &n1108 => @PLACE(446, -2431) => @ORIENT("R0");
// %t4698 @TEXT("n1108", key="name", size=0.75);
// &n1108 @WIRE(mode="straight") {#X927:1 %t4698:p};
// %t4699 = $IO_PORT @ATTACH &n1109 => @PLACE(446, -2435) => @ORIENT("R0");
// %t4699 @TEXT("n1109", key="name", size=0.75);
// &n1109 @WIRE(mode="straight") {#X927:2 %t4699:p};
// %t4700 = $IO_PORT @ATTACH &n350 => @PLACE(466, -2433) => @ORIENT("MY");
// %t4700 @TEXT("n350", key="name", size=0.75);
// &n350 @WIRE(mode="straight") {#X927:3 %t4700:p};
// %t4701 = $SUPPLY @ATTACH &vdd => @PLACE(456, -2422);
// &vdd @WIRE(mode="straight") {#X927:4 %t4701:p};
// %t4702 = $GROUND @ATTACH &vss => @PLACE(456, -2444);
// &vss @WIRE(mode="straight") {#X927:5 %t4702:p};
// %t4703 = $IO_PORT @ATTACH &n900 => @PLACE(326, -2462) => @ORIENT("R0");
// %t4703 @TEXT("n900", key="name", size=0.75);
// &n900 @WIRE(mode="straight") {#X928:1 %t4703:p};
// %t4704 = $IO_PORT @ATTACH &n901 => @PLACE(326, -2466) => @ORIENT("R0");
// %t4704 @TEXT("n901", key="name", size=0.75);
// &n901 @WIRE(mode="straight") {#X928:2 %t4704:p};
// %t4705 = $IO_PORT @ATTACH &n1138 => @PLACE(346, -2464) => @ORIENT("MY");
// %t4705 @TEXT("n1138", key="name", size=0.75);
// &n1138 @WIRE(mode="straight") {#X928:3 %t4705:p};
// %t4706 = $SUPPLY @ATTACH &vdd => @PLACE(336, -2453);
// &vdd @WIRE(mode="straight") {#X928:4 %t4706:p};
// %t4707 = $GROUND @ATTACH &vss => @PLACE(336, -2475);
// &vss @WIRE(mode="straight") {#X928:5 %t4707:p};
// %t4708 = $IO_PORT @ATTACH &n902 => @PLACE(366, -2462) => @ORIENT("R0");
// %t4708 @TEXT("n902", key="name", size=0.75);
// &n902 @WIRE(mode="straight") {#X929:1 %t4708:p};
// %t4709 = $IO_PORT @ATTACH &n903 => @PLACE(366, -2466) => @ORIENT("R0");
// %t4709 @TEXT("n903", key="name", size=0.75);
// &n903 @WIRE(mode="straight") {#X929:2 %t4709:p};
// %t4710 = $IO_PORT @ATTACH &n913 => @PLACE(386, -2464) => @ORIENT("MY");
// %t4710 @TEXT("n913", key="name", size=0.75);
// &n913 @WIRE(mode="straight") {#X929:3 %t4710:p};
// %t4711 = $SUPPLY @ATTACH &vdd => @PLACE(376, -2453);
// &vdd @WIRE(mode="straight") {#X929:4 %t4711:p};
// %t4712 = $GROUND @ATTACH &vss => @PLACE(376, -2475);
// &vss @WIRE(mode="straight") {#X929:5 %t4712:p};
// %t4713 = $IO_PORT @ATTACH &n1138 => @PLACE(406, -2462) => @ORIENT("R0");
// %t4713 @TEXT("n1138", key="name", size=0.75);
// &n1138 @WIRE(mode="straight") {#X930:1 %t4713:p};
// %t4714 = $IO_PORT @ATTACH &n913 => @PLACE(406, -2466) => @ORIENT("R0");
// %t4714 @TEXT("n913", key="name", size=0.75);
// &n913 @WIRE(mode="straight") {#X930:2 %t4714:p};
// %t4715 = $IO_PORT @ATTACH &n1139 => @PLACE(426, -2464) => @ORIENT("MY");
// %t4715 @TEXT("n1139", key="name", size=0.75);
// &n1139 @WIRE(mode="straight") {#X930:3 %t4715:p};
// %t4716 = $SUPPLY @ATTACH &vdd => @PLACE(416, -2453);
// &vdd @WIRE(mode="straight") {#X930:4 %t4716:p};
// %t4717 = $GROUND @ATTACH &vss => @PLACE(416, -2475);
// &vss @WIRE(mode="straight") {#X930:5 %t4717:p};
// %t4718 = $IO_PORT @ATTACH &n1139 => @PLACE(446, -2462) => @ORIENT("R0");
// %t4718 @TEXT("n1139", key="name", size=0.75);
// &n1139 @WIRE(mode="straight") {#X931:1 %t4718:p};
// %t4719 = $IO_PORT @ATTACH &n909 => @PLACE(446, -2466) => @ORIENT("R0");
// %t4719 @TEXT("n909", key="name", size=0.75);
// &n909 @WIRE(mode="straight") {#X931:2 %t4719:p};
// %t4720 = $IO_PORT @ATTACH &n1140 => @PLACE(466, -2464) => @ORIENT("MY");
// %t4720 @TEXT("n1140", key="name", size=0.75);
// &n1140 @WIRE(mode="straight") {#X931:3 %t4720:p};
// %t4721 = $SUPPLY @ATTACH &vdd => @PLACE(456, -2453);
// &vdd @WIRE(mode="straight") {#X931:4 %t4721:p};
// %t4722 = $GROUND @ATTACH &vss => @PLACE(456, -2475);
// &vss @WIRE(mode="straight") {#X931:5 %t4722:p};
// %t4723 = $IO_PORT @ATTACH &n1141 => @PLACE(326, -2493) => @ORIENT("R0");
// %t4723 @TEXT("n1141", key="name", size=0.75);
// &n1141 @WIRE(mode="straight") {#X932:1 %t4723:p};
// %t4724 = $IO_PORT @ATTACH &n1140 => @PLACE(326, -2497) => @ORIENT("R0");
// %t4724 @TEXT("n1140", key="name", size=0.75);
// &n1140 @WIRE(mode="straight") {#X932:2 %t4724:p};
// %t4725 = $IO_PORT @ATTACH &n243 => @PLACE(346, -2495) => @ORIENT("MY");
// %t4725 @TEXT("n243", key="name", size=0.75);
// &n243 @WIRE(mode="straight") {#X932:3 %t4725:p};
// %t4726 = $SUPPLY @ATTACH &vdd => @PLACE(336, -2484);
// &vdd @WIRE(mode="straight") {#X932:4 %t4726:p};
// %t4727 = $GROUND @ATTACH &vss => @PLACE(336, -2506);
// &vss @WIRE(mode="straight") {#X932:5 %t4727:p};
// %t4728 = $IO_PORT @ATTACH &n935 => @PLACE(366, -2493) => @ORIENT("R0");
// %t4728 @TEXT("n935", key="name", size=0.75);
// &n935 @WIRE(mode="straight") {#X933:1 %t4728:p};
// %t4729 = $IO_PORT @ATTACH &n936 => @PLACE(366, -2497) => @ORIENT("R0");
// %t4729 @TEXT("n936", key="name", size=0.75);
// &n936 @WIRE(mode="straight") {#X933:2 %t4729:p};
// %t4730 = $IO_PORT @ATTACH &n1142 => @PLACE(386, -2495) => @ORIENT("MY");
// %t4730 @TEXT("n1142", key="name", size=0.75);
// &n1142 @WIRE(mode="straight") {#X933:3 %t4730:p};
// %t4731 = $SUPPLY @ATTACH &vdd => @PLACE(376, -2484);
// &vdd @WIRE(mode="straight") {#X933:4 %t4731:p};
// %t4732 = $GROUND @ATTACH &vss => @PLACE(376, -2506);
// &vss @WIRE(mode="straight") {#X933:5 %t4732:p};
// %t4733 = $IO_PORT @ATTACH &n1142 => @PLACE(406, -2493) => @ORIENT("R0");
// %t4733 @TEXT("n1142", key="name", size=0.75);
// &n1142 @WIRE(mode="straight") {#X934:1 %t4733:p};
// %t4734 = $IO_PORT @ATTACH &n948 => @PLACE(406, -2497) => @ORIENT("R0");
// %t4734 @TEXT("n948", key="name", size=0.75);
// &n948 @WIRE(mode="straight") {#X934:2 %t4734:p};
// %t4735 = $IO_PORT @ATTACH &n1143 => @PLACE(426, -2495) => @ORIENT("MY");
// %t4735 @TEXT("n1143", key="name", size=0.75);
// &n1143 @WIRE(mode="straight") {#X934:3 %t4735:p};
// %t4736 = $SUPPLY @ATTACH &vdd => @PLACE(416, -2484);
// &vdd @WIRE(mode="straight") {#X934:4 %t4736:p};
// %t4737 = $GROUND @ATTACH &vss => @PLACE(416, -2506);
// &vss @WIRE(mode="straight") {#X934:5 %t4737:p};
// %t4738 = $IO_PORT @ATTACH &n1143 => @PLACE(446, -2493) => @ORIENT("R0");
// %t4738 @TEXT("n1143", key="name", size=0.75);
// &n1143 @WIRE(mode="straight") {#X935:1 %t4738:p};
// %t4739 = $IO_PORT @ATTACH &n944 => @PLACE(446, -2497) => @ORIENT("R0");
// %t4739 @TEXT("n944", key="name", size=0.75);
// &n944 @WIRE(mode="straight") {#X935:2 %t4739:p};
// %t4740 = $IO_PORT @ATTACH &n353 => @PLACE(466, -2495) => @ORIENT("MY");
// %t4740 @TEXT("n353", key="name", size=0.75);
// &n353 @WIRE(mode="straight") {#X935:3 %t4740:p};
// %t4741 = $SUPPLY @ATTACH &vdd => @PLACE(456, -2484);
// &vdd @WIRE(mode="straight") {#X935:4 %t4741:p};
// %t4742 = $GROUND @ATTACH &vss => @PLACE(456, -2506);
// &vss @WIRE(mode="straight") {#X935:5 %t4742:p};
// %t4743 = $IO_PORT @ATTACH &n1144 => @PLACE(494, -2338) => @ORIENT("R0");
// %t4743 @TEXT("n1144", key="name", size=0.75);
// &n1144 @WIRE(mode="straight") {#X936:1 %t4743:p};
// %t4744 = $IO_PORT @ATTACH &n353 => @PLACE(494, -2342) => @ORIENT("R0");
// %t4744 @TEXT("n353", key="name", size=0.75);
// &n353 @WIRE(mode="straight") {#X936:2 %t4744:p};
// %t4745 = $IO_PORT @ATTACH &n240 => @PLACE(514, -2340) => @ORIENT("MY");
// %t4745 @TEXT("n240", key="name", size=0.75);
// &n240 @WIRE(mode="straight") {#X936:3 %t4745:p};
// %t4746 = $SUPPLY @ATTACH &vdd => @PLACE(504, -2329);
// &vdd @WIRE(mode="straight") {#X936:4 %t4746:p};
// %t4747 = $GROUND @ATTACH &vss => @PLACE(504, -2351);
// &vss @WIRE(mode="straight") {#X936:5 %t4747:p};
// %t4748 = $IO_PORT @ATTACH &n1145 => @PLACE(534, -2338) => @ORIENT("R0");
// %t4748 @TEXT("n1145", key="name", size=0.75);
// &n1145 @WIRE(mode="straight") {#X937:1 %t4748:p};
// %t4749 = $IO_PORT @ATTACH &n184 => @PLACE(534, -2342) => @ORIENT("R0");
// %t4749 @TEXT("n184", key="name", size=0.75);
// &n184 @WIRE(mode="straight") {#X937:2 %t4749:p};
// %t4750 = $IO_PORT @ATTACH &n179 => @PLACE(554, -2340) => @ORIENT("MY");
// %t4750 @TEXT("n179", key="name", size=0.75);
// &n179 @WIRE(mode="straight") {#X937:3 %t4750:p};
// %t4751 = $SUPPLY @ATTACH &vdd => @PLACE(544, -2329);
// &vdd @WIRE(mode="straight") {#X937:4 %t4751:p};
// %t4752 = $GROUND @ATTACH &vss => @PLACE(544, -2351);
// &vss @WIRE(mode="straight") {#X937:5 %t4752:p};
// %t4753 = $IO_PORT @ATTACH &n1146 => @PLACE(574, -2338) => @ORIENT("R0");
// %t4753 @TEXT("n1146", key="name", size=0.75);
// &n1146 @WIRE(mode="straight") {#X938:1 %t4753:p};
// %t4754 = $IO_PORT @ATTACH &n1147 => @PLACE(574, -2342) => @ORIENT("R0");
// %t4754 @TEXT("n1147", key="name", size=0.75);
// &n1147 @WIRE(mode="straight") {#X938:2 %t4754:p};
// %t4755 = $IO_PORT @ATTACH &n1148 => @PLACE(594, -2340) => @ORIENT("MY");
// %t4755 @TEXT("n1148", key="name", size=0.75);
// &n1148 @WIRE(mode="straight") {#X938:3 %t4755:p};
// %t4756 = $SUPPLY @ATTACH &vdd => @PLACE(584, -2329);
// &vdd @WIRE(mode="straight") {#X938:4 %t4756:p};
// %t4757 = $GROUND @ATTACH &vss => @PLACE(584, -2351);
// &vss @WIRE(mode="straight") {#X938:5 %t4757:p};
// %t4758 = $IO_PORT @ATTACH &n1149 => @PLACE(614, -2338) => @ORIENT("R0");
// %t4758 @TEXT("n1149", key="name", size=0.75);
// &n1149 @WIRE(mode="straight") {#X939:1 %t4758:p};
// %t4759 = $IO_PORT @ATTACH &n184 => @PLACE(614, -2342) => @ORIENT("R0");
// %t4759 @TEXT("n184", key="name", size=0.75);
// &n184 @WIRE(mode="straight") {#X939:2 %t4759:p};
// %t4760 = $IO_PORT @ATTACH &n1150 => @PLACE(635, -2340) => @ORIENT("MY");
// %t4760 @TEXT("n1150", key="name", size=0.75);
// &n1150 @WIRE(mode="straight") {#X939:3 %t4760:p};
// %t4761 = $SUPPLY @ATTACH &vdd => @PLACE(624, -2329);
// &vdd @WIRE(mode="straight") {#X939:4 %t4761:p};
// %t4762 = $GROUND @ATTACH &vss => @PLACE(624, -2351);
// &vss @WIRE(mode="straight") {#X939:5 %t4762:p};
// %t4763 = $IO_PORT @ATTACH &n1148 => @PLACE(494, -2369) => @ORIENT("R0");
// %t4763 @TEXT("n1148", key="name", size=0.75);
// &n1148 @WIRE(mode="straight") {#X940:1 %t4763:p};
// %t4764 = $IO_PORT @ATTACH &n1150 => @PLACE(494, -2373) => @ORIENT("R0");
// %t4764 @TEXT("n1150", key="name", size=0.75);
// &n1150 @WIRE(mode="straight") {#X940:2 %t4764:p};
// %t4765 = $IO_PORT @ATTACH &n171 => @PLACE(514, -2371) => @ORIENT("MY");
// %t4765 @TEXT("n171", key="name", size=0.75);
// &n171 @WIRE(mode="straight") {#X940:3 %t4765:p};
// %t4766 = $SUPPLY @ATTACH &vdd => @PLACE(504, -2360);
// &vdd @WIRE(mode="straight") {#X940:4 %t4766:p};
// %t4767 = $GROUND @ATTACH &vss => @PLACE(504, -2382);
// &vss @WIRE(mode="straight") {#X940:5 %t4767:p};
// %t4768 = $IO_PORT @ATTACH &n962 => @PLACE(534, -2369) => @ORIENT("R0");
// %t4768 @TEXT("n962", key="name", size=0.75);
// &n962 @WIRE(mode="straight") {#X941:1 %t4768:p};
// %t4769 = $IO_PORT @ATTACH &n233 => @PLACE(534, -2373) => @ORIENT("R0");
// %t4769 @TEXT("n233", key="name", size=0.75);
// &n233 @WIRE(mode="straight") {#X941:2 %t4769:p};
// %t4770 = $IO_PORT @ATTACH &n1146 => @PLACE(554, -2371) => @ORIENT("MY");
// %t4770 @TEXT("n1146", key="name", size=0.75);
// &n1146 @WIRE(mode="straight") {#X941:3 %t4770:p};
// %t4771 = $SUPPLY @ATTACH &vdd => @PLACE(544, -2360);
// &vdd @WIRE(mode="straight") {#X941:4 %t4771:p};
// %t4772 = $GROUND @ATTACH &vss => @PLACE(544, -2382);
// &vss @WIRE(mode="straight") {#X941:5 %t4772:p};
// %t4773 = $IO_PORT @ATTACH &n962 => @PLACE(574, -2369) => @ORIENT("R0");
// %t4773 @TEXT("n962", key="name", size=0.75);
// &n962 @WIRE(mode="straight") {#X942:1 %t4773:p};
// %t4774 = $IO_PORT @ATTACH &n238 => @PLACE(574, -2373) => @ORIENT("R0");
// %t4774 @TEXT("n238", key="name", size=0.75);
// &n238 @WIRE(mode="straight") {#X942:2 %t4774:p};
// %t4775 = $IO_PORT @ATTACH &n1147 => @PLACE(594, -2371) => @ORIENT("MY");
// %t4775 @TEXT("n1147", key="name", size=0.75);
// &n1147 @WIRE(mode="straight") {#X942:3 %t4775:p};
// %t4776 = $SUPPLY @ATTACH &vdd => @PLACE(584, -2360);
// &vdd @WIRE(mode="straight") {#X942:4 %t4776:p};
// %t4777 = $GROUND @ATTACH &vss => @PLACE(584, -2382);
// &vss @WIRE(mode="straight") {#X942:5 %t4777:p};
// %t4778 = $IO_PORT @ATTACH &n962 => @PLACE(614, -2369) => @ORIENT("R0");
// %t4778 @TEXT("n962", key="name", size=0.75);
// &n962 @WIRE(mode="straight") {#X943:1 %t4778:p};
// %t4779 = $IO_PORT @ATTACH &n88 => @PLACE(614, -2373) => @ORIENT("R0");
// %t4779 @TEXT("n88", key="name", size=0.75);
// &n88 @WIRE(mode="straight") {#X943:2 %t4779:p};
// %t4780 = $IO_PORT @ATTACH &n1149 => @PLACE(635, -2371) => @ORIENT("MY");
// %t4780 @TEXT("n1149", key="name", size=0.75);
// &n1149 @WIRE(mode="straight") {#X943:3 %t4780:p};
// %t4781 = $SUPPLY @ATTACH &vdd => @PLACE(624, -2360);
// &vdd @WIRE(mode="straight") {#X943:4 %t4781:p};
// %t4782 = $GROUND @ATTACH &vss => @PLACE(624, -2382);
// &vss @WIRE(mode="straight") {#X943:5 %t4782:p};
// %t4783 = $IO_PORT @ATTACH &n1151 => @PLACE(494, -2400) => @ORIENT("R0");
// %t4783 @TEXT("n1151", key="name", size=0.75);
// &n1151 @WIRE(mode="straight") {#X944:1 %t4783:p};
// %t4784 = $IO_PORT @ATTACH &n1152 => @PLACE(494, -2404) => @ORIENT("R0");
// %t4784 @TEXT("n1152", key="name", size=0.75);
// &n1152 @WIRE(mode="straight") {#X944:2 %t4784:p};
// %t4785 = $IO_PORT @ATTACH &n1153 => @PLACE(514, -2402) => @ORIENT("MY");
// %t4785 @TEXT("n1153", key="name", size=0.75);
// &n1153 @WIRE(mode="straight") {#X944:3 %t4785:p};
// %t4786 = $SUPPLY @ATTACH &vdd => @PLACE(504, -2391);
// &vdd @WIRE(mode="straight") {#X944:4 %t4786:p};
// %t4787 = $GROUND @ATTACH &vss => @PLACE(504, -2413);
// &vss @WIRE(mode="straight") {#X944:5 %t4787:p};
// %t4788 = $IO_PORT @ATTACH &n1153 => @PLACE(534, -2400) => @ORIENT("R0");
// %t4788 @TEXT("n1153", key="name", size=0.75);
// &n1153 @WIRE(mode="straight") {#X945:1 %t4788:p};
// %t4789 = $IO_PORT @ATTACH &n1014 => @PLACE(534, -2404) => @ORIENT("R0");
// %t4789 @TEXT("n1014", key="name", size=0.75);
// &n1014 @WIRE(mode="straight") {#X945:2 %t4789:p};
// %t4790 = $IO_PORT @ATTACH &n1154 => @PLACE(554, -2402) => @ORIENT("MY");
// %t4790 @TEXT("n1154", key="name", size=0.75);
// &n1154 @WIRE(mode="straight") {#X945:3 %t4790:p};
// %t4791 = $SUPPLY @ATTACH &vdd => @PLACE(544, -2391);
// &vdd @WIRE(mode="straight") {#X945:4 %t4791:p};
// %t4792 = $GROUND @ATTACH &vss => @PLACE(544, -2413);
// &vss @WIRE(mode="straight") {#X945:5 %t4792:p};
// %t4793 = $IO_PORT @ATTACH &n1154 => @PLACE(574, -2400) => @ORIENT("R0");
// %t4793 @TEXT("n1154", key="name", size=0.75);
// &n1154 @WIRE(mode="straight") {#X946:1 %t4793:p};
// %t4794 = $IO_PORT @ATTACH &n1016 => @PLACE(574, -2404) => @ORIENT("R0");
// %t4794 @TEXT("n1016", key="name", size=0.75);
// &n1016 @WIRE(mode="straight") {#X946:2 %t4794:p};
// %t4795 = $IO_PORT @ATTACH &n1155 => @PLACE(594, -2402) => @ORIENT("MY");
// %t4795 @TEXT("n1155", key="name", size=0.75);
// &n1155 @WIRE(mode="straight") {#X946:3 %t4795:p};
// %t4796 = $SUPPLY @ATTACH &vdd => @PLACE(584, -2391);
// &vdd @WIRE(mode="straight") {#X946:4 %t4796:p};
// %t4797 = $GROUND @ATTACH &vss => @PLACE(584, -2413);
// &vss @WIRE(mode="straight") {#X946:5 %t4797:p};
// %t4798 = $IO_PORT @ATTACH &n1155 => @PLACE(614, -2400) => @ORIENT("R0");
// %t4798 @TEXT("n1155", key="name", size=0.75);
// &n1155 @WIRE(mode="straight") {#X947:1 %t4798:p};
// %t4799 = $IO_PORT @ATTACH &n1018 => @PLACE(614, -2404) => @ORIENT("R0");
// %t4799 @TEXT("n1018", key="name", size=0.75);
// &n1018 @WIRE(mode="straight") {#X947:2 %t4799:p};
// %t4800 = $IO_PORT @ATTACH &n165 => @PLACE(635, -2402) => @ORIENT("MY");
// %t4800 @TEXT("n165", key="name", size=0.75);
// &n165 @WIRE(mode="straight") {#X947:3 %t4800:p};
// %t4801 = $SUPPLY @ATTACH &vdd => @PLACE(624, -2391);
// &vdd @WIRE(mode="straight") {#X947:4 %t4801:p};
// %t4802 = $GROUND @ATTACH &vss => @PLACE(624, -2413);
// &vss @WIRE(mode="straight") {#X947:5 %t4802:p};
// %t4803 = $IO_PORT @ATTACH &n963 => @PLACE(494, -2431) => @ORIENT("R0");
// %t4803 @TEXT("n963", key="name", size=0.75);
// &n963 @WIRE(mode="straight") {#X948:1 %t4803:p};
// %t4804 = $IO_PORT @ATTACH &n244 => @PLACE(494, -2435) => @ORIENT("R0");
// %t4804 @TEXT("n244", key="name", size=0.75);
// &n244 @WIRE(mode="straight") {#X948:2 %t4804:p};
// %t4805 = $IO_PORT @ATTACH &n1151 => @PLACE(514, -2433) => @ORIENT("MY");
// %t4805 @TEXT("n1151", key="name", size=0.75);
// &n1151 @WIRE(mode="straight") {#X948:3 %t4805:p};
// %t4806 = $SUPPLY @ATTACH &vdd => @PLACE(504, -2422);
// &vdd @WIRE(mode="straight") {#X948:4 %t4806:p};
// %t4807 = $GROUND @ATTACH &vss => @PLACE(504, -2444);
// &vss @WIRE(mode="straight") {#X948:5 %t4807:p};
// %t4808 = $IO_PORT @ATTACH &n963 => @PLACE(534, -2431) => @ORIENT("R0");
// %t4808 @TEXT("n963", key="name", size=0.75);
// &n963 @WIRE(mode="straight") {#X949:1 %t4808:p};
// %t4809 = $IO_PORT @ATTACH &n1031 => @PLACE(534, -2435) => @ORIENT("R0");
// %t4809 @TEXT("n1031", key="name", size=0.75);
// &n1031 @WIRE(mode="straight") {#X949:2 %t4809:p};
// %t4810 = $IO_PORT @ATTACH &n1152 => @PLACE(554, -2433) => @ORIENT("MY");
// %t4810 @TEXT("n1152", key="name", size=0.75);
// &n1152 @WIRE(mode="straight") {#X949:3 %t4810:p};
// %t4811 = $SUPPLY @ATTACH &vdd => @PLACE(544, -2422);
// &vdd @WIRE(mode="straight") {#X949:4 %t4811:p};
// %t4812 = $GROUND @ATTACH &vss => @PLACE(544, -2444);
// &vss @WIRE(mode="straight") {#X949:5 %t4812:p};
// %t4813 = $IO_PORT @ATTACH &n1145 => @PLACE(574, -2431) => @ORIENT("R0");
// %t4813 @TEXT("n1145", key="name", size=0.75);
// &n1145 @WIRE(mode="straight") {#X950:1 %t4813:p};
// %t4814 = $IO_PORT @ATTACH &n1156 => @PLACE(574, -2435) => @ORIENT("R0");
// %t4814 @TEXT("n1156", key="name", size=0.75);
// &n1156 @WIRE(mode="straight") {#X950:2 %t4814:p};
// %t4815 = $IO_PORT @ATTACH &n1157 => @PLACE(594, -2433) => @ORIENT("MY");
// %t4815 @TEXT("n1157", key="name", size=0.75);
// &n1157 @WIRE(mode="straight") {#X950:3 %t4815:p};
// %t4816 = $SUPPLY @ATTACH &vdd => @PLACE(584, -2422);
// &vdd @WIRE(mode="straight") {#X950:4 %t4816:p};
// %t4817 = $GROUND @ATTACH &vss => @PLACE(584, -2444);
// &vss @WIRE(mode="straight") {#X950:5 %t4817:p};
// %t4818 = $IO_PORT @ATTACH &n1158 => @PLACE(614, -2431) => @ORIENT("R0");
// %t4818 @TEXT("n1158", key="name", size=0.75);
// &n1158 @WIRE(mode="straight") {#X951:1 %t4818:p};
// %t4819 = $IO_PORT @ATTACH &n958 => @PLACE(614, -2435) => @ORIENT("R0");
// %t4819 @TEXT("n958", key="name", size=0.75);
// &n958 @WIRE(mode="straight") {#X951:2 %t4819:p};
// %t4820 = $IO_PORT @ATTACH &n1159 => @PLACE(635, -2433) => @ORIENT("MY");
// %t4820 @TEXT("n1159", key="name", size=0.75);
// &n1159 @WIRE(mode="straight") {#X951:3 %t4820:p};
// %t4821 = $SUPPLY @ATTACH &vdd => @PLACE(624, -2422);
// &vdd @WIRE(mode="straight") {#X951:4 %t4821:p};
// %t4822 = $GROUND @ATTACH &vss => @PLACE(624, -2444);
// &vss @WIRE(mode="straight") {#X951:5 %t4822:p};
// %t4823 = $IO_PORT @ATTACH &n959 => @PLACE(494, -2462) => @ORIENT("R0");
// %t4823 @TEXT("n959", key="name", size=0.75);
// &n959 @WIRE(mode="straight") {#X952:1 %t4823:p};
// %t4824 = $IO_PORT @ATTACH &n961 => @PLACE(494, -2466) => @ORIENT("R0");
// %t4824 @TEXT("n961", key="name", size=0.75);
// &n961 @WIRE(mode="straight") {#X952:2 %t4824:p};
// %t4825 = $IO_PORT @ATTACH &n1160 => @PLACE(514, -2464) => @ORIENT("MY");
// %t4825 @TEXT("n1160", key="name", size=0.75);
// &n1160 @WIRE(mode="straight") {#X952:3 %t4825:p};
// %t4826 = $SUPPLY @ATTACH &vdd => @PLACE(504, -2453);
// &vdd @WIRE(mode="straight") {#X952:4 %t4826:p};
// %t4827 = $GROUND @ATTACH &vss => @PLACE(504, -2475);
// &vss @WIRE(mode="straight") {#X952:5 %t4827:p};
// %t4828 = $IO_PORT @ATTACH &n964 => @PLACE(534, -2462) => @ORIENT("R0");
// %t4828 @TEXT("n964", key="name", size=0.75);
// &n964 @WIRE(mode="straight") {#X953:1 %t4828:p};
// %t4829 = $IO_PORT @ATTACH &n967 => @PLACE(534, -2466) => @ORIENT("R0");
// %t4829 @TEXT("n967", key="name", size=0.75);
// &n967 @WIRE(mode="straight") {#X953:2 %t4829:p};
// %t4830 = $IO_PORT @ATTACH &n1161 => @PLACE(554, -2464) => @ORIENT("MY");
// %t4830 @TEXT("n1161", key="name", size=0.75);
// &n1161 @WIRE(mode="straight") {#X953:3 %t4830:p};
// %t4831 = $SUPPLY @ATTACH &vdd => @PLACE(544, -2453);
// &vdd @WIRE(mode="straight") {#X953:4 %t4831:p};
// %t4832 = $GROUND @ATTACH &vss => @PLACE(544, -2475);
// &vss @WIRE(mode="straight") {#X953:5 %t4832:p};
// %t4833 = $IO_PORT @ATTACH &n1157 => @PLACE(574, -2462) => @ORIENT("R0");
// %t4833 @TEXT("n1157", key="name", size=0.75);
// &n1157 @WIRE(mode="straight") {#X954:1 %t4833:p};
// %t4834 = $IO_PORT @ATTACH &n1159 => @PLACE(574, -2466) => @ORIENT("R0");
// %t4834 @TEXT("n1159", key="name", size=0.75);
// &n1159 @WIRE(mode="straight") {#X954:2 %t4834:p};
// %t4835 = $IO_PORT @ATTACH &n1162 => @PLACE(594, -2464) => @ORIENT("MY");
// %t4835 @TEXT("n1162", key="name", size=0.75);
// &n1162 @WIRE(mode="straight") {#X954:3 %t4835:p};
// %t4836 = $SUPPLY @ATTACH &vdd => @PLACE(584, -2453);
// &vdd @WIRE(mode="straight") {#X954:4 %t4836:p};
// %t4837 = $GROUND @ATTACH &vss => @PLACE(584, -2475);
// &vss @WIRE(mode="straight") {#X954:5 %t4837:p};
// %t4838 = $IO_PORT @ATTACH &n1160 => @PLACE(614, -2462) => @ORIENT("R0");
// %t4838 @TEXT("n1160", key="name", size=0.75);
// &n1160 @WIRE(mode="straight") {#X955:1 %t4838:p};
// %t4839 = $IO_PORT @ATTACH &n1161 => @PLACE(614, -2466) => @ORIENT("R0");
// %t4839 @TEXT("n1161", key="name", size=0.75);
// &n1161 @WIRE(mode="straight") {#X955:2 %t4839:p};
// %t4840 = $IO_PORT @ATTACH &n1163 => @PLACE(635, -2464) => @ORIENT("MY");
// %t4840 @TEXT("n1163", key="name", size=0.75);
// &n1163 @WIRE(mode="straight") {#X955:3 %t4840:p};
// %t4841 = $SUPPLY @ATTACH &vdd => @PLACE(624, -2453);
// &vdd @WIRE(mode="straight") {#X955:4 %t4841:p};
// %t4842 = $GROUND @ATTACH &vss => @PLACE(624, -2475);
// &vss @WIRE(mode="straight") {#X955:5 %t4842:p};
// %t4843 = $IO_PORT @ATTACH &n1162 => @PLACE(494, -2493) => @ORIENT("R0");
// %t4843 @TEXT("n1162", key="name", size=0.75);
// &n1162 @WIRE(mode="straight") {#X956:1 %t4843:p};
// %t4844 = $IO_PORT @ATTACH &n1163 => @PLACE(494, -2497) => @ORIENT("R0");
// %t4844 @TEXT("n1163", key="name", size=0.75);
// &n1163 @WIRE(mode="straight") {#X956:2 %t4844:p};
// %t4845 = $IO_PORT @ATTACH &n1164 => @PLACE(514, -2495) => @ORIENT("MY");
// %t4845 @TEXT("n1164", key="name", size=0.75);
// &n1164 @WIRE(mode="straight") {#X956:3 %t4845:p};
// %t4846 = $SUPPLY @ATTACH &vdd => @PLACE(504, -2484);
// &vdd @WIRE(mode="straight") {#X956:4 %t4846:p};
// %t4847 = $GROUND @ATTACH &vss => @PLACE(504, -2506);
// &vss @WIRE(mode="straight") {#X956:5 %t4847:p};
// %t4848 = $IO_PORT @ATTACH &n1164 => @PLACE(534, -2493) => @ORIENT("R0");
// %t4848 @TEXT("n1164", key="name", size=0.75);
// &n1164 @WIRE(mode="straight") {#X957:1 %t4848:p};
// %t4849 = $IO_PORT @ATTACH &n184 => @PLACE(534, -2497) => @ORIENT("R0");
// %t4849 @TEXT("n184", key="name", size=0.75);
// &n184 @WIRE(mode="straight") {#X957:2 %t4849:p};
// %t4850 = $IO_PORT @ATTACH &n159 => @PLACE(554, -2495) => @ORIENT("MY");
// %t4850 @TEXT("n159", key="name", size=0.75);
// &n159 @WIRE(mode="straight") {#X957:3 %t4850:p};
// %t4851 = $SUPPLY @ATTACH &vdd => @PLACE(544, -2484);
// &vdd @WIRE(mode="straight") {#X957:4 %t4851:p};
// %t4852 = $GROUND @ATTACH &vss => @PLACE(544, -2506);
// &vss @WIRE(mode="straight") {#X957:5 %t4852:p};
// %t4853 = $IO_PORT @ATTACH &n51 => @PLACE(574, -2493) => @ORIENT("R0");
// %t4853 @TEXT("n51", key="name", size=0.75);
// &n51 @WIRE(mode="straight") {#X958:1 %t4853:p};
// %t4854 = $IO_PORT @ATTACH &n1165 => @PLACE(574, -2497) => @ORIENT("R0");
// %t4854 @TEXT("n1165", key="name", size=0.75);
// &n1165 @WIRE(mode="straight") {#X958:2 %t4854:p};
// %t4855 = $IO_PORT @ATTACH &n1145 => @PLACE(594, -2495) => @ORIENT("MY");
// %t4855 @TEXT("n1145", key="name", size=0.75);
// &n1145 @WIRE(mode="straight") {#X958:3 %t4855:p};
// %t4856 = $SUPPLY @ATTACH &vdd => @PLACE(584, -2484);
// &vdd @WIRE(mode="straight") {#X958:4 %t4856:p};
// %t4857 = $GROUND @ATTACH &vss => @PLACE(584, -2506);
// &vss @WIRE(mode="straight") {#X958:5 %t4857:p};
// %t4858 = $IO_PORT @ATTACH &n231 => @PLACE(614, -2493) => @ORIENT("R0");
// %t4858 @TEXT("n231", key="name", size=0.75);
// &n231 @WIRE(mode="straight") {#X959:1 %t4858:p};
// %t4859 = $IO_PORT @ATTACH &n239 => @PLACE(614, -2497) => @ORIENT("R0");
// %t4859 @TEXT("n239", key="name", size=0.75);
// &n239 @WIRE(mode="straight") {#X959:2 %t4859:p};
// %t4860 = $IO_PORT @ATTACH &n1019 => @PLACE(635, -2495) => @ORIENT("MY");
// %t4860 @TEXT("n1019", key="name", size=0.75);
// &n1019 @WIRE(mode="straight") {#X959:3 %t4860:p};
// %t4861 = $SUPPLY @ATTACH &vdd => @PLACE(624, -2484);
// &vdd @WIRE(mode="straight") {#X959:4 %t4861:p};
// %t4862 = $GROUND @ATTACH &vss => @PLACE(624, -2506);
// &vss @WIRE(mode="straight") {#X959:5 %t4862:p};
// %t4863 = $IO_PORT @ATTACH &n962 => @PLACE(-11, -2536) => @ORIENT("R0");
// %t4863 @TEXT("n962", key="name", size=0.75);
// &n962 @WIRE(mode="straight") {#X960:1 %t4863:p};
// %t4864 = $IO_PORT @ATTACH &n1019 => @PLACE(-11, -2540) => @ORIENT("R0");
// %t4864 @TEXT("n1019", key="name", size=0.75);
// &n1019 @WIRE(mode="straight") {#X960:2 %t4864:p};
// %t4865 = $IO_PORT @ATTACH &n1166 => @PLACE(10, -2538) => @ORIENT("MY");
// %t4865 @TEXT("n1166", key="name", size=0.75);
// &n1166 @WIRE(mode="straight") {#X960:3 %t4865:p};
// %t4866 = $SUPPLY @ATTACH &vdd => @PLACE(0, -2527);
// &vdd @WIRE(mode="straight") {#X960:4 %t4866:p};
// %t4867 = $GROUND @ATTACH &vss => @PLACE(0, -2549);
// &vss @WIRE(mode="straight") {#X960:5 %t4867:p};
// %t4868 = $IO_PORT @ATTACH &n1166 => @PLACE(30, -2536) => @ORIENT("R0");
// %t4868 @TEXT("n1166", key="name", size=0.75);
// &n1166 @WIRE(mode="straight") {#X961:1 %t4868:p};
// %t4869 = $IO_PORT @ATTACH &n233 => @PLACE(30, -2540) => @ORIENT("R0");
// %t4869 @TEXT("n233", key="name", size=0.75);
// &n233 @WIRE(mode="straight") {#X961:2 %t4869:p};
// %t4870 = $IO_PORT @ATTACH &n1156 => @PLACE(50, -2538) => @ORIENT("MY");
// %t4870 @TEXT("n1156", key="name", size=0.75);
// &n1156 @WIRE(mode="straight") {#X961:3 %t4870:p};
// %t4871 = $SUPPLY @ATTACH &vdd => @PLACE(40, -2527);
// &vdd @WIRE(mode="straight") {#X961:4 %t4871:p};
// %t4872 = $GROUND @ATTACH &vss => @PLACE(40, -2549);
// &vss @WIRE(mode="straight") {#X961:5 %t4872:p};
// %t4873 = $IO_PORT @ATTACH &n351 => @PLACE(70, -2536) => @ORIENT("R0");
// %t4873 @TEXT("n351", key="name", size=0.75);
// &n351 @WIRE(mode="straight") {#X962:1 %t4873:p};
// %t4874 = $IO_PORT @ATTACH &n244 => @PLACE(70, -2540) => @ORIENT("R0");
// %t4874 @TEXT("n244", key="name", size=0.75);
// &n244 @WIRE(mode="straight") {#X962:2 %t4874:p};
// %t4875 = $IO_PORT @ATTACH &n1167 => @PLACE(90, -2538) => @ORIENT("MY");
// %t4875 @TEXT("n1167", key="name", size=0.75);
// &n1167 @WIRE(mode="straight") {#X962:3 %t4875:p};
// %t4876 = $SUPPLY @ATTACH &vdd => @PLACE(80, -2527);
// &vdd @WIRE(mode="straight") {#X962:4 %t4876:p};
// %t4877 = $GROUND @ATTACH &vss => @PLACE(80, -2549);
// &vss @WIRE(mode="straight") {#X962:5 %t4877:p};
// %t4878 = $IO_PORT @ATTACH &n956 => @PLACE(110, -2536) => @ORIENT("R0");
// %t4878 @TEXT("n956", key="name", size=0.75);
// &n956 @WIRE(mode="straight") {#X963:1 %t4878:p};
// %t4879 = $IO_PORT @ATTACH &n1167 => @PLACE(110, -2540) => @ORIENT("R0");
// %t4879 @TEXT("n1167", key="name", size=0.75);
// &n1167 @WIRE(mode="straight") {#X963:2 %t4879:p};
// %t4880 = $IO_PORT @ATTACH &n1158 => @PLACE(130, -2538) => @ORIENT("MY");
// %t4880 @TEXT("n1158", key="name", size=0.75);
// &n1158 @WIRE(mode="straight") {#X963:3 %t4880:p};
// %t4881 = $SUPPLY @ATTACH &vdd => @PLACE(120, -2527);
// &vdd @WIRE(mode="straight") {#X963:4 %t4881:p};
// %t4882 = $GROUND @ATTACH &vss => @PLACE(120, -2549);
// &vss @WIRE(mode="straight") {#X963:5 %t4882:p};
// %t4883 = $IO_PORT @ATTACH &n1031 => @PLACE(-11, -2567) => @ORIENT("R0");
// %t4883 @TEXT("n1031", key="name", size=0.75);
// &n1031 @WIRE(mode="straight") {#X964:1 %t4883:p};
// %t4884 = $IO_PORT @ATTACH &n241 => @PLACE(-11, -2571) => @ORIENT("R0");
// %t4884 @TEXT("n241", key="name", size=0.75);
// &n241 @WIRE(mode="straight") {#X964:2 %t4884:p};
// %t4885 = $IO_PORT @ATTACH &n957 => @PLACE(10, -2569) => @ORIENT("MY");
// %t4885 @TEXT("n957", key="name", size=0.75);
// &n957 @WIRE(mode="straight") {#X964:3 %t4885:p};
// %t4886 = $SUPPLY @ATTACH &vdd => @PLACE(0, -2558);
// &vdd @WIRE(mode="straight") {#X964:4 %t4886:p};
// %t4887 = $GROUND @ATTACH &vss => @PLACE(0, -2580);
// &vss @WIRE(mode="straight") {#X964:5 %t4887:p};
// %t4888 = $IO_PORT @ATTACH &coarse0 => @PLACE(30, -2567) => @ORIENT("R0");
// %t4888 @TEXT("coarse0", key="name", size=0.75);
// &coarse0 @WIRE(mode="straight") {#X965:1 %t4888:p};
// %t4889 = $IO_PORT @ATTACH &coarse1 => @PLACE(30, -2571) => @ORIENT("R0");
// %t4889 @TEXT("coarse1", key="name", size=0.75);
// &coarse1 @WIRE(mode="straight") {#X965:2 %t4889:p};
// %t4890 = $IO_PORT @ATTACH &n1168 => @PLACE(50, -2569) => @ORIENT("MY");
// %t4890 @TEXT("n1168", key="name", size=0.75);
// &n1168 @WIRE(mode="straight") {#X965:3 %t4890:p};
// %t4891 = $SUPPLY @ATTACH &vdd => @PLACE(40, -2558);
// &vdd @WIRE(mode="straight") {#X965:4 %t4891:p};
// %t4892 = $GROUND @ATTACH &vss => @PLACE(40, -2580);
// &vss @WIRE(mode="straight") {#X965:5 %t4892:p};
// %t4893 = $IO_PORT @ATTACH &coarse2 => @PLACE(70, -2567) => @ORIENT("R0");
// %t4893 @TEXT("coarse2", key="name", size=0.75);
// &coarse2 @WIRE(mode="straight") {#X966:1 %t4893:p};
// %t4894 = $IO_PORT @ATTACH &coarse3 => @PLACE(70, -2571) => @ORIENT("R0");
// %t4894 @TEXT("coarse3", key="name", size=0.75);
// &coarse3 @WIRE(mode="straight") {#X966:2 %t4894:p};
// %t4895 = $IO_PORT @ATTACH &n1169 => @PLACE(90, -2569) => @ORIENT("MY");
// %t4895 @TEXT("n1169", key="name", size=0.75);
// &n1169 @WIRE(mode="straight") {#X966:3 %t4895:p};
// %t4896 = $SUPPLY @ATTACH &vdd => @PLACE(80, -2558);
// &vdd @WIRE(mode="straight") {#X966:4 %t4896:p};
// %t4897 = $GROUND @ATTACH &vss => @PLACE(80, -2580);
// &vss @WIRE(mode="straight") {#X966:5 %t4897:p};
// %t4898 = $IO_PORT @ATTACH &coarse4 => @PLACE(110, -2567) => @ORIENT("R0");
// %t4898 @TEXT("coarse4", key="name", size=0.75);
// &coarse4 @WIRE(mode="straight") {#X967:1 %t4898:p};
// %t4899 = $IO_PORT @ATTACH &coarse5 => @PLACE(110, -2571) => @ORIENT("R0");
// %t4899 @TEXT("coarse5", key="name", size=0.75);
// &coarse5 @WIRE(mode="straight") {#X967:2 %t4899:p};
// %t4900 = $IO_PORT @ATTACH &n1170 => @PLACE(130, -2569) => @ORIENT("MY");
// %t4900 @TEXT("n1170", key="name", size=0.75);
// &n1170 @WIRE(mode="straight") {#X967:3 %t4900:p};
// %t4901 = $SUPPLY @ATTACH &vdd => @PLACE(120, -2558);
// &vdd @WIRE(mode="straight") {#X967:4 %t4901:p};
// %t4902 = $GROUND @ATTACH &vss => @PLACE(120, -2580);
// &vss @WIRE(mode="straight") {#X967:5 %t4902:p};
// %t4903 = $IO_PORT @ATTACH &coarse6 => @PLACE(-11, -2598) => @ORIENT("R0");
// %t4903 @TEXT("coarse6", key="name", size=0.75);
// &coarse6 @WIRE(mode="straight") {#X968:1 %t4903:p};
// %t4904 = $IO_PORT @ATTACH &coarse7 => @PLACE(-11, -2602) => @ORIENT("R0");
// %t4904 @TEXT("coarse7", key="name", size=0.75);
// &coarse7 @WIRE(mode="straight") {#X968:2 %t4904:p};
// %t4905 = $IO_PORT @ATTACH &n1171 => @PLACE(10, -2600) => @ORIENT("MY");
// %t4905 @TEXT("n1171", key="name", size=0.75);
// &n1171 @WIRE(mode="straight") {#X968:3 %t4905:p};
// %t4906 = $SUPPLY @ATTACH &vdd => @PLACE(0, -2589);
// &vdd @WIRE(mode="straight") {#X968:4 %t4906:p};
// %t4907 = $GROUND @ATTACH &vss => @PLACE(0, -2611);
// &vss @WIRE(mode="straight") {#X968:5 %t4907:p};
// %t4908 = $IO_PORT @ATTACH &n1168 => @PLACE(30, -2598) => @ORIENT("R0");
// %t4908 @TEXT("n1168", key="name", size=0.75);
// &n1168 @WIRE(mode="straight") {#X969:1 %t4908:p};
// %t4909 = $IO_PORT @ATTACH &n1169 => @PLACE(30, -2602) => @ORIENT("R0");
// %t4909 @TEXT("n1169", key="name", size=0.75);
// &n1169 @WIRE(mode="straight") {#X969:2 %t4909:p};
// %t4910 = $IO_PORT @ATTACH &n1172 => @PLACE(50, -2600) => @ORIENT("MY");
// %t4910 @TEXT("n1172", key="name", size=0.75);
// &n1172 @WIRE(mode="straight") {#X969:3 %t4910:p};
// %t4911 = $SUPPLY @ATTACH &vdd => @PLACE(40, -2589);
// &vdd @WIRE(mode="straight") {#X969:4 %t4911:p};
// %t4912 = $GROUND @ATTACH &vss => @PLACE(40, -2611);
// &vss @WIRE(mode="straight") {#X969:5 %t4912:p};
// %t4913 = $IO_PORT @ATTACH &n1170 => @PLACE(70, -2598) => @ORIENT("R0");
// %t4913 @TEXT("n1170", key="name", size=0.75);
// &n1170 @WIRE(mode="straight") {#X970:1 %t4913:p};
// %t4914 = $IO_PORT @ATTACH &n1171 => @PLACE(70, -2602) => @ORIENT("R0");
// %t4914 @TEXT("n1171", key="name", size=0.75);
// &n1171 @WIRE(mode="straight") {#X970:2 %t4914:p};
// %t4915 = $IO_PORT @ATTACH &n1173 => @PLACE(90, -2600) => @ORIENT("MY");
// %t4915 @TEXT("n1173", key="name", size=0.75);
// &n1173 @WIRE(mode="straight") {#X970:3 %t4915:p};
// %t4916 = $SUPPLY @ATTACH &vdd => @PLACE(80, -2589);
// &vdd @WIRE(mode="straight") {#X970:4 %t4916:p};
// %t4917 = $GROUND @ATTACH &vss => @PLACE(80, -2611);
// &vss @WIRE(mode="straight") {#X970:5 %t4917:p};
// %t4918 = $IO_PORT @ATTACH &n1172 => @PLACE(110, -2598) => @ORIENT("R0");
// %t4918 @TEXT("n1172", key="name", size=0.75);
// &n1172 @WIRE(mode="straight") {#X971:1 %t4918:p};
// %t4919 = $IO_PORT @ATTACH &n1173 => @PLACE(110, -2602) => @ORIENT("R0");
// %t4919 @TEXT("n1173", key="name", size=0.75);
// &n1173 @WIRE(mode="straight") {#X971:2 %t4919:p};
// %t4920 = $IO_PORT @ATTACH &n1174 => @PLACE(130, -2600) => @ORIENT("MY");
// %t4920 @TEXT("n1174", key="name", size=0.75);
// &n1174 @WIRE(mode="straight") {#X971:3 %t4920:p};
// %t4921 = $SUPPLY @ATTACH &vdd => @PLACE(120, -2589);
// &vdd @WIRE(mode="straight") {#X971:4 %t4921:p};
// %t4922 = $GROUND @ATTACH &vss => @PLACE(120, -2611);
// &vss @WIRE(mode="straight") {#X971:5 %t4922:p};
// %t4923 = $IO_PORT @ATTACH &n1053 => @PLACE(-11, -2631) => @ORIENT("R0");
// %t4923 @TEXT("n1053", key="name", size=0.75);
// &n1053 @WIRE(mode="straight") {#X972:1 %t4923:p};
// %t4924 = $IO_PORT @ATTACH &n1175 => @PLACE(-11, -2635) => @ORIENT("R0");
// %t4924 @TEXT("n1175", key="name", size=0.75);
// &n1175 @WIRE(mode="straight") {#X972:2 %t4924:p};
// %t4925 = $IO_PORT @ATTACH &n1176 => @PLACE(10, -2633) => @ORIENT("MY");
// %t4925 @TEXT("n1176", key="name", size=0.75);
// &n1176 @WIRE(mode="straight") {#X972:3 %t4925:p};
// %t4926 = $SUPPLY @ATTACH &vdd => @PLACE(0, -2622);
// &vdd @WIRE(mode="straight") {#X972:4 %t4926:p};
// %t4927 = $GROUND @ATTACH &vss => @PLACE(0, -2644);
// &vss @WIRE(mode="straight") {#X972:5 %t4927:p};
// %t4928 = $IO_PORT @ATTACH &n1177 => @PLACE(30, -2631) => @ORIENT("R0");
// %t4928 @TEXT("n1177", key="name", size=0.75);
// &n1177 @WIRE(mode="straight") {#X973:1 %t4928:p};
// %t4929 = $IO_PORT @ATTACH &n1176 => @PLACE(30, -2635) => @ORIENT("R0");
// %t4929 @TEXT("n1176", key="name", size=0.75);
// &n1176 @WIRE(mode="straight") {#X973:2 %t4929:p};
// %t4930 = $IO_PORT @ATTACH &n1178 => @PLACE(50, -2633) => @ORIENT("MY");
// %t4930 @TEXT("n1178", key="name", size=0.75);
// &n1178 @WIRE(mode="straight") {#X973:3 %t4930:p};
// %t4931 = $SUPPLY @ATTACH &vdd => @PLACE(40, -2622);
// &vdd @WIRE(mode="straight") {#X973:4 %t4931:p};
// %t4932 = $GROUND @ATTACH &vss => @PLACE(40, -2644);
// &vss @WIRE(mode="straight") {#X973:5 %t4932:p};
// %t4933 = $IO_PORT @ATTACH &n1178 => @PLACE(70, -2631) => @ORIENT("R0");
// %t4933 @TEXT("n1178", key="name", size=0.75);
// &n1178 @WIRE(mode="straight") {#X974:1 %t4933:p};
// %t4934 = $IO_PORT @ATTACH &n203 => @PLACE(70, -2635) => @ORIENT("R0");
// %t4934 @TEXT("n203", key="name", size=0.75);
// &n203 @WIRE(mode="straight") {#X974:2 %t4934:p};
// %t4935 = $IO_PORT @ATTACH &n1179 => @PLACE(90, -2633) => @ORIENT("MY");
// %t4935 @TEXT("n1179", key="name", size=0.75);
// &n1179 @WIRE(mode="straight") {#X974:3 %t4935:p};
// %t4936 = $SUPPLY @ATTACH &vdd => @PLACE(80, -2622);
// &vdd @WIRE(mode="straight") {#X974:4 %t4936:p};
// %t4937 = $GROUND @ATTACH &vss => @PLACE(80, -2644);
// &vss @WIRE(mode="straight") {#X974:5 %t4937:p};
// %t4938 = $IO_PORT @ATTACH &n1180 => @PLACE(110, -2631) => @ORIENT("R0");
// %t4938 @TEXT("n1180", key="name", size=0.75);
// &n1180 @WIRE(mode="straight") {#X975:1 %t4938:p};
// %t4939 = $IO_PORT @ATTACH &n1181 => @PLACE(110, -2635) => @ORIENT("R0");
// %t4939 @TEXT("n1181", key="name", size=0.75);
// &n1181 @WIRE(mode="straight") {#X975:2 %t4939:p};
// %t4940 = $IO_PORT @ATTACH &n1182 => @PLACE(130, -2633) => @ORIENT("MY");
// %t4940 @TEXT("n1182", key="name", size=0.75);
// &n1182 @WIRE(mode="straight") {#X975:3 %t4940:p};
// %t4941 = $SUPPLY @ATTACH &vdd => @PLACE(120, -2622);
// &vdd @WIRE(mode="straight") {#X975:4 %t4941:p};
// %t4942 = $GROUND @ATTACH &vss => @PLACE(120, -2644);
// &vss @WIRE(mode="straight") {#X975:5 %t4942:p};
// %t4943 = $IO_PORT @ATTACH &n1183 => @PLACE(-11, -2666) => @ORIENT("R0");
// %t4943 @TEXT("n1183", key="name", size=0.75);
// &n1183 @WIRE(mode="straight") {#X976:1 %t4943:p};
// %t4944 = $IO_PORT @ATTACH &n1184 => @PLACE(-11, -2670) => @ORIENT("R0");
// %t4944 @TEXT("n1184", key="name", size=0.75);
// &n1184 @WIRE(mode="straight") {#X976:2 %t4944:p};
// %t4945 = $IO_PORT @ATTACH &n1185 => @PLACE(10, -2668) => @ORIENT("MY");
// %t4945 @TEXT("n1185", key="name", size=0.75);
// &n1185 @WIRE(mode="straight") {#X976:3 %t4945:p};
// %t4946 = $SUPPLY @ATTACH &vdd => @PLACE(0, -2657);
// &vdd @WIRE(mode="straight") {#X976:4 %t4946:p};
// %t4947 = $GROUND @ATTACH &vss => @PLACE(0, -2679);
// &vss @WIRE(mode="straight") {#X976:5 %t4947:p};
// %t4948 = $IO_PORT @ATTACH &n1182 => @PLACE(30, -2666) => @ORIENT("R0");
// %t4948 @TEXT("n1182", key="name", size=0.75);
// &n1182 @WIRE(mode="straight") {#X977:1 %t4948:p};
// %t4949 = $IO_PORT @ATTACH &n1185 => @PLACE(30, -2670) => @ORIENT("R0");
// %t4949 @TEXT("n1185", key="name", size=0.75);
// &n1185 @WIRE(mode="straight") {#X977:2 %t4949:p};
// %t4950 = $IO_PORT @ATTACH &n1186 => @PLACE(50, -2668) => @ORIENT("MY");
// %t4950 @TEXT("n1186", key="name", size=0.75);
// &n1186 @WIRE(mode="straight") {#X977:3 %t4950:p};
// %t4951 = $SUPPLY @ATTACH &vdd => @PLACE(40, -2657);
// &vdd @WIRE(mode="straight") {#X977:4 %t4951:p};
// %t4952 = $GROUND @ATTACH &vss => @PLACE(40, -2679);
// &vss @WIRE(mode="straight") {#X977:5 %t4952:p};
// %t4953 = $IO_PORT @ATTACH &n1187 => @PLACE(70, -2666) => @ORIENT("R0");
// %t4953 @TEXT("n1187", key="name", size=0.75);
// &n1187 @WIRE(mode="straight") {#X978:1 %t4953:p};
// %t4954 = $IO_PORT @ATTACH &n1188 => @PLACE(70, -2670) => @ORIENT("R0");
// %t4954 @TEXT("n1188", key="name", size=0.75);
// &n1188 @WIRE(mode="straight") {#X978:2 %t4954:p};
// %t4955 = $IO_PORT @ATTACH &n1189 => @PLACE(90, -2668) => @ORIENT("MY");
// %t4955 @TEXT("n1189", key="name", size=0.75);
// &n1189 @WIRE(mode="straight") {#X978:3 %t4955:p};
// %t4956 = $SUPPLY @ATTACH &vdd => @PLACE(80, -2657);
// &vdd @WIRE(mode="straight") {#X978:4 %t4956:p};
// %t4957 = $GROUND @ATTACH &vss => @PLACE(80, -2679);
// &vss @WIRE(mode="straight") {#X978:5 %t4957:p};
// %t4958 = $IO_PORT @ATTACH &n1190 => @PLACE(110, -2666) => @ORIENT("R0");
// %t4958 @TEXT("n1190", key="name", size=0.75);
// &n1190 @WIRE(mode="straight") {#X979:1 %t4958:p};
// %t4959 = $IO_PORT @ATTACH &n1191 => @PLACE(110, -2670) => @ORIENT("R0");
// %t4959 @TEXT("n1191", key="name", size=0.75);
// &n1191 @WIRE(mode="straight") {#X979:2 %t4959:p};
// %t4960 = $IO_PORT @ATTACH &n1192 => @PLACE(130, -2668) => @ORIENT("MY");
// %t4960 @TEXT("n1192", key="name", size=0.75);
// &n1192 @WIRE(mode="straight") {#X979:3 %t4960:p};
// %t4961 = $SUPPLY @ATTACH &vdd => @PLACE(120, -2657);
// &vdd @WIRE(mode="straight") {#X979:4 %t4961:p};
// %t4962 = $GROUND @ATTACH &vss => @PLACE(120, -2679);
// &vss @WIRE(mode="straight") {#X979:5 %t4962:p};
// %t4963 = $IO_PORT @ATTACH &n1189 => @PLACE(-11, -2701) => @ORIENT("R0");
// %t4963 @TEXT("n1189", key="name", size=0.75);
// &n1189 @WIRE(mode="straight") {#X980:1 %t4963:p};
// %t4964 = $IO_PORT @ATTACH &n1192 => @PLACE(-11, -2705) => @ORIENT("R0");
// %t4964 @TEXT("n1192", key="name", size=0.75);
// &n1192 @WIRE(mode="straight") {#X980:2 %t4964:p};
// %t4965 = $IO_PORT @ATTACH &n1193 => @PLACE(10, -2703) => @ORIENT("MY");
// %t4965 @TEXT("n1193", key="name", size=0.75);
// &n1193 @WIRE(mode="straight") {#X980:3 %t4965:p};
// %t4966 = $SUPPLY @ATTACH &vdd => @PLACE(0, -2692);
// &vdd @WIRE(mode="straight") {#X980:4 %t4966:p};
// %t4967 = $GROUND @ATTACH &vss => @PLACE(0, -2714);
// &vss @WIRE(mode="straight") {#X980:5 %t4967:p};
// %t4968 = $IO_PORT @ATTACH &n1194 => @PLACE(30, -2701) => @ORIENT("R0");
// %t4968 @TEXT("n1194", key="name", size=0.75);
// &n1194 @WIRE(mode="straight") {#X981:1 %t4968:p};
// %t4969 = $IO_PORT @ATTACH &n1195 => @PLACE(30, -2705) => @ORIENT("R0");
// %t4969 @TEXT("n1195", key="name", size=0.75);
// &n1195 @WIRE(mode="straight") {#X981:2 %t4969:p};
// %t4970 = $IO_PORT @ATTACH &n1196 => @PLACE(50, -2703) => @ORIENT("MY");
// %t4970 @TEXT("n1196", key="name", size=0.75);
// &n1196 @WIRE(mode="straight") {#X981:3 %t4970:p};
// %t4971 = $SUPPLY @ATTACH &vdd => @PLACE(40, -2692);
// &vdd @WIRE(mode="straight") {#X981:4 %t4971:p};
// %t4972 = $GROUND @ATTACH &vss => @PLACE(40, -2714);
// &vss @WIRE(mode="straight") {#X981:5 %t4972:p};
// %t4973 = $IO_PORT @ATTACH &n1197 => @PLACE(70, -2701) => @ORIENT("R0");
// %t4973 @TEXT("n1197", key="name", size=0.75);
// &n1197 @WIRE(mode="straight") {#X982:1 %t4973:p};
// %t4974 = $IO_PORT @ATTACH &n1198 => @PLACE(70, -2705) => @ORIENT("R0");
// %t4974 @TEXT("n1198", key="name", size=0.75);
// &n1198 @WIRE(mode="straight") {#X982:2 %t4974:p};
// %t4975 = $IO_PORT @ATTACH &n1199 => @PLACE(90, -2703) => @ORIENT("MY");
// %t4975 @TEXT("n1199", key="name", size=0.75);
// &n1199 @WIRE(mode="straight") {#X982:3 %t4975:p};
// %t4976 = $SUPPLY @ATTACH &vdd => @PLACE(80, -2692);
// &vdd @WIRE(mode="straight") {#X982:4 %t4976:p};
// %t4977 = $GROUND @ATTACH &vss => @PLACE(80, -2714);
// &vss @WIRE(mode="straight") {#X982:5 %t4977:p};
// %t4978 = $IO_PORT @ATTACH &n1196 => @PLACE(110, -2701) => @ORIENT("R0");
// %t4978 @TEXT("n1196", key="name", size=0.75);
// &n1196 @WIRE(mode="straight") {#X983:1 %t4978:p};
// %t4979 = $IO_PORT @ATTACH &n1199 => @PLACE(110, -2705) => @ORIENT("R0");
// %t4979 @TEXT("n1199", key="name", size=0.75);
// &n1199 @WIRE(mode="straight") {#X983:2 %t4979:p};
// %t4980 = $IO_PORT @ATTACH &n1200 => @PLACE(130, -2703) => @ORIENT("MY");
// %t4980 @TEXT("n1200", key="name", size=0.75);
// &n1200 @WIRE(mode="straight") {#X983:3 %t4980:p};
// %t4981 = $SUPPLY @ATTACH &vdd => @PLACE(120, -2692);
// &vdd @WIRE(mode="straight") {#X983:4 %t4981:p};
// %t4982 = $GROUND @ATTACH &vss => @PLACE(120, -2714);
// &vss @WIRE(mode="straight") {#X983:5 %t4982:p};
// %t4983 = $IO_PORT @ATTACH &n1201 => @PLACE(158, -2536) => @ORIENT("R0");
// %t4983 @TEXT("n1201", key="name", size=0.75);
// &n1201 @WIRE(mode="straight") {#X984:1 %t4983:p};
// %t4984 = $IO_PORT @ATTACH &n1202 => @PLACE(158, -2540) => @ORIENT("R0");
// %t4984 @TEXT("n1202", key="name", size=0.75);
// &n1202 @WIRE(mode="straight") {#X984:2 %t4984:p};
// %t4985 = $IO_PORT @ATTACH &n1203 => @PLACE(178, -2538) => @ORIENT("MY");
// %t4985 @TEXT("n1203", key="name", size=0.75);
// &n1203 @WIRE(mode="straight") {#X984:3 %t4985:p};
// %t4986 = $SUPPLY @ATTACH &vdd => @PLACE(168, -2527);
// &vdd @WIRE(mode="straight") {#X984:4 %t4986:p};
// %t4987 = $GROUND @ATTACH &vss => @PLACE(168, -2549);
// &vss @WIRE(mode="straight") {#X984:5 %t4987:p};
// %t4988 = $IO_PORT @ATTACH &n1204 => @PLACE(198, -2536) => @ORIENT("R0");
// %t4988 @TEXT("n1204", key="name", size=0.75);
// &n1204 @WIRE(mode="straight") {#X985:1 %t4988:p};
// %t4989 = $IO_PORT @ATTACH &n1205 => @PLACE(198, -2540) => @ORIENT("R0");
// %t4989 @TEXT("n1205", key="name", size=0.75);
// &n1205 @WIRE(mode="straight") {#X985:2 %t4989:p};
// %t4990 = $IO_PORT @ATTACH &n1206 => @PLACE(218, -2538) => @ORIENT("MY");
// %t4990 @TEXT("n1206", key="name", size=0.75);
// &n1206 @WIRE(mode="straight") {#X985:3 %t4990:p};
// %t4991 = $SUPPLY @ATTACH &vdd => @PLACE(208, -2527);
// &vdd @WIRE(mode="straight") {#X985:4 %t4991:p};
// %t4992 = $GROUND @ATTACH &vss => @PLACE(208, -2549);
// &vss @WIRE(mode="straight") {#X985:5 %t4992:p};
// %t4993 = $IO_PORT @ATTACH &n1203 => @PLACE(238, -2536) => @ORIENT("R0");
// %t4993 @TEXT("n1203", key="name", size=0.75);
// &n1203 @WIRE(mode="straight") {#X986:1 %t4993:p};
// %t4994 = $IO_PORT @ATTACH &n1206 => @PLACE(238, -2540) => @ORIENT("R0");
// %t4994 @TEXT("n1206", key="name", size=0.75);
// &n1206 @WIRE(mode="straight") {#X986:2 %t4994:p};
// %t4995 = $IO_PORT @ATTACH &n1207 => @PLACE(258, -2538) => @ORIENT("MY");
// %t4995 @TEXT("n1207", key="name", size=0.75);
// &n1207 @WIRE(mode="straight") {#X986:3 %t4995:p};
// %t4996 = $SUPPLY @ATTACH &vdd => @PLACE(248, -2527);
// &vdd @WIRE(mode="straight") {#X986:4 %t4996:p};
// %t4997 = $GROUND @ATTACH &vss => @PLACE(248, -2549);
// &vss @WIRE(mode="straight") {#X986:5 %t4997:p};
// %t4998 = $IO_PORT @ATTACH &n1208 => @PLACE(278, -2536) => @ORIENT("R0");
// %t4998 @TEXT("n1208", key="name", size=0.75);
// &n1208 @WIRE(mode="straight") {#X987:1 %t4998:p};
// %t4999 = $IO_PORT @ATTACH &n1209 => @PLACE(278, -2540) => @ORIENT("R0");
// %t4999 @TEXT("n1209", key="name", size=0.75);
// &n1209 @WIRE(mode="straight") {#X987:2 %t4999:p};
// %t5000 = $IO_PORT @ATTACH &n1210 => @PLACE(298, -2538) => @ORIENT("MY");
// %t5000 @TEXT("n1210", key="name", size=0.75);
// &n1210 @WIRE(mode="straight") {#X987:3 %t5000:p};
// %t5001 = $SUPPLY @ATTACH &vdd => @PLACE(288, -2527);
// &vdd @WIRE(mode="straight") {#X987:4 %t5001:p};
// %t5002 = $GROUND @ATTACH &vss => @PLACE(288, -2549);
// &vss @WIRE(mode="straight") {#X987:5 %t5002:p};
// %t5003 = $IO_PORT @ATTACH &n1211 => @PLACE(158, -2567) => @ORIENT("R0");
// %t5003 @TEXT("n1211", key="name", size=0.75);
// &n1211 @WIRE(mode="straight") {#X988:1 %t5003:p};
// %t5004 = $IO_PORT @ATTACH &n1212 => @PLACE(158, -2571) => @ORIENT("R0");
// %t5004 @TEXT("n1212", key="name", size=0.75);
// &n1212 @WIRE(mode="straight") {#X988:2 %t5004:p};
// %t5005 = $IO_PORT @ATTACH &n1213 => @PLACE(178, -2569) => @ORIENT("MY");
// %t5005 @TEXT("n1213", key="name", size=0.75);
// &n1213 @WIRE(mode="straight") {#X988:3 %t5005:p};
// %t5006 = $SUPPLY @ATTACH &vdd => @PLACE(168, -2558);
// &vdd @WIRE(mode="straight") {#X988:4 %t5006:p};
// %t5007 = $GROUND @ATTACH &vss => @PLACE(168, -2580);
// &vss @WIRE(mode="straight") {#X988:5 %t5007:p};
// %t5008 = $IO_PORT @ATTACH &n1210 => @PLACE(198, -2567) => @ORIENT("R0");
// %t5008 @TEXT("n1210", key="name", size=0.75);
// &n1210 @WIRE(mode="straight") {#X989:1 %t5008:p};
// %t5009 = $IO_PORT @ATTACH &n1213 => @PLACE(198, -2571) => @ORIENT("R0");
// %t5009 @TEXT("n1213", key="name", size=0.75);
// &n1213 @WIRE(mode="straight") {#X989:2 %t5009:p};
// %t5010 = $IO_PORT @ATTACH &n1214 => @PLACE(218, -2569) => @ORIENT("MY");
// %t5010 @TEXT("n1214", key="name", size=0.75);
// &n1214 @WIRE(mode="straight") {#X989:3 %t5010:p};
// %t5011 = $SUPPLY @ATTACH &vdd => @PLACE(208, -2558);
// &vdd @WIRE(mode="straight") {#X989:4 %t5011:p};
// %t5012 = $GROUND @ATTACH &vss => @PLACE(208, -2580);
// &vss @WIRE(mode="straight") {#X989:5 %t5012:p};
// %t5013 = $IO_PORT @ATTACH &n1215 => @PLACE(238, -2567) => @ORIENT("R0");
// %t5013 @TEXT("n1215", key="name", size=0.75);
// &n1215 @WIRE(mode="straight") {#X990:1 %t5013:p};
// %t5014 = $IO_PORT @ATTACH &n1216 => @PLACE(238, -2571) => @ORIENT("R0");
// %t5014 @TEXT("n1216", key="name", size=0.75);
// &n1216 @WIRE(mode="straight") {#X990:2 %t5014:p};
// %t5015 = $IO_PORT @ATTACH &n1217 => @PLACE(258, -2569) => @ORIENT("MY");
// %t5015 @TEXT("n1217", key="name", size=0.75);
// &n1217 @WIRE(mode="straight") {#X990:3 %t5015:p};
// %t5016 = $SUPPLY @ATTACH &vdd => @PLACE(248, -2558);
// &vdd @WIRE(mode="straight") {#X990:4 %t5016:p};
// %t5017 = $GROUND @ATTACH &vss => @PLACE(248, -2580);
// &vss @WIRE(mode="straight") {#X990:5 %t5017:p};
// %t5018 = $IO_PORT @ATTACH &n1218 => @PLACE(278, -2567) => @ORIENT("R0");
// %t5018 @TEXT("n1218", key="name", size=0.75);
// &n1218 @WIRE(mode="straight") {#X991:1 %t5018:p};
// %t5019 = $IO_PORT @ATTACH &n1219 => @PLACE(278, -2571) => @ORIENT("R0");
// %t5019 @TEXT("n1219", key="name", size=0.75);
// &n1219 @WIRE(mode="straight") {#X991:2 %t5019:p};
// %t5020 = $IO_PORT @ATTACH &n1220 => @PLACE(298, -2569) => @ORIENT("MY");
// %t5020 @TEXT("n1220", key="name", size=0.75);
// &n1220 @WIRE(mode="straight") {#X991:3 %t5020:p};
// %t5021 = $SUPPLY @ATTACH &vdd => @PLACE(288, -2558);
// &vdd @WIRE(mode="straight") {#X991:4 %t5021:p};
// %t5022 = $GROUND @ATTACH &vss => @PLACE(288, -2580);
// &vss @WIRE(mode="straight") {#X991:5 %t5022:p};
// %t5023 = $IO_PORT @ATTACH &n1217 => @PLACE(158, -2598) => @ORIENT("R0");
// %t5023 @TEXT("n1217", key="name", size=0.75);
// &n1217 @WIRE(mode="straight") {#X992:1 %t5023:p};
// %t5024 = $IO_PORT @ATTACH &n1220 => @PLACE(158, -2602) => @ORIENT("R0");
// %t5024 @TEXT("n1220", key="name", size=0.75);
// &n1220 @WIRE(mode="straight") {#X992:2 %t5024:p};
// %t5025 = $IO_PORT @ATTACH &n1221 => @PLACE(178, -2600) => @ORIENT("MY");
// %t5025 @TEXT("n1221", key="name", size=0.75);
// &n1221 @WIRE(mode="straight") {#X992:3 %t5025:p};
// %t5026 = $SUPPLY @ATTACH &vdd => @PLACE(168, -2589);
// &vdd @WIRE(mode="straight") {#X992:4 %t5026:p};
// %t5027 = $GROUND @ATTACH &vss => @PLACE(168, -2611);
// &vss @WIRE(mode="straight") {#X992:5 %t5027:p};
// %t5028 = $IO_PORT @ATTACH &n1222 => @PLACE(198, -2598) => @ORIENT("R0");
// %t5028 @TEXT("n1222", key="name", size=0.75);
// &n1222 @WIRE(mode="straight") {#X993:1 %t5028:p};
// %t5029 = $IO_PORT @ATTACH &n1223 => @PLACE(198, -2602) => @ORIENT("R0");
// %t5029 @TEXT("n1223", key="name", size=0.75);
// &n1223 @WIRE(mode="straight") {#X993:2 %t5029:p};
// %t5030 = $IO_PORT @ATTACH &n1224 => @PLACE(218, -2600) => @ORIENT("MY");
// %t5030 @TEXT("n1224", key="name", size=0.75);
// &n1224 @WIRE(mode="straight") {#X993:3 %t5030:p};
// %t5031 = $SUPPLY @ATTACH &vdd => @PLACE(208, -2589);
// &vdd @WIRE(mode="straight") {#X993:4 %t5031:p};
// %t5032 = $GROUND @ATTACH &vss => @PLACE(208, -2611);
// &vss @WIRE(mode="straight") {#X993:5 %t5032:p};
// %t5033 = $IO_PORT @ATTACH &n1225 => @PLACE(238, -2598) => @ORIENT("R0");
// %t5033 @TEXT("n1225", key="name", size=0.75);
// &n1225 @WIRE(mode="straight") {#X994:1 %t5033:p};
// %t5034 = $IO_PORT @ATTACH &n1226 => @PLACE(238, -2602) => @ORIENT("R0");
// %t5034 @TEXT("n1226", key="name", size=0.75);
// &n1226 @WIRE(mode="straight") {#X994:2 %t5034:p};
// %t5035 = $IO_PORT @ATTACH &n1227 => @PLACE(258, -2600) => @ORIENT("MY");
// %t5035 @TEXT("n1227", key="name", size=0.75);
// &n1227 @WIRE(mode="straight") {#X994:3 %t5035:p};
// %t5036 = $SUPPLY @ATTACH &vdd => @PLACE(248, -2589);
// &vdd @WIRE(mode="straight") {#X994:4 %t5036:p};
// %t5037 = $GROUND @ATTACH &vss => @PLACE(248, -2611);
// &vss @WIRE(mode="straight") {#X994:5 %t5037:p};
// %t5038 = $IO_PORT @ATTACH &n1224 => @PLACE(278, -2598) => @ORIENT("R0");
// %t5038 @TEXT("n1224", key="name", size=0.75);
// &n1224 @WIRE(mode="straight") {#X995:1 %t5038:p};
// %t5039 = $IO_PORT @ATTACH &n1227 => @PLACE(278, -2602) => @ORIENT("R0");
// %t5039 @TEXT("n1227", key="name", size=0.75);
// &n1227 @WIRE(mode="straight") {#X995:2 %t5039:p};
// %t5040 = $IO_PORT @ATTACH &n1228 => @PLACE(298, -2600) => @ORIENT("MY");
// %t5040 @TEXT("n1228", key="name", size=0.75);
// &n1228 @WIRE(mode="straight") {#X995:3 %t5040:p};
// %t5041 = $SUPPLY @ATTACH &vdd => @PLACE(288, -2589);
// &vdd @WIRE(mode="straight") {#X995:4 %t5041:p};
// %t5042 = $GROUND @ATTACH &vss => @PLACE(288, -2611);
// &vss @WIRE(mode="straight") {#X995:5 %t5042:p};
// %t5043 = $IO_PORT @ATTACH &n1229 => @PLACE(158, -2631) => @ORIENT("R0");
// %t5043 @TEXT("n1229", key="name", size=0.75);
// &n1229 @WIRE(mode="straight") {#X996:1 %t5043:p};
// %t5044 = $IO_PORT @ATTACH &n1230 => @PLACE(158, -2635) => @ORIENT("R0");
// %t5044 @TEXT("n1230", key="name", size=0.75);
// &n1230 @WIRE(mode="straight") {#X996:2 %t5044:p};
// %t5045 = $IO_PORT @ATTACH &n1231 => @PLACE(178, -2633) => @ORIENT("MY");
// %t5045 @TEXT("n1231", key="name", size=0.75);
// &n1231 @WIRE(mode="straight") {#X996:3 %t5045:p};
// %t5046 = $SUPPLY @ATTACH &vdd => @PLACE(168, -2622);
// &vdd @WIRE(mode="straight") {#X996:4 %t5046:p};
// %t5047 = $GROUND @ATTACH &vss => @PLACE(168, -2644);
// &vss @WIRE(mode="straight") {#X996:5 %t5047:p};
// %t5048 = $IO_PORT @ATTACH &n1232 => @PLACE(198, -2631) => @ORIENT("R0");
// %t5048 @TEXT("n1232", key="name", size=0.75);
// &n1232 @WIRE(mode="straight") {#X997:1 %t5048:p};
// %t5049 = $IO_PORT @ATTACH &n1233 => @PLACE(198, -2635) => @ORIENT("R0");
// %t5049 @TEXT("n1233", key="name", size=0.75);
// &n1233 @WIRE(mode="straight") {#X997:2 %t5049:p};
// %t5050 = $IO_PORT @ATTACH &n1234 => @PLACE(218, -2633) => @ORIENT("MY");
// %t5050 @TEXT("n1234", key="name", size=0.75);
// &n1234 @WIRE(mode="straight") {#X997:3 %t5050:p};
// %t5051 = $SUPPLY @ATTACH &vdd => @PLACE(208, -2622);
// &vdd @WIRE(mode="straight") {#X997:4 %t5051:p};
// %t5052 = $GROUND @ATTACH &vss => @PLACE(208, -2644);
// &vss @WIRE(mode="straight") {#X997:5 %t5052:p};
// %t5053 = $IO_PORT @ATTACH &n1231 => @PLACE(238, -2631) => @ORIENT("R0");
// %t5053 @TEXT("n1231", key="name", size=0.75);
// &n1231 @WIRE(mode="straight") {#X998:1 %t5053:p};
// %t5054 = $IO_PORT @ATTACH &n1234 => @PLACE(238, -2635) => @ORIENT("R0");
// %t5054 @TEXT("n1234", key="name", size=0.75);
// &n1234 @WIRE(mode="straight") {#X998:2 %t5054:p};
// %t5055 = $IO_PORT @ATTACH &n1235 => @PLACE(258, -2633) => @ORIENT("MY");
// %t5055 @TEXT("n1235", key="name", size=0.75);
// &n1235 @WIRE(mode="straight") {#X998:3 %t5055:p};
// %t5056 = $SUPPLY @ATTACH &vdd => @PLACE(248, -2622);
// &vdd @WIRE(mode="straight") {#X998:4 %t5056:p};
// %t5057 = $GROUND @ATTACH &vss => @PLACE(248, -2644);
// &vss @WIRE(mode="straight") {#X998:5 %t5057:p};
// %t5058 = $IO_PORT @ATTACH &n1052 => @PLACE(278, -2631) => @ORIENT("R0");
// %t5058 @TEXT("n1052", key="name", size=0.75);
// &n1052 @WIRE(mode="straight") {#X999:1 %t5058:p};
// %t5059 = $IO_PORT @ATTACH &n1175 => @PLACE(278, -2635) => @ORIENT("R0");
// %t5059 @TEXT("n1175", key="name", size=0.75);
// &n1175 @WIRE(mode="straight") {#X999:2 %t5059:p};
// %t5060 = $IO_PORT @ATTACH &n1236 => @PLACE(298, -2633) => @ORIENT("MY");
// %t5060 @TEXT("n1236", key="name", size=0.75);
// &n1236 @WIRE(mode="straight") {#X999:3 %t5060:p};
// %t5061 = $SUPPLY @ATTACH &vdd => @PLACE(288, -2622);
// &vdd @WIRE(mode="straight") {#X999:4 %t5061:p};
// %t5062 = $GROUND @ATTACH &vss => @PLACE(288, -2644);
// &vss @WIRE(mode="straight") {#X999:5 %t5062:p};
// %t5063 = $IO_PORT @ATTACH &n184 => @PLACE(158, -2666) => @ORIENT("R0");
// %t5063 @TEXT("n184", key="name", size=0.75);
// &n184 @WIRE(mode="straight") {#X1000:1 %t5063:p};
// %t5064 = $IO_PORT @ATTACH &n1053 => @PLACE(158, -2670) => @ORIENT("R0");
// %t5064 @TEXT("n1053", key="name", size=0.75);
// &n1053 @WIRE(mode="straight") {#X1000:2 %t5064:p};
// %t5065 = $IO_PORT @ATTACH &n1237 => @PLACE(178, -2668) => @ORIENT("MY");
// %t5065 @TEXT("n1237", key="name", size=0.75);
// &n1237 @WIRE(mode="straight") {#X1000:3 %t5065:p};
// %t5066 = $SUPPLY @ATTACH &vdd => @PLACE(168, -2657);
// &vdd @WIRE(mode="straight") {#X1000:4 %t5066:p};
// %t5067 = $GROUND @ATTACH &vss => @PLACE(168, -2679);
// &vss @WIRE(mode="straight") {#X1000:5 %t5067:p};
// %t5068 = $IO_PORT @ATTACH &n1238 => @PLACE(198, -2666) => @ORIENT("R0");
// %t5068 @TEXT("n1238", key="name", size=0.75);
// &n1238 @WIRE(mode="straight") {#X1001:1 %t5068:p};
// %t5069 = $IO_PORT @ATTACH &n1055 => @PLACE(198, -2670) => @ORIENT("R0");
// %t5069 @TEXT("n1055", key="name", size=0.75);
// &n1055 @WIRE(mode="straight") {#X1001:2 %t5069:p};
// %t5070 = $IO_PORT @ATTACH &n1177 => @PLACE(218, -2668) => @ORIENT("MY");
// %t5070 @TEXT("n1177", key="name", size=0.75);
// &n1177 @WIRE(mode="straight") {#X1001:3 %t5070:p};
// %t5071 = $SUPPLY @ATTACH &vdd => @PLACE(208, -2657);
// &vdd @WIRE(mode="straight") {#X1001:4 %t5071:p};
// %t5072 = $GROUND @ATTACH &vss => @PLACE(208, -2679);
// &vss @WIRE(mode="straight") {#X1001:5 %t5072:p};
// %t5073 = $IO_PORT @ATTACH &n1236 => @PLACE(238, -2666) => @ORIENT("R0");
// %t5073 @TEXT("n1236", key="name", size=0.75);
// &n1236 @WIRE(mode="straight") {#X1002:1 %t5073:p};
// %t5074 = $IO_PORT @ATTACH &n1237 => @PLACE(238, -2670) => @ORIENT("R0");
// %t5074 @TEXT("n1237", key="name", size=0.75);
// &n1237 @WIRE(mode="straight") {#X1002:2 %t5074:p};
// %t5075 = $IO_PORT @ATTACH &n1239 => @PLACE(258, -2668) => @ORIENT("MY");
// %t5075 @TEXT("n1239", key="name", size=0.75);
// &n1239 @WIRE(mode="straight") {#X1002:3 %t5075:p};
// %t5076 = $SUPPLY @ATTACH &vdd => @PLACE(248, -2657);
// &vdd @WIRE(mode="straight") {#X1002:4 %t5076:p};
// %t5077 = $GROUND @ATTACH &vss => @PLACE(248, -2679);
// &vss @WIRE(mode="straight") {#X1002:5 %t5077:p};
// %t5078 = $IO_PORT @ATTACH &n1239 => @PLACE(278, -2666) => @ORIENT("R0");
// %t5078 @TEXT("n1239", key="name", size=0.75);
// &n1239 @WIRE(mode="straight") {#X1003:1 %t5078:p};
// %t5079 = $IO_PORT @ATTACH &n1177 => @PLACE(278, -2670) => @ORIENT("R0");
// %t5079 @TEXT("n1177", key="name", size=0.75);
// &n1177 @WIRE(mode="straight") {#X1003:2 %t5079:p};
// %t5080 = $IO_PORT @ATTACH &n1240 => @PLACE(298, -2668) => @ORIENT("MY");
// %t5080 @TEXT("n1240", key="name", size=0.75);
// &n1240 @WIRE(mode="straight") {#X1003:3 %t5080:p};
// %t5081 = $SUPPLY @ATTACH &vdd => @PLACE(288, -2657);
// &vdd @WIRE(mode="straight") {#X1003:4 %t5081:p};
// %t5082 = $GROUND @ATTACH &vss => @PLACE(288, -2679);
// &vss @WIRE(mode="straight") {#X1003:5 %t5082:p};
// %t5083 = $IO_PORT @ATTACH &n1241 => @PLACE(158, -2701) => @ORIENT("R0");
// %t5083 @TEXT("n1241", key="name", size=0.75);
// &n1241 @WIRE(mode="straight") {#X1004:1 %t5083:p};
// %t5084 = $IO_PORT @ATTACH &n1242 => @PLACE(158, -2705) => @ORIENT("R0");
// %t5084 @TEXT("n1242", key="name", size=0.75);
// &n1242 @WIRE(mode="straight") {#X1004:2 %t5084:p};
// %t5085 = $IO_PORT @ATTACH &n1243 => @PLACE(178, -2703) => @ORIENT("MY");
// %t5085 @TEXT("n1243", key="name", size=0.75);
// &n1243 @WIRE(mode="straight") {#X1004:3 %t5085:p};
// %t5086 = $SUPPLY @ATTACH &vdd => @PLACE(168, -2692);
// &vdd @WIRE(mode="straight") {#X1004:4 %t5086:p};
// %t5087 = $GROUND @ATTACH &vss => @PLACE(168, -2714);
// &vss @WIRE(mode="straight") {#X1004:5 %t5087:p};
// %t5088 = $IO_PORT @ATTACH &n1244 => @PLACE(198, -2701) => @ORIENT("R0");
// %t5088 @TEXT("n1244", key="name", size=0.75);
// &n1244 @WIRE(mode="straight") {#X1005:1 %t5088:p};
// %t5089 = $IO_PORT @ATTACH &n1245 => @PLACE(198, -2705) => @ORIENT("R0");
// %t5089 @TEXT("n1245", key="name", size=0.75);
// &n1245 @WIRE(mode="straight") {#X1005:2 %t5089:p};
// %t5090 = $IO_PORT @ATTACH &n1246 => @PLACE(218, -2703) => @ORIENT("MY");
// %t5090 @TEXT("n1246", key="name", size=0.75);
// &n1246 @WIRE(mode="straight") {#X1005:3 %t5090:p};
// %t5091 = $SUPPLY @ATTACH &vdd => @PLACE(208, -2692);
// &vdd @WIRE(mode="straight") {#X1005:4 %t5091:p};
// %t5092 = $GROUND @ATTACH &vss => @PLACE(208, -2714);
// &vss @WIRE(mode="straight") {#X1005:5 %t5092:p};
// %t5093 = $IO_PORT @ATTACH &n1247 => @PLACE(238, -2701) => @ORIENT("R0");
// %t5093 @TEXT("n1247", key="name", size=0.75);
// &n1247 @WIRE(mode="straight") {#X1006:1 %t5093:p};
// %t5094 = $IO_PORT @ATTACH &n1243 => @PLACE(238, -2705) => @ORIENT("R0");
// %t5094 @TEXT("n1243", key="name", size=0.75);
// &n1243 @WIRE(mode="straight") {#X1006:2 %t5094:p};
// %t5095 = $IO_PORT @ATTACH &n1248 => @PLACE(258, -2703) => @ORIENT("MY");
// %t5095 @TEXT("n1248", key="name", size=0.75);
// &n1248 @WIRE(mode="straight") {#X1006:3 %t5095:p};
// %t5096 = $SUPPLY @ATTACH &vdd => @PLACE(248, -2692);
// &vdd @WIRE(mode="straight") {#X1006:4 %t5096:p};
// %t5097 = $GROUND @ATTACH &vss => @PLACE(248, -2714);
// &vss @WIRE(mode="straight") {#X1006:5 %t5097:p};
// %t5098 = $IO_PORT @ATTACH &n1248 => @PLACE(278, -2701) => @ORIENT("R0");
// %t5098 @TEXT("n1248", key="name", size=0.75);
// &n1248 @WIRE(mode="straight") {#X1007:1 %t5098:p};
// %t5099 = $IO_PORT @ATTACH &n1246 => @PLACE(278, -2705) => @ORIENT("R0");
// %t5099 @TEXT("n1246", key="name", size=0.75);
// &n1246 @WIRE(mode="straight") {#X1007:2 %t5099:p};
// %t5100 = $IO_PORT @ATTACH &n1249 => @PLACE(298, -2703) => @ORIENT("MY");
// %t5100 @TEXT("n1249", key="name", size=0.75);
// &n1249 @WIRE(mode="straight") {#X1007:3 %t5100:p};
// %t5101 = $SUPPLY @ATTACH &vdd => @PLACE(288, -2692);
// &vdd @WIRE(mode="straight") {#X1007:4 %t5101:p};
// %t5102 = $GROUND @ATTACH &vss => @PLACE(288, -2714);
// &vss @WIRE(mode="straight") {#X1007:5 %t5102:p};
// %t5103 = $IO_PORT @ATTACH &n1250 => @PLACE(326, -2536) => @ORIENT("R0");
// %t5103 @TEXT("n1250", key="name", size=0.75);
// &n1250 @WIRE(mode="straight") {#X1008:1 %t5103:p};
// %t5104 = $IO_PORT @ATTACH &n1251 => @PLACE(326, -2540) => @ORIENT("R0");
// %t5104 @TEXT("n1251", key="name", size=0.75);
// &n1251 @WIRE(mode="straight") {#X1008:2 %t5104:p};
// %t5105 = $IO_PORT @ATTACH &n1252 => @PLACE(346, -2538) => @ORIENT("MY");
// %t5105 @TEXT("n1252", key="name", size=0.75);
// &n1252 @WIRE(mode="straight") {#X1008:3 %t5105:p};
// %t5106 = $SUPPLY @ATTACH &vdd => @PLACE(336, -2527);
// &vdd @WIRE(mode="straight") {#X1008:4 %t5106:p};
// %t5107 = $GROUND @ATTACH &vss => @PLACE(336, -2549);
// &vss @WIRE(mode="straight") {#X1008:5 %t5107:p};
// %t5108 = $IO_PORT @ATTACH &n1253 => @PLACE(366, -2536) => @ORIENT("R0");
// %t5108 @TEXT("n1253", key="name", size=0.75);
// &n1253 @WIRE(mode="straight") {#X1009:1 %t5108:p};
// %t5109 = $IO_PORT @ATTACH &n1242 => @PLACE(366, -2540) => @ORIENT("R0");
// %t5109 @TEXT("n1242", key="name", size=0.75);
// &n1242 @WIRE(mode="straight") {#X1009:2 %t5109:p};
// %t5110 = $IO_PORT @ATTACH &n1254 => @PLACE(386, -2538) => @ORIENT("MY");
// %t5110 @TEXT("n1254", key="name", size=0.75);
// &n1254 @WIRE(mode="straight") {#X1009:3 %t5110:p};
// %t5111 = $SUPPLY @ATTACH &vdd => @PLACE(376, -2527);
// &vdd @WIRE(mode="straight") {#X1009:4 %t5111:p};
// %t5112 = $GROUND @ATTACH &vss => @PLACE(376, -2549);
// &vss @WIRE(mode="straight") {#X1009:5 %t5112:p};
// %t5113 = $IO_PORT @ATTACH &n1254 => @PLACE(406, -2536) => @ORIENT("R0");
// %t5113 @TEXT("n1254", key="name", size=0.75);
// &n1254 @WIRE(mode="straight") {#X1010:1 %t5113:p};
// %t5114 = $IO_PORT @ATTACH &n1252 => @PLACE(406, -2540) => @ORIENT("R0");
// %t5114 @TEXT("n1252", key="name", size=0.75);
// &n1252 @WIRE(mode="straight") {#X1010:2 %t5114:p};
// %t5115 = $IO_PORT @ATTACH &n1255 => @PLACE(426, -2538) => @ORIENT("MY");
// %t5115 @TEXT("n1255", key="name", size=0.75);
// &n1255 @WIRE(mode="straight") {#X1010:3 %t5115:p};
// %t5116 = $SUPPLY @ATTACH &vdd => @PLACE(416, -2527);
// &vdd @WIRE(mode="straight") {#X1010:4 %t5116:p};
// %t5117 = $GROUND @ATTACH &vss => @PLACE(416, -2549);
// &vss @WIRE(mode="straight") {#X1010:5 %t5117:p};
// %t5118 = $IO_PORT @ATTACH &n1256 => @PLACE(446, -2536) => @ORIENT("R0");
// %t5118 @TEXT("n1256", key="name", size=0.75);
// &n1256 @WIRE(mode="straight") {#X1011:1 %t5118:p};
// %t5119 = $IO_PORT @ATTACH &n1257 => @PLACE(446, -2540) => @ORIENT("R0");
// %t5119 @TEXT("n1257", key="name", size=0.75);
// &n1257 @WIRE(mode="straight") {#X1011:2 %t5119:p};
// %t5120 = $IO_PORT @ATTACH &n1258 => @PLACE(466, -2538) => @ORIENT("MY");
// %t5120 @TEXT("n1258", key="name", size=0.75);
// &n1258 @WIRE(mode="straight") {#X1011:3 %t5120:p};
// %t5121 = $SUPPLY @ATTACH &vdd => @PLACE(456, -2527);
// &vdd @WIRE(mode="straight") {#X1011:4 %t5121:p};
// %t5122 = $GROUND @ATTACH &vss => @PLACE(456, -2549);
// &vss @WIRE(mode="straight") {#X1011:5 %t5122:p};
// %t5123 = $IO_PORT @ATTACH &n1244 => @PLACE(326, -2567) => @ORIENT("R0");
// %t5123 @TEXT("n1244", key="name", size=0.75);
// &n1244 @WIRE(mode="straight") {#X1012:1 %t5123:p};
// %t5124 = $IO_PORT @ATTACH &n1251 => @PLACE(326, -2571) => @ORIENT("R0");
// %t5124 @TEXT("n1251", key="name", size=0.75);
// &n1251 @WIRE(mode="straight") {#X1012:2 %t5124:p};
// %t5125 = $IO_PORT @ATTACH &n1259 => @PLACE(346, -2569) => @ORIENT("MY");
// %t5125 @TEXT("n1259", key="name", size=0.75);
// &n1259 @WIRE(mode="straight") {#X1012:3 %t5125:p};
// %t5126 = $SUPPLY @ATTACH &vdd => @PLACE(336, -2558);
// &vdd @WIRE(mode="straight") {#X1012:4 %t5126:p};
// %t5127 = $GROUND @ATTACH &vss => @PLACE(336, -2580);
// &vss @WIRE(mode="straight") {#X1012:5 %t5127:p};
// %t5128 = $IO_PORT @ATTACH &n1247 => @PLACE(366, -2567) => @ORIENT("R0");
// %t5128 @TEXT("n1247", key="name", size=0.75);
// &n1247 @WIRE(mode="straight") {#X1013:1 %t5128:p};
// %t5129 = $IO_PORT @ATTACH &n1258 => @PLACE(366, -2571) => @ORIENT("R0");
// %t5129 @TEXT("n1258", key="name", size=0.75);
// &n1258 @WIRE(mode="straight") {#X1013:2 %t5129:p};
// %t5130 = $IO_PORT @ATTACH &n1260 => @PLACE(386, -2569) => @ORIENT("MY");
// %t5130 @TEXT("n1260", key="name", size=0.75);
// &n1260 @WIRE(mode="straight") {#X1013:3 %t5130:p};
// %t5131 = $SUPPLY @ATTACH &vdd => @PLACE(376, -2558);
// &vdd @WIRE(mode="straight") {#X1013:4 %t5131:p};
// %t5132 = $GROUND @ATTACH &vss => @PLACE(376, -2580);
// &vss @WIRE(mode="straight") {#X1013:5 %t5132:p};
// %t5133 = $IO_PORT @ATTACH &n1260 => @PLACE(406, -2567) => @ORIENT("R0");
// %t5133 @TEXT("n1260", key="name", size=0.75);
// &n1260 @WIRE(mode="straight") {#X1014:1 %t5133:p};
// %t5134 = $IO_PORT @ATTACH &n1259 => @PLACE(406, -2571) => @ORIENT("R0");
// %t5134 @TEXT("n1259", key="name", size=0.75);
// &n1259 @WIRE(mode="straight") {#X1014:2 %t5134:p};
// %t5135 = $IO_PORT @ATTACH &n1261 => @PLACE(426, -2569) => @ORIENT("MY");
// %t5135 @TEXT("n1261", key="name", size=0.75);
// &n1261 @WIRE(mode="straight") {#X1014:3 %t5135:p};
// %t5136 = $SUPPLY @ATTACH &vdd => @PLACE(416, -2558);
// &vdd @WIRE(mode="straight") {#X1014:4 %t5136:p};
// %t5137 = $GROUND @ATTACH &vss => @PLACE(416, -2580);
// &vss @WIRE(mode="straight") {#X1014:5 %t5137:p};
// %t5138 = $IO_PORT @ATTACH &n1175 => @PLACE(446, -2567) => @ORIENT("R0");
// %t5138 @TEXT("n1175", key="name", size=0.75);
// &n1175 @WIRE(mode="straight") {#X1015:1 %t5138:p};
// %t5139 = $IO_PORT @ATTACH &n184 => @PLACE(446, -2571) => @ORIENT("R0");
// %t5139 @TEXT("n184", key="name", size=0.75);
// &n184 @WIRE(mode="straight") {#X1015:2 %t5139:p};
// %t5140 = $IO_PORT @ATTACH &n981 => @PLACE(466, -2569) => @ORIENT("MY");
// %t5140 @TEXT("n981", key="name", size=0.75);
// &n981 @WIRE(mode="straight") {#X1015:3 %t5140:p};
// %t5141 = $SUPPLY @ATTACH &vdd => @PLACE(456, -2558);
// &vdd @WIRE(mode="straight") {#X1015:4 %t5141:p};
// %t5142 = $GROUND @ATTACH &vss => @PLACE(456, -2580);
// &vss @WIRE(mode="straight") {#X1015:5 %t5142:p};
// %t5143 = $IO_PORT @ATTACH &n1262 => @PLACE(326, -2598) => @ORIENT("R0");
// %t5143 @TEXT("n1262", key="name", size=0.75);
// &n1262 @WIRE(mode="straight") {#X1016:1 %t5143:p};
// %t5144 = $IO_PORT @ATTACH &n1263 => @PLACE(326, -2602) => @ORIENT("R0");
// %t5144 @TEXT("n1263", key="name", size=0.75);
// &n1263 @WIRE(mode="straight") {#X1016:2 %t5144:p};
// %t5145 = $IO_PORT @ATTACH &n1264 => @PLACE(346, -2600) => @ORIENT("MY");
// %t5145 @TEXT("n1264", key="name", size=0.75);
// &n1264 @WIRE(mode="straight") {#X1016:3 %t5145:p};
// %t5146 = $SUPPLY @ATTACH &vdd => @PLACE(336, -2589);
// &vdd @WIRE(mode="straight") {#X1016:4 %t5146:p};
// %t5147 = $GROUND @ATTACH &vss => @PLACE(336, -2611);
// &vss @WIRE(mode="straight") {#X1016:5 %t5147:p};
// %t5148 = $IO_PORT @ATTACH &n1055 => @PLACE(366, -2598) => @ORIENT("R0");
// %t5148 @TEXT("n1055", key="name", size=0.75);
// &n1055 @WIRE(mode="straight") {#X1017:1 %t5148:p};
// %t5149 = $IO_PORT @ATTACH &n203 => @PLACE(366, -2602) => @ORIENT("R0");
// %t5149 @TEXT("n203", key="name", size=0.75);
// &n203 @WIRE(mode="straight") {#X1017:2 %t5149:p};
// %t5150 = $IO_PORT @ATTACH &n189 => @PLACE(386, -2600) => @ORIENT("MY");
// %t5150 @TEXT("n189", key="name", size=0.75);
// &n189 @WIRE(mode="straight") {#X1017:3 %t5150:p};
// %t5151 = $SUPPLY @ATTACH &vdd => @PLACE(376, -2589);
// &vdd @WIRE(mode="straight") {#X1017:4 %t5151:p};
// %t5152 = $GROUND @ATTACH &vss => @PLACE(376, -2611);
// &vss @WIRE(mode="straight") {#X1017:5 %t5152:p};
// %t5153 = $IO_PORT @ATTACH &n1265 => @PLACE(406, -2598) => @ORIENT("R0");
// %t5153 @TEXT("n1265", key="name", size=0.75);
// &n1265 @WIRE(mode="straight") {#X1018:1 %t5153:p};
// %t5154 = $IO_PORT @ATTACH &n203 => @PLACE(406, -2602) => @ORIENT("R0");
// %t5154 @TEXT("n203", key="name", size=0.75);
// &n203 @WIRE(mode="straight") {#X1018:2 %t5154:p};
// %t5155 = $IO_PORT @ATTACH &n1266 => @PLACE(426, -2600) => @ORIENT("MY");
// %t5155 @TEXT("n1266", key="name", size=0.75);
// &n1266 @WIRE(mode="straight") {#X1018:3 %t5155:p};
// %t5156 = $SUPPLY @ATTACH &vdd => @PLACE(416, -2589);
// &vdd @WIRE(mode="straight") {#X1018:4 %t5156:p};
// %t5157 = $GROUND @ATTACH &vss => @PLACE(416, -2611);
// &vss @WIRE(mode="straight") {#X1018:5 %t5157:p};
// %t5158 = $IO_PORT @ATTACH &n1238 => @PLACE(446, -2598) => @ORIENT("R0");
// %t5158 @TEXT("n1238", key="name", size=0.75);
// &n1238 @WIRE(mode="straight") {#X1019:1 %t5158:p};
// %t5159 = $IO_PORT @ATTACH &n1056 => @PLACE(446, -2602) => @ORIENT("R0");
// %t5159 @TEXT("n1056", key="name", size=0.75);
// &n1056 @WIRE(mode="straight") {#X1019:2 %t5159:p};
// %t5160 = $IO_PORT @ATTACH &n186 => @PLACE(466, -2600) => @ORIENT("MY");
// %t5160 @TEXT("n186", key="name", size=0.75);
// &n186 @WIRE(mode="straight") {#X1019:3 %t5160:p};
// %t5161 = $SUPPLY @ATTACH &vdd => @PLACE(456, -2589);
// &vdd @WIRE(mode="straight") {#X1019:4 %t5161:p};
// %t5162 = $GROUND @ATTACH &vss => @PLACE(456, -2611);
// &vss @WIRE(mode="straight") {#X1019:5 %t5162:p};
// %t5163 = $IO_PORT @ATTACH &state_out0 => @PLACE(326, -2631) => @ORIENT("R0");
// %t5163 @TEXT("state_out0", key="name", size=0.75);
// &state_out0 @WIRE(mode="straight") {#X1020:1 %t5163:p};
// %t5164 = $IO_PORT @ATTACH &state_out1 => @PLACE(326, -2635) => @ORIENT("R0");
// %t5164 @TEXT("state_out1", key="name", size=0.75);
// &state_out1 @WIRE(mode="straight") {#X1020:2 %t5164:p};
// %t5165 = $IO_PORT @ATTACH &n1103 => @PLACE(346, -2633) => @ORIENT("MY");
// %t5165 @TEXT("n1103", key="name", size=0.75);
// &n1103 @WIRE(mode="straight") {#X1020:3 %t5165:p};
// %t5166 = $SUPPLY @ATTACH &vdd => @PLACE(336, -2622);
// &vdd @WIRE(mode="straight") {#X1020:4 %t5166:p};
// %t5167 = $GROUND @ATTACH &vss => @PLACE(336, -2644);
// &vss @WIRE(mode="straight") {#X1020:5 %t5167:p};
// %t5168 = $IO_PORT @ATTACH &n1103 => @PLACE(366, -2631) => @ORIENT("R0");
// %t5168 @TEXT("n1103", key="name", size=0.75);
// &n1103 @WIRE(mode="straight") {#X1021:1 %t5168:p};
// %t5169 = $IO_PORT @ATTACH &state_out2 => @PLACE(366, -2635) => @ORIENT("R0");
// %t5169 @TEXT("state_out2", key="name", size=0.75);
// &state_out2 @WIRE(mode="straight") {#X1021:2 %t5169:p};
// %t5170 = $IO_PORT @ATTACH &n1045 => @PLACE(386, -2633) => @ORIENT("MY");
// %t5170 @TEXT("n1045", key="name", size=0.75);
// &n1045 @WIRE(mode="straight") {#X1021:3 %t5170:p};
// %t5171 = $SUPPLY @ATTACH &vdd => @PLACE(376, -2622);
// &vdd @WIRE(mode="straight") {#X1021:4 %t5171:p};
// %t5172 = $GROUND @ATTACH &vss => @PLACE(376, -2644);
// &vss @WIRE(mode="straight") {#X1021:5 %t5172:p};
// %t5173 = $IO_PORT @ATTACH &n1069 => @PLACE(406, -2633) => @ORIENT("R0");
// %t5173 @TEXT("n1069", key="name", size=0.75);
// &n1069 @WIRE(mode="straight") {#X1022:1 %t5173:p};
// %t5174 = $IO_PORT @ATTACH &n1044 => @PLACE(426, -2633) => @ORIENT("MY");
// %t5174 @TEXT("n1044", key="name", size=0.75);
// &n1044 @WIRE(mode="straight") {#X1022:2 %t5174:p};
// %t5175 = $SUPPLY @ATTACH &vdd => @PLACE(416, -2624);
// &vdd @WIRE(mode="straight") {#X1022:3 %t5175:p};
// %t5176 = $GROUND @ATTACH &vss => @PLACE(416, -2642);
// &vss @WIRE(mode="straight") {#X1022:4 %t5176:p};
// %t5177 = $IO_PORT @ATTACH &n1074 => @PLACE(446, -2633) => @ORIENT("R0");
// %t5177 @TEXT("n1074", key="name", size=0.75);
// &n1074 @WIRE(mode="straight") {#X1023:1 %t5177:p};
// %t5178 = $IO_PORT @ATTACH &n1042 => @PLACE(466, -2633) => @ORIENT("MY");
// %t5178 @TEXT("n1042", key="name", size=0.75);
// &n1042 @WIRE(mode="straight") {#X1023:2 %t5178:p};
// %t5179 = $SUPPLY @ATTACH &vdd => @PLACE(456, -2624);
// &vdd @WIRE(mode="straight") {#X1023:3 %t5179:p};
// %t5180 = $GROUND @ATTACH &vss => @PLACE(456, -2642);
// &vss @WIRE(mode="straight") {#X1023:4 %t5180:p};
// %t5181 = $IO_PORT @ATTACH &n1081 => @PLACE(326, -2668) => @ORIENT("R0");
// %t5181 @TEXT("n1081", key="name", size=0.75);
// &n1081 @WIRE(mode="straight") {#X1024:1 %t5181:p};
// %t5182 = $IO_PORT @ATTACH &n1040 => @PLACE(346, -2668) => @ORIENT("MY");
// %t5182 @TEXT("n1040", key="name", size=0.75);
// &n1040 @WIRE(mode="straight") {#X1024:2 %t5182:p};
// %t5183 = $SUPPLY @ATTACH &vdd => @PLACE(336, -2659);
// &vdd @WIRE(mode="straight") {#X1024:3 %t5183:p};
// %t5184 = $GROUND @ATTACH &vss => @PLACE(336, -2677);
// &vss @WIRE(mode="straight") {#X1024:4 %t5184:p};
// %t5185 = $IO_PORT @ATTACH &n1088 => @PLACE(366, -2668) => @ORIENT("R0");
// %t5185 @TEXT("n1088", key="name", size=0.75);
// &n1088 @WIRE(mode="straight") {#X1025:1 %t5185:p};
// %t5186 = $IO_PORT @ATTACH &n1267 => @PLACE(386, -2668) => @ORIENT("MY");
// %t5186 @TEXT("n1267", key="name", size=0.75);
// &n1267 @WIRE(mode="straight") {#X1025:2 %t5186:p};
// %t5187 = $SUPPLY @ATTACH &vdd => @PLACE(376, -2659);
// &vdd @WIRE(mode="straight") {#X1025:3 %t5187:p};
// %t5188 = $GROUND @ATTACH &vss => @PLACE(376, -2677);
// &vss @WIRE(mode="straight") {#X1025:4 %t5188:p};
// %t5189 = $IO_PORT @ATTACH &n1174 => @PLACE(406, -2668) => @ORIENT("R0");
// %t5189 @TEXT("n1174", key="name", size=0.75);
// &n1174 @WIRE(mode="straight") {#X1026:1 %t5189:p};
// %t5190 = $IO_PORT @ATTACH &n1268 => @PLACE(426, -2668) => @ORIENT("MY");
// %t5190 @TEXT("n1268", key="name", size=0.75);
// &n1268 @WIRE(mode="straight") {#X1026:2 %t5190:p};
// %t5191 = $SUPPLY @ATTACH &vdd => @PLACE(416, -2659);
// &vdd @WIRE(mode="straight") {#X1026:3 %t5191:p};
// %t5192 = $GROUND @ATTACH &vss => @PLACE(416, -2677);
// &vss @WIRE(mode="straight") {#X1026:4 %t5192:p};
// %t5193 = $IO_PORT @ATTACH &n960 => @PLACE(446, -2668) => @ORIENT("R0");
// %t5193 @TEXT("n960", key="name", size=0.75);
// &n960 @WIRE(mode="straight") {#X1027:1 %t5193:p};
// %t5194 = $IO_PORT @ATTACH &n1030 => @PLACE(466, -2668) => @ORIENT("MY");
// %t5194 @TEXT("n1030", key="name", size=0.75);
// &n1030 @WIRE(mode="straight") {#X1027:2 %t5194:p};
// %t5195 = $SUPPLY @ATTACH &vdd => @PLACE(456, -2659);
// &vdd @WIRE(mode="straight") {#X1027:3 %t5195:p};
// %t5196 = $GROUND @ATTACH &vss => @PLACE(456, -2677);
// &vss @WIRE(mode="straight") {#X1027:4 %t5196:p};
// %t5197 = $IO_PORT @ATTACH &n1102 => @PLACE(326, -2703) => @ORIENT("R0");
// %t5197 @TEXT("n1102", key="name", size=0.75);
// &n1102 @WIRE(mode="straight") {#X1028:1 %t5197:p};
// %t5198 = $IO_PORT @ATTACH &n999 => @PLACE(346, -2703) => @ORIENT("MY");
// %t5198 @TEXT("n999", key="name", size=0.75);
// &n999 @WIRE(mode="straight") {#X1028:2 %t5198:p};
// %t5199 = $SUPPLY @ATTACH &vdd => @PLACE(336, -2694);
// &vdd @WIRE(mode="straight") {#X1028:3 %t5199:p};
// %t5200 = $GROUND @ATTACH &vss => @PLACE(336, -2712);
// &vss @WIRE(mode="straight") {#X1028:4 %t5200:p};
// %t5201 = $IO_PORT @ATTACH &range_error => @PLACE(366, -2703) => @ORIENT("R0");
// %t5201 @TEXT("range_error", key="name", size=0.75);
// &range_error @WIRE(mode="straight") {#X1029:1 %t5201:p};
// %t5202 = $IO_PORT @ATTACH &n1269 => @PLACE(386, -2703) => @ORIENT("MY");
// %t5202 @TEXT("n1269", key="name", size=0.75);
// &n1269 @WIRE(mode="straight") {#X1029:2 %t5202:p};
// %t5203 = $SUPPLY @ATTACH &vdd => @PLACE(376, -2694);
// &vdd @WIRE(mode="straight") {#X1029:3 %t5203:p};
// %t5204 = $GROUND @ATTACH &vss => @PLACE(376, -2712);
// &vss @WIRE(mode="straight") {#X1029:4 %t5204:p};
// %t5205 = $IO_PORT @ATTACH &n1000 => @PLACE(406, -2703) => @ORIENT("R0");
// %t5205 @TEXT("n1000", key="name", size=0.75);
// &n1000 @WIRE(mode="straight") {#X1030:1 %t5205:p};
// %t5206 = $IO_PORT @ATTACH &n1175 => @PLACE(426, -2703) => @ORIENT("MY");
// %t5206 @TEXT("n1175", key="name", size=0.75);
// &n1175 @WIRE(mode="straight") {#X1030:2 %t5206:p};
// %t5207 = $SUPPLY @ATTACH &vdd => @PLACE(416, -2694);
// &vdd @WIRE(mode="straight") {#X1030:3 %t5207:p};
// %t5208 = $GROUND @ATTACH &vss => @PLACE(416, -2712);
// &vss @WIRE(mode="straight") {#X1030:4 %t5208:p};
// %t5209 = $IO_PORT @ATTACH &n1033 => @PLACE(446, -2703) => @ORIENT("R0");
// %t5209 @TEXT("n1033", key="name", size=0.75);
// &n1033 @WIRE(mode="straight") {#X1031:1 %t5209:p};
// %t5210 = $IO_PORT @ATTACH &n1052 => @PLACE(466, -2703) => @ORIENT("MY");
// %t5210 @TEXT("n1052", key="name", size=0.75);
// &n1052 @WIRE(mode="straight") {#X1031:2 %t5210:p};
// %t5211 = $SUPPLY @ATTACH &vdd => @PLACE(456, -2694);
// &vdd @WIRE(mode="straight") {#X1031:3 %t5211:p};
// %t5212 = $GROUND @ATTACH &vss => @PLACE(456, -2712);
// &vss @WIRE(mode="straight") {#X1031:4 %t5212:p};
// %t5213 = $IO_PORT @ATTACH &n1041 => @PLACE(494, -2538) => @ORIENT("R0");
// %t5213 @TEXT("n1041", key="name", size=0.75);
// &n1041 @WIRE(mode="straight") {#X1032:1 %t5213:p};
// %t5214 = $IO_PORT @ATTACH &n1053 => @PLACE(514, -2538) => @ORIENT("MY");
// %t5214 @TEXT("n1053", key="name", size=0.75);
// &n1053 @WIRE(mode="straight") {#X1032:2 %t5214:p};
// %t5215 = $SUPPLY @ATTACH &vdd => @PLACE(504, -2529);
// &vdd @WIRE(mode="straight") {#X1032:3 %t5215:p};
// %t5216 = $GROUND @ATTACH &vss => @PLACE(504, -2547);
// &vss @WIRE(mode="straight") {#X1032:4 %t5216:p};
// %t5217 = $IO_PORT @ATTACH &n1043 => @PLACE(534, -2538) => @ORIENT("R0");
// %t5217 @TEXT("n1043", key="name", size=0.75);
// &n1043 @WIRE(mode="straight") {#X1033:1 %t5217:p};
// %t5218 = $IO_PORT @ATTACH &n1238 => @PLACE(554, -2538) => @ORIENT("MY");
// %t5218 @TEXT("n1238", key="name", size=0.75);
// &n1238 @WIRE(mode="straight") {#X1033:2 %t5218:p};
// %t5219 = $SUPPLY @ATTACH &vdd => @PLACE(544, -2529);
// &vdd @WIRE(mode="straight") {#X1033:3 %t5219:p};
// %t5220 = $GROUND @ATTACH &vss => @PLACE(544, -2547);
// &vss @WIRE(mode="straight") {#X1033:4 %t5220:p};
// %t5221 = $IO_PORT @ATTACH &n1045 => @PLACE(574, -2538) => @ORIENT("R0");
// %t5221 @TEXT("n1045", key="name", size=0.75);
// &n1045 @WIRE(mode="straight") {#X1034:1 %t5221:p};
// %t5222 = $IO_PORT @ATTACH &n1055 => @PLACE(594, -2538) => @ORIENT("MY");
// %t5222 @TEXT("n1055", key="name", size=0.75);
// &n1055 @WIRE(mode="straight") {#X1034:2 %t5222:p};
// %t5223 = $SUPPLY @ATTACH &vdd => @PLACE(584, -2529);
// &vdd @WIRE(mode="straight") {#X1034:3 %t5223:p};
// %t5224 = $GROUND @ATTACH &vss => @PLACE(584, -2547);
// &vss @WIRE(mode="straight") {#X1034:4 %t5224:p};
// %t5225 = $IO_PORT @ATTACH &n1002 => @PLACE(614, -2538) => @ORIENT("R0");
// %t5225 @TEXT("n1002", key="name", size=0.75);
// &n1002 @WIRE(mode="straight") {#X1035:1 %t5225:p};
// %t5226 = $IO_PORT @ATTACH &n184 => @PLACE(635, -2538) => @ORIENT("MY");
// %t5226 @TEXT("n184", key="name", size=0.75);
// &n184 @WIRE(mode="straight") {#X1035:2 %t5226:p};
// %t5227 = $SUPPLY @ATTACH &vdd => @PLACE(624, -2529);
// &vdd @WIRE(mode="straight") {#X1035:3 %t5227:p};
// %t5228 = $GROUND @ATTACH &vss => @PLACE(624, -2547);
// &vss @WIRE(mode="straight") {#X1035:4 %t5228:p};
// %t5229 = $IO_PORT @ATTACH &n1124 => @PLACE(494, -2567) => @ORIENT("R0");
// %t5229 @TEXT("n1124", key="name", size=0.75);
// &n1124 @WIRE(mode="straight") {#X1036:1 %t5229:p};
// %t5230 = $IO_PORT @ATTACH &n1031 => @PLACE(494, -2571) => @ORIENT("R0");
// %t5230 @TEXT("n1031", key="name", size=0.75);
// &n1031 @WIRE(mode="straight") {#X1036:2 %t5230:p};
// %t5231 = $IO_PORT @ATTACH &n1270 => @PLACE(514, -2569) => @ORIENT("MY");
// %t5231 @TEXT("n1270", key="name", size=0.75);
// &n1270 @WIRE(mode="straight") {#X1036:3 %t5231:p};
// %t5232 = $SUPPLY @ATTACH &vdd => @PLACE(504, -2558);
// &vdd @WIRE(mode="straight") {#X1036:4 %t5232:p};
// %t5233 = $GROUND @ATTACH &vss => @PLACE(504, -2580);
// &vss @WIRE(mode="straight") {#X1036:5 %t5233:p};
// %t5234 = $IO_PORT @ATTACH &n1127 => @PLACE(534, -2567) => @ORIENT("R0");
// %t5234 @TEXT("n1127", key="name", size=0.75);
// &n1127 @WIRE(mode="straight") {#X1037:1 %t5234:p};
// %t5235 = $IO_PORT @ATTACH &n349 => @PLACE(534, -2571) => @ORIENT("R0");
// %t5235 @TEXT("n349", key="name", size=0.75);
// &n349 @WIRE(mode="straight") {#X1037:2 %t5235:p};
// %t5236 = $IO_PORT @ATTACH &n1271 => @PLACE(554, -2569) => @ORIENT("MY");
// %t5236 @TEXT("n1271", key="name", size=0.75);
// &n1271 @WIRE(mode="straight") {#X1037:3 %t5236:p};
// %t5237 = $SUPPLY @ATTACH &vdd => @PLACE(544, -2558);
// &vdd @WIRE(mode="straight") {#X1037:4 %t5237:p};
// %t5238 = $GROUND @ATTACH &vss => @PLACE(544, -2580);
// &vss @WIRE(mode="straight") {#X1037:5 %t5238:p};
// %t5239 = $IO_PORT @ATTACH &n1270 => @PLACE(574, -2567) => @ORIENT("R0");
// %t5239 @TEXT("n1270", key="name", size=0.75);
// &n1270 @WIRE(mode="straight") {#X1038:1 %t5239:p};
// %t5240 = $IO_PORT @ATTACH &n1271 => @PLACE(574, -2571) => @ORIENT("R0");
// %t5240 @TEXT("n1271", key="name", size=0.75);
// &n1271 @WIRE(mode="straight") {#X1038:2 %t5240:p};
// %t5241 = $IO_PORT @ATTACH &n238 => @PLACE(594, -2569) => @ORIENT("MY");
// %t5241 @TEXT("n238", key="name", size=0.75);
// &n238 @WIRE(mode="straight") {#X1038:3 %t5241:p};
// %t5242 = $SUPPLY @ATTACH &vdd => @PLACE(584, -2558);
// &vdd @WIRE(mode="straight") {#X1038:4 %t5242:p};
// %t5243 = $GROUND @ATTACH &vss => @PLACE(584, -2580);
// &vss @WIRE(mode="straight") {#X1038:5 %t5243:p};
// %t5244 = $IO_PORT @ATTACH &n54 => @PLACE(614, -2567) => @ORIENT("R0");
// %t5244 @TEXT("n54", key="name", size=0.75);
// &n54 @WIRE(mode="straight") {#X1039:1 %t5244:p};
// %t5245 = $IO_PORT @ATTACH &n1030 => @PLACE(614, -2571) => @ORIENT("R0");
// %t5245 @TEXT("n1030", key="name", size=0.75);
// &n1030 @WIRE(mode="straight") {#X1039:2 %t5245:p};
// %t5246 = $IO_PORT @ATTACH &n1272 => @PLACE(635, -2569) => @ORIENT("MY");
// %t5246 @TEXT("n1272", key="name", size=0.75);
// &n1272 @WIRE(mode="straight") {#X1039:3 %t5246:p};
// %t5247 = $SUPPLY @ATTACH &vdd => @PLACE(624, -2558);
// &vdd @WIRE(mode="straight") {#X1039:4 %t5247:p};
// %t5248 = $GROUND @ATTACH &vss => @PLACE(624, -2580);
// &vss @WIRE(mode="straight") {#X1039:5 %t5248:p};
// %t5249 = $IO_PORT @ATTACH &n1270 => @PLACE(494, -2598) => @ORIENT("R0");
// %t5249 @TEXT("n1270", key="name", size=0.75);
// &n1270 @WIRE(mode="straight") {#X1040:1 %t5249:p};
// %t5250 = $IO_PORT @ATTACH &n1267 => @PLACE(494, -2602) => @ORIENT("R0");
// %t5250 @TEXT("n1267", key="name", size=0.75);
// &n1267 @WIRE(mode="straight") {#X1040:2 %t5250:p};
// %t5251 = $IO_PORT @ATTACH &n1273 => @PLACE(514, -2600) => @ORIENT("MY");
// %t5251 @TEXT("n1273", key="name", size=0.75);
// &n1273 @WIRE(mode="straight") {#X1040:3 %t5251:p};
// %t5252 = $SUPPLY @ATTACH &vdd => @PLACE(504, -2589);
// &vdd @WIRE(mode="straight") {#X1040:4 %t5252:p};
// %t5253 = $GROUND @ATTACH &vss => @PLACE(504, -2611);
// &vss @WIRE(mode="straight") {#X1040:5 %t5253:p};
// %t5254 = $IO_PORT @ATTACH &n1272 => @PLACE(534, -2598) => @ORIENT("R0");
// %t5254 @TEXT("n1272", key="name", size=0.75);
// &n1272 @WIRE(mode="straight") {#X1041:1 %t5254:p};
// %t5255 = $IO_PORT @ATTACH &n1273 => @PLACE(534, -2602) => @ORIENT("R0");
// %t5255 @TEXT("n1273", key="name", size=0.75);
// &n1273 @WIRE(mode="straight") {#X1041:2 %t5255:p};
// %t5256 = $IO_PORT @ATTACH &n1274 => @PLACE(554, -2600) => @ORIENT("MY");
// %t5256 @TEXT("n1274", key="name", size=0.75);
// &n1274 @WIRE(mode="straight") {#X1041:3 %t5256:p};
// %t5257 = $SUPPLY @ATTACH &vdd => @PLACE(544, -2589);
// &vdd @WIRE(mode="straight") {#X1041:4 %t5257:p};
// %t5258 = $GROUND @ATTACH &vss => @PLACE(544, -2611);
// &vss @WIRE(mode="straight") {#X1041:5 %t5258:p};
// %t5259 = $IO_PORT @ATTACH &n1271 => @PLACE(574, -2598) => @ORIENT("R0");
// %t5259 @TEXT("n1271", key="name", size=0.75);
// &n1271 @WIRE(mode="straight") {#X1042:1 %t5259:p};
// %t5260 = $IO_PORT @ATTACH &n1268 => @PLACE(574, -2602) => @ORIENT("R0");
// %t5260 @TEXT("n1268", key="name", size=0.75);
// &n1268 @WIRE(mode="straight") {#X1042:2 %t5260:p};
// %t5261 = $IO_PORT @ATTACH &n1275 => @PLACE(594, -2600) => @ORIENT("MY");
// %t5261 @TEXT("n1275", key="name", size=0.75);
// &n1275 @WIRE(mode="straight") {#X1042:3 %t5261:p};
// %t5262 = $SUPPLY @ATTACH &vdd => @PLACE(584, -2589);
// &vdd @WIRE(mode="straight") {#X1042:4 %t5262:p};
// %t5263 = $GROUND @ATTACH &vss => @PLACE(584, -2611);
// &vss @WIRE(mode="straight") {#X1042:5 %t5263:p};
// %t5264 = $IO_PORT @ATTACH &n1274 => @PLACE(614, -2598) => @ORIENT("R0");
// %t5264 @TEXT("n1274", key="name", size=0.75);
// &n1274 @WIRE(mode="straight") {#X1043:1 %t5264:p};
// %t5265 = $IO_PORT @ATTACH &n1275 => @PLACE(614, -2602) => @ORIENT("R0");
// %t5265 @TEXT("n1275", key="name", size=0.75);
// &n1275 @WIRE(mode="straight") {#X1043:2 %t5265:p};
// %t5266 = $IO_PORT @ATTACH &n232 => @PLACE(635, -2600) => @ORIENT("MY");
// %t5266 @TEXT("n232", key="name", size=0.75);
// &n232 @WIRE(mode="straight") {#X1043:3 %t5266:p};
// %t5267 = $SUPPLY @ATTACH &vdd => @PLACE(624, -2589);
// &vdd @WIRE(mode="straight") {#X1043:4 %t5267:p};
// %t5268 = $GROUND @ATTACH &vss => @PLACE(624, -2611);
// &vss @WIRE(mode="straight") {#X1043:5 %t5268:p};
// %t5269 = $IO_PORT @ATTACH &n236 => @PLACE(494, -2631) => @ORIENT("R0");
// %t5269 @TEXT("n236", key="name", size=0.75);
// &n236 @WIRE(mode="straight") {#X1044:1 %t5269:p};
// %t5270 = $IO_PORT @ATTACH &n115 => @PLACE(494, -2635) => @ORIENT("R0");
// %t5270 @TEXT("n115", key="name", size=0.75);
// &n115 @WIRE(mode="straight") {#X1044:2 %t5270:p};
// %t5271 = $IO_PORT @ATTACH &n234 => @PLACE(514, -2633) => @ORIENT("MY");
// %t5271 @TEXT("n234", key="name", size=0.75);
// &n234 @WIRE(mode="straight") {#X1044:3 %t5271:p};
// %t5272 = $SUPPLY @ATTACH &vdd => @PLACE(504, -2622);
// &vdd @WIRE(mode="straight") {#X1044:4 %t5272:p};
// %t5273 = $GROUND @ATTACH &vss => @PLACE(504, -2644);
// &vss @WIRE(mode="straight") {#X1044:5 %t5273:p};
// %t5274 = $IO_PORT @ATTACH &vss => @PLACE(534, -2629) => @ORIENT("R0");
// %t5274 @TEXT("vss", key="name", size=0.75);
// &vss @WIRE(mode="straight") {#X1045:1 %t5274:p};
// %t5275 = $IO_PORT @ATTACH &target_k0 => @PLACE(534, -2633) => @ORIENT("R0");
// %t5275 @TEXT("target_k0", key="name", size=0.75);
// &target_k0 @WIRE(mode="straight") {#X1045:2 %t5275:p};
// %t5276 = $IO_PORT @ATTACH &n1111 => @PLACE(534, -2637) => @ORIENT("R0");
// %t5276 @TEXT("n1111", key="name", size=0.75);
// &n1111 @WIRE(mode="straight") {#X1045:3 %t5276:p};
// %t5277 = $IO_PORT @ATTACH &n1276 => @PLACE(554, -2633) => @ORIENT("MY");
// %t5277 @TEXT("n1276", key="name", size=0.75);
// &n1276 @WIRE(mode="straight") {#X1045:4 %t5277:p};
// %t5278 = $SUPPLY @ATTACH &vdd => @PLACE(544, -2620);
// &vdd @WIRE(mode="straight") {#X1045:5 %t5278:p};
// %t5279 = $GROUND @ATTACH &vss => @PLACE(544, -2646);
// &vss @WIRE(mode="straight") {#X1045:6 %t5279:p};
// %t5280 = $IO_PORT @ATTACH &target_k0 => @PLACE(574, -2629) => @ORIENT("R0");
// %t5280 @TEXT("target_k0", key="name", size=0.75);
// &target_k0 @WIRE(mode="straight") {#X1046:1 %t5280:p};
// %t5281 = $IO_PORT @ATTACH &n462 => @PLACE(574, -2633) => @ORIENT("R0");
// %t5281 @TEXT("n462", key="name", size=0.75);
// &n462 @WIRE(mode="straight") {#X1046:2 %t5281:p};
// %t5282 = $IO_PORT @ATTACH &n1111 => @PLACE(574, -2637) => @ORIENT("R0");
// %t5282 @TEXT("n1111", key="name", size=0.75);
// &n1111 @WIRE(mode="straight") {#X1046:3 %t5282:p};
// %t5283 = $IO_PORT @ATTACH &n1277 => @PLACE(594, -2633) => @ORIENT("MY");
// %t5283 @TEXT("n1277", key="name", size=0.75);
// &n1277 @WIRE(mode="straight") {#X1046:4 %t5283:p};
// %t5284 = $SUPPLY @ATTACH &vdd => @PLACE(584, -2620);
// &vdd @WIRE(mode="straight") {#X1046:5 %t5284:p};
// %t5285 = $GROUND @ATTACH &vss => @PLACE(584, -2646);
// &vss @WIRE(mode="straight") {#X1046:6 %t5285:p};
// %t5286 = $IO_PORT @ATTACH &target_k1 => @PLACE(614, -2629) => @ORIENT("R0");
// %t5286 @TEXT("target_k1", key="name", size=0.75);
// &target_k1 @WIRE(mode="straight") {#X1047:1 %t5286:p};
// %t5287 = $IO_PORT @ATTACH &n450 => @PLACE(614, -2633) => @ORIENT("R0");
// %t5287 @TEXT("n450", key="name", size=0.75);
// &n450 @WIRE(mode="straight") {#X1047:2 %t5287:p};
// %t5288 = $IO_PORT @ATTACH &n1111 => @PLACE(614, -2637) => @ORIENT("R0");
// %t5288 @TEXT("n1111", key="name", size=0.75);
// &n1111 @WIRE(mode="straight") {#X1047:3 %t5288:p};
// %t5289 = $IO_PORT @ATTACH &n1278 => @PLACE(635, -2633) => @ORIENT("MY");
// %t5289 @TEXT("n1278", key="name", size=0.75);
// &n1278 @WIRE(mode="straight") {#X1047:4 %t5289:p};
// %t5290 = $SUPPLY @ATTACH &vdd => @PLACE(624, -2620);
// &vdd @WIRE(mode="straight") {#X1047:5 %t5290:p};
// %t5291 = $GROUND @ATTACH &vss => @PLACE(624, -2646);
// &vss @WIRE(mode="straight") {#X1047:6 %t5291:p};
// %t5292 = $IO_PORT @ATTACH &target_k2 => @PLACE(494, -2664) => @ORIENT("R0");
// %t5292 @TEXT("target_k2", key="name", size=0.75);
// &target_k2 @WIRE(mode="straight") {#X1048:1 %t5292:p};
// %t5293 = $IO_PORT @ATTACH &n453 => @PLACE(494, -2668) => @ORIENT("R0");
// %t5293 @TEXT("n453", key="name", size=0.75);
// &n453 @WIRE(mode="straight") {#X1048:2 %t5293:p};
// %t5294 = $IO_PORT @ATTACH &n1111 => @PLACE(494, -2672) => @ORIENT("R0");
// %t5294 @TEXT("n1111", key="name", size=0.75);
// &n1111 @WIRE(mode="straight") {#X1048:3 %t5294:p};
// %t5295 = $IO_PORT @ATTACH &n1279 => @PLACE(514, -2668) => @ORIENT("MY");
// %t5295 @TEXT("n1279", key="name", size=0.75);
// &n1279 @WIRE(mode="straight") {#X1048:4 %t5295:p};
// %t5296 = $SUPPLY @ATTACH &vdd => @PLACE(504, -2655);
// &vdd @WIRE(mode="straight") {#X1048:5 %t5296:p};
// %t5297 = $GROUND @ATTACH &vss => @PLACE(504, -2681);
// &vss @WIRE(mode="straight") {#X1048:6 %t5297:p};
// %t5298 = $IO_PORT @ATTACH &target_k3 => @PLACE(534, -2664) => @ORIENT("R0");
// %t5298 @TEXT("target_k3", key="name", size=0.75);
// &target_k3 @WIRE(mode="straight") {#X1049:1 %t5298:p};
// %t5299 = $IO_PORT @ATTACH &n456 => @PLACE(534, -2668) => @ORIENT("R0");
// %t5299 @TEXT("n456", key="name", size=0.75);
// &n456 @WIRE(mode="straight") {#X1049:2 %t5299:p};
// %t5300 = $IO_PORT @ATTACH &n1111 => @PLACE(534, -2672) => @ORIENT("R0");
// %t5300 @TEXT("n1111", key="name", size=0.75);
// &n1111 @WIRE(mode="straight") {#X1049:3 %t5300:p};
// %t5301 = $IO_PORT @ATTACH &n1280 => @PLACE(554, -2668) => @ORIENT("MY");
// %t5301 @TEXT("n1280", key="name", size=0.75);
// &n1280 @WIRE(mode="straight") {#X1049:4 %t5301:p};
// %t5302 = $SUPPLY @ATTACH &vdd => @PLACE(544, -2655);
// &vdd @WIRE(mode="straight") {#X1049:5 %t5302:p};
// %t5303 = $GROUND @ATTACH &vss => @PLACE(544, -2681);
// &vss @WIRE(mode="straight") {#X1049:6 %t5303:p};
// %t5304 = $IO_PORT @ATTACH &target_k4 => @PLACE(574, -2664) => @ORIENT("R0");
// %t5304 @TEXT("target_k4", key="name", size=0.75);
// &target_k4 @WIRE(mode="straight") {#X1050:1 %t5304:p};
// %t5305 = $IO_PORT @ATTACH &n459 => @PLACE(574, -2668) => @ORIENT("R0");
// %t5305 @TEXT("n459", key="name", size=0.75);
// &n459 @WIRE(mode="straight") {#X1050:2 %t5305:p};
// %t5306 = $IO_PORT @ATTACH &n1111 => @PLACE(574, -2672) => @ORIENT("R0");
// %t5306 @TEXT("n1111", key="name", size=0.75);
// &n1111 @WIRE(mode="straight") {#X1050:3 %t5306:p};
// %t5307 = $IO_PORT @ATTACH &n1281 => @PLACE(594, -2668) => @ORIENT("MY");
// %t5307 @TEXT("n1281", key="name", size=0.75);
// &n1281 @WIRE(mode="straight") {#X1050:4 %t5307:p};
// %t5308 = $SUPPLY @ATTACH &vdd => @PLACE(584, -2655);
// &vdd @WIRE(mode="straight") {#X1050:5 %t5308:p};
// %t5309 = $GROUND @ATTACH &vss => @PLACE(584, -2681);
// &vss @WIRE(mode="straight") {#X1050:6 %t5309:p};
// %t5310 = $IO_PORT @ATTACH &target_k5 => @PLACE(614, -2664) => @ORIENT("R0");
// %t5310 @TEXT("target_k5", key="name", size=0.75);
// &target_k5 @WIRE(mode="straight") {#X1051:1 %t5310:p};
// %t5311 = $IO_PORT @ATTACH &n461 => @PLACE(614, -2668) => @ORIENT("R0");
// %t5311 @TEXT("n461", key="name", size=0.75);
// &n461 @WIRE(mode="straight") {#X1051:2 %t5311:p};
// %t5312 = $IO_PORT @ATTACH &n1111 => @PLACE(614, -2672) => @ORIENT("R0");
// %t5312 @TEXT("n1111", key="name", size=0.75);
// &n1111 @WIRE(mode="straight") {#X1051:3 %t5312:p};
// %t5313 = $IO_PORT @ATTACH &n1282 => @PLACE(635, -2668) => @ORIENT("MY");
// %t5313 @TEXT("n1282", key="name", size=0.75);
// &n1282 @WIRE(mode="straight") {#X1051:4 %t5313:p};
// %t5314 = $SUPPLY @ATTACH &vdd => @PLACE(624, -2655);
// &vdd @WIRE(mode="straight") {#X1051:5 %t5314:p};
// %t5315 = $GROUND @ATTACH &vss => @PLACE(624, -2681);
// &vss @WIRE(mode="straight") {#X1051:6 %t5315:p};
// %t5316 = $IO_PORT @ATTACH &vss => @PLACE(494, -2699) => @ORIENT("R0");
// %t5316 @TEXT("vss", key="name", size=0.75);
// &vss @WIRE(mode="straight") {#X1052:1 %t5316:p};
// %t5317 = $IO_PORT @ATTACH &n734 => @PLACE(494, -2703) => @ORIENT("R0");
// %t5317 @TEXT("n734", key="name", size=0.75);
// &n734 @WIRE(mode="straight") {#X1052:2 %t5317:p};
// %t5318 = $IO_PORT @ATTACH &n1111 => @PLACE(494, -2707) => @ORIENT("R0");
// %t5318 @TEXT("n1111", key="name", size=0.75);
// &n1111 @WIRE(mode="straight") {#X1052:3 %t5318:p};
// %t5319 = $IO_PORT @ATTACH &n1283 => @PLACE(514, -2703) => @ORIENT("MY");
// %t5319 @TEXT("n1283", key="name", size=0.75);
// &n1283 @WIRE(mode="straight") {#X1052:4 %t5319:p};
// %t5320 = $SUPPLY @ATTACH &vdd => @PLACE(504, -2690);
// &vdd @WIRE(mode="straight") {#X1052:5 %t5320:p};
// %t5321 = $GROUND @ATTACH &vss => @PLACE(504, -2716);
// &vss @WIRE(mode="straight") {#X1052:6 %t5321:p};
// %t5322 = $IO_PORT @ATTACH &n1276 => @PLACE(534, -2699) => @ORIENT("R0");
// %t5322 @TEXT("n1276", key="name", size=0.75);
// &n1276 @WIRE(mode="straight") {#X1053:1 %t5322:p};
// %t5323 = $IO_PORT @ATTACH &vss => @PLACE(534, -2703) => @ORIENT("R0");
// %t5323 @TEXT("vss", key="name", size=0.75);
// &vss @WIRE(mode="straight") {#X1053:2 %t5323:p};
// %t5324 = $IO_PORT @ATTACH &n1113 => @PLACE(534, -2707) => @ORIENT("R0");
// %t5324 @TEXT("n1113", key="name", size=0.75);
// &n1113 @WIRE(mode="straight") {#X1053:3 %t5324:p};
// %t5325 = $IO_PORT @ATTACH &n1284 => @PLACE(554, -2703) => @ORIENT("MY");
// %t5325 @TEXT("n1284", key="name", size=0.75);
// &n1284 @WIRE(mode="straight") {#X1053:4 %t5325:p};
// %t5326 = $SUPPLY @ATTACH &vdd => @PLACE(544, -2690);
// &vdd @WIRE(mode="straight") {#X1053:5 %t5326:p};
// %t5327 = $GROUND @ATTACH &vss => @PLACE(544, -2716);
// &vss @WIRE(mode="straight") {#X1053:6 %t5327:p};
// %t5328 = $IO_PORT @ATTACH &n1277 => @PLACE(574, -2699) => @ORIENT("R0");
// %t5328 @TEXT("n1277", key="name", size=0.75);
// &n1277 @WIRE(mode="straight") {#X1054:1 %t5328:p};
// %t5329 = $IO_PORT @ATTACH &vss => @PLACE(574, -2703) => @ORIENT("R0");
// %t5329 @TEXT("vss", key="name", size=0.75);
// &vss @WIRE(mode="straight") {#X1054:2 %t5329:p};
// %t5330 = $IO_PORT @ATTACH &n1113 => @PLACE(574, -2707) => @ORIENT("R0");
// %t5330 @TEXT("n1113", key="name", size=0.75);
// &n1113 @WIRE(mode="straight") {#X1054:3 %t5330:p};
// %t5331 = $IO_PORT @ATTACH &n1285 => @PLACE(594, -2703) => @ORIENT("MY");
// %t5331 @TEXT("n1285", key="name", size=0.75);
// &n1285 @WIRE(mode="straight") {#X1054:4 %t5331:p};
// %t5332 = $SUPPLY @ATTACH &vdd => @PLACE(584, -2690);
// &vdd @WIRE(mode="straight") {#X1054:5 %t5332:p};
// %t5333 = $GROUND @ATTACH &vss => @PLACE(584, -2716);
// &vss @WIRE(mode="straight") {#X1054:6 %t5333:p};
// %t5334 = $IO_PORT @ATTACH &n1278 => @PLACE(614, -2699) => @ORIENT("R0");
// %t5334 @TEXT("n1278", key="name", size=0.75);
// &n1278 @WIRE(mode="straight") {#X1055:1 %t5334:p};
// %t5335 = $IO_PORT @ATTACH &target_k0 => @PLACE(614, -2703) => @ORIENT("R0");
// %t5335 @TEXT("target_k0", key="name", size=0.75);
// &target_k0 @WIRE(mode="straight") {#X1055:2 %t5335:p};
// %t5336 = $IO_PORT @ATTACH &n1113 => @PLACE(614, -2707) => @ORIENT("R0");
// %t5336 @TEXT("n1113", key="name", size=0.75);
// &n1113 @WIRE(mode="straight") {#X1055:3 %t5336:p};
// %t5337 = $IO_PORT @ATTACH &n1286 => @PLACE(635, -2703) => @ORIENT("MY");
// %t5337 @TEXT("n1286", key="name", size=0.75);
// &n1286 @WIRE(mode="straight") {#X1055:4 %t5337:p};
// %t5338 = $SUPPLY @ATTACH &vdd => @PLACE(624, -2690);
// &vdd @WIRE(mode="straight") {#X1055:5 %t5338:p};
// %t5339 = $GROUND @ATTACH &vss => @PLACE(624, -2716);
// &vss @WIRE(mode="straight") {#X1055:6 %t5339:p};
// %t5340 = $IO_PORT @ATTACH &n1279 => @PLACE(-11, -2744) => @ORIENT("R0");
// %t5340 @TEXT("n1279", key="name", size=0.75);
// &n1279 @WIRE(mode="straight") {#X1056:1 %t5340:p};
// %t5341 = $IO_PORT @ATTACH &target_k1 => @PLACE(-11, -2748) => @ORIENT("R0");
// %t5341 @TEXT("target_k1", key="name", size=0.75);
// &target_k1 @WIRE(mode="straight") {#X1056:2 %t5341:p};
// %t5342 = $IO_PORT @ATTACH &n1113 => @PLACE(-11, -2752) => @ORIENT("R0");
// %t5342 @TEXT("n1113", key="name", size=0.75);
// &n1113 @WIRE(mode="straight") {#X1056:3 %t5342:p};
// %t5343 = $IO_PORT @ATTACH &n1287 => @PLACE(10, -2748) => @ORIENT("MY");
// %t5343 @TEXT("n1287", key="name", size=0.75);
// &n1287 @WIRE(mode="straight") {#X1056:4 %t5343:p};
// %t5344 = $SUPPLY @ATTACH &vdd => @PLACE(0, -2735);
// &vdd @WIRE(mode="straight") {#X1056:5 %t5344:p};
// %t5345 = $GROUND @ATTACH &vss => @PLACE(0, -2761);
// &vss @WIRE(mode="straight") {#X1056:6 %t5345:p};
// %t5346 = $IO_PORT @ATTACH &n1280 => @PLACE(30, -2744) => @ORIENT("R0");
// %t5346 @TEXT("n1280", key="name", size=0.75);
// &n1280 @WIRE(mode="straight") {#X1057:1 %t5346:p};
// %t5347 = $IO_PORT @ATTACH &target_k2 => @PLACE(30, -2748) => @ORIENT("R0");
// %t5347 @TEXT("target_k2", key="name", size=0.75);
// &target_k2 @WIRE(mode="straight") {#X1057:2 %t5347:p};
// %t5348 = $IO_PORT @ATTACH &n1113 => @PLACE(30, -2752) => @ORIENT("R0");
// %t5348 @TEXT("n1113", key="name", size=0.75);
// &n1113 @WIRE(mode="straight") {#X1057:3 %t5348:p};
// %t5349 = $IO_PORT @ATTACH &n1288 => @PLACE(50, -2748) => @ORIENT("MY");
// %t5349 @TEXT("n1288", key="name", size=0.75);
// &n1288 @WIRE(mode="straight") {#X1057:4 %t5349:p};
// %t5350 = $SUPPLY @ATTACH &vdd => @PLACE(40, -2735);
// &vdd @WIRE(mode="straight") {#X1057:5 %t5350:p};
// %t5351 = $GROUND @ATTACH &vss => @PLACE(40, -2761);
// &vss @WIRE(mode="straight") {#X1057:6 %t5351:p};
// %t5352 = $IO_PORT @ATTACH &n1281 => @PLACE(70, -2744) => @ORIENT("R0");
// %t5352 @TEXT("n1281", key="name", size=0.75);
// &n1281 @WIRE(mode="straight") {#X1058:1 %t5352:p};
// %t5353 = $IO_PORT @ATTACH &target_k3 => @PLACE(70, -2748) => @ORIENT("R0");
// %t5353 @TEXT("target_k3", key="name", size=0.75);
// &target_k3 @WIRE(mode="straight") {#X1058:2 %t5353:p};
// %t5354 = $IO_PORT @ATTACH &n1113 => @PLACE(70, -2752) => @ORIENT("R0");
// %t5354 @TEXT("n1113", key="name", size=0.75);
// &n1113 @WIRE(mode="straight") {#X1058:3 %t5354:p};
// %t5355 = $IO_PORT @ATTACH &n1289 => @PLACE(90, -2748) => @ORIENT("MY");
// %t5355 @TEXT("n1289", key="name", size=0.75);
// &n1289 @WIRE(mode="straight") {#X1058:4 %t5355:p};
// %t5356 = $SUPPLY @ATTACH &vdd => @PLACE(80, -2735);
// &vdd @WIRE(mode="straight") {#X1058:5 %t5356:p};
// %t5357 = $GROUND @ATTACH &vss => @PLACE(80, -2761);
// &vss @WIRE(mode="straight") {#X1058:6 %t5357:p};
// %t5358 = $IO_PORT @ATTACH &n1282 => @PLACE(110, -2744) => @ORIENT("R0");
// %t5358 @TEXT("n1282", key="name", size=0.75);
// &n1282 @WIRE(mode="straight") {#X1059:1 %t5358:p};
// %t5359 = $IO_PORT @ATTACH &target_k4 => @PLACE(110, -2748) => @ORIENT("R0");
// %t5359 @TEXT("target_k4", key="name", size=0.75);
// &target_k4 @WIRE(mode="straight") {#X1059:2 %t5359:p};
// %t5360 = $IO_PORT @ATTACH &n1113 => @PLACE(110, -2752) => @ORIENT("R0");
// %t5360 @TEXT("n1113", key="name", size=0.75);
// &n1113 @WIRE(mode="straight") {#X1059:3 %t5360:p};
// %t5361 = $IO_PORT @ATTACH &n1290 => @PLACE(130, -2748) => @ORIENT("MY");
// %t5361 @TEXT("n1290", key="name", size=0.75);
// &n1290 @WIRE(mode="straight") {#X1059:4 %t5361:p};
// %t5362 = $SUPPLY @ATTACH &vdd => @PLACE(120, -2735);
// &vdd @WIRE(mode="straight") {#X1059:5 %t5362:p};
// %t5363 = $GROUND @ATTACH &vss => @PLACE(120, -2761);
// &vss @WIRE(mode="straight") {#X1059:6 %t5363:p};
// %t5364 = $IO_PORT @ATTACH &n1283 => @PLACE(-11, -2779) => @ORIENT("R0");
// %t5364 @TEXT("n1283", key="name", size=0.75);
// &n1283 @WIRE(mode="straight") {#X1060:1 %t5364:p};
// %t5365 = $IO_PORT @ATTACH &target_k5 => @PLACE(-11, -2783) => @ORIENT("R0");
// %t5365 @TEXT("target_k5", key="name", size=0.75);
// &target_k5 @WIRE(mode="straight") {#X1060:2 %t5365:p};
// %t5366 = $IO_PORT @ATTACH &n1113 => @PLACE(-11, -2787) => @ORIENT("R0");
// %t5366 @TEXT("n1113", key="name", size=0.75);
// &n1113 @WIRE(mode="straight") {#X1060:3 %t5366:p};
// %t5367 = $IO_PORT @ATTACH &n1291 => @PLACE(10, -2783) => @ORIENT("MY");
// %t5367 @TEXT("n1291", key="name", size=0.75);
// &n1291 @WIRE(mode="straight") {#X1060:4 %t5367:p};
// %t5368 = $SUPPLY @ATTACH &vdd => @PLACE(0, -2770);
// &vdd @WIRE(mode="straight") {#X1060:5 %t5368:p};
// %t5369 = $GROUND @ATTACH &vss => @PLACE(0, -2796);
// &vss @WIRE(mode="straight") {#X1060:6 %t5369:p};
// %t5370 = $IO_PORT @ATTACH &n1284 => @PLACE(30, -2779) => @ORIENT("R0");
// %t5370 @TEXT("n1284", key="name", size=0.75);
// &n1284 @WIRE(mode="straight") {#X1061:1 %t5370:p};
// %t5371 = $IO_PORT @ATTACH &target_k0 => @PLACE(30, -2783) => @ORIENT("R0");
// %t5371 @TEXT("target_k0", key="name", size=0.75);
// &target_k0 @WIRE(mode="straight") {#X1061:2 %t5371:p};
// %t5372 = $IO_PORT @ATTACH &n1117 => @PLACE(30, -2787) => @ORIENT("R0");
// %t5372 @TEXT("n1117", key="name", size=0.75);
// &n1117 @WIRE(mode="straight") {#X1061:3 %t5372:p};
// %t5373 = $IO_PORT @ATTACH &n1292 => @PLACE(50, -2783) => @ORIENT("MY");
// %t5373 @TEXT("n1292", key="name", size=0.75);
// &n1292 @WIRE(mode="straight") {#X1061:4 %t5373:p};
// %t5374 = $SUPPLY @ATTACH &vdd => @PLACE(40, -2770);
// &vdd @WIRE(mode="straight") {#X1061:5 %t5374:p};
// %t5375 = $GROUND @ATTACH &vss => @PLACE(40, -2796);
// &vss @WIRE(mode="straight") {#X1061:6 %t5375:p};
// %t5376 = $IO_PORT @ATTACH &n1285 => @PLACE(70, -2779) => @ORIENT("R0");
// %t5376 @TEXT("n1285", key="name", size=0.75);
// &n1285 @WIRE(mode="straight") {#X1062:1 %t5376:p};
// %t5377 = $IO_PORT @ATTACH &target_k1 => @PLACE(70, -2783) => @ORIENT("R0");
// %t5377 @TEXT("target_k1", key="name", size=0.75);
// &target_k1 @WIRE(mode="straight") {#X1062:2 %t5377:p};
// %t5378 = $IO_PORT @ATTACH &n1117 => @PLACE(70, -2787) => @ORIENT("R0");
// %t5378 @TEXT("n1117", key="name", size=0.75);
// &n1117 @WIRE(mode="straight") {#X1062:3 %t5378:p};
// %t5379 = $IO_PORT @ATTACH &n1293 => @PLACE(90, -2783) => @ORIENT("MY");
// %t5379 @TEXT("n1293", key="name", size=0.75);
// &n1293 @WIRE(mode="straight") {#X1062:4 %t5379:p};
// %t5380 = $SUPPLY @ATTACH &vdd => @PLACE(80, -2770);
// &vdd @WIRE(mode="straight") {#X1062:5 %t5380:p};
// %t5381 = $GROUND @ATTACH &vss => @PLACE(80, -2796);
// &vss @WIRE(mode="straight") {#X1062:6 %t5381:p};
// %t5382 = $IO_PORT @ATTACH &n1286 => @PLACE(110, -2779) => @ORIENT("R0");
// %t5382 @TEXT("n1286", key="name", size=0.75);
// &n1286 @WIRE(mode="straight") {#X1063:1 %t5382:p};
// %t5383 = $IO_PORT @ATTACH &n758 => @PLACE(110, -2783) => @ORIENT("R0");
// %t5383 @TEXT("n758", key="name", size=0.75);
// &n758 @WIRE(mode="straight") {#X1063:2 %t5383:p};
// %t5384 = $IO_PORT @ATTACH &n1117 => @PLACE(110, -2787) => @ORIENT("R0");
// %t5384 @TEXT("n1117", key="name", size=0.75);
// &n1117 @WIRE(mode="straight") {#X1063:3 %t5384:p};
// %t5385 = $IO_PORT @ATTACH &n1294 => @PLACE(130, -2783) => @ORIENT("MY");
// %t5385 @TEXT("n1294", key="name", size=0.75);
// &n1294 @WIRE(mode="straight") {#X1063:4 %t5385:p};
// %t5386 = $SUPPLY @ATTACH &vdd => @PLACE(120, -2770);
// &vdd @WIRE(mode="straight") {#X1063:5 %t5386:p};
// %t5387 = $GROUND @ATTACH &vss => @PLACE(120, -2796);
// &vss @WIRE(mode="straight") {#X1063:6 %t5387:p};
// %t5388 = $IO_PORT @ATTACH &n1287 => @PLACE(-11, -2814) => @ORIENT("R0");
// %t5388 @TEXT("n1287", key="name", size=0.75);
// &n1287 @WIRE(mode="straight") {#X1064:1 %t5388:p};
// %t5389 = $IO_PORT @ATTACH &n465 => @PLACE(-11, -2818) => @ORIENT("R0");
// %t5389 @TEXT("n465", key="name", size=0.75);
// &n465 @WIRE(mode="straight") {#X1064:2 %t5389:p};
// %t5390 = $IO_PORT @ATTACH &n1117 => @PLACE(-11, -2822) => @ORIENT("R0");
// %t5390 @TEXT("n1117", key="name", size=0.75);
// &n1117 @WIRE(mode="straight") {#X1064:3 %t5390:p};
// %t5391 = $IO_PORT @ATTACH &n1295 => @PLACE(10, -2818) => @ORIENT("MY");
// %t5391 @TEXT("n1295", key="name", size=0.75);
// &n1295 @WIRE(mode="straight") {#X1064:4 %t5391:p};
// %t5392 = $SUPPLY @ATTACH &vdd => @PLACE(0, -2805);
// &vdd @WIRE(mode="straight") {#X1064:5 %t5392:p};
// %t5393 = $GROUND @ATTACH &vss => @PLACE(0, -2831);
// &vss @WIRE(mode="straight") {#X1064:6 %t5393:p};
// %t5394 = $IO_PORT @ATTACH &n1288 => @PLACE(30, -2814) => @ORIENT("R0");
// %t5394 @TEXT("n1288", key="name", size=0.75);
// &n1288 @WIRE(mode="straight") {#X1065:1 %t5394:p};
// %t5395 = $IO_PORT @ATTACH &n468 => @PLACE(30, -2818) => @ORIENT("R0");
// %t5395 @TEXT("n468", key="name", size=0.75);
// &n468 @WIRE(mode="straight") {#X1065:2 %t5395:p};
// %t5396 = $IO_PORT @ATTACH &n1117 => @PLACE(30, -2822) => @ORIENT("R0");
// %t5396 @TEXT("n1117", key="name", size=0.75);
// &n1117 @WIRE(mode="straight") {#X1065:3 %t5396:p};
// %t5397 = $IO_PORT @ATTACH &n1296 => @PLACE(50, -2818) => @ORIENT("MY");
// %t5397 @TEXT("n1296", key="name", size=0.75);
// &n1296 @WIRE(mode="straight") {#X1065:4 %t5397:p};
// %t5398 = $SUPPLY @ATTACH &vdd => @PLACE(40, -2805);
// &vdd @WIRE(mode="straight") {#X1065:5 %t5398:p};
// %t5399 = $GROUND @ATTACH &vss => @PLACE(40, -2831);
// &vss @WIRE(mode="straight") {#X1065:6 %t5399:p};
// %t5400 = $IO_PORT @ATTACH &n1289 => @PLACE(70, -2814) => @ORIENT("R0");
// %t5400 @TEXT("n1289", key="name", size=0.75);
// &n1289 @WIRE(mode="straight") {#X1066:1 %t5400:p};
// %t5401 = $IO_PORT @ATTACH &n471 => @PLACE(70, -2818) => @ORIENT("R0");
// %t5401 @TEXT("n471", key="name", size=0.75);
// &n471 @WIRE(mode="straight") {#X1066:2 %t5401:p};
// %t5402 = $IO_PORT @ATTACH &n1117 => @PLACE(70, -2822) => @ORIENT("R0");
// %t5402 @TEXT("n1117", key="name", size=0.75);
// &n1117 @WIRE(mode="straight") {#X1066:3 %t5402:p};
// %t5403 = $IO_PORT @ATTACH &n1297 => @PLACE(90, -2818) => @ORIENT("MY");
// %t5403 @TEXT("n1297", key="name", size=0.75);
// &n1297 @WIRE(mode="straight") {#X1066:4 %t5403:p};
// %t5404 = $SUPPLY @ATTACH &vdd => @PLACE(80, -2805);
// &vdd @WIRE(mode="straight") {#X1066:5 %t5404:p};
// %t5405 = $GROUND @ATTACH &vss => @PLACE(80, -2831);
// &vss @WIRE(mode="straight") {#X1066:6 %t5405:p};
// %t5406 = $IO_PORT @ATTACH &n1290 => @PLACE(110, -2814) => @ORIENT("R0");
// %t5406 @TEXT("n1290", key="name", size=0.75);
// &n1290 @WIRE(mode="straight") {#X1067:1 %t5406:p};
// %t5407 = $IO_PORT @ATTACH &n473 => @PLACE(110, -2818) => @ORIENT("R0");
// %t5407 @TEXT("n473", key="name", size=0.75);
// &n473 @WIRE(mode="straight") {#X1067:2 %t5407:p};
// %t5408 = $IO_PORT @ATTACH &n1117 => @PLACE(110, -2822) => @ORIENT("R0");
// %t5408 @TEXT("n1117", key="name", size=0.75);
// &n1117 @WIRE(mode="straight") {#X1067:3 %t5408:p};
// %t5409 = $IO_PORT @ATTACH &n1298 => @PLACE(130, -2818) => @ORIENT("MY");
// %t5409 @TEXT("n1298", key="name", size=0.75);
// &n1298 @WIRE(mode="straight") {#X1067:4 %t5409:p};
// %t5410 = $SUPPLY @ATTACH &vdd => @PLACE(120, -2805);
// &vdd @WIRE(mode="straight") {#X1067:5 %t5410:p};
// %t5411 = $GROUND @ATTACH &vss => @PLACE(120, -2831);
// &vss @WIRE(mode="straight") {#X1067:6 %t5411:p};
// %t5412 = $IO_PORT @ATTACH &n1291 => @PLACE(-11, -2849) => @ORIENT("R0");
// %t5412 @TEXT("n1291", key="name", size=0.75);
// &n1291 @WIRE(mode="straight") {#X1068:1 %t5412:p};
// %t5413 = $IO_PORT @ATTACH &n475 => @PLACE(-11, -2853) => @ORIENT("R0");
// %t5413 @TEXT("n475", key="name", size=0.75);
// &n475 @WIRE(mode="straight") {#X1068:2 %t5413:p};
// %t5414 = $IO_PORT @ATTACH &n1117 => @PLACE(-11, -2857) => @ORIENT("R0");
// %t5414 @TEXT("n1117", key="name", size=0.75);
// &n1117 @WIRE(mode="straight") {#X1068:3 %t5414:p};
// %t5415 = $IO_PORT @ATTACH &n1299 => @PLACE(10, -2853) => @ORIENT("MY");
// %t5415 @TEXT("n1299", key="name", size=0.75);
// &n1299 @WIRE(mode="straight") {#X1068:4 %t5415:p};
// %t5416 = $SUPPLY @ATTACH &vdd => @PLACE(0, -2840);
// &vdd @WIRE(mode="straight") {#X1068:5 %t5416:p};
// %t5417 = $GROUND @ATTACH &vss => @PLACE(0, -2866);
// &vss @WIRE(mode="straight") {#X1068:6 %t5417:p};
// %t5418 = $IO_PORT @ATTACH &vss => @PLACE(30, -2849) => @ORIENT("R0");
// %t5418 @TEXT("vss", key="name", size=0.75);
// &vss @WIRE(mode="straight") {#X1069:1 %t5418:p};
// %t5419 = $IO_PORT @ATTACH &n765 => @PLACE(30, -2853) => @ORIENT("R0");
// %t5419 @TEXT("n765", key="name", size=0.75);
// &n765 @WIRE(mode="straight") {#X1069:2 %t5419:p};
// %t5420 = $IO_PORT @ATTACH &n1117 => @PLACE(30, -2857) => @ORIENT("R0");
// %t5420 @TEXT("n1117", key="name", size=0.75);
// &n1117 @WIRE(mode="straight") {#X1069:3 %t5420:p};
// %t5421 = $IO_PORT @ATTACH &n1300 => @PLACE(50, -2853) => @ORIENT("MY");
// %t5421 @TEXT("n1300", key="name", size=0.75);
// &n1300 @WIRE(mode="straight") {#X1069:4 %t5421:p};
// %t5422 = $SUPPLY @ATTACH &vdd => @PLACE(40, -2840);
// &vdd @WIRE(mode="straight") {#X1069:5 %t5422:p};
// %t5423 = $GROUND @ATTACH &vss => @PLACE(40, -2866);
// &vss @WIRE(mode="straight") {#X1069:6 %t5423:p};
// %t5424 = $IO_PORT @ATTACH &n1292 => @PLACE(70, -2849) => @ORIENT("R0");
// %t5424 @TEXT("n1292", key="name", size=0.75);
// &n1292 @WIRE(mode="straight") {#X1070:1 %t5424:p};
// %t5425 = $IO_PORT @ATTACH &vss => @PLACE(70, -2853) => @ORIENT("R0");
// %t5425 @TEXT("vss", key="name", size=0.75);
// &vss @WIRE(mode="straight") {#X1070:2 %t5425:p};
// %t5426 = $IO_PORT @ATTACH &n1121 => @PLACE(70, -2857) => @ORIENT("R0");
// %t5426 @TEXT("n1121", key="name", size=0.75);
// &n1121 @WIRE(mode="straight") {#X1070:3 %t5426:p};
// %t5427 = $IO_PORT @ATTACH &n1301 => @PLACE(90, -2853) => @ORIENT("MY");
// %t5427 @TEXT("n1301", key="name", size=0.75);
// &n1301 @WIRE(mode="straight") {#X1070:4 %t5427:p};
// %t5428 = $SUPPLY @ATTACH &vdd => @PLACE(80, -2840);
// &vdd @WIRE(mode="straight") {#X1070:5 %t5428:p};
// %t5429 = $GROUND @ATTACH &vss => @PLACE(80, -2866);
// &vss @WIRE(mode="straight") {#X1070:6 %t5429:p};
// %t5430 = $IO_PORT @ATTACH &n1293 => @PLACE(110, -2849) => @ORIENT("R0");
// %t5430 @TEXT("n1293", key="name", size=0.75);
// &n1293 @WIRE(mode="straight") {#X1071:1 %t5430:p};
// %t5431 = $IO_PORT @ATTACH &target_k0 => @PLACE(110, -2853) => @ORIENT("R0");
// %t5431 @TEXT("target_k0", key="name", size=0.75);
// &target_k0 @WIRE(mode="straight") {#X1071:2 %t5431:p};
// %t5432 = $IO_PORT @ATTACH &n1121 => @PLACE(110, -2857) => @ORIENT("R0");
// %t5432 @TEXT("n1121", key="name", size=0.75);
// &n1121 @WIRE(mode="straight") {#X1071:3 %t5432:p};
// %t5433 = $IO_PORT @ATTACH &n1302 => @PLACE(130, -2853) => @ORIENT("MY");
// %t5433 @TEXT("n1302", key="name", size=0.75);
// &n1302 @WIRE(mode="straight") {#X1071:4 %t5433:p};
// %t5434 = $SUPPLY @ATTACH &vdd => @PLACE(120, -2840);
// &vdd @WIRE(mode="straight") {#X1071:5 %t5434:p};
// %t5435 = $GROUND @ATTACH &vss => @PLACE(120, -2866);
// &vss @WIRE(mode="straight") {#X1071:6 %t5435:p};
// %t5436 = $IO_PORT @ATTACH &n1294 => @PLACE(-11, -2884) => @ORIENT("R0");
// %t5436 @TEXT("n1294", key="name", size=0.75);
// &n1294 @WIRE(mode="straight") {#X1072:1 %t5436:p};
// %t5437 = $IO_PORT @ATTACH &n462 => @PLACE(-11, -2888) => @ORIENT("R0");
// %t5437 @TEXT("n462", key="name", size=0.75);
// &n462 @WIRE(mode="straight") {#X1072:2 %t5437:p};
// %t5438 = $IO_PORT @ATTACH &n1121 => @PLACE(-11, -2892) => @ORIENT("R0");
// %t5438 @TEXT("n1121", key="name", size=0.75);
// &n1121 @WIRE(mode="straight") {#X1072:3 %t5438:p};
// %t5439 = $IO_PORT @ATTACH &n1303 => @PLACE(10, -2888) => @ORIENT("MY");
// %t5439 @TEXT("n1303", key="name", size=0.75);
// &n1303 @WIRE(mode="straight") {#X1072:4 %t5439:p};
// %t5440 = $SUPPLY @ATTACH &vdd => @PLACE(0, -2875);
// &vdd @WIRE(mode="straight") {#X1072:5 %t5440:p};
// %t5441 = $GROUND @ATTACH &vss => @PLACE(0, -2901);
// &vss @WIRE(mode="straight") {#X1072:6 %t5441:p};
// %t5442 = $IO_PORT @ATTACH &n1295 => @PLACE(30, -2884) => @ORIENT("R0");
// %t5442 @TEXT("n1295", key="name", size=0.75);
// &n1295 @WIRE(mode="straight") {#X1073:1 %t5442:p};
// %t5443 = $IO_PORT @ATTACH &n450 => @PLACE(30, -2888) => @ORIENT("R0");
// %t5443 @TEXT("n450", key="name", size=0.75);
// &n450 @WIRE(mode="straight") {#X1073:2 %t5443:p};
// %t5444 = $IO_PORT @ATTACH &n1121 => @PLACE(30, -2892) => @ORIENT("R0");
// %t5444 @TEXT("n1121", key="name", size=0.75);
// &n1121 @WIRE(mode="straight") {#X1073:3 %t5444:p};
// %t5445 = $IO_PORT @ATTACH &n1304 => @PLACE(50, -2888) => @ORIENT("MY");
// %t5445 @TEXT("n1304", key="name", size=0.75);
// &n1304 @WIRE(mode="straight") {#X1073:4 %t5445:p};
// %t5446 = $SUPPLY @ATTACH &vdd => @PLACE(40, -2875);
// &vdd @WIRE(mode="straight") {#X1073:5 %t5446:p};
// %t5447 = $GROUND @ATTACH &vss => @PLACE(40, -2901);
// &vss @WIRE(mode="straight") {#X1073:6 %t5447:p};
// %t5448 = $IO_PORT @ATTACH &n1296 => @PLACE(70, -2884) => @ORIENT("R0");
// %t5448 @TEXT("n1296", key="name", size=0.75);
// &n1296 @WIRE(mode="straight") {#X1074:1 %t5448:p};
// %t5449 = $IO_PORT @ATTACH &n453 => @PLACE(70, -2888) => @ORIENT("R0");
// %t5449 @TEXT("n453", key="name", size=0.75);
// &n453 @WIRE(mode="straight") {#X1074:2 %t5449:p};
// %t5450 = $IO_PORT @ATTACH &n1121 => @PLACE(70, -2892) => @ORIENT("R0");
// %t5450 @TEXT("n1121", key="name", size=0.75);
// &n1121 @WIRE(mode="straight") {#X1074:3 %t5450:p};
// %t5451 = $IO_PORT @ATTACH &n1305 => @PLACE(90, -2888) => @ORIENT("MY");
// %t5451 @TEXT("n1305", key="name", size=0.75);
// &n1305 @WIRE(mode="straight") {#X1074:4 %t5451:p};
// %t5452 = $SUPPLY @ATTACH &vdd => @PLACE(80, -2875);
// &vdd @WIRE(mode="straight") {#X1074:5 %t5452:p};
// %t5453 = $GROUND @ATTACH &vss => @PLACE(80, -2901);
// &vss @WIRE(mode="straight") {#X1074:6 %t5453:p};
// %t5454 = $IO_PORT @ATTACH &n1297 => @PLACE(110, -2884) => @ORIENT("R0");
// %t5454 @TEXT("n1297", key="name", size=0.75);
// &n1297 @WIRE(mode="straight") {#X1075:1 %t5454:p};
// %t5455 = $IO_PORT @ATTACH &n477 => @PLACE(110, -2888) => @ORIENT("R0");
// %t5455 @TEXT("n477", key="name", size=0.75);
// &n477 @WIRE(mode="straight") {#X1075:2 %t5455:p};
// %t5456 = $IO_PORT @ATTACH &n1121 => @PLACE(110, -2892) => @ORIENT("R0");
// %t5456 @TEXT("n1121", key="name", size=0.75);
// &n1121 @WIRE(mode="straight") {#X1075:3 %t5456:p};
// %t5457 = $IO_PORT @ATTACH &n1306 => @PLACE(130, -2888) => @ORIENT("MY");
// %t5457 @TEXT("n1306", key="name", size=0.75);
// &n1306 @WIRE(mode="straight") {#X1075:4 %t5457:p};
// %t5458 = $SUPPLY @ATTACH &vdd => @PLACE(120, -2875);
// &vdd @WIRE(mode="straight") {#X1075:5 %t5458:p};
// %t5459 = $GROUND @ATTACH &vss => @PLACE(120, -2901);
// &vss @WIRE(mode="straight") {#X1075:6 %t5459:p};
// %t5460 = $IO_PORT @ATTACH &n1298 => @PLACE(-11, -2919) => @ORIENT("R0");
// %t5460 @TEXT("n1298", key="name", size=0.75);
// &n1298 @WIRE(mode="straight") {#X1076:1 %t5460:p};
// %t5461 = $IO_PORT @ATTACH &n479 => @PLACE(-11, -2923) => @ORIENT("R0");
// %t5461 @TEXT("n479", key="name", size=0.75);
// &n479 @WIRE(mode="straight") {#X1076:2 %t5461:p};
// %t5462 = $IO_PORT @ATTACH &n1121 => @PLACE(-11, -2927) => @ORIENT("R0");
// %t5462 @TEXT("n1121", key="name", size=0.75);
// &n1121 @WIRE(mode="straight") {#X1076:3 %t5462:p};
// %t5463 = $IO_PORT @ATTACH &n1307 => @PLACE(10, -2923) => @ORIENT("MY");
// %t5463 @TEXT("n1307", key="name", size=0.75);
// &n1307 @WIRE(mode="straight") {#X1076:4 %t5463:p};
// %t5464 = $SUPPLY @ATTACH &vdd => @PLACE(0, -2910);
// &vdd @WIRE(mode="straight") {#X1076:5 %t5464:p};
// %t5465 = $GROUND @ATTACH &vss => @PLACE(0, -2936);
// &vss @WIRE(mode="straight") {#X1076:6 %t5465:p};
// %t5466 = $IO_PORT @ATTACH &n1299 => @PLACE(30, -2919) => @ORIENT("R0");
// %t5466 @TEXT("n1299", key="name", size=0.75);
// &n1299 @WIRE(mode="straight") {#X1077:1 %t5466:p};
// %t5467 = $IO_PORT @ATTACH &n481 => @PLACE(30, -2923) => @ORIENT("R0");
// %t5467 @TEXT("n481", key="name", size=0.75);
// &n481 @WIRE(mode="straight") {#X1077:2 %t5467:p};
// %t5468 = $IO_PORT @ATTACH &n1121 => @PLACE(30, -2927) => @ORIENT("R0");
// %t5468 @TEXT("n1121", key="name", size=0.75);
// &n1121 @WIRE(mode="straight") {#X1077:3 %t5468:p};
// %t5469 = $IO_PORT @ATTACH &n1308 => @PLACE(50, -2923) => @ORIENT("MY");
// %t5469 @TEXT("n1308", key="name", size=0.75);
// &n1308 @WIRE(mode="straight") {#X1077:4 %t5469:p};
// %t5470 = $SUPPLY @ATTACH &vdd => @PLACE(40, -2910);
// &vdd @WIRE(mode="straight") {#X1077:5 %t5470:p};
// %t5471 = $GROUND @ATTACH &vss => @PLACE(40, -2936);
// &vss @WIRE(mode="straight") {#X1077:6 %t5471:p};
// %t5472 = $IO_PORT @ATTACH &n1300 => @PLACE(70, -2919) => @ORIENT("R0");
// %t5472 @TEXT("n1300", key="name", size=0.75);
// &n1300 @WIRE(mode="straight") {#X1078:1 %t5472:p};
// %t5473 = $IO_PORT @ATTACH &n497 => @PLACE(70, -2923) => @ORIENT("R0");
// %t5473 @TEXT("n497", key="name", size=0.75);
// &n497 @WIRE(mode="straight") {#X1078:2 %t5473:p};
// %t5474 = $IO_PORT @ATTACH &n1121 => @PLACE(70, -2927) => @ORIENT("R0");
// %t5474 @TEXT("n1121", key="name", size=0.75);
// &n1121 @WIRE(mode="straight") {#X1078:3 %t5474:p};
// %t5475 = $IO_PORT @ATTACH &n1309 => @PLACE(90, -2923) => @ORIENT("MY");
// %t5475 @TEXT("n1309", key="name", size=0.75);
// &n1309 @WIRE(mode="straight") {#X1078:4 %t5475:p};
// %t5476 = $SUPPLY @ATTACH &vdd => @PLACE(80, -2910);
// &vdd @WIRE(mode="straight") {#X1078:5 %t5476:p};
// %t5477 = $GROUND @ATTACH &vss => @PLACE(80, -2936);
// &vss @WIRE(mode="straight") {#X1078:6 %t5477:p};
// %t5478 = $IO_PORT @ATTACH &target_k0 => @PLACE(110, -2919) => @ORIENT("R0");
// %t5478 @TEXT("target_k0", key="name", size=0.75);
// &target_k0 @WIRE(mode="straight") {#X1079:1 %t5478:p};
// %t5479 = $IO_PORT @ATTACH &n1301 => @PLACE(110, -2923) => @ORIENT("R0");
// %t5479 @TEXT("n1301", key="name", size=0.75);
// &n1301 @WIRE(mode="straight") {#X1079:2 %t5479:p};
// %t5480 = $IO_PORT @ATTACH &n1061 => @PLACE(110, -2927) => @ORIENT("R0");
// %t5480 @TEXT("n1061", key="name", size=0.75);
// &n1061 @WIRE(mode="straight") {#X1079:3 %t5480:p};
// %t5481 = $IO_PORT @ATTACH &n1310 => @PLACE(130, -2923) => @ORIENT("MY");
// %t5481 @TEXT("n1310", key="name", size=0.75);
// &n1310 @WIRE(mode="straight") {#X1079:4 %t5481:p};
// %t5482 = $SUPPLY @ATTACH &vdd => @PLACE(120, -2910);
// &vdd @WIRE(mode="straight") {#X1079:5 %t5482:p};
// %t5483 = $GROUND @ATTACH &vss => @PLACE(120, -2936);
// &vss @WIRE(mode="straight") {#X1079:6 %t5483:p};
// %t5484 = $IO_PORT @ATTACH &n462 => @PLACE(158, -2744) => @ORIENT("R0");
// %t5484 @TEXT("n462", key="name", size=0.75);
// &n462 @WIRE(mode="straight") {#X1080:1 %t5484:p};
// %t5485 = $IO_PORT @ATTACH &n1302 => @PLACE(158, -2748) => @ORIENT("R0");
// %t5485 @TEXT("n1302", key="name", size=0.75);
// &n1302 @WIRE(mode="straight") {#X1080:2 %t5485:p};
// %t5486 = $IO_PORT @ATTACH &n1061 => @PLACE(158, -2752) => @ORIENT("R0");
// %t5486 @TEXT("n1061", key="name", size=0.75);
// &n1061 @WIRE(mode="straight") {#X1080:3 %t5486:p};
// %t5487 = $IO_PORT @ATTACH &n1311 => @PLACE(178, -2748) => @ORIENT("MY");
// %t5487 @TEXT("n1311", key="name", size=0.75);
// &n1311 @WIRE(mode="straight") {#X1080:4 %t5487:p};
// %t5488 = $SUPPLY @ATTACH &vdd => @PLACE(168, -2735);
// &vdd @WIRE(mode="straight") {#X1080:5 %t5488:p};
// %t5489 = $GROUND @ATTACH &vss => @PLACE(168, -2761);
// &vss @WIRE(mode="straight") {#X1080:6 %t5489:p};
// %t5490 = $IO_PORT @ATTACH &n483 => @PLACE(198, -2744) => @ORIENT("R0");
// %t5490 @TEXT("n483", key="name", size=0.75);
// &n483 @WIRE(mode="straight") {#X1081:1 %t5490:p};
// %t5491 = $IO_PORT @ATTACH &n1303 => @PLACE(198, -2748) => @ORIENT("R0");
// %t5491 @TEXT("n1303", key="name", size=0.75);
// &n1303 @WIRE(mode="straight") {#X1081:2 %t5491:p};
// %t5492 = $IO_PORT @ATTACH &n1061 => @PLACE(198, -2752) => @ORIENT("R0");
// %t5492 @TEXT("n1061", key="name", size=0.75);
// &n1061 @WIRE(mode="straight") {#X1081:3 %t5492:p};
// %t5493 = $IO_PORT @ATTACH &n1312 => @PLACE(218, -2748) => @ORIENT("MY");
// %t5493 @TEXT("n1312", key="name", size=0.75);
// &n1312 @WIRE(mode="straight") {#X1081:4 %t5493:p};
// %t5494 = $SUPPLY @ATTACH &vdd => @PLACE(208, -2735);
// &vdd @WIRE(mode="straight") {#X1081:5 %t5494:p};
// %t5495 = $GROUND @ATTACH &vss => @PLACE(208, -2761);
// &vss @WIRE(mode="straight") {#X1081:6 %t5495:p};
// %t5496 = $IO_PORT @ATTACH &n486 => @PLACE(238, -2744) => @ORIENT("R0");
// %t5496 @TEXT("n486", key="name", size=0.75);
// &n486 @WIRE(mode="straight") {#X1082:1 %t5496:p};
// %t5497 = $IO_PORT @ATTACH &n1304 => @PLACE(238, -2748) => @ORIENT("R0");
// %t5497 @TEXT("n1304", key="name", size=0.75);
// &n1304 @WIRE(mode="straight") {#X1082:2 %t5497:p};
// %t5498 = $IO_PORT @ATTACH &n1061 => @PLACE(238, -2752) => @ORIENT("R0");
// %t5498 @TEXT("n1061", key="name", size=0.75);
// &n1061 @WIRE(mode="straight") {#X1082:3 %t5498:p};
// %t5499 = $IO_PORT @ATTACH &n1313 => @PLACE(258, -2748) => @ORIENT("MY");
// %t5499 @TEXT("n1313", key="name", size=0.75);
// &n1313 @WIRE(mode="straight") {#X1082:4 %t5499:p};
// %t5500 = $SUPPLY @ATTACH &vdd => @PLACE(248, -2735);
// &vdd @WIRE(mode="straight") {#X1082:5 %t5500:p};
// %t5501 = $GROUND @ATTACH &vss => @PLACE(248, -2761);
// &vss @WIRE(mode="straight") {#X1082:6 %t5501:p};
// %t5502 = $IO_PORT @ATTACH &n489 => @PLACE(278, -2744) => @ORIENT("R0");
// %t5502 @TEXT("n489", key="name", size=0.75);
// &n489 @WIRE(mode="straight") {#X1083:1 %t5502:p};
// %t5503 = $IO_PORT @ATTACH &n1305 => @PLACE(278, -2748) => @ORIENT("R0");
// %t5503 @TEXT("n1305", key="name", size=0.75);
// &n1305 @WIRE(mode="straight") {#X1083:2 %t5503:p};
// %t5504 = $IO_PORT @ATTACH &n1061 => @PLACE(278, -2752) => @ORIENT("R0");
// %t5504 @TEXT("n1061", key="name", size=0.75);
// &n1061 @WIRE(mode="straight") {#X1083:3 %t5504:p};
// %t5505 = $IO_PORT @ATTACH &n1314 => @PLACE(298, -2748) => @ORIENT("MY");
// %t5505 @TEXT("n1314", key="name", size=0.75);
// &n1314 @WIRE(mode="straight") {#X1083:4 %t5505:p};
// %t5506 = $SUPPLY @ATTACH &vdd => @PLACE(288, -2735);
// &vdd @WIRE(mode="straight") {#X1083:5 %t5506:p};
// %t5507 = $GROUND @ATTACH &vss => @PLACE(288, -2761);
// &vss @WIRE(mode="straight") {#X1083:6 %t5507:p};
// %t5508 = $IO_PORT @ATTACH &n492 => @PLACE(158, -2779) => @ORIENT("R0");
// %t5508 @TEXT("n492", key="name", size=0.75);
// &n492 @WIRE(mode="straight") {#X1084:1 %t5508:p};
// %t5509 = $IO_PORT @ATTACH &n1306 => @PLACE(158, -2783) => @ORIENT("R0");
// %t5509 @TEXT("n1306", key="name", size=0.75);
// &n1306 @WIRE(mode="straight") {#X1084:2 %t5509:p};
// %t5510 = $IO_PORT @ATTACH &n1061 => @PLACE(158, -2787) => @ORIENT("R0");
// %t5510 @TEXT("n1061", key="name", size=0.75);
// &n1061 @WIRE(mode="straight") {#X1084:3 %t5510:p};
// %t5511 = $IO_PORT @ATTACH &n1315 => @PLACE(178, -2783) => @ORIENT("MY");
// %t5511 @TEXT("n1315", key="name", size=0.75);
// &n1315 @WIRE(mode="straight") {#X1084:4 %t5511:p};
// %t5512 = $SUPPLY @ATTACH &vdd => @PLACE(168, -2770);
// &vdd @WIRE(mode="straight") {#X1084:5 %t5512:p};
// %t5513 = $GROUND @ATTACH &vss => @PLACE(168, -2796);
// &vss @WIRE(mode="straight") {#X1084:6 %t5513:p};
// %t5514 = $IO_PORT @ATTACH &n494 => @PLACE(198, -2779) => @ORIENT("R0");
// %t5514 @TEXT("n494", key="name", size=0.75);
// &n494 @WIRE(mode="straight") {#X1085:1 %t5514:p};
// %t5515 = $IO_PORT @ATTACH &n1307 => @PLACE(198, -2783) => @ORIENT("R0");
// %t5515 @TEXT("n1307", key="name", size=0.75);
// &n1307 @WIRE(mode="straight") {#X1085:2 %t5515:p};
// %t5516 = $IO_PORT @ATTACH &n1061 => @PLACE(198, -2787) => @ORIENT("R0");
// %t5516 @TEXT("n1061", key="name", size=0.75);
// &n1061 @WIRE(mode="straight") {#X1085:3 %t5516:p};
// %t5517 = $IO_PORT @ATTACH &n1316 => @PLACE(218, -2783) => @ORIENT("MY");
// %t5517 @TEXT("n1316", key="name", size=0.75);
// &n1316 @WIRE(mode="straight") {#X1085:4 %t5517:p};
// %t5518 = $SUPPLY @ATTACH &vdd => @PLACE(208, -2770);
// &vdd @WIRE(mode="straight") {#X1085:5 %t5518:p};
// %t5519 = $GROUND @ATTACH &vss => @PLACE(208, -2796);
// &vss @WIRE(mode="straight") {#X1085:6 %t5519:p};
// %t5520 = $IO_PORT @ATTACH &n496 => @PLACE(238, -2779) => @ORIENT("R0");
// %t5520 @TEXT("n496", key="name", size=0.75);
// &n496 @WIRE(mode="straight") {#X1086:1 %t5520:p};
// %t5521 = $IO_PORT @ATTACH &n1308 => @PLACE(238, -2783) => @ORIENT("R0");
// %t5521 @TEXT("n1308", key="name", size=0.75);
// &n1308 @WIRE(mode="straight") {#X1086:2 %t5521:p};
// %t5522 = $IO_PORT @ATTACH &n1061 => @PLACE(238, -2787) => @ORIENT("R0");
// %t5522 @TEXT("n1061", key="name", size=0.75);
// &n1061 @WIRE(mode="straight") {#X1086:3 %t5522:p};
// %t5523 = $IO_PORT @ATTACH &n1317 => @PLACE(258, -2783) => @ORIENT("MY");
// %t5523 @TEXT("n1317", key="name", size=0.75);
// &n1317 @WIRE(mode="straight") {#X1086:4 %t5523:p};
// %t5524 = $SUPPLY @ATTACH &vdd => @PLACE(248, -2770);
// &vdd @WIRE(mode="straight") {#X1086:5 %t5524:p};
// %t5525 = $GROUND @ATTACH &vss => @PLACE(248, -2796);
// &vss @WIRE(mode="straight") {#X1086:6 %t5525:p};
// %t5526 = $IO_PORT @ATTACH &n499 => @PLACE(278, -2779) => @ORIENT("R0");
// %t5526 @TEXT("n499", key="name", size=0.75);
// &n499 @WIRE(mode="straight") {#X1087:1 %t5526:p};
// %t5527 = $IO_PORT @ATTACH &n1309 => @PLACE(278, -2783) => @ORIENT("R0");
// %t5527 @TEXT("n1309", key="name", size=0.75);
// &n1309 @WIRE(mode="straight") {#X1087:2 %t5527:p};
// %t5528 = $IO_PORT @ATTACH &n1061 => @PLACE(278, -2787) => @ORIENT("R0");
// %t5528 @TEXT("n1061", key="name", size=0.75);
// &n1061 @WIRE(mode="straight") {#X1087:3 %t5528:p};
// %t5529 = $IO_PORT @ATTACH &n1318 => @PLACE(298, -2783) => @ORIENT("MY");
// %t5529 @TEXT("n1318", key="name", size=0.75);
// &n1318 @WIRE(mode="straight") {#X1087:4 %t5529:p};
// %t5530 = $SUPPLY @ATTACH &vdd => @PLACE(288, -2770);
// &vdd @WIRE(mode="straight") {#X1087:5 %t5530:p};
// %t5531 = $GROUND @ATTACH &vss => @PLACE(288, -2796);
// &vss @WIRE(mode="straight") {#X1087:6 %t5531:p};
// %t5532 = $IO_PORT @ATTACH &n801 => @PLACE(158, -2814) => @ORIENT("R0");
// %t5532 @TEXT("n801", key="name", size=0.75);
// &n801 @WIRE(mode="straight") {#X1088:1 %t5532:p};
// %t5533 = $IO_PORT @ATTACH &vss => @PLACE(158, -2818) => @ORIENT("R0");
// %t5533 @TEXT("vss", key="name", size=0.75);
// &vss @WIRE(mode="straight") {#X1088:2 %t5533:p};
// %t5534 = $IO_PORT @ATTACH &n1061 => @PLACE(158, -2822) => @ORIENT("R0");
// %t5534 @TEXT("n1061", key="name", size=0.75);
// &n1061 @WIRE(mode="straight") {#X1088:3 %t5534:p};
// %t5535 = $IO_PORT @ATTACH &n1319 => @PLACE(178, -2818) => @ORIENT("MY");
// %t5535 @TEXT("n1319", key="name", size=0.75);
// &n1319 @WIRE(mode="straight") {#X1088:4 %t5535:p};
// %t5536 = $SUPPLY @ATTACH &vdd => @PLACE(168, -2805);
// &vdd @WIRE(mode="straight") {#X1088:5 %t5536:p};
// %t5537 = $GROUND @ATTACH &vss => @PLACE(168, -2831);
// &vss @WIRE(mode="straight") {#X1088:6 %t5537:p};
// %t5538 = $IO_PORT @ATTACH &n1310 => @PLACE(198, -2814) => @ORIENT("R0");
// %t5538 @TEXT("n1310", key="name", size=0.75);
// &n1310 @WIRE(mode="straight") {#X1089:1 %t5538:p};
// %t5539 = $IO_PORT @ATTACH &vss => @PLACE(198, -2818) => @ORIENT("R0");
// %t5539 @TEXT("vss", key="name", size=0.75);
// &vss @WIRE(mode="straight") {#X1089:2 %t5539:p};
// %t5540 = $IO_PORT @ATTACH &n117 => @PLACE(198, -2822) => @ORIENT("R0");
// %t5540 @TEXT("n117", key="name", size=0.75);
// &n117 @WIRE(mode="straight") {#X1089:3 %t5540:p};
// %t5541 = $IO_PORT @ATTACH &n640 => @PLACE(218, -2818) => @ORIENT("MY");
// %t5541 @TEXT("n640", key="name", size=0.75);
// &n640 @WIRE(mode="straight") {#X1089:4 %t5541:p};
// %t5542 = $SUPPLY @ATTACH &vdd => @PLACE(208, -2805);
// &vdd @WIRE(mode="straight") {#X1089:5 %t5542:p};
// %t5543 = $GROUND @ATTACH &vss => @PLACE(208, -2831);
// &vss @WIRE(mode="straight") {#X1089:6 %t5543:p};
// %t5544 = $IO_PORT @ATTACH &n1311 => @PLACE(238, -2814) => @ORIENT("R0");
// %t5544 @TEXT("n1311", key="name", size=0.75);
// &n1311 @WIRE(mode="straight") {#X1090:1 %t5544:p};
// %t5545 = $IO_PORT @ATTACH &vss => @PLACE(238, -2818) => @ORIENT("R0");
// %t5545 @TEXT("vss", key="name", size=0.75);
// &vss @WIRE(mode="straight") {#X1090:2 %t5545:p};
// %t5546 = $IO_PORT @ATTACH &n117 => @PLACE(238, -2822) => @ORIENT("R0");
// %t5546 @TEXT("n117", key="name", size=0.75);
// &n117 @WIRE(mode="straight") {#X1090:3 %t5546:p};
// %t5547 = $IO_PORT @ATTACH &n643 => @PLACE(258, -2818) => @ORIENT("MY");
// %t5547 @TEXT("n643", key="name", size=0.75);
// &n643 @WIRE(mode="straight") {#X1090:4 %t5547:p};
// %t5548 = $SUPPLY @ATTACH &vdd => @PLACE(248, -2805);
// &vdd @WIRE(mode="straight") {#X1090:5 %t5548:p};
// %t5549 = $GROUND @ATTACH &vss => @PLACE(248, -2831);
// &vss @WIRE(mode="straight") {#X1090:6 %t5549:p};
// %t5550 = $IO_PORT @ATTACH &n1312 => @PLACE(278, -2814) => @ORIENT("R0");
// %t5550 @TEXT("n1312", key="name", size=0.75);
// &n1312 @WIRE(mode="straight") {#X1091:1 %t5550:p};
// %t5551 = $IO_PORT @ATTACH &n1310 => @PLACE(278, -2818) => @ORIENT("R0");
// %t5551 @TEXT("n1310", key="name", size=0.75);
// &n1310 @WIRE(mode="straight") {#X1091:2 %t5551:p};
// %t5552 = $IO_PORT @ATTACH &n117 => @PLACE(278, -2822) => @ORIENT("R0");
// %t5552 @TEXT("n117", key="name", size=0.75);
// &n117 @WIRE(mode="straight") {#X1091:3 %t5552:p};
// %t5553 = $IO_PORT @ATTACH &n646 => @PLACE(298, -2818) => @ORIENT("MY");
// %t5553 @TEXT("n646", key="name", size=0.75);
// &n646 @WIRE(mode="straight") {#X1091:4 %t5553:p};
// %t5554 = $SUPPLY @ATTACH &vdd => @PLACE(288, -2805);
// &vdd @WIRE(mode="straight") {#X1091:5 %t5554:p};
// %t5555 = $GROUND @ATTACH &vss => @PLACE(288, -2831);
// &vss @WIRE(mode="straight") {#X1091:6 %t5555:p};
// %t5556 = $IO_PORT @ATTACH &n1313 => @PLACE(158, -2849) => @ORIENT("R0");
// %t5556 @TEXT("n1313", key="name", size=0.75);
// &n1313 @WIRE(mode="straight") {#X1092:1 %t5556:p};
// %t5557 = $IO_PORT @ATTACH &n1311 => @PLACE(158, -2853) => @ORIENT("R0");
// %t5557 @TEXT("n1311", key="name", size=0.75);
// &n1311 @WIRE(mode="straight") {#X1092:2 %t5557:p};
// %t5558 = $IO_PORT @ATTACH &n117 => @PLACE(158, -2857) => @ORIENT("R0");
// %t5558 @TEXT("n117", key="name", size=0.75);
// &n117 @WIRE(mode="straight") {#X1092:3 %t5558:p};
// %t5559 = $IO_PORT @ATTACH &n649 => @PLACE(178, -2853) => @ORIENT("MY");
// %t5559 @TEXT("n649", key="name", size=0.75);
// &n649 @WIRE(mode="straight") {#X1092:4 %t5559:p};
// %t5560 = $SUPPLY @ATTACH &vdd => @PLACE(168, -2840);
// &vdd @WIRE(mode="straight") {#X1092:5 %t5560:p};
// %t5561 = $GROUND @ATTACH &vss => @PLACE(168, -2866);
// &vss @WIRE(mode="straight") {#X1092:6 %t5561:p};
// %t5562 = $IO_PORT @ATTACH &n1314 => @PLACE(198, -2849) => @ORIENT("R0");
// %t5562 @TEXT("n1314", key="name", size=0.75);
// &n1314 @WIRE(mode="straight") {#X1093:1 %t5562:p};
// %t5563 = $IO_PORT @ATTACH &n1312 => @PLACE(198, -2853) => @ORIENT("R0");
// %t5563 @TEXT("n1312", key="name", size=0.75);
// &n1312 @WIRE(mode="straight") {#X1093:2 %t5563:p};
// %t5564 = $IO_PORT @ATTACH &n117 => @PLACE(198, -2857) => @ORIENT("R0");
// %t5564 @TEXT("n117", key="name", size=0.75);
// &n117 @WIRE(mode="straight") {#X1093:3 %t5564:p};
// %t5565 = $IO_PORT @ATTACH &n652 => @PLACE(218, -2853) => @ORIENT("MY");
// %t5565 @TEXT("n652", key="name", size=0.75);
// &n652 @WIRE(mode="straight") {#X1093:4 %t5565:p};
// %t5566 = $SUPPLY @ATTACH &vdd => @PLACE(208, -2840);
// &vdd @WIRE(mode="straight") {#X1093:5 %t5566:p};
// %t5567 = $GROUND @ATTACH &vss => @PLACE(208, -2866);
// &vss @WIRE(mode="straight") {#X1093:6 %t5567:p};
// %t5568 = $IO_PORT @ATTACH &n1315 => @PLACE(238, -2849) => @ORIENT("R0");
// %t5568 @TEXT("n1315", key="name", size=0.75);
// &n1315 @WIRE(mode="straight") {#X1094:1 %t5568:p};
// %t5569 = $IO_PORT @ATTACH &n1313 => @PLACE(238, -2853) => @ORIENT("R0");
// %t5569 @TEXT("n1313", key="name", size=0.75);
// &n1313 @WIRE(mode="straight") {#X1094:2 %t5569:p};
// %t5570 = $IO_PORT @ATTACH &n117 => @PLACE(238, -2857) => @ORIENT("R0");
// %t5570 @TEXT("n117", key="name", size=0.75);
// &n117 @WIRE(mode="straight") {#X1094:3 %t5570:p};
// %t5571 = $IO_PORT @ATTACH &n655 => @PLACE(258, -2853) => @ORIENT("MY");
// %t5571 @TEXT("n655", key="name", size=0.75);
// &n655 @WIRE(mode="straight") {#X1094:4 %t5571:p};
// %t5572 = $SUPPLY @ATTACH &vdd => @PLACE(248, -2840);
// &vdd @WIRE(mode="straight") {#X1094:5 %t5572:p};
// %t5573 = $GROUND @ATTACH &vss => @PLACE(248, -2866);
// &vss @WIRE(mode="straight") {#X1094:6 %t5573:p};
// %t5574 = $IO_PORT @ATTACH &n1316 => @PLACE(278, -2849) => @ORIENT("R0");
// %t5574 @TEXT("n1316", key="name", size=0.75);
// &n1316 @WIRE(mode="straight") {#X1095:1 %t5574:p};
// %t5575 = $IO_PORT @ATTACH &n1314 => @PLACE(278, -2853) => @ORIENT("R0");
// %t5575 @TEXT("n1314", key="name", size=0.75);
// &n1314 @WIRE(mode="straight") {#X1095:2 %t5575:p};
// %t5576 = $IO_PORT @ATTACH &n117 => @PLACE(278, -2857) => @ORIENT("R0");
// %t5576 @TEXT("n117", key="name", size=0.75);
// &n117 @WIRE(mode="straight") {#X1095:3 %t5576:p};
// %t5577 = $IO_PORT @ATTACH &n658 => @PLACE(298, -2853) => @ORIENT("MY");
// %t5577 @TEXT("n658", key="name", size=0.75);
// &n658 @WIRE(mode="straight") {#X1095:4 %t5577:p};
// %t5578 = $SUPPLY @ATTACH &vdd => @PLACE(288, -2840);
// &vdd @WIRE(mode="straight") {#X1095:5 %t5578:p};
// %t5579 = $GROUND @ATTACH &vss => @PLACE(288, -2866);
// &vss @WIRE(mode="straight") {#X1095:6 %t5579:p};
// %t5580 = $IO_PORT @ATTACH &n1317 => @PLACE(158, -2884) => @ORIENT("R0");
// %t5580 @TEXT("n1317", key="name", size=0.75);
// &n1317 @WIRE(mode="straight") {#X1096:1 %t5580:p};
// %t5581 = $IO_PORT @ATTACH &n1315 => @PLACE(158, -2888) => @ORIENT("R0");
// %t5581 @TEXT("n1315", key="name", size=0.75);
// &n1315 @WIRE(mode="straight") {#X1096:2 %t5581:p};
// %t5582 = $IO_PORT @ATTACH &n117 => @PLACE(158, -2892) => @ORIENT("R0");
// %t5582 @TEXT("n117", key="name", size=0.75);
// &n117 @WIRE(mode="straight") {#X1096:3 %t5582:p};
// %t5583 = $IO_PORT @ATTACH &n661 => @PLACE(178, -2888) => @ORIENT("MY");
// %t5583 @TEXT("n661", key="name", size=0.75);
// &n661 @WIRE(mode="straight") {#X1096:4 %t5583:p};
// %t5584 = $SUPPLY @ATTACH &vdd => @PLACE(168, -2875);
// &vdd @WIRE(mode="straight") {#X1096:5 %t5584:p};
// %t5585 = $GROUND @ATTACH &vss => @PLACE(168, -2901);
// &vss @WIRE(mode="straight") {#X1096:6 %t5585:p};
// %t5586 = $IO_PORT @ATTACH &n1318 => @PLACE(198, -2884) => @ORIENT("R0");
// %t5586 @TEXT("n1318", key="name", size=0.75);
// &n1318 @WIRE(mode="straight") {#X1097:1 %t5586:p};
// %t5587 = $IO_PORT @ATTACH &n1316 => @PLACE(198, -2888) => @ORIENT("R0");
// %t5587 @TEXT("n1316", key="name", size=0.75);
// &n1316 @WIRE(mode="straight") {#X1097:2 %t5587:p};
// %t5588 = $IO_PORT @ATTACH &n117 => @PLACE(198, -2892) => @ORIENT("R0");
// %t5588 @TEXT("n117", key="name", size=0.75);
// &n117 @WIRE(mode="straight") {#X1097:3 %t5588:p};
// %t5589 = $IO_PORT @ATTACH &n664 => @PLACE(218, -2888) => @ORIENT("MY");
// %t5589 @TEXT("n664", key="name", size=0.75);
// &n664 @WIRE(mode="straight") {#X1097:4 %t5589:p};
// %t5590 = $SUPPLY @ATTACH &vdd => @PLACE(208, -2875);
// &vdd @WIRE(mode="straight") {#X1097:5 %t5590:p};
// %t5591 = $GROUND @ATTACH &vss => @PLACE(208, -2901);
// &vss @WIRE(mode="straight") {#X1097:6 %t5591:p};
// %t5592 = $IO_PORT @ATTACH &n1319 => @PLACE(238, -2884) => @ORIENT("R0");
// %t5592 @TEXT("n1319", key="name", size=0.75);
// &n1319 @WIRE(mode="straight") {#X1098:1 %t5592:p};
// %t5593 = $IO_PORT @ATTACH &n1317 => @PLACE(238, -2888) => @ORIENT("R0");
// %t5593 @TEXT("n1317", key="name", size=0.75);
// &n1317 @WIRE(mode="straight") {#X1098:2 %t5593:p};
// %t5594 = $IO_PORT @ATTACH &n117 => @PLACE(238, -2892) => @ORIENT("R0");
// %t5594 @TEXT("n117", key="name", size=0.75);
// &n117 @WIRE(mode="straight") {#X1098:3 %t5594:p};
// %t5595 = $IO_PORT @ATTACH &n667 => @PLACE(258, -2888) => @ORIENT("MY");
// %t5595 @TEXT("n667", key="name", size=0.75);
// &n667 @WIRE(mode="straight") {#X1098:4 %t5595:p};
// %t5596 = $SUPPLY @ATTACH &vdd => @PLACE(248, -2875);
// &vdd @WIRE(mode="straight") {#X1098:5 %t5596:p};
// %t5597 = $GROUND @ATTACH &vss => @PLACE(248, -2901);
// &vss @WIRE(mode="straight") {#X1098:6 %t5597:p};
// %t5598 = $IO_PORT @ATTACH &n1031 => @PLACE(278, -2884) => @ORIENT("R0");
// %t5598 @TEXT("n1031", key="name", size=0.75);
// &n1031 @WIRE(mode="straight") {#X1099:1 %t5598:p};
// %t5599 = $IO_PORT @ATTACH &n1107 => @PLACE(278, -2888) => @ORIENT("R0");
// %t5599 @TEXT("n1107", key="name", size=0.75);
// &n1107 @WIRE(mode="straight") {#X1099:2 %t5599:p};
// %t5600 = $IO_PORT @ATTACH &n117 => @PLACE(278, -2892) => @ORIENT("R0");
// %t5600 @TEXT("n117", key="name", size=0.75);
// &n117 @WIRE(mode="straight") {#X1099:3 %t5600:p};
// %t5601 = $IO_PORT @ATTACH &n978 => @PLACE(298, -2888) => @ORIENT("MY");
// %t5601 @TEXT("n978", key="name", size=0.75);
// &n978 @WIRE(mode="straight") {#X1099:4 %t5601:p};
// %t5602 = $SUPPLY @ATTACH &vdd => @PLACE(288, -2875);
// &vdd @WIRE(mode="straight") {#X1099:5 %t5602:p};
// %t5603 = $GROUND @ATTACH &vss => @PLACE(288, -2901);
// &vss @WIRE(mode="straight") {#X1099:6 %t5603:p};
// %t5604 = $IO_PORT @ATTACH &n297 => @PLACE(158, -2919) => @ORIENT("R0");
// %t5604 @TEXT("n297", key="name", size=0.75);
// &n297 @WIRE(mode="straight") {#X1100:1 %t5604:p};
// %t5605 = $IO_PORT @ATTACH &coarse0 => @PLACE(158, -2923) => @ORIENT("R0");
// %t5605 @TEXT("coarse0", key="name", size=0.75);
// &coarse0 @WIRE(mode="straight") {#X1100:2 %t5605:p};
// %t5606 = $IO_PORT @ATTACH &n978 => @PLACE(158, -2927) => @ORIENT("R0");
// %t5606 @TEXT("n978", key="name", size=0.75);
// &n978 @WIRE(mode="straight") {#X1100:3 %t5606:p};
// %t5607 = $IO_PORT @ATTACH &n322 => @PLACE(178, -2923) => @ORIENT("MY");
// %t5607 @TEXT("n322", key="name", size=0.75);
// &n322 @WIRE(mode="straight") {#X1100:4 %t5607:p};
// %t5608 = $SUPPLY @ATTACH &vdd => @PLACE(168, -2910);
// &vdd @WIRE(mode="straight") {#X1100:5 %t5608:p};
// %t5609 = $GROUND @ATTACH &vss => @PLACE(168, -2936);
// &vss @WIRE(mode="straight") {#X1100:6 %t5609:p};
// %t5610 = $IO_PORT @ATTACH &n299 => @PLACE(198, -2919) => @ORIENT("R0");
// %t5610 @TEXT("n299", key="name", size=0.75);
// &n299 @WIRE(mode="straight") {#X1101:1 %t5610:p};
// %t5611 = $IO_PORT @ATTACH &coarse1 => @PLACE(198, -2923) => @ORIENT("R0");
// %t5611 @TEXT("coarse1", key="name", size=0.75);
// &coarse1 @WIRE(mode="straight") {#X1101:2 %t5611:p};
// %t5612 = $IO_PORT @ATTACH &n978 => @PLACE(198, -2927) => @ORIENT("R0");
// %t5612 @TEXT("n978", key="name", size=0.75);
// &n978 @WIRE(mode="straight") {#X1101:3 %t5612:p};
// %t5613 = $IO_PORT @ATTACH &n251 => @PLACE(218, -2923) => @ORIENT("MY");
// %t5613 @TEXT("n251", key="name", size=0.75);
// &n251 @WIRE(mode="straight") {#X1101:4 %t5613:p};
// %t5614 = $SUPPLY @ATTACH &vdd => @PLACE(208, -2910);
// &vdd @WIRE(mode="straight") {#X1101:5 %t5614:p};
// %t5615 = $GROUND @ATTACH &vss => @PLACE(208, -2936);
// &vss @WIRE(mode="straight") {#X1101:6 %t5615:p};
// %t5616 = $IO_PORT @ATTACH &n301 => @PLACE(238, -2919) => @ORIENT("R0");
// %t5616 @TEXT("n301", key="name", size=0.75);
// &n301 @WIRE(mode="straight") {#X1102:1 %t5616:p};
// %t5617 = $IO_PORT @ATTACH &coarse2 => @PLACE(238, -2923) => @ORIENT("R0");
// %t5617 @TEXT("coarse2", key="name", size=0.75);
// &coarse2 @WIRE(mode="straight") {#X1102:2 %t5617:p};
// %t5618 = $IO_PORT @ATTACH &n978 => @PLACE(238, -2927) => @ORIENT("R0");
// %t5618 @TEXT("n978", key="name", size=0.75);
// &n978 @WIRE(mode="straight") {#X1102:3 %t5618:p};
// %t5619 = $IO_PORT @ATTACH &n325 => @PLACE(258, -2923) => @ORIENT("MY");
// %t5619 @TEXT("n325", key="name", size=0.75);
// &n325 @WIRE(mode="straight") {#X1102:4 %t5619:p};
// %t5620 = $SUPPLY @ATTACH &vdd => @PLACE(248, -2910);
// &vdd @WIRE(mode="straight") {#X1102:5 %t5620:p};
// %t5621 = $GROUND @ATTACH &vss => @PLACE(248, -2936);
// &vss @WIRE(mode="straight") {#X1102:6 %t5621:p};
// %t5622 = $IO_PORT @ATTACH &n303 => @PLACE(278, -2919) => @ORIENT("R0");
// %t5622 @TEXT("n303", key="name", size=0.75);
// &n303 @WIRE(mode="straight") {#X1103:1 %t5622:p};
// %t5623 = $IO_PORT @ATTACH &coarse3 => @PLACE(278, -2923) => @ORIENT("R0");
// %t5623 @TEXT("coarse3", key="name", size=0.75);
// &coarse3 @WIRE(mode="straight") {#X1103:2 %t5623:p};
// %t5624 = $IO_PORT @ATTACH &n978 => @PLACE(278, -2927) => @ORIENT("R0");
// %t5624 @TEXT("n978", key="name", size=0.75);
// &n978 @WIRE(mode="straight") {#X1103:3 %t5624:p};
// %t5625 = $IO_PORT @ATTACH &n327 => @PLACE(298, -2923) => @ORIENT("MY");
// %t5625 @TEXT("n327", key="name", size=0.75);
// &n327 @WIRE(mode="straight") {#X1103:4 %t5625:p};
// %t5626 = $SUPPLY @ATTACH &vdd => @PLACE(288, -2910);
// &vdd @WIRE(mode="straight") {#X1103:5 %t5626:p};
// %t5627 = $GROUND @ATTACH &vss => @PLACE(288, -2936);
// &vss @WIRE(mode="straight") {#X1103:6 %t5627:p};
// %t5628 = $IO_PORT @ATTACH &n305 => @PLACE(326, -2744) => @ORIENT("R0");
// %t5628 @TEXT("n305", key="name", size=0.75);
// &n305 @WIRE(mode="straight") {#X1104:1 %t5628:p};
// %t5629 = $IO_PORT @ATTACH &coarse4 => @PLACE(326, -2748) => @ORIENT("R0");
// %t5629 @TEXT("coarse4", key="name", size=0.75);
// &coarse4 @WIRE(mode="straight") {#X1104:2 %t5629:p};
// %t5630 = $IO_PORT @ATTACH &n978 => @PLACE(326, -2752) => @ORIENT("R0");
// %t5630 @TEXT("n978", key="name", size=0.75);
// &n978 @WIRE(mode="straight") {#X1104:3 %t5630:p};
// %t5631 = $IO_PORT @ATTACH &n329 => @PLACE(346, -2748) => @ORIENT("MY");
// %t5631 @TEXT("n329", key="name", size=0.75);
// &n329 @WIRE(mode="straight") {#X1104:4 %t5631:p};
// %t5632 = $SUPPLY @ATTACH &vdd => @PLACE(336, -2735);
// &vdd @WIRE(mode="straight") {#X1104:5 %t5632:p};
// %t5633 = $GROUND @ATTACH &vss => @PLACE(336, -2761);
// &vss @WIRE(mode="straight") {#X1104:6 %t5633:p};
// %t5634 = $IO_PORT @ATTACH &n307 => @PLACE(366, -2744) => @ORIENT("R0");
// %t5634 @TEXT("n307", key="name", size=0.75);
// &n307 @WIRE(mode="straight") {#X1105:1 %t5634:p};
// %t5635 = $IO_PORT @ATTACH &coarse5 => @PLACE(366, -2748) => @ORIENT("R0");
// %t5635 @TEXT("coarse5", key="name", size=0.75);
// &coarse5 @WIRE(mode="straight") {#X1105:2 %t5635:p};
// %t5636 = $IO_PORT @ATTACH &n978 => @PLACE(366, -2752) => @ORIENT("R0");
// %t5636 @TEXT("n978", key="name", size=0.75);
// &n978 @WIRE(mode="straight") {#X1105:3 %t5636:p};
// %t5637 = $IO_PORT @ATTACH &n331 => @PLACE(386, -2748) => @ORIENT("MY");
// %t5637 @TEXT("n331", key="name", size=0.75);
// &n331 @WIRE(mode="straight") {#X1105:4 %t5637:p};
// %t5638 = $SUPPLY @ATTACH &vdd => @PLACE(376, -2735);
// &vdd @WIRE(mode="straight") {#X1105:5 %t5638:p};
// %t5639 = $GROUND @ATTACH &vss => @PLACE(376, -2761);
// &vss @WIRE(mode="straight") {#X1105:6 %t5639:p};
// %t5640 = $IO_PORT @ATTACH &n309 => @PLACE(406, -2744) => @ORIENT("R0");
// %t5640 @TEXT("n309", key="name", size=0.75);
// &n309 @WIRE(mode="straight") {#X1106:1 %t5640:p};
// %t5641 = $IO_PORT @ATTACH &coarse6 => @PLACE(406, -2748) => @ORIENT("R0");
// %t5641 @TEXT("coarse6", key="name", size=0.75);
// &coarse6 @WIRE(mode="straight") {#X1106:2 %t5641:p};
// %t5642 = $IO_PORT @ATTACH &n978 => @PLACE(406, -2752) => @ORIENT("R0");
// %t5642 @TEXT("n978", key="name", size=0.75);
// &n978 @WIRE(mode="straight") {#X1106:3 %t5642:p};
// %t5643 = $IO_PORT @ATTACH &n333 => @PLACE(426, -2748) => @ORIENT("MY");
// %t5643 @TEXT("n333", key="name", size=0.75);
// &n333 @WIRE(mode="straight") {#X1106:4 %t5643:p};
// %t5644 = $SUPPLY @ATTACH &vdd => @PLACE(416, -2735);
// &vdd @WIRE(mode="straight") {#X1106:5 %t5644:p};
// %t5645 = $GROUND @ATTACH &vss => @PLACE(416, -2761);
// &vss @WIRE(mode="straight") {#X1106:6 %t5645:p};
// %t5646 = $IO_PORT @ATTACH &n311 => @PLACE(446, -2744) => @ORIENT("R0");
// %t5646 @TEXT("n311", key="name", size=0.75);
// &n311 @WIRE(mode="straight") {#X1107:1 %t5646:p};
// %t5647 = $IO_PORT @ATTACH &coarse7 => @PLACE(446, -2748) => @ORIENT("R0");
// %t5647 @TEXT("coarse7", key="name", size=0.75);
// &coarse7 @WIRE(mode="straight") {#X1107:2 %t5647:p};
// %t5648 = $IO_PORT @ATTACH &n978 => @PLACE(446, -2752) => @ORIENT("R0");
// %t5648 @TEXT("n978", key="name", size=0.75);
// &n978 @WIRE(mode="straight") {#X1107:3 %t5648:p};
// %t5649 = $IO_PORT @ATTACH &n522 => @PLACE(466, -2748) => @ORIENT("MY");
// %t5649 @TEXT("n522", key="name", size=0.75);
// &n522 @WIRE(mode="straight") {#X1107:4 %t5649:p};
// %t5650 = $SUPPLY @ATTACH &vdd => @PLACE(456, -2735);
// &vdd @WIRE(mode="straight") {#X1107:5 %t5650:p};
// %t5651 = $GROUND @ATTACH &vss => @PLACE(456, -2761);
// &vss @WIRE(mode="straight") {#X1107:6 %t5651:p};
// %t5652 = $IO_PORT @ATTACH &dac0 => @PLACE(326, -2779) => @ORIENT("R0");
// %t5652 @TEXT("dac0", key="name", size=0.75);
// &dac0 @WIRE(mode="straight") {#X1108:1 %t5652:p};
// %t5653 = $IO_PORT @ATTACH &n312 => @PLACE(326, -2783) => @ORIENT("R0");
// %t5653 @TEXT("n312", key="name", size=0.75);
// &n312 @WIRE(mode="straight") {#X1108:2 %t5653:p};
// %t5654 = $IO_PORT @ATTACH &n978 => @PLACE(326, -2787) => @ORIENT("R0");
// %t5654 @TEXT("n978", key="name", size=0.75);
// &n978 @WIRE(mode="straight") {#X1108:3 %t5654:p};
// %t5655 = $IO_PORT @ATTACH &n335 => @PLACE(346, -2783) => @ORIENT("MY");
// %t5655 @TEXT("n335", key="name", size=0.75);
// &n335 @WIRE(mode="straight") {#X1108:4 %t5655:p};
// %t5656 = $SUPPLY @ATTACH &vdd => @PLACE(336, -2770);
// &vdd @WIRE(mode="straight") {#X1108:5 %t5656:p};
// %t5657 = $GROUND @ATTACH &vss => @PLACE(336, -2796);
// &vss @WIRE(mode="straight") {#X1108:6 %t5657:p};
// %t5658 = $IO_PORT @ATTACH &dac1 => @PLACE(366, -2779) => @ORIENT("R0");
// %t5658 @TEXT("dac1", key="name", size=0.75);
// &dac1 @WIRE(mode="straight") {#X1109:1 %t5658:p};
// %t5659 = $IO_PORT @ATTACH &n313 => @PLACE(366, -2783) => @ORIENT("R0");
// %t5659 @TEXT("n313", key="name", size=0.75);
// &n313 @WIRE(mode="straight") {#X1109:2 %t5659:p};
// %t5660 = $IO_PORT @ATTACH &n978 => @PLACE(366, -2787) => @ORIENT("R0");
// %t5660 @TEXT("n978", key="name", size=0.75);
// &n978 @WIRE(mode="straight") {#X1109:3 %t5660:p};
// %t5661 = $IO_PORT @ATTACH &n337 => @PLACE(386, -2783) => @ORIENT("MY");
// %t5661 @TEXT("n337", key="name", size=0.75);
// &n337 @WIRE(mode="straight") {#X1109:4 %t5661:p};
// %t5662 = $SUPPLY @ATTACH &vdd => @PLACE(376, -2770);
// &vdd @WIRE(mode="straight") {#X1109:5 %t5662:p};
// %t5663 = $GROUND @ATTACH &vss => @PLACE(376, -2796);
// &vss @WIRE(mode="straight") {#X1109:6 %t5663:p};
// %t5664 = $IO_PORT @ATTACH &dac2 => @PLACE(406, -2779) => @ORIENT("R0");
// %t5664 @TEXT("dac2", key="name", size=0.75);
// &dac2 @WIRE(mode="straight") {#X1110:1 %t5664:p};
// %t5665 = $IO_PORT @ATTACH &n314 => @PLACE(406, -2783) => @ORIENT("R0");
// %t5665 @TEXT("n314", key="name", size=0.75);
// &n314 @WIRE(mode="straight") {#X1110:2 %t5665:p};
// %t5666 = $IO_PORT @ATTACH &n978 => @PLACE(406, -2787) => @ORIENT("R0");
// %t5666 @TEXT("n978", key="name", size=0.75);
// &n978 @WIRE(mode="straight") {#X1110:3 %t5666:p};
// %t5667 = $IO_PORT @ATTACH &n339 => @PLACE(426, -2783) => @ORIENT("MY");
// %t5667 @TEXT("n339", key="name", size=0.75);
// &n339 @WIRE(mode="straight") {#X1110:4 %t5667:p};
// %t5668 = $SUPPLY @ATTACH &vdd => @PLACE(416, -2770);
// &vdd @WIRE(mode="straight") {#X1110:5 %t5668:p};
// %t5669 = $GROUND @ATTACH &vss => @PLACE(416, -2796);
// &vss @WIRE(mode="straight") {#X1110:6 %t5669:p};
// %t5670 = $IO_PORT @ATTACH &dac3 => @PLACE(446, -2779) => @ORIENT("R0");
// %t5670 @TEXT("dac3", key="name", size=0.75);
// &dac3 @WIRE(mode="straight") {#X1111:1 %t5670:p};
// %t5671 = $IO_PORT @ATTACH &n315 => @PLACE(446, -2783) => @ORIENT("R0");
// %t5671 @TEXT("n315", key="name", size=0.75);
// &n315 @WIRE(mode="straight") {#X1111:2 %t5671:p};
// %t5672 = $IO_PORT @ATTACH &n978 => @PLACE(446, -2787) => @ORIENT("R0");
// %t5672 @TEXT("n978", key="name", size=0.75);
// &n978 @WIRE(mode="straight") {#X1111:3 %t5672:p};
// %t5673 = $IO_PORT @ATTACH &n341 => @PLACE(466, -2783) => @ORIENT("MY");
// %t5673 @TEXT("n341", key="name", size=0.75);
// &n341 @WIRE(mode="straight") {#X1111:4 %t5673:p};
// %t5674 = $SUPPLY @ATTACH &vdd => @PLACE(456, -2770);
// &vdd @WIRE(mode="straight") {#X1111:5 %t5674:p};
// %t5675 = $GROUND @ATTACH &vss => @PLACE(456, -2796);
// &vss @WIRE(mode="straight") {#X1111:6 %t5675:p};
// %t5676 = $IO_PORT @ATTACH &dac4 => @PLACE(326, -2814) => @ORIENT("R0");
// %t5676 @TEXT("dac4", key="name", size=0.75);
// &dac4 @WIRE(mode="straight") {#X1112:1 %t5676:p};
// %t5677 = $IO_PORT @ATTACH &n316 => @PLACE(326, -2818) => @ORIENT("R0");
// %t5677 @TEXT("n316", key="name", size=0.75);
// &n316 @WIRE(mode="straight") {#X1112:2 %t5677:p};
// %t5678 = $IO_PORT @ATTACH &n978 => @PLACE(326, -2822) => @ORIENT("R0");
// %t5678 @TEXT("n978", key="name", size=0.75);
// &n978 @WIRE(mode="straight") {#X1112:3 %t5678:p};
// %t5679 = $IO_PORT @ATTACH &n343 => @PLACE(346, -2818) => @ORIENT("MY");
// %t5679 @TEXT("n343", key="name", size=0.75);
// &n343 @WIRE(mode="straight") {#X1112:4 %t5679:p};
// %t5680 = $SUPPLY @ATTACH &vdd => @PLACE(336, -2805);
// &vdd @WIRE(mode="straight") {#X1112:5 %t5680:p};
// %t5681 = $GROUND @ATTACH &vss => @PLACE(336, -2831);
// &vss @WIRE(mode="straight") {#X1112:6 %t5681:p};
// %t5682 = $IO_PORT @ATTACH &vss => @PLACE(366, -2814) => @ORIENT("R0");
// %t5682 @TEXT("vss", key="name", size=0.75);
// &vss @WIRE(mode="straight") {#X1113:1 %t5682:p};
// %t5683 = $IO_PORT @ATTACH &n317 => @PLACE(366, -2818) => @ORIENT("R0");
// %t5683 @TEXT("n317", key="name", size=0.75);
// &n317 @WIRE(mode="straight") {#X1113:2 %t5683:p};
// %t5684 = $IO_PORT @ATTACH &n978 => @PLACE(366, -2822) => @ORIENT("R0");
// %t5684 @TEXT("n978", key="name", size=0.75);
// &n978 @WIRE(mode="straight") {#X1113:3 %t5684:p};
// %t5685 = $IO_PORT @ATTACH &n1320 => @PLACE(386, -2818) => @ORIENT("MY");
// %t5685 @TEXT("n1320", key="name", size=0.75);
// &n1320 @WIRE(mode="straight") {#X1113:4 %t5685:p};
// %t5686 = $SUPPLY @ATTACH &vdd => @PLACE(376, -2805);
// &vdd @WIRE(mode="straight") {#X1113:5 %t5686:p};
// %t5687 = $GROUND @ATTACH &vss => @PLACE(376, -2831);
// &vss @WIRE(mode="straight") {#X1113:6 %t5687:p};
// %t5688 = $IO_PORT @ATTACH &n404 => @PLACE(406, -2814) => @ORIENT("R0");
// %t5688 @TEXT("n404", key="name", size=0.75);
// &n404 @WIRE(mode="straight") {#X1114:1 %t5688:p};
// %t5689 = $IO_PORT @ATTACH &measured1 => @PLACE(406, -2818) => @ORIENT("R0");
// %t5689 @TEXT("measured1", key="name", size=0.75);
// &measured1 @WIRE(mode="straight") {#X1114:2 %t5689:p};
// %t5690 = $IO_PORT @ATTACH &n1107 => @PLACE(406, -2822) => @ORIENT("R0");
// %t5690 @TEXT("n1107", key="name", size=0.75);
// &n1107 @WIRE(mode="straight") {#X1114:3 %t5690:p};
// %t5691 = $IO_PORT @ATTACH &n269 => @PLACE(426, -2818) => @ORIENT("MY");
// %t5691 @TEXT("n269", key="name", size=0.75);
// &n269 @WIRE(mode="straight") {#X1114:4 %t5691:p};
// %t5692 = $SUPPLY @ATTACH &vdd => @PLACE(416, -2805);
// &vdd @WIRE(mode="straight") {#X1114:5 %t5692:p};
// %t5693 = $GROUND @ATTACH &vss => @PLACE(416, -2831);
// &vss @WIRE(mode="straight") {#X1114:6 %t5693:p};
// %t5694 = $IO_PORT @ATTACH &n406 => @PLACE(446, -2814) => @ORIENT("R0");
// %t5694 @TEXT("n406", key="name", size=0.75);
// &n406 @WIRE(mode="straight") {#X1115:1 %t5694:p};
// %t5695 = $IO_PORT @ATTACH &measured2 => @PLACE(446, -2818) => @ORIENT("R0");
// %t5695 @TEXT("measured2", key="name", size=0.75);
// &measured2 @WIRE(mode="straight") {#X1115:2 %t5695:p};
// %t5696 = $IO_PORT @ATTACH &n1107 => @PLACE(446, -2822) => @ORIENT("R0");
// %t5696 @TEXT("n1107", key="name", size=0.75);
// &n1107 @WIRE(mode="straight") {#X1115:3 %t5696:p};
// %t5697 = $IO_PORT @ATTACH &n293 => @PLACE(466, -2818) => @ORIENT("MY");
// %t5697 @TEXT("n293", key="name", size=0.75);
// &n293 @WIRE(mode="straight") {#X1115:4 %t5697:p};
// %t5698 = $SUPPLY @ATTACH &vdd => @PLACE(456, -2805);
// &vdd @WIRE(mode="straight") {#X1115:5 %t5698:p};
// %t5699 = $GROUND @ATTACH &vss => @PLACE(456, -2831);
// &vss @WIRE(mode="straight") {#X1115:6 %t5699:p};
// %t5700 = $IO_PORT @ATTACH &n408 => @PLACE(326, -2849) => @ORIENT("R0");
// %t5700 @TEXT("n408", key="name", size=0.75);
// &n408 @WIRE(mode="straight") {#X1116:1 %t5700:p};
// %t5701 = $IO_PORT @ATTACH &measured3 => @PLACE(326, -2853) => @ORIENT("R0");
// %t5701 @TEXT("measured3", key="name", size=0.75);
// &measured3 @WIRE(mode="straight") {#X1116:2 %t5701:p};
// %t5702 = $IO_PORT @ATTACH &n1107 => @PLACE(326, -2857) => @ORIENT("R0");
// %t5702 @TEXT("n1107", key="name", size=0.75);
// &n1107 @WIRE(mode="straight") {#X1116:3 %t5702:p};
// %t5703 = $IO_PORT @ATTACH &n291 => @PLACE(346, -2853) => @ORIENT("MY");
// %t5703 @TEXT("n291", key="name", size=0.75);
// &n291 @WIRE(mode="straight") {#X1116:4 %t5703:p};
// %t5704 = $SUPPLY @ATTACH &vdd => @PLACE(336, -2840);
// &vdd @WIRE(mode="straight") {#X1116:5 %t5704:p};
// %t5705 = $GROUND @ATTACH &vss => @PLACE(336, -2866);
// &vss @WIRE(mode="straight") {#X1116:6 %t5705:p};
// %t5706 = $IO_PORT @ATTACH &n411 => @PLACE(366, -2849) => @ORIENT("R0");
// %t5706 @TEXT("n411", key="name", size=0.75);
// &n411 @WIRE(mode="straight") {#X1117:1 %t5706:p};
// %t5707 = $IO_PORT @ATTACH &n441 => @PLACE(366, -2853) => @ORIENT("R0");
// %t5707 @TEXT("n441", key="name", size=0.75);
// &n441 @WIRE(mode="straight") {#X1117:2 %t5707:p};
// %t5708 = $IO_PORT @ATTACH &n1107 => @PLACE(366, -2857) => @ORIENT("R0");
// %t5708 @TEXT("n1107", key="name", size=0.75);
// &n1107 @WIRE(mode="straight") {#X1117:3 %t5708:p};
// %t5709 = $IO_PORT @ATTACH &n289 => @PLACE(386, -2853) => @ORIENT("MY");
// %t5709 @TEXT("n289", key="name", size=0.75);
// &n289 @WIRE(mode="straight") {#X1117:4 %t5709:p};
// %t5710 = $SUPPLY @ATTACH &vdd => @PLACE(376, -2840);
// &vdd @WIRE(mode="straight") {#X1117:5 %t5710:p};
// %t5711 = $GROUND @ATTACH &vss => @PLACE(376, -2866);
// &vss @WIRE(mode="straight") {#X1117:6 %t5711:p};
// %t5712 = $IO_PORT @ATTACH &n414 => @PLACE(406, -2849) => @ORIENT("R0");
// %t5712 @TEXT("n414", key="name", size=0.75);
// &n414 @WIRE(mode="straight") {#X1118:1 %t5712:p};
// %t5713 = $IO_PORT @ATTACH &n444 => @PLACE(406, -2853) => @ORIENT("R0");
// %t5713 @TEXT("n444", key="name", size=0.75);
// &n444 @WIRE(mode="straight") {#X1118:2 %t5713:p};
// %t5714 = $IO_PORT @ATTACH &n1107 => @PLACE(406, -2857) => @ORIENT("R0");
// %t5714 @TEXT("n1107", key="name", size=0.75);
// &n1107 @WIRE(mode="straight") {#X1118:3 %t5714:p};
// %t5715 = $IO_PORT @ATTACH &n287 => @PLACE(426, -2853) => @ORIENT("MY");
// %t5715 @TEXT("n287", key="name", size=0.75);
// &n287 @WIRE(mode="straight") {#X1118:4 %t5715:p};
// %t5716 = $SUPPLY @ATTACH &vdd => @PLACE(416, -2840);
// &vdd @WIRE(mode="straight") {#X1118:5 %t5716:p};
// %t5717 = $GROUND @ATTACH &vss => @PLACE(416, -2866);
// &vss @WIRE(mode="straight") {#X1118:6 %t5717:p};
// %t5718 = $IO_PORT @ATTACH &n417 => @PLACE(446, -2849) => @ORIENT("R0");
// %t5718 @TEXT("n417", key="name", size=0.75);
// &n417 @WIRE(mode="straight") {#X1119:1 %t5718:p};
// %t5719 = $IO_PORT @ATTACH &n447 => @PLACE(446, -2853) => @ORIENT("R0");
// %t5719 @TEXT("n447", key="name", size=0.75);
// &n447 @WIRE(mode="straight") {#X1119:2 %t5719:p};
// %t5720 = $IO_PORT @ATTACH &n1107 => @PLACE(446, -2857) => @ORIENT("R0");
// %t5720 @TEXT("n1107", key="name", size=0.75);
// &n1107 @WIRE(mode="straight") {#X1119:3 %t5720:p};
// %t5721 = $IO_PORT @ATTACH &n285 => @PLACE(466, -2853) => @ORIENT("MY");
// %t5721 @TEXT("n285", key="name", size=0.75);
// &n285 @WIRE(mode="straight") {#X1119:4 %t5721:p};
// %t5722 = $SUPPLY @ATTACH &vdd => @PLACE(456, -2840);
// &vdd @WIRE(mode="straight") {#X1119:5 %t5722:p};
// %t5723 = $GROUND @ATTACH &vss => @PLACE(456, -2866);
// &vss @WIRE(mode="straight") {#X1119:6 %t5723:p};
// %t5724 = $IO_PORT @ATTACH &n420 => @PLACE(326, -2884) => @ORIENT("R0");
// %t5724 @TEXT("n420", key="name", size=0.75);
// &n420 @WIRE(mode="straight") {#X1120:1 %t5724:p};
// %t5725 = $IO_PORT @ATTACH &n506 => @PLACE(326, -2888) => @ORIENT("R0");
// %t5725 @TEXT("n506", key="name", size=0.75);
// &n506 @WIRE(mode="straight") {#X1120:2 %t5725:p};
// %t5726 = $IO_PORT @ATTACH &n1107 => @PLACE(326, -2892) => @ORIENT("R0");
// %t5726 @TEXT("n1107", key="name", size=0.75);
// &n1107 @WIRE(mode="straight") {#X1120:3 %t5726:p};
// %t5727 = $IO_PORT @ATTACH &n283 => @PLACE(346, -2888) => @ORIENT("MY");
// %t5727 @TEXT("n283", key="name", size=0.75);
// &n283 @WIRE(mode="straight") {#X1120:4 %t5727:p};
// %t5728 = $SUPPLY @ATTACH &vdd => @PLACE(336, -2875);
// &vdd @WIRE(mode="straight") {#X1120:5 %t5728:p};
// %t5729 = $GROUND @ATTACH &vss => @PLACE(336, -2901);
// &vss @WIRE(mode="straight") {#X1120:6 %t5729:p};
// %t5730 = $IO_PORT @ATTACH &n423 => @PLACE(366, -2884) => @ORIENT("R0");
// %t5730 @TEXT("n423", key="name", size=0.75);
// &n423 @WIRE(mode="straight") {#X1121:1 %t5730:p};
// %t5731 = $IO_PORT @ATTACH &n562 => @PLACE(366, -2888) => @ORIENT("R0");
// %t5731 @TEXT("n562", key="name", size=0.75);
// &n562 @WIRE(mode="straight") {#X1121:2 %t5731:p};
// %t5732 = $IO_PORT @ATTACH &n1107 => @PLACE(366, -2892) => @ORIENT("R0");
// %t5732 @TEXT("n1107", key="name", size=0.75);
// &n1107 @WIRE(mode="straight") {#X1121:3 %t5732:p};
// %t5733 = $IO_PORT @ATTACH &n281 => @PLACE(386, -2888) => @ORIENT("MY");
// %t5733 @TEXT("n281", key="name", size=0.75);
// &n281 @WIRE(mode="straight") {#X1121:4 %t5733:p};
// %t5734 = $SUPPLY @ATTACH &vdd => @PLACE(376, -2875);
// &vdd @WIRE(mode="straight") {#X1121:5 %t5734:p};
// %t5735 = $GROUND @ATTACH &vss => @PLACE(376, -2901);
// &vss @WIRE(mode="straight") {#X1121:6 %t5735:p};
// %t5736 = $IO_PORT @ATTACH &n426 => @PLACE(406, -2884) => @ORIENT("R0");
// %t5736 @TEXT("n426", key="name", size=0.75);
// &n426 @WIRE(mode="straight") {#X1122:1 %t5736:p};
// %t5737 = $IO_PORT @ATTACH &n565 => @PLACE(406, -2888) => @ORIENT("R0");
// %t5737 @TEXT("n565", key="name", size=0.75);
// &n565 @WIRE(mode="straight") {#X1122:2 %t5737:p};
// %t5738 = $IO_PORT @ATTACH &n1107 => @PLACE(406, -2892) => @ORIENT("R0");
// %t5738 @TEXT("n1107", key="name", size=0.75);
// &n1107 @WIRE(mode="straight") {#X1122:3 %t5738:p};
// %t5739 = $IO_PORT @ATTACH &n279 => @PLACE(426, -2888) => @ORIENT("MY");
// %t5739 @TEXT("n279", key="name", size=0.75);
// &n279 @WIRE(mode="straight") {#X1122:4 %t5739:p};
// %t5740 = $SUPPLY @ATTACH &vdd => @PLACE(416, -2875);
// &vdd @WIRE(mode="straight") {#X1122:5 %t5740:p};
// %t5741 = $GROUND @ATTACH &vss => @PLACE(416, -2901);
// &vss @WIRE(mode="straight") {#X1122:6 %t5741:p};
// %t5742 = $IO_PORT @ATTACH &n429 => @PLACE(446, -2884) => @ORIENT("R0");
// %t5742 @TEXT("n429", key="name", size=0.75);
// &n429 @WIRE(mode="straight") {#X1123:1 %t5742:p};
// %t5743 = $IO_PORT @ATTACH &n509 => @PLACE(446, -2888) => @ORIENT("R0");
// %t5743 @TEXT("n509", key="name", size=0.75);
// &n509 @WIRE(mode="straight") {#X1123:2 %t5743:p};
// %t5744 = $IO_PORT @ATTACH &n1107 => @PLACE(446, -2892) => @ORIENT("R0");
// %t5744 @TEXT("n1107", key="name", size=0.75);
// &n1107 @WIRE(mode="straight") {#X1123:3 %t5744:p};
// %t5745 = $IO_PORT @ATTACH &n277 => @PLACE(466, -2888) => @ORIENT("MY");
// %t5745 @TEXT("n277", key="name", size=0.75);
// &n277 @WIRE(mode="straight") {#X1123:4 %t5745:p};
// %t5746 = $SUPPLY @ATTACH &vdd => @PLACE(456, -2875);
// &vdd @WIRE(mode="straight") {#X1123:5 %t5746:p};
// %t5747 = $GROUND @ATTACH &vss => @PLACE(456, -2901);
// &vss @WIRE(mode="straight") {#X1123:6 %t5747:p};
// %t5748 = $IO_PORT @ATTACH &n432 => @PLACE(326, -2919) => @ORIENT("R0");
// %t5748 @TEXT("n432", key="name", size=0.75);
// &n432 @WIRE(mode="straight") {#X1124:1 %t5748:p};
// %t5749 = $IO_PORT @ATTACH &n512 => @PLACE(326, -2923) => @ORIENT("R0");
// %t5749 @TEXT("n512", key="name", size=0.75);
// &n512 @WIRE(mode="straight") {#X1124:2 %t5749:p};
// %t5750 = $IO_PORT @ATTACH &n1107 => @PLACE(326, -2927) => @ORIENT("R0");
// %t5750 @TEXT("n1107", key="name", size=0.75);
// &n1107 @WIRE(mode="straight") {#X1124:3 %t5750:p};
// %t5751 = $IO_PORT @ATTACH &n275 => @PLACE(346, -2923) => @ORIENT("MY");
// %t5751 @TEXT("n275", key="name", size=0.75);
// &n275 @WIRE(mode="straight") {#X1124:4 %t5751:p};
// %t5752 = $SUPPLY @ATTACH &vdd => @PLACE(336, -2910);
// &vdd @WIRE(mode="straight") {#X1124:5 %t5752:p};
// %t5753 = $GROUND @ATTACH &vss => @PLACE(336, -2936);
// &vss @WIRE(mode="straight") {#X1124:6 %t5753:p};
// %t5754 = $IO_PORT @ATTACH &n435 => @PLACE(366, -2919) => @ORIENT("R0");
// %t5754 @TEXT("n435", key="name", size=0.75);
// &n435 @WIRE(mode="straight") {#X1125:1 %t5754:p};
// %t5755 = $IO_PORT @ATTACH &n568 => @PLACE(366, -2923) => @ORIENT("R0");
// %t5755 @TEXT("n568", key="name", size=0.75);
// &n568 @WIRE(mode="straight") {#X1125:2 %t5755:p};
// %t5756 = $IO_PORT @ATTACH &n1107 => @PLACE(366, -2927) => @ORIENT("R0");
// %t5756 @TEXT("n1107", key="name", size=0.75);
// &n1107 @WIRE(mode="straight") {#X1125:3 %t5756:p};
// %t5757 = $IO_PORT @ATTACH &n273 => @PLACE(386, -2923) => @ORIENT("MY");
// %t5757 @TEXT("n273", key="name", size=0.75);
// &n273 @WIRE(mode="straight") {#X1125:4 %t5757:p};
// %t5758 = $SUPPLY @ATTACH &vdd => @PLACE(376, -2910);
// &vdd @WIRE(mode="straight") {#X1125:5 %t5758:p};
// %t5759 = $GROUND @ATTACH &vss => @PLACE(376, -2936);
// &vss @WIRE(mode="straight") {#X1125:6 %t5759:p};
// %t5760 = $IO_PORT @ATTACH &n438 => @PLACE(406, -2919) => @ORIENT("R0");
// %t5760 @TEXT("n438", key="name", size=0.75);
// &n438 @WIRE(mode="straight") {#X1126:1 %t5760:p};
// %t5761 = $IO_PORT @ATTACH &n571 => @PLACE(406, -2923) => @ORIENT("R0");
// %t5761 @TEXT("n571", key="name", size=0.75);
// &n571 @WIRE(mode="straight") {#X1126:2 %t5761:p};
// %t5762 = $IO_PORT @ATTACH &n1107 => @PLACE(406, -2927) => @ORIENT("R0");
// %t5762 @TEXT("n1107", key="name", size=0.75);
// &n1107 @WIRE(mode="straight") {#X1126:3 %t5762:p};
// %t5763 = $IO_PORT @ATTACH &n271 => @PLACE(426, -2923) => @ORIENT("MY");
// %t5763 @TEXT("n271", key="name", size=0.75);
// &n271 @WIRE(mode="straight") {#X1126:4 %t5763:p};
// %t5764 = $SUPPLY @ATTACH &vdd => @PLACE(416, -2910);
// &vdd @WIRE(mode="straight") {#X1126:5 %t5764:p};
// %t5765 = $GROUND @ATTACH &vss => @PLACE(416, -2936);
// &vss @WIRE(mode="straight") {#X1126:6 %t5765:p};
// %t5766 = $IO_PORT @ATTACH &n322 => @PLACE(446, -2919) => @ORIENT("R0");
// %t5766 @TEXT("n322", key="name", size=0.75);
// &n322 @WIRE(mode="straight") {#X1127:1 %t5766:p};
// %t5767 = $IO_PORT @ATTACH &vdd => @PLACE(446, -2923) => @ORIENT("R0");
// %t5767 @TEXT("vdd", key="name", size=0.75);
// &vdd @WIRE(mode="straight") {#X1127:2 %t5767:p};
// %t5768 = $IO_PORT @ATTACH &n1132 => @PLACE(446, -2927) => @ORIENT("R0");
// %t5768 @TEXT("n1132", key="name", size=0.75);
// &n1132 @WIRE(mode="straight") {#X1127:3 %t5768:p};
// %t5769 = $IO_PORT @ATTACH &n1321 => @PLACE(466, -2923) => @ORIENT("MY");
// %t5769 @TEXT("n1321", key="name", size=0.75);
// &n1321 @WIRE(mode="straight") {#X1127:4 %t5769:p};
// %t5770 = $SUPPLY @ATTACH &vdd => @PLACE(456, -2910);
// &vdd @WIRE(mode="straight") {#X1127:5 %t5770:p};
// %t5771 = $GROUND @ATTACH &vss => @PLACE(456, -2936);
// &vss @WIRE(mode="straight") {#X1127:6 %t5771:p};
// %t5772 = $IO_PORT @ATTACH &n252 => @PLACE(494, -2744) => @ORIENT("R0");
// %t5772 @TEXT("n252", key="name", size=0.75);
// &n252 @WIRE(mode="straight") {#X1128:1 %t5772:p};
// %t5773 = $IO_PORT @ATTACH &vdd => @PLACE(494, -2748) => @ORIENT("R0");
// %t5773 @TEXT("vdd", key="name", size=0.75);
// &vdd @WIRE(mode="straight") {#X1128:2 %t5773:p};
// %t5774 = $IO_PORT @ATTACH &n1132 => @PLACE(494, -2752) => @ORIENT("R0");
// %t5774 @TEXT("n1132", key="name", size=0.75);
// &n1132 @WIRE(mode="straight") {#X1128:3 %t5774:p};
// %t5775 = $IO_PORT @ATTACH &n1322 => @PLACE(514, -2748) => @ORIENT("MY");
// %t5775 @TEXT("n1322", key="name", size=0.75);
// &n1322 @WIRE(mode="straight") {#X1128:4 %t5775:p};
// %t5776 = $SUPPLY @ATTACH &vdd => @PLACE(504, -2735);
// &vdd @WIRE(mode="straight") {#X1128:5 %t5776:p};
// %t5777 = $GROUND @ATTACH &vss => @PLACE(504, -2761);
// &vss @WIRE(mode="straight") {#X1128:6 %t5777:p};
// %t5778 = $IO_PORT @ATTACH &n513 => @PLACE(534, -2744) => @ORIENT("R0");
// %t5778 @TEXT("n513", key="name", size=0.75);
// &n513 @WIRE(mode="straight") {#X1129:1 %t5778:p};
// %t5779 = $IO_PORT @ATTACH &vdd => @PLACE(534, -2748) => @ORIENT("R0");
// %t5779 @TEXT("vdd", key="name", size=0.75);
// &vdd @WIRE(mode="straight") {#X1129:2 %t5779:p};
// %t5780 = $IO_PORT @ATTACH &n1132 => @PLACE(534, -2752) => @ORIENT("R0");
// %t5780 @TEXT("n1132", key="name", size=0.75);
// &n1132 @WIRE(mode="straight") {#X1129:3 %t5780:p};
// %t5781 = $IO_PORT @ATTACH &n1323 => @PLACE(554, -2748) => @ORIENT("MY");
// %t5781 @TEXT("n1323", key="name", size=0.75);
// &n1323 @WIRE(mode="straight") {#X1129:4 %t5781:p};
// %t5782 = $SUPPLY @ATTACH &vdd => @PLACE(544, -2735);
// &vdd @WIRE(mode="straight") {#X1129:5 %t5782:p};
// %t5783 = $GROUND @ATTACH &vss => @PLACE(544, -2761);
// &vss @WIRE(mode="straight") {#X1129:6 %t5783:p};
// %t5784 = $IO_PORT @ATTACH &n515 => @PLACE(574, -2744) => @ORIENT("R0");
// %t5784 @TEXT("n515", key="name", size=0.75);
// &n515 @WIRE(mode="straight") {#X1130:1 %t5784:p};
// %t5785 = $IO_PORT @ATTACH &vdd => @PLACE(574, -2748) => @ORIENT("R0");
// %t5785 @TEXT("vdd", key="name", size=0.75);
// &vdd @WIRE(mode="straight") {#X1130:2 %t5785:p};
// %t5786 = $IO_PORT @ATTACH &n1132 => @PLACE(574, -2752) => @ORIENT("R0");
// %t5786 @TEXT("n1132", key="name", size=0.75);
// &n1132 @WIRE(mode="straight") {#X1130:3 %t5786:p};
// %t5787 = $IO_PORT @ATTACH &n1324 => @PLACE(594, -2748) => @ORIENT("MY");
// %t5787 @TEXT("n1324", key="name", size=0.75);
// &n1324 @WIRE(mode="straight") {#X1130:4 %t5787:p};
// %t5788 = $SUPPLY @ATTACH &vdd => @PLACE(584, -2735);
// &vdd @WIRE(mode="straight") {#X1130:5 %t5788:p};
// %t5789 = $GROUND @ATTACH &vss => @PLACE(584, -2761);
// &vss @WIRE(mode="straight") {#X1130:6 %t5789:p};
// %t5790 = $IO_PORT @ATTACH &n517 => @PLACE(614, -2744) => @ORIENT("R0");
// %t5790 @TEXT("n517", key="name", size=0.75);
// &n517 @WIRE(mode="straight") {#X1131:1 %t5790:p};
// %t5791 = $IO_PORT @ATTACH &vdd => @PLACE(614, -2748) => @ORIENT("R0");
// %t5791 @TEXT("vdd", key="name", size=0.75);
// &vdd @WIRE(mode="straight") {#X1131:2 %t5791:p};
// %t5792 = $IO_PORT @ATTACH &n1132 => @PLACE(614, -2752) => @ORIENT("R0");
// %t5792 @TEXT("n1132", key="name", size=0.75);
// &n1132 @WIRE(mode="straight") {#X1131:3 %t5792:p};
// %t5793 = $IO_PORT @ATTACH &n1325 => @PLACE(635, -2748) => @ORIENT("MY");
// %t5793 @TEXT("n1325", key="name", size=0.75);
// &n1325 @WIRE(mode="straight") {#X1131:4 %t5793:p};
// %t5794 = $SUPPLY @ATTACH &vdd => @PLACE(624, -2735);
// &vdd @WIRE(mode="straight") {#X1131:5 %t5794:p};
// %t5795 = $GROUND @ATTACH &vss => @PLACE(624, -2761);
// &vss @WIRE(mode="straight") {#X1131:6 %t5795:p};
// %t5796 = $IO_PORT @ATTACH &n519 => @PLACE(494, -2779) => @ORIENT("R0");
// %t5796 @TEXT("n519", key="name", size=0.75);
// &n519 @WIRE(mode="straight") {#X1132:1 %t5796:p};
// %t5797 = $IO_PORT @ATTACH &vdd => @PLACE(494, -2783) => @ORIENT("R0");
// %t5797 @TEXT("vdd", key="name", size=0.75);
// &vdd @WIRE(mode="straight") {#X1132:2 %t5797:p};
// %t5798 = $IO_PORT @ATTACH &n1132 => @PLACE(494, -2787) => @ORIENT("R0");
// %t5798 @TEXT("n1132", key="name", size=0.75);
// &n1132 @WIRE(mode="straight") {#X1132:3 %t5798:p};
// %t5799 = $IO_PORT @ATTACH &n1326 => @PLACE(514, -2783) => @ORIENT("MY");
// %t5799 @TEXT("n1326", key="name", size=0.75);
// &n1326 @WIRE(mode="straight") {#X1132:4 %t5799:p};
// %t5800 = $SUPPLY @ATTACH &vdd => @PLACE(504, -2770);
// &vdd @WIRE(mode="straight") {#X1132:5 %t5800:p};
// %t5801 = $GROUND @ATTACH &vss => @PLACE(504, -2796);
// &vss @WIRE(mode="straight") {#X1132:6 %t5801:p};
// %t5802 = $IO_PORT @ATTACH &n521 => @PLACE(534, -2779) => @ORIENT("R0");
// %t5802 @TEXT("n521", key="name", size=0.75);
// &n521 @WIRE(mode="straight") {#X1133:1 %t5802:p};
// %t5803 = $IO_PORT @ATTACH &vdd => @PLACE(534, -2783) => @ORIENT("R0");
// %t5803 @TEXT("vdd", key="name", size=0.75);
// &vdd @WIRE(mode="straight") {#X1133:2 %t5803:p};
// %t5804 = $IO_PORT @ATTACH &n1132 => @PLACE(534, -2787) => @ORIENT("R0");
// %t5804 @TEXT("n1132", key="name", size=0.75);
// &n1132 @WIRE(mode="straight") {#X1133:3 %t5804:p};
// %t5805 = $IO_PORT @ATTACH &n1327 => @PLACE(554, -2783) => @ORIENT("MY");
// %t5805 @TEXT("n1327", key="name", size=0.75);
// &n1327 @WIRE(mode="straight") {#X1133:4 %t5805:p};
// %t5806 = $SUPPLY @ATTACH &vdd => @PLACE(544, -2770);
// &vdd @WIRE(mode="straight") {#X1133:5 %t5806:p};
// %t5807 = $GROUND @ATTACH &vss => @PLACE(544, -2796);
// &vss @WIRE(mode="straight") {#X1133:6 %t5807:p};
// %t5808 = $IO_PORT @ATTACH &n524 => @PLACE(574, -2779) => @ORIENT("R0");
// %t5808 @TEXT("n524", key="name", size=0.75);
// &n524 @WIRE(mode="straight") {#X1134:1 %t5808:p};
// %t5809 = $IO_PORT @ATTACH &vdd => @PLACE(574, -2783) => @ORIENT("R0");
// %t5809 @TEXT("vdd", key="name", size=0.75);
// &vdd @WIRE(mode="straight") {#X1134:2 %t5809:p};
// %t5810 = $IO_PORT @ATTACH &n1132 => @PLACE(574, -2787) => @ORIENT("R0");
// %t5810 @TEXT("n1132", key="name", size=0.75);
// &n1132 @WIRE(mode="straight") {#X1134:3 %t5810:p};
// %t5811 = $IO_PORT @ATTACH &n1328 => @PLACE(594, -2783) => @ORIENT("MY");
// %t5811 @TEXT("n1328", key="name", size=0.75);
// &n1328 @WIRE(mode="straight") {#X1134:4 %t5811:p};
// %t5812 = $SUPPLY @ATTACH &vdd => @PLACE(584, -2770);
// &vdd @WIRE(mode="straight") {#X1134:5 %t5812:p};
// %t5813 = $GROUND @ATTACH &vss => @PLACE(584, -2796);
// &vss @WIRE(mode="straight") {#X1134:6 %t5813:p};
// %t5814 = $IO_PORT @ATTACH &n539 => @PLACE(614, -2779) => @ORIENT("R0");
// %t5814 @TEXT("n539", key="name", size=0.75);
// &n539 @WIRE(mode="straight") {#X1135:1 %t5814:p};
// %t5815 = $IO_PORT @ATTACH &n525 => @PLACE(614, -2783) => @ORIENT("R0");
// %t5815 @TEXT("n525", key="name", size=0.75);
// &n525 @WIRE(mode="straight") {#X1135:2 %t5815:p};
// %t5816 = $IO_PORT @ATTACH &n1270 => @PLACE(614, -2787) => @ORIENT("R0");
// %t5816 @TEXT("n1270", key="name", size=0.75);
// &n1270 @WIRE(mode="straight") {#X1135:3 %t5816:p};
// %t5817 = $IO_PORT @ATTACH &n1329 => @PLACE(635, -2783) => @ORIENT("MY");
// %t5817 @TEXT("n1329", key="name", size=0.75);
// &n1329 @WIRE(mode="straight") {#X1135:4 %t5817:p};
// %t5818 = $SUPPLY @ATTACH &vdd => @PLACE(624, -2770);
// &vdd @WIRE(mode="straight") {#X1135:5 %t5818:p};
// %t5819 = $GROUND @ATTACH &vss => @PLACE(624, -2796);
// &vss @WIRE(mode="straight") {#X1135:6 %t5819:p};
// %t5820 = $IO_PORT @ATTACH &n542 => @PLACE(494, -2814) => @ORIENT("R0");
// %t5820 @TEXT("n542", key="name", size=0.75);
// &n542 @WIRE(mode="straight") {#X1136:1 %t5820:p};
// %t5821 = $IO_PORT @ATTACH &n527 => @PLACE(494, -2818) => @ORIENT("R0");
// %t5821 @TEXT("n527", key="name", size=0.75);
// &n527 @WIRE(mode="straight") {#X1136:2 %t5821:p};
// %t5822 = $IO_PORT @ATTACH &n1270 => @PLACE(494, -2822) => @ORIENT("R0");
// %t5822 @TEXT("n1270", key="name", size=0.75);
// &n1270 @WIRE(mode="straight") {#X1136:3 %t5822:p};
// %t5823 = $IO_PORT @ATTACH &n1330 => @PLACE(514, -2818) => @ORIENT("MY");
// %t5823 @TEXT("n1330", key="name", size=0.75);
// &n1330 @WIRE(mode="straight") {#X1136:4 %t5823:p};
// %t5824 = $SUPPLY @ATTACH &vdd => @PLACE(504, -2805);
// &vdd @WIRE(mode="straight") {#X1136:5 %t5824:p};
// %t5825 = $GROUND @ATTACH &vss => @PLACE(504, -2831);
// &vss @WIRE(mode="straight") {#X1136:6 %t5825:p};
// %t5826 = $IO_PORT @ATTACH &n545 => @PLACE(534, -2814) => @ORIENT("R0");
// %t5826 @TEXT("n545", key="name", size=0.75);
// &n545 @WIRE(mode="straight") {#X1137:1 %t5826:p};
// %t5827 = $IO_PORT @ATTACH &n529 => @PLACE(534, -2818) => @ORIENT("R0");
// %t5827 @TEXT("n529", key="name", size=0.75);
// &n529 @WIRE(mode="straight") {#X1137:2 %t5827:p};
// %t5828 = $IO_PORT @ATTACH &n1270 => @PLACE(534, -2822) => @ORIENT("R0");
// %t5828 @TEXT("n1270", key="name", size=0.75);
// &n1270 @WIRE(mode="straight") {#X1137:3 %t5828:p};
// %t5829 = $IO_PORT @ATTACH &n1331 => @PLACE(554, -2818) => @ORIENT("MY");
// %t5829 @TEXT("n1331", key="name", size=0.75);
// &n1331 @WIRE(mode="straight") {#X1137:4 %t5829:p};
// %t5830 = $SUPPLY @ATTACH &vdd => @PLACE(544, -2805);
// &vdd @WIRE(mode="straight") {#X1137:5 %t5830:p};
// %t5831 = $GROUND @ATTACH &vss => @PLACE(544, -2831);
// &vss @WIRE(mode="straight") {#X1137:6 %t5831:p};
// %t5832 = $IO_PORT @ATTACH &n548 => @PLACE(574, -2814) => @ORIENT("R0");
// %t5832 @TEXT("n548", key="name", size=0.75);
// &n548 @WIRE(mode="straight") {#X1138:1 %t5832:p};
// %t5833 = $IO_PORT @ATTACH &n531 => @PLACE(574, -2818) => @ORIENT("R0");
// %t5833 @TEXT("n531", key="name", size=0.75);
// &n531 @WIRE(mode="straight") {#X1138:2 %t5833:p};
// %t5834 = $IO_PORT @ATTACH &n1270 => @PLACE(574, -2822) => @ORIENT("R0");
// %t5834 @TEXT("n1270", key="name", size=0.75);
// &n1270 @WIRE(mode="straight") {#X1138:3 %t5834:p};
// %t5835 = $IO_PORT @ATTACH &n1332 => @PLACE(594, -2818) => @ORIENT("MY");
// %t5835 @TEXT("n1332", key="name", size=0.75);
// &n1332 @WIRE(mode="straight") {#X1138:4 %t5835:p};
// %t5836 = $SUPPLY @ATTACH &vdd => @PLACE(584, -2805);
// &vdd @WIRE(mode="straight") {#X1138:5 %t5836:p};
// %t5837 = $GROUND @ATTACH &vss => @PLACE(584, -2831);
// &vss @WIRE(mode="straight") {#X1138:6 %t5837:p};
// %t5838 = $IO_PORT @ATTACH &n551 => @PLACE(614, -2814) => @ORIENT("R0");
// %t5838 @TEXT("n551", key="name", size=0.75);
// &n551 @WIRE(mode="straight") {#X1139:1 %t5838:p};
// %t5839 = $IO_PORT @ATTACH &n533 => @PLACE(614, -2818) => @ORIENT("R0");
// %t5839 @TEXT("n533", key="name", size=0.75);
// &n533 @WIRE(mode="straight") {#X1139:2 %t5839:p};
// %t5840 = $IO_PORT @ATTACH &n1270 => @PLACE(614, -2822) => @ORIENT("R0");
// %t5840 @TEXT("n1270", key="name", size=0.75);
// &n1270 @WIRE(mode="straight") {#X1139:3 %t5840:p};
// %t5841 = $IO_PORT @ATTACH &n1333 => @PLACE(635, -2818) => @ORIENT("MY");
// %t5841 @TEXT("n1333", key="name", size=0.75);
// &n1333 @WIRE(mode="straight") {#X1139:4 %t5841:p};
// %t5842 = $SUPPLY @ATTACH &vdd => @PLACE(624, -2805);
// &vdd @WIRE(mode="straight") {#X1139:5 %t5842:p};
// %t5843 = $GROUND @ATTACH &vss => @PLACE(624, -2831);
// &vss @WIRE(mode="straight") {#X1139:6 %t5843:p};
// %t5844 = $IO_PORT @ATTACH &n554 => @PLACE(494, -2849) => @ORIENT("R0");
// %t5844 @TEXT("n554", key="name", size=0.75);
// &n554 @WIRE(mode="straight") {#X1140:1 %t5844:p};
// %t5845 = $IO_PORT @ATTACH &n535 => @PLACE(494, -2853) => @ORIENT("R0");
// %t5845 @TEXT("n535", key="name", size=0.75);
// &n535 @WIRE(mode="straight") {#X1140:2 %t5845:p};
// %t5846 = $IO_PORT @ATTACH &n1270 => @PLACE(494, -2857) => @ORIENT("R0");
// %t5846 @TEXT("n1270", key="name", size=0.75);
// &n1270 @WIRE(mode="straight") {#X1140:3 %t5846:p};
// %t5847 = $IO_PORT @ATTACH &n1334 => @PLACE(514, -2853) => @ORIENT("MY");
// %t5847 @TEXT("n1334", key="name", size=0.75);
// &n1334 @WIRE(mode="straight") {#X1140:4 %t5847:p};
// %t5848 = $SUPPLY @ATTACH &vdd => @PLACE(504, -2840);
// &vdd @WIRE(mode="straight") {#X1140:5 %t5848:p};
// %t5849 = $GROUND @ATTACH &vss => @PLACE(504, -2866);
// &vss @WIRE(mode="straight") {#X1140:6 %t5849:p};
// %t5850 = $IO_PORT @ATTACH &n556 => @PLACE(534, -2849) => @ORIENT("R0");
// %t5850 @TEXT("n556", key="name", size=0.75);
// &n556 @WIRE(mode="straight") {#X1141:1 %t5850:p};
// %t5851 = $IO_PORT @ATTACH &n537 => @PLACE(534, -2853) => @ORIENT("R0");
// %t5851 @TEXT("n537", key="name", size=0.75);
// &n537 @WIRE(mode="straight") {#X1141:2 %t5851:p};
// %t5852 = $IO_PORT @ATTACH &n1270 => @PLACE(534, -2857) => @ORIENT("R0");
// %t5852 @TEXT("n1270", key="name", size=0.75);
// &n1270 @WIRE(mode="straight") {#X1141:3 %t5852:p};
// %t5853 = $IO_PORT @ATTACH &n1335 => @PLACE(554, -2853) => @ORIENT("MY");
// %t5853 @TEXT("n1335", key="name", size=0.75);
// &n1335 @WIRE(mode="straight") {#X1141:4 %t5853:p};
// %t5854 = $SUPPLY @ATTACH &vdd => @PLACE(544, -2840);
// &vdd @WIRE(mode="straight") {#X1141:5 %t5854:p};
// %t5855 = $GROUND @ATTACH &vss => @PLACE(544, -2866);
// &vss @WIRE(mode="straight") {#X1141:6 %t5855:p};
// %t5856 = $IO_PORT @ATTACH &n267 => @PLACE(574, -2849) => @ORIENT("R0");
// %t5856 @TEXT("n267", key="name", size=0.75);
// &n267 @WIRE(mode="straight") {#X1142:1 %t5856:p};
// %t5857 = $IO_PORT @ATTACH &vss => @PLACE(574, -2853) => @ORIENT("R0");
// %t5857 @TEXT("vss", key="name", size=0.75);
// &vss @WIRE(mode="straight") {#X1142:2 %t5857:p};
// %t5858 = $IO_PORT @ATTACH &n243 => @PLACE(574, -2857) => @ORIENT("R0");
// %t5858 @TEXT("n243", key="name", size=0.75);
// &n243 @WIRE(mode="straight") {#X1142:3 %t5858:p};
// %t5859 = $IO_PORT @ATTACH &n1336 => @PLACE(594, -2853) => @ORIENT("MY");
// %t5859 @TEXT("n1336", key="name", size=0.75);
// &n1336 @WIRE(mode="straight") {#X1142:4 %t5859:p};
// %t5860 = $SUPPLY @ATTACH &vdd => @PLACE(584, -2840);
// &vdd @WIRE(mode="straight") {#X1142:5 %t5860:p};
// %t5861 = $GROUND @ATTACH &vss => @PLACE(584, -2866);
// &vss @WIRE(mode="straight") {#X1142:6 %t5861:p};
// %t5862 = $IO_PORT @ATTACH &n501 => @PLACE(614, -2849) => @ORIENT("R0");
// %t5862 @TEXT("n501", key="name", size=0.75);
// &n501 @WIRE(mode="straight") {#X1143:1 %t5862:p};
// %t5863 = $IO_PORT @ATTACH &vss => @PLACE(614, -2853) => @ORIENT("R0");
// %t5863 @TEXT("vss", key="name", size=0.75);
// &vss @WIRE(mode="straight") {#X1143:2 %t5863:p};
// %t5864 = $IO_PORT @ATTACH &n243 => @PLACE(614, -2857) => @ORIENT("R0");
// %t5864 @TEXT("n243", key="name", size=0.75);
// &n243 @WIRE(mode="straight") {#X1143:3 %t5864:p};
// %t5865 = $IO_PORT @ATTACH &n1337 => @PLACE(635, -2853) => @ORIENT("MY");
// %t5865 @TEXT("n1337", key="name", size=0.75);
// &n1337 @WIRE(mode="straight") {#X1143:4 %t5865:p};
// %t5866 = $SUPPLY @ATTACH &vdd => @PLACE(624, -2840);
// &vdd @WIRE(mode="straight") {#X1143:5 %t5866:p};
// %t5867 = $GROUND @ATTACH &vss => @PLACE(624, -2866);
// &vss @WIRE(mode="straight") {#X1143:6 %t5867:p};
// %t5868 = $IO_PORT @ATTACH &n574 => @PLACE(494, -2884) => @ORIENT("R0");
// %t5868 @TEXT("n574", key="name", size=0.75);
// &n574 @WIRE(mode="straight") {#X1144:1 %t5868:p};
// %t5869 = $IO_PORT @ATTACH &vss => @PLACE(494, -2888) => @ORIENT("R0");
// %t5869 @TEXT("vss", key="name", size=0.75);
// &vss @WIRE(mode="straight") {#X1144:2 %t5869:p};
// %t5870 = $IO_PORT @ATTACH &n243 => @PLACE(494, -2892) => @ORIENT("R0");
// %t5870 @TEXT("n243", key="name", size=0.75);
// &n243 @WIRE(mode="straight") {#X1144:3 %t5870:p};
// %t5871 = $IO_PORT @ATTACH &n1338 => @PLACE(514, -2888) => @ORIENT("MY");
// %t5871 @TEXT("n1338", key="name", size=0.75);
// &n1338 @WIRE(mode="straight") {#X1144:4 %t5871:p};
// %t5872 = $SUPPLY @ATTACH &vdd => @PLACE(504, -2875);
// &vdd @WIRE(mode="straight") {#X1144:5 %t5872:p};
// %t5873 = $GROUND @ATTACH &vss => @PLACE(504, -2901);
// &vss @WIRE(mode="straight") {#X1144:6 %t5873:p};
// %t5874 = $IO_PORT @ATTACH &n503 => @PLACE(534, -2884) => @ORIENT("R0");
// %t5874 @TEXT("n503", key="name", size=0.75);
// &n503 @WIRE(mode="straight") {#X1145:1 %t5874:p};
// %t5875 = $IO_PORT @ATTACH &vss => @PLACE(534, -2888) => @ORIENT("R0");
// %t5875 @TEXT("vss", key="name", size=0.75);
// &vss @WIRE(mode="straight") {#X1145:2 %t5875:p};
// %t5876 = $IO_PORT @ATTACH &n243 => @PLACE(534, -2892) => @ORIENT("R0");
// %t5876 @TEXT("n243", key="name", size=0.75);
// &n243 @WIRE(mode="straight") {#X1145:3 %t5876:p};
// %t5877 = $IO_PORT @ATTACH &n1339 => @PLACE(554, -2888) => @ORIENT("MY");
// %t5877 @TEXT("n1339", key="name", size=0.75);
// &n1339 @WIRE(mode="straight") {#X1145:4 %t5877:p};
// %t5878 = $SUPPLY @ATTACH &vdd => @PLACE(544, -2875);
// &vdd @WIRE(mode="straight") {#X1145:5 %t5878:p};
// %t5879 = $GROUND @ATTACH &vss => @PLACE(544, -2901);
// &vss @WIRE(mode="straight") {#X1145:6 %t5879:p};
// %t5880 = $IO_PORT @ATTACH &n577 => @PLACE(574, -2884) => @ORIENT("R0");
// %t5880 @TEXT("n577", key="name", size=0.75);
// &n577 @WIRE(mode="straight") {#X1146:1 %t5880:p};
// %t5881 = $IO_PORT @ATTACH &vss => @PLACE(574, -2888) => @ORIENT("R0");
// %t5881 @TEXT("vss", key="name", size=0.75);
// &vss @WIRE(mode="straight") {#X1146:2 %t5881:p};
// %t5882 = $IO_PORT @ATTACH &n243 => @PLACE(574, -2892) => @ORIENT("R0");
// %t5882 @TEXT("n243", key="name", size=0.75);
// &n243 @WIRE(mode="straight") {#X1146:3 %t5882:p};
// %t5883 = $IO_PORT @ATTACH &n1340 => @PLACE(594, -2888) => @ORIENT("MY");
// %t5883 @TEXT("n1340", key="name", size=0.75);
// &n1340 @WIRE(mode="straight") {#X1146:4 %t5883:p};
// %t5884 = $SUPPLY @ATTACH &vdd => @PLACE(584, -2875);
// &vdd @WIRE(mode="straight") {#X1146:5 %t5884:p};
// %t5885 = $GROUND @ATTACH &vss => @PLACE(584, -2901);
// &vss @WIRE(mode="straight") {#X1146:6 %t5885:p};
// %t5886 = $IO_PORT @ATTACH &n580 => @PLACE(614, -2884) => @ORIENT("R0");
// %t5886 @TEXT("n580", key="name", size=0.75);
// &n580 @WIRE(mode="straight") {#X1147:1 %t5886:p};
// %t5887 = $IO_PORT @ATTACH &vss => @PLACE(614, -2888) => @ORIENT("R0");
// %t5887 @TEXT("vss", key="name", size=0.75);
// &vss @WIRE(mode="straight") {#X1147:2 %t5887:p};
// %t5888 = $IO_PORT @ATTACH &n243 => @PLACE(614, -2892) => @ORIENT("R0");
// %t5888 @TEXT("n243", key="name", size=0.75);
// &n243 @WIRE(mode="straight") {#X1147:3 %t5888:p};
// %t5889 = $IO_PORT @ATTACH &n1341 => @PLACE(635, -2888) => @ORIENT("MY");
// %t5889 @TEXT("n1341", key="name", size=0.75);
// &n1341 @WIRE(mode="straight") {#X1147:4 %t5889:p};
// %t5890 = $SUPPLY @ATTACH &vdd => @PLACE(624, -2875);
// &vdd @WIRE(mode="straight") {#X1147:5 %t5890:p};
// %t5891 = $GROUND @ATTACH &vss => @PLACE(624, -2901);
// &vss @WIRE(mode="straight") {#X1147:6 %t5891:p};
// %t5892 = $IO_PORT @ATTACH &n1336 => @PLACE(494, -2919) => @ORIENT("R0");
// %t5892 @TEXT("n1336", key="name", size=0.75);
// &n1336 @WIRE(mode="straight") {#X1148:1 %t5892:p};
// %t5893 = $IO_PORT @ATTACH &vss => @PLACE(494, -2923) => @ORIENT("R0");
// %t5893 @TEXT("vss", key="name", size=0.75);
// &vss @WIRE(mode="straight") {#X1148:2 %t5893:p};
// %t5894 = $IO_PORT @ATTACH &n351 => @PLACE(494, -2927) => @ORIENT("R0");
// %t5894 @TEXT("n351", key="name", size=0.75);
// &n351 @WIRE(mode="straight") {#X1148:3 %t5894:p};
// %t5895 = $IO_PORT @ATTACH &n1342 => @PLACE(514, -2923) => @ORIENT("MY");
// %t5895 @TEXT("n1342", key="name", size=0.75);
// &n1342 @WIRE(mode="straight") {#X1148:4 %t5895:p};
// %t5896 = $SUPPLY @ATTACH &vdd => @PLACE(504, -2910);
// &vdd @WIRE(mode="straight") {#X1148:5 %t5896:p};
// %t5897 = $GROUND @ATTACH &vss => @PLACE(504, -2936);
// &vss @WIRE(mode="straight") {#X1148:6 %t5897:p};
// %t5898 = $IO_PORT @ATTACH &n1337 => @PLACE(534, -2919) => @ORIENT("R0");
// %t5898 @TEXT("n1337", key="name", size=0.75);
// &n1337 @WIRE(mode="straight") {#X1149:1 %t5898:p};
// %t5899 = $IO_PORT @ATTACH &vss => @PLACE(534, -2923) => @ORIENT("R0");
// %t5899 @TEXT("vss", key="name", size=0.75);
// &vss @WIRE(mode="straight") {#X1149:2 %t5899:p};
// %t5900 = $IO_PORT @ATTACH &n351 => @PLACE(534, -2927) => @ORIENT("R0");
// %t5900 @TEXT("n351", key="name", size=0.75);
// &n351 @WIRE(mode="straight") {#X1149:3 %t5900:p};
// %t5901 = $IO_PORT @ATTACH &n1343 => @PLACE(554, -2923) => @ORIENT("MY");
// %t5901 @TEXT("n1343", key="name", size=0.75);
// &n1343 @WIRE(mode="straight") {#X1149:4 %t5901:p};
// %t5902 = $SUPPLY @ATTACH &vdd => @PLACE(544, -2910);
// &vdd @WIRE(mode="straight") {#X1149:5 %t5902:p};
// %t5903 = $GROUND @ATTACH &vss => @PLACE(544, -2936);
// &vss @WIRE(mode="straight") {#X1149:6 %t5903:p};
// %t5904 = $IO_PORT @ATTACH &n1338 => @PLACE(574, -2919) => @ORIENT("R0");
// %t5904 @TEXT("n1338", key="name", size=0.75);
// &n1338 @WIRE(mode="straight") {#X1150:1 %t5904:p};
// %t5905 = $IO_PORT @ATTACH &vss => @PLACE(574, -2923) => @ORIENT("R0");
// %t5905 @TEXT("vss", key="name", size=0.75);
// &vss @WIRE(mode="straight") {#X1150:2 %t5905:p};
// %t5906 = $IO_PORT @ATTACH &n351 => @PLACE(574, -2927) => @ORIENT("R0");
// %t5906 @TEXT("n351", key="name", size=0.75);
// &n351 @WIRE(mode="straight") {#X1150:3 %t5906:p};
// %t5907 = $IO_PORT @ATTACH &n1344 => @PLACE(594, -2923) => @ORIENT("MY");
// %t5907 @TEXT("n1344", key="name", size=0.75);
// &n1344 @WIRE(mode="straight") {#X1150:4 %t5907:p};
// %t5908 = $SUPPLY @ATTACH &vdd => @PLACE(584, -2910);
// &vdd @WIRE(mode="straight") {#X1150:5 %t5908:p};
// %t5909 = $GROUND @ATTACH &vss => @PLACE(584, -2936);
// &vss @WIRE(mode="straight") {#X1150:6 %t5909:p};
// %t5910 = $IO_PORT @ATTACH &n1339 => @PLACE(614, -2919) => @ORIENT("R0");
// %t5910 @TEXT("n1339", key="name", size=0.75);
// &n1339 @WIRE(mode="straight") {#X1151:1 %t5910:p};
// %t5911 = $IO_PORT @ATTACH &vss => @PLACE(614, -2923) => @ORIENT("R0");
// %t5911 @TEXT("vss", key="name", size=0.75);
// &vss @WIRE(mode="straight") {#X1151:2 %t5911:p};
// %t5912 = $IO_PORT @ATTACH &n351 => @PLACE(614, -2927) => @ORIENT("R0");
// %t5912 @TEXT("n351", key="name", size=0.75);
// &n351 @WIRE(mode="straight") {#X1151:3 %t5912:p};
// %t5913 = $IO_PORT @ATTACH &n1345 => @PLACE(635, -2923) => @ORIENT("MY");
// %t5913 @TEXT("n1345", key="name", size=0.75);
// &n1345 @WIRE(mode="straight") {#X1151:4 %t5913:p};
// %t5914 = $SUPPLY @ATTACH &vdd => @PLACE(624, -2910);
// &vdd @WIRE(mode="straight") {#X1151:5 %t5914:p};
// %t5915 = $GROUND @ATTACH &vss => @PLACE(624, -2936);
// &vss @WIRE(mode="straight") {#X1151:6 %t5915:p};
// %t5916 = $IO_PORT @ATTACH &n1340 => @PLACE(-11, -2964) => @ORIENT("R0");
// %t5916 @TEXT("n1340", key="name", size=0.75);
// &n1340 @WIRE(mode="straight") {#X1152:1 %t5916:p};
// %t5917 = $IO_PORT @ATTACH &vss => @PLACE(-11, -2968) => @ORIENT("R0");
// %t5917 @TEXT("vss", key="name", size=0.75);
// &vss @WIRE(mode="straight") {#X1152:2 %t5917:p};
// %t5918 = $IO_PORT @ATTACH &n351 => @PLACE(-11, -2972) => @ORIENT("R0");
// %t5918 @TEXT("n351", key="name", size=0.75);
// &n351 @WIRE(mode="straight") {#X1152:3 %t5918:p};
// %t5919 = $IO_PORT @ATTACH &n1346 => @PLACE(10, -2968) => @ORIENT("MY");
// %t5919 @TEXT("n1346", key="name", size=0.75);
// &n1346 @WIRE(mode="straight") {#X1152:4 %t5919:p};
// %t5920 = $SUPPLY @ATTACH &vdd => @PLACE(0, -2955);
// &vdd @WIRE(mode="straight") {#X1152:5 %t5920:p};
// %t5921 = $GROUND @ATTACH &vss => @PLACE(0, -2981);
// &vss @WIRE(mode="straight") {#X1152:6 %t5921:p};
// %t5922 = $IO_PORT @ATTACH &n1341 => @PLACE(30, -2964) => @ORIENT("R0");
// %t5922 @TEXT("n1341", key="name", size=0.75);
// &n1341 @WIRE(mode="straight") {#X1153:1 %t5922:p};
// %t5923 = $IO_PORT @ATTACH &vss => @PLACE(30, -2968) => @ORIENT("R0");
// %t5923 @TEXT("vss", key="name", size=0.75);
// &vss @WIRE(mode="straight") {#X1153:2 %t5923:p};
// %t5924 = $IO_PORT @ATTACH &n351 => @PLACE(30, -2972) => @ORIENT("R0");
// %t5924 @TEXT("n351", key="name", size=0.75);
// &n351 @WIRE(mode="straight") {#X1153:3 %t5924:p};
// %t5925 = $IO_PORT @ATTACH &n1347 => @PLACE(50, -2968) => @ORIENT("MY");
// %t5925 @TEXT("n1347", key="name", size=0.75);
// &n1347 @WIRE(mode="straight") {#X1153:4 %t5925:p};
// %t5926 = $SUPPLY @ATTACH &vdd => @PLACE(40, -2955);
// &vdd @WIRE(mode="straight") {#X1153:5 %t5926:p};
// %t5927 = $GROUND @ATTACH &vss => @PLACE(40, -2981);
// &vss @WIRE(mode="straight") {#X1153:6 %t5927:p};
// %t5928 = $IO_PORT @ATTACH &n1342 => @PLACE(70, -2964) => @ORIENT("R0");
// %t5928 @TEXT("n1342", key="name", size=0.75);
// &n1342 @WIRE(mode="straight") {#X1154:1 %t5928:p};
// %t5929 = $IO_PORT @ATTACH &vss => @PLACE(70, -2968) => @ORIENT("R0");
// %t5929 @TEXT("vss", key="name", size=0.75);
// &vss @WIRE(mode="straight") {#X1154:2 %t5929:p};
// %t5930 = $IO_PORT @ATTACH &n236 => @PLACE(70, -2972) => @ORIENT("R0");
// %t5930 @TEXT("n236", key="name", size=0.75);
// &n236 @WIRE(mode="straight") {#X1154:3 %t5930:p};
// %t5931 = $IO_PORT @ATTACH &n1348 => @PLACE(90, -2968) => @ORIENT("MY");
// %t5931 @TEXT("n1348", key="name", size=0.75);
// &n1348 @WIRE(mode="straight") {#X1154:4 %t5931:p};
// %t5932 = $SUPPLY @ATTACH &vdd => @PLACE(80, -2955);
// &vdd @WIRE(mode="straight") {#X1154:5 %t5932:p};
// %t5933 = $GROUND @ATTACH &vss => @PLACE(80, -2981);
// &vss @WIRE(mode="straight") {#X1154:6 %t5933:p};
// %t5934 = $IO_PORT @ATTACH &n1343 => @PLACE(110, -2964) => @ORIENT("R0");
// %t5934 @TEXT("n1343", key="name", size=0.75);
// &n1343 @WIRE(mode="straight") {#X1155:1 %t5934:p};
// %t5935 = $IO_PORT @ATTACH &vss => @PLACE(110, -2968) => @ORIENT("R0");
// %t5935 @TEXT("vss", key="name", size=0.75);
// &vss @WIRE(mode="straight") {#X1155:2 %t5935:p};
// %t5936 = $IO_PORT @ATTACH &n236 => @PLACE(110, -2972) => @ORIENT("R0");
// %t5936 @TEXT("n236", key="name", size=0.75);
// &n236 @WIRE(mode="straight") {#X1155:3 %t5936:p};
// %t5937 = $IO_PORT @ATTACH &n1349 => @PLACE(130, -2968) => @ORIENT("MY");
// %t5937 @TEXT("n1349", key="name", size=0.75);
// &n1349 @WIRE(mode="straight") {#X1155:4 %t5937:p};
// %t5938 = $SUPPLY @ATTACH &vdd => @PLACE(120, -2955);
// &vdd @WIRE(mode="straight") {#X1155:5 %t5938:p};
// %t5939 = $GROUND @ATTACH &vss => @PLACE(120, -2981);
// &vss @WIRE(mode="straight") {#X1155:6 %t5939:p};
// %t5940 = $IO_PORT @ATTACH &n1344 => @PLACE(-11, -2999) => @ORIENT("R0");
// %t5940 @TEXT("n1344", key="name", size=0.75);
// &n1344 @WIRE(mode="straight") {#X1156:1 %t5940:p};
// %t5941 = $IO_PORT @ATTACH &vss => @PLACE(-11, -3003) => @ORIENT("R0");
// %t5941 @TEXT("vss", key="name", size=0.75);
// &vss @WIRE(mode="straight") {#X1156:2 %t5941:p};
// %t5942 = $IO_PORT @ATTACH &n236 => @PLACE(-11, -3007) => @ORIENT("R0");
// %t5942 @TEXT("n236", key="name", size=0.75);
// &n236 @WIRE(mode="straight") {#X1156:3 %t5942:p};
// %t5943 = $IO_PORT @ATTACH &n1350 => @PLACE(10, -3003) => @ORIENT("MY");
// %t5943 @TEXT("n1350", key="name", size=0.75);
// &n1350 @WIRE(mode="straight") {#X1156:4 %t5943:p};
// %t5944 = $SUPPLY @ATTACH &vdd => @PLACE(0, -2990);
// &vdd @WIRE(mode="straight") {#X1156:5 %t5944:p};
// %t5945 = $GROUND @ATTACH &vss => @PLACE(0, -3016);
// &vss @WIRE(mode="straight") {#X1156:6 %t5945:p};
// %t5946 = $IO_PORT @ATTACH &n1345 => @PLACE(30, -2999) => @ORIENT("R0");
// %t5946 @TEXT("n1345", key="name", size=0.75);
// &n1345 @WIRE(mode="straight") {#X1157:1 %t5946:p};
// %t5947 = $IO_PORT @ATTACH &vss => @PLACE(30, -3003) => @ORIENT("R0");
// %t5947 @TEXT("vss", key="name", size=0.75);
// &vss @WIRE(mode="straight") {#X1157:2 %t5947:p};
// %t5948 = $IO_PORT @ATTACH &n236 => @PLACE(30, -3007) => @ORIENT("R0");
// %t5948 @TEXT("n236", key="name", size=0.75);
// &n236 @WIRE(mode="straight") {#X1157:3 %t5948:p};
// %t5949 = $IO_PORT @ATTACH &n1351 => @PLACE(50, -3003) => @ORIENT("MY");
// %t5949 @TEXT("n1351", key="name", size=0.75);
// &n1351 @WIRE(mode="straight") {#X1157:4 %t5949:p};
// %t5950 = $SUPPLY @ATTACH &vdd => @PLACE(40, -2990);
// &vdd @WIRE(mode="straight") {#X1157:5 %t5950:p};
// %t5951 = $GROUND @ATTACH &vss => @PLACE(40, -3016);
// &vss @WIRE(mode="straight") {#X1157:6 %t5951:p};
// %t5952 = $IO_PORT @ATTACH &n1346 => @PLACE(70, -2999) => @ORIENT("R0");
// %t5952 @TEXT("n1346", key="name", size=0.75);
// &n1346 @WIRE(mode="straight") {#X1158:1 %t5952:p};
// %t5953 = $IO_PORT @ATTACH &vss => @PLACE(70, -3003) => @ORIENT("R0");
// %t5953 @TEXT("vss", key="name", size=0.75);
// &vss @WIRE(mode="straight") {#X1158:2 %t5953:p};
// %t5954 = $IO_PORT @ATTACH &n236 => @PLACE(70, -3007) => @ORIENT("R0");
// %t5954 @TEXT("n236", key="name", size=0.75);
// &n236 @WIRE(mode="straight") {#X1158:3 %t5954:p};
// %t5955 = $IO_PORT @ATTACH &n1352 => @PLACE(90, -3003) => @ORIENT("MY");
// %t5955 @TEXT("n1352", key="name", size=0.75);
// &n1352 @WIRE(mode="straight") {#X1158:4 %t5955:p};
// %t5956 = $SUPPLY @ATTACH &vdd => @PLACE(80, -2990);
// &vdd @WIRE(mode="straight") {#X1158:5 %t5956:p};
// %t5957 = $GROUND @ATTACH &vss => @PLACE(80, -3016);
// &vss @WIRE(mode="straight") {#X1158:6 %t5957:p};
// %t5958 = $IO_PORT @ATTACH &n1347 => @PLACE(110, -2999) => @ORIENT("R0");
// %t5958 @TEXT("n1347", key="name", size=0.75);
// &n1347 @WIRE(mode="straight") {#X1159:1 %t5958:p};
// %t5959 = $IO_PORT @ATTACH &vss => @PLACE(110, -3003) => @ORIENT("R0");
// %t5959 @TEXT("vss", key="name", size=0.75);
// &vss @WIRE(mode="straight") {#X1159:2 %t5959:p};
// %t5960 = $IO_PORT @ATTACH &n236 => @PLACE(110, -3007) => @ORIENT("R0");
// %t5960 @TEXT("n236", key="name", size=0.75);
// &n236 @WIRE(mode="straight") {#X1159:3 %t5960:p};
// %t5961 = $IO_PORT @ATTACH &n1353 => @PLACE(130, -3003) => @ORIENT("MY");
// %t5961 @TEXT("n1353", key="name", size=0.75);
// &n1353 @WIRE(mode="straight") {#X1159:4 %t5961:p};
// %t5962 = $SUPPLY @ATTACH &vdd => @PLACE(120, -2990);
// &vdd @WIRE(mode="straight") {#X1159:5 %t5962:p};
// %t5963 = $GROUND @ATTACH &vss => @PLACE(120, -3016);
// &vss @WIRE(mode="straight") {#X1159:6 %t5963:p};
// %t5964 = $IO_PORT @ATTACH &vss => @PLACE(-11, -3034) => @ORIENT("R0");
// %t5964 @TEXT("vss", key="name", size=0.75);
// &vss @WIRE(mode="straight") {#X1160:1 %t5964:p};
// %t5965 = $IO_PORT @ATTACH &n1348 => @PLACE(-11, -3038) => @ORIENT("R0");
// %t5965 @TEXT("n1348", key="name", size=0.75);
// &n1348 @WIRE(mode="straight") {#X1160:2 %t5965:p};
// %t5966 = $IO_PORT @ATTACH &n960 => @PLACE(-11, -3042) => @ORIENT("R0");
// %t5966 @TEXT("n960", key="name", size=0.75);
// &n960 @WIRE(mode="straight") {#X1160:3 %t5966:p};
// %t5967 = $IO_PORT @ATTACH &n1354 => @PLACE(10, -3038) => @ORIENT("MY");
// %t5967 @TEXT("n1354", key="name", size=0.75);
// &n1354 @WIRE(mode="straight") {#X1160:4 %t5967:p};
// %t5968 = $SUPPLY @ATTACH &vdd => @PLACE(0, -3025);
// &vdd @WIRE(mode="straight") {#X1160:5 %t5968:p};
// %t5969 = $GROUND @ATTACH &vss => @PLACE(0, -3051);
// &vss @WIRE(mode="straight") {#X1160:6 %t5969:p};
// %t5970 = $IO_PORT @ATTACH &vss => @PLACE(30, -3034) => @ORIENT("R0");
// %t5970 @TEXT("vss", key="name", size=0.75);
// &vss @WIRE(mode="straight") {#X1161:1 %t5970:p};
// %t5971 = $IO_PORT @ATTACH &n1349 => @PLACE(30, -3038) => @ORIENT("R0");
// %t5971 @TEXT("n1349", key="name", size=0.75);
// &n1349 @WIRE(mode="straight") {#X1161:2 %t5971:p};
// %t5972 = $IO_PORT @ATTACH &n960 => @PLACE(30, -3042) => @ORIENT("R0");
// %t5972 @TEXT("n960", key="name", size=0.75);
// &n960 @WIRE(mode="straight") {#X1161:3 %t5972:p};
// %t5973 = $IO_PORT @ATTACH &n1355 => @PLACE(50, -3038) => @ORIENT("MY");
// %t5973 @TEXT("n1355", key="name", size=0.75);
// &n1355 @WIRE(mode="straight") {#X1161:4 %t5973:p};
// %t5974 = $SUPPLY @ATTACH &vdd => @PLACE(40, -3025);
// &vdd @WIRE(mode="straight") {#X1161:5 %t5974:p};
// %t5975 = $GROUND @ATTACH &vss => @PLACE(40, -3051);
// &vss @WIRE(mode="straight") {#X1161:6 %t5975:p};
// %t5976 = $IO_PORT @ATTACH &vss => @PLACE(70, -3034) => @ORIENT("R0");
// %t5976 @TEXT("vss", key="name", size=0.75);
// &vss @WIRE(mode="straight") {#X1162:1 %t5976:p};
// %t5977 = $IO_PORT @ATTACH &n1350 => @PLACE(70, -3038) => @ORIENT("R0");
// %t5977 @TEXT("n1350", key="name", size=0.75);
// &n1350 @WIRE(mode="straight") {#X1162:2 %t5977:p};
// %t5978 = $IO_PORT @ATTACH &n960 => @PLACE(70, -3042) => @ORIENT("R0");
// %t5978 @TEXT("n960", key="name", size=0.75);
// &n960 @WIRE(mode="straight") {#X1162:3 %t5978:p};
// %t5979 = $IO_PORT @ATTACH &n1356 => @PLACE(90, -3038) => @ORIENT("MY");
// %t5979 @TEXT("n1356", key="name", size=0.75);
// &n1356 @WIRE(mode="straight") {#X1162:4 %t5979:p};
// %t5980 = $SUPPLY @ATTACH &vdd => @PLACE(80, -3025);
// &vdd @WIRE(mode="straight") {#X1162:5 %t5980:p};
// %t5981 = $GROUND @ATTACH &vss => @PLACE(80, -3051);
// &vss @WIRE(mode="straight") {#X1162:6 %t5981:p};
// %t5982 = $IO_PORT @ATTACH &vss => @PLACE(110, -3034) => @ORIENT("R0");
// %t5982 @TEXT("vss", key="name", size=0.75);
// &vss @WIRE(mode="straight") {#X1163:1 %t5982:p};
// %t5983 = $IO_PORT @ATTACH &n1351 => @PLACE(110, -3038) => @ORIENT("R0");
// %t5983 @TEXT("n1351", key="name", size=0.75);
// &n1351 @WIRE(mode="straight") {#X1163:2 %t5983:p};
// %t5984 = $IO_PORT @ATTACH &n960 => @PLACE(110, -3042) => @ORIENT("R0");
// %t5984 @TEXT("n960", key="name", size=0.75);
// &n960 @WIRE(mode="straight") {#X1163:3 %t5984:p};
// %t5985 = $IO_PORT @ATTACH &n1357 => @PLACE(130, -3038) => @ORIENT("MY");
// %t5985 @TEXT("n1357", key="name", size=0.75);
// &n1357 @WIRE(mode="straight") {#X1163:4 %t5985:p};
// %t5986 = $SUPPLY @ATTACH &vdd => @PLACE(120, -3025);
// &vdd @WIRE(mode="straight") {#X1163:5 %t5986:p};
// %t5987 = $GROUND @ATTACH &vss => @PLACE(120, -3051);
// &vss @WIRE(mode="straight") {#X1163:6 %t5987:p};
// %t5988 = $IO_PORT @ATTACH &vss => @PLACE(-11, -3069) => @ORIENT("R0");
// %t5988 @TEXT("vss", key="name", size=0.75);
// &vss @WIRE(mode="straight") {#X1164:1 %t5988:p};
// %t5989 = $IO_PORT @ATTACH &n1352 => @PLACE(-11, -3073) => @ORIENT("R0");
// %t5989 @TEXT("n1352", key="name", size=0.75);
// &n1352 @WIRE(mode="straight") {#X1164:2 %t5989:p};
// %t5990 = $IO_PORT @ATTACH &n960 => @PLACE(-11, -3077) => @ORIENT("R0");
// %t5990 @TEXT("n960", key="name", size=0.75);
// &n960 @WIRE(mode="straight") {#X1164:3 %t5990:p};
// %t5991 = $IO_PORT @ATTACH &n1358 => @PLACE(10, -3073) => @ORIENT("MY");
// %t5991 @TEXT("n1358", key="name", size=0.75);
// &n1358 @WIRE(mode="straight") {#X1164:4 %t5991:p};
// %t5992 = $SUPPLY @ATTACH &vdd => @PLACE(0, -3060);
// &vdd @WIRE(mode="straight") {#X1164:5 %t5992:p};
// %t5993 = $GROUND @ATTACH &vss => @PLACE(0, -3086);
// &vss @WIRE(mode="straight") {#X1164:6 %t5993:p};
// %t5994 = $IO_PORT @ATTACH &vss => @PLACE(30, -3069) => @ORIENT("R0");
// %t5994 @TEXT("vss", key="name", size=0.75);
// &vss @WIRE(mode="straight") {#X1165:1 %t5994:p};
// %t5995 = $IO_PORT @ATTACH &n1353 => @PLACE(30, -3073) => @ORIENT("R0");
// %t5995 @TEXT("n1353", key="name", size=0.75);
// &n1353 @WIRE(mode="straight") {#X1165:2 %t5995:p};
// %t5996 = $IO_PORT @ATTACH &n960 => @PLACE(30, -3077) => @ORIENT("R0");
// %t5996 @TEXT("n960", key="name", size=0.75);
// &n960 @WIRE(mode="straight") {#X1165:3 %t5996:p};
// %t5997 = $IO_PORT @ATTACH &n1359 => @PLACE(50, -3073) => @ORIENT("MY");
// %t5997 @TEXT("n1359", key="name", size=0.75);
// &n1359 @WIRE(mode="straight") {#X1165:4 %t5997:p};
// %t5998 = $SUPPLY @ATTACH &vdd => @PLACE(40, -3060);
// &vdd @WIRE(mode="straight") {#X1165:5 %t5998:p};
// %t5999 = $GROUND @ATTACH &vss => @PLACE(40, -3086);
// &vss @WIRE(mode="straight") {#X1165:6 %t5999:p};
// %t6000 = $IO_PORT @ATTACH &n1354 => @PLACE(70, -3069) => @ORIENT("R0");
// %t6000 @TEXT("n1354", key="name", size=0.75);
// &n1354 @WIRE(mode="straight") {#X1166:1 %t6000:p};
// %t6001 = $IO_PORT @ATTACH &vss => @PLACE(70, -3073) => @ORIENT("R0");
// %t6001 @TEXT("vss", key="name", size=0.75);
// &vss @WIRE(mode="straight") {#X1166:2 %t6001:p};
// %t6002 = $IO_PORT @ATTACH &n234 => @PLACE(70, -3077) => @ORIENT("R0");
// %t6002 @TEXT("n234", key="name", size=0.75);
// &n234 @WIRE(mode="straight") {#X1166:3 %t6002:p};
// %t6003 = $IO_PORT @ATTACH &n1360 => @PLACE(90, -3073) => @ORIENT("MY");
// %t6003 @TEXT("n1360", key="name", size=0.75);
// &n1360 @WIRE(mode="straight") {#X1166:4 %t6003:p};
// %t6004 = $SUPPLY @ATTACH &vdd => @PLACE(80, -3060);
// &vdd @WIRE(mode="straight") {#X1166:5 %t6004:p};
// %t6005 = $GROUND @ATTACH &vss => @PLACE(80, -3086);
// &vss @WIRE(mode="straight") {#X1166:6 %t6005:p};
// %t6006 = $IO_PORT @ATTACH &n1355 => @PLACE(110, -3069) => @ORIENT("R0");
// %t6006 @TEXT("n1355", key="name", size=0.75);
// &n1355 @WIRE(mode="straight") {#X1167:1 %t6006:p};
// %t6007 = $IO_PORT @ATTACH &vss => @PLACE(110, -3073) => @ORIENT("R0");
// %t6007 @TEXT("vss", key="name", size=0.75);
// &vss @WIRE(mode="straight") {#X1167:2 %t6007:p};
// %t6008 = $IO_PORT @ATTACH &n234 => @PLACE(110, -3077) => @ORIENT("R0");
// %t6008 @TEXT("n234", key="name", size=0.75);
// &n234 @WIRE(mode="straight") {#X1167:3 %t6008:p};
// %t6009 = $IO_PORT @ATTACH &n1361 => @PLACE(130, -3073) => @ORIENT("MY");
// %t6009 @TEXT("n1361", key="name", size=0.75);
// &n1361 @WIRE(mode="straight") {#X1167:4 %t6009:p};
// %t6010 = $SUPPLY @ATTACH &vdd => @PLACE(120, -3060);
// &vdd @WIRE(mode="straight") {#X1167:5 %t6010:p};
// %t6011 = $GROUND @ATTACH &vss => @PLACE(120, -3086);
// &vss @WIRE(mode="straight") {#X1167:6 %t6011:p};
// %t6012 = $IO_PORT @ATTACH &n1356 => @PLACE(-11, -3104) => @ORIENT("R0");
// %t6012 @TEXT("n1356", key="name", size=0.75);
// &n1356 @WIRE(mode="straight") {#X1168:1 %t6012:p};
// %t6013 = $IO_PORT @ATTACH &vss => @PLACE(-11, -3108) => @ORIENT("R0");
// %t6013 @TEXT("vss", key="name", size=0.75);
// &vss @WIRE(mode="straight") {#X1168:2 %t6013:p};
// %t6014 = $IO_PORT @ATTACH &n234 => @PLACE(-11, -3112) => @ORIENT("R0");
// %t6014 @TEXT("n234", key="name", size=0.75);
// &n234 @WIRE(mode="straight") {#X1168:3 %t6014:p};
// %t6015 = $IO_PORT @ATTACH &n1362 => @PLACE(10, -3108) => @ORIENT("MY");
// %t6015 @TEXT("n1362", key="name", size=0.75);
// &n1362 @WIRE(mode="straight") {#X1168:4 %t6015:p};
// %t6016 = $SUPPLY @ATTACH &vdd => @PLACE(0, -3095);
// &vdd @WIRE(mode="straight") {#X1168:5 %t6016:p};
// %t6017 = $GROUND @ATTACH &vss => @PLACE(0, -3121);
// &vss @WIRE(mode="straight") {#X1168:6 %t6017:p};
// %t6018 = $IO_PORT @ATTACH &n1357 => @PLACE(30, -3104) => @ORIENT("R0");
// %t6018 @TEXT("n1357", key="name", size=0.75);
// &n1357 @WIRE(mode="straight") {#X1169:1 %t6018:p};
// %t6019 = $IO_PORT @ATTACH &vss => @PLACE(30, -3108) => @ORIENT("R0");
// %t6019 @TEXT("vss", key="name", size=0.75);
// &vss @WIRE(mode="straight") {#X1169:2 %t6019:p};
// %t6020 = $IO_PORT @ATTACH &n234 => @PLACE(30, -3112) => @ORIENT("R0");
// %t6020 @TEXT("n234", key="name", size=0.75);
// &n234 @WIRE(mode="straight") {#X1169:3 %t6020:p};
// %t6021 = $IO_PORT @ATTACH &n1363 => @PLACE(50, -3108) => @ORIENT("MY");
// %t6021 @TEXT("n1363", key="name", size=0.75);
// &n1363 @WIRE(mode="straight") {#X1169:4 %t6021:p};
// %t6022 = $SUPPLY @ATTACH &vdd => @PLACE(40, -3095);
// &vdd @WIRE(mode="straight") {#X1169:5 %t6022:p};
// %t6023 = $GROUND @ATTACH &vss => @PLACE(40, -3121);
// &vss @WIRE(mode="straight") {#X1169:6 %t6023:p};
// %t6024 = $IO_PORT @ATTACH &n1358 => @PLACE(70, -3104) => @ORIENT("R0");
// %t6024 @TEXT("n1358", key="name", size=0.75);
// &n1358 @WIRE(mode="straight") {#X1170:1 %t6024:p};
// %t6025 = $IO_PORT @ATTACH &vss => @PLACE(70, -3108) => @ORIENT("R0");
// %t6025 @TEXT("vss", key="name", size=0.75);
// &vss @WIRE(mode="straight") {#X1170:2 %t6025:p};
// %t6026 = $IO_PORT @ATTACH &n234 => @PLACE(70, -3112) => @ORIENT("R0");
// %t6026 @TEXT("n234", key="name", size=0.75);
// &n234 @WIRE(mode="straight") {#X1170:3 %t6026:p};
// %t6027 = $IO_PORT @ATTACH &n1364 => @PLACE(90, -3108) => @ORIENT("MY");
// %t6027 @TEXT("n1364", key="name", size=0.75);
// &n1364 @WIRE(mode="straight") {#X1170:4 %t6027:p};
// %t6028 = $SUPPLY @ATTACH &vdd => @PLACE(80, -3095);
// &vdd @WIRE(mode="straight") {#X1170:5 %t6028:p};
// %t6029 = $GROUND @ATTACH &vss => @PLACE(80, -3121);
// &vss @WIRE(mode="straight") {#X1170:6 %t6029:p};
// %t6030 = $IO_PORT @ATTACH &n1359 => @PLACE(110, -3104) => @ORIENT("R0");
// %t6030 @TEXT("n1359", key="name", size=0.75);
// &n1359 @WIRE(mode="straight") {#X1171:1 %t6030:p};
// %t6031 = $IO_PORT @ATTACH &vss => @PLACE(110, -3108) => @ORIENT("R0");
// %t6031 @TEXT("vss", key="name", size=0.75);
// &vss @WIRE(mode="straight") {#X1171:2 %t6031:p};
// %t6032 = $IO_PORT @ATTACH &n234 => @PLACE(110, -3112) => @ORIENT("R0");
// %t6032 @TEXT("n234", key="name", size=0.75);
// &n234 @WIRE(mode="straight") {#X1171:3 %t6032:p};
// %t6033 = $IO_PORT @ATTACH &n1365 => @PLACE(130, -3108) => @ORIENT("MY");
// %t6033 @TEXT("n1365", key="name", size=0.75);
// &n1365 @WIRE(mode="straight") {#X1171:4 %t6033:p};
// %t6034 = $SUPPLY @ATTACH &vdd => @PLACE(120, -3095);
// &vdd @WIRE(mode="straight") {#X1171:5 %t6034:p};
// %t6035 = $GROUND @ATTACH &vss => @PLACE(120, -3121);
// &vss @WIRE(mode="straight") {#X1171:6 %t6035:p};
// %t6036 = $IO_PORT @ATTACH &n1360 => @PLACE(-11, -3139) => @ORIENT("R0");
// %t6036 @TEXT("n1360", key="name", size=0.75);
// &n1360 @WIRE(mode="straight") {#X1172:1 %t6036:p};
// %t6037 = $IO_PORT @ATTACH &n1366 => @PLACE(-11, -3143) => @ORIENT("R0");
// %t6037 @TEXT("n1366", key="name", size=0.75);
// &n1366 @WIRE(mode="straight") {#X1172:2 %t6037:p};
// %t6038 = $IO_PORT @ATTACH &n238 => @PLACE(-11, -3147) => @ORIENT("R0");
// %t6038 @TEXT("n238", key="name", size=0.75);
// &n238 @WIRE(mode="straight") {#X1172:3 %t6038:p};
// %t6039 = $IO_PORT @ATTACH &n1367 => @PLACE(10, -3143) => @ORIENT("MY");
// %t6039 @TEXT("n1367", key="name", size=0.75);
// &n1367 @WIRE(mode="straight") {#X1172:4 %t6039:p};
// %t6040 = $SUPPLY @ATTACH &vdd => @PLACE(0, -3130);
// &vdd @WIRE(mode="straight") {#X1172:5 %t6040:p};
// %t6041 = $GROUND @ATTACH &vss => @PLACE(0, -3156);
// &vss @WIRE(mode="straight") {#X1172:6 %t6041:p};
// %t6042 = $IO_PORT @ATTACH &n1361 => @PLACE(30, -3139) => @ORIENT("R0");
// %t6042 @TEXT("n1361", key="name", size=0.75);
// &n1361 @WIRE(mode="straight") {#X1173:1 %t6042:p};
// %t6043 = $IO_PORT @ATTACH &n1368 => @PLACE(30, -3143) => @ORIENT("R0");
// %t6043 @TEXT("n1368", key="name", size=0.75);
// &n1368 @WIRE(mode="straight") {#X1173:2 %t6043:p};
// %t6044 = $IO_PORT @ATTACH &n238 => @PLACE(30, -3147) => @ORIENT("R0");
// %t6044 @TEXT("n238", key="name", size=0.75);
// &n238 @WIRE(mode="straight") {#X1173:3 %t6044:p};
// %t6045 = $IO_PORT @ATTACH &n1369 => @PLACE(50, -3143) => @ORIENT("MY");
// %t6045 @TEXT("n1369", key="name", size=0.75);
// &n1369 @WIRE(mode="straight") {#X1173:4 %t6045:p};
// %t6046 = $SUPPLY @ATTACH &vdd => @PLACE(40, -3130);
// &vdd @WIRE(mode="straight") {#X1173:5 %t6046:p};
// %t6047 = $GROUND @ATTACH &vss => @PLACE(40, -3156);
// &vss @WIRE(mode="straight") {#X1173:6 %t6047:p};
// %t6048 = $IO_PORT @ATTACH &n1362 => @PLACE(70, -3139) => @ORIENT("R0");
// %t6048 @TEXT("n1362", key="name", size=0.75);
// &n1362 @WIRE(mode="straight") {#X1174:1 %t6048:p};
// %t6049 = $IO_PORT @ATTACH &n1366 => @PLACE(70, -3143) => @ORIENT("R0");
// %t6049 @TEXT("n1366", key="name", size=0.75);
// &n1366 @WIRE(mode="straight") {#X1174:2 %t6049:p};
// %t6050 = $IO_PORT @ATTACH &n238 => @PLACE(70, -3147) => @ORIENT("R0");
// %t6050 @TEXT("n238", key="name", size=0.75);
// &n238 @WIRE(mode="straight") {#X1174:3 %t6050:p};
// %t6051 = $IO_PORT @ATTACH &n1370 => @PLACE(90, -3143) => @ORIENT("MY");
// %t6051 @TEXT("n1370", key="name", size=0.75);
// &n1370 @WIRE(mode="straight") {#X1174:4 %t6051:p};
// %t6052 = $SUPPLY @ATTACH &vdd => @PLACE(80, -3130);
// &vdd @WIRE(mode="straight") {#X1174:5 %t6052:p};
// %t6053 = $GROUND @ATTACH &vss => @PLACE(80, -3156);
// &vss @WIRE(mode="straight") {#X1174:6 %t6053:p};
// %t6054 = $IO_PORT @ATTACH &n1363 => @PLACE(110, -3139) => @ORIENT("R0");
// %t6054 @TEXT("n1363", key="name", size=0.75);
// &n1363 @WIRE(mode="straight") {#X1175:1 %t6054:p};
// %t6055 = $IO_PORT @ATTACH &n1368 => @PLACE(110, -3143) => @ORIENT("R0");
// %t6055 @TEXT("n1368", key="name", size=0.75);
// &n1368 @WIRE(mode="straight") {#X1175:2 %t6055:p};
// %t6056 = $IO_PORT @ATTACH &n238 => @PLACE(110, -3147) => @ORIENT("R0");
// %t6056 @TEXT("n238", key="name", size=0.75);
// &n238 @WIRE(mode="straight") {#X1175:3 %t6056:p};
// %t6057 = $IO_PORT @ATTACH &n1371 => @PLACE(130, -3143) => @ORIENT("MY");
// %t6057 @TEXT("n1371", key="name", size=0.75);
// &n1371 @WIRE(mode="straight") {#X1175:4 %t6057:p};
// %t6058 = $SUPPLY @ATTACH &vdd => @PLACE(120, -3130);
// &vdd @WIRE(mode="straight") {#X1175:5 %t6058:p};
// %t6059 = $GROUND @ATTACH &vss => @PLACE(120, -3156);
// &vss @WIRE(mode="straight") {#X1175:6 %t6059:p};
// %t6060 = $IO_PORT @ATTACH &n1364 => @PLACE(158, -2964) => @ORIENT("R0");
// %t6060 @TEXT("n1364", key="name", size=0.75);
// &n1364 @WIRE(mode="straight") {#X1176:1 %t6060:p};
// %t6061 = $IO_PORT @ATTACH &n1366 => @PLACE(158, -2968) => @ORIENT("R0");
// %t6061 @TEXT("n1366", key="name", size=0.75);
// &n1366 @WIRE(mode="straight") {#X1176:2 %t6061:p};
// %t6062 = $IO_PORT @ATTACH &n238 => @PLACE(158, -2972) => @ORIENT("R0");
// %t6062 @TEXT("n238", key="name", size=0.75);
// &n238 @WIRE(mode="straight") {#X1176:3 %t6062:p};
// %t6063 = $IO_PORT @ATTACH &n1372 => @PLACE(178, -2968) => @ORIENT("MY");
// %t6063 @TEXT("n1372", key="name", size=0.75);
// &n1372 @WIRE(mode="straight") {#X1176:4 %t6063:p};
// %t6064 = $SUPPLY @ATTACH &vdd => @PLACE(168, -2955);
// &vdd @WIRE(mode="straight") {#X1176:5 %t6064:p};
// %t6065 = $GROUND @ATTACH &vss => @PLACE(168, -2981);
// &vss @WIRE(mode="straight") {#X1176:6 %t6065:p};
// %t6066 = $IO_PORT @ATTACH &n1365 => @PLACE(198, -2964) => @ORIENT("R0");
// %t6066 @TEXT("n1365", key="name", size=0.75);
// &n1365 @WIRE(mode="straight") {#X1177:1 %t6066:p};
// %t6067 = $IO_PORT @ATTACH &n1366 => @PLACE(198, -2968) => @ORIENT("R0");
// %t6067 @TEXT("n1366", key="name", size=0.75);
// &n1366 @WIRE(mode="straight") {#X1177:2 %t6067:p};
// %t6068 = $IO_PORT @ATTACH &n238 => @PLACE(198, -2972) => @ORIENT("R0");
// %t6068 @TEXT("n238", key="name", size=0.75);
// &n238 @WIRE(mode="straight") {#X1177:3 %t6068:p};
// %t6069 = $IO_PORT @ATTACH &n1373 => @PLACE(218, -2968) => @ORIENT("MY");
// %t6069 @TEXT("n1373", key="name", size=0.75);
// &n1373 @WIRE(mode="straight") {#X1177:4 %t6069:p};
// %t6070 = $SUPPLY @ATTACH &vdd => @PLACE(208, -2955);
// &vdd @WIRE(mode="straight") {#X1177:5 %t6070:p};
// %t6071 = $GROUND @ATTACH &vss => @PLACE(208, -2981);
// &vss @WIRE(mode="straight") {#X1177:6 %t6071:p};
// %t6072 = $IO_PORT @ATTACH &n1374 => @PLACE(238, -2964) => @ORIENT("R0");
// %t6072 @TEXT("n1374", key="name", size=0.75);
// &n1374 @WIRE(mode="straight") {#X1178:1 %t6072:p};
// %t6073 = $IO_PORT @ATTACH &n1367 => @PLACE(238, -2968) => @ORIENT("R0");
// %t6073 @TEXT("n1367", key="name", size=0.75);
// &n1367 @WIRE(mode="straight") {#X1178:2 %t6073:p};
// %t6074 = $IO_PORT @ATTACH &n88 => @PLACE(238, -2972) => @ORIENT("R0");
// %t6074 @TEXT("n88", key="name", size=0.75);
// &n88 @WIRE(mode="straight") {#X1178:3 %t6074:p};
// %t6075 = $IO_PORT @ATTACH &n169 => @PLACE(258, -2968) => @ORIENT("MY");
// %t6075 @TEXT("n169", key="name", size=0.75);
// &n169 @WIRE(mode="straight") {#X1178:4 %t6075:p};
// %t6076 = $SUPPLY @ATTACH &vdd => @PLACE(248, -2955);
// &vdd @WIRE(mode="straight") {#X1178:5 %t6076:p};
// %t6077 = $GROUND @ATTACH &vss => @PLACE(248, -2981);
// &vss @WIRE(mode="straight") {#X1178:6 %t6077:p};
// %t6078 = $IO_PORT @ATTACH &n1375 => @PLACE(278, -2964) => @ORIENT("R0");
// %t6078 @TEXT("n1375", key="name", size=0.75);
// &n1375 @WIRE(mode="straight") {#X1179:1 %t6078:p};
// %t6079 = $IO_PORT @ATTACH &n1369 => @PLACE(278, -2968) => @ORIENT("R0");
// %t6079 @TEXT("n1369", key="name", size=0.75);
// &n1369 @WIRE(mode="straight") {#X1179:2 %t6079:p};
// %t6080 = $IO_PORT @ATTACH &n88 => @PLACE(278, -2972) => @ORIENT("R0");
// %t6080 @TEXT("n88", key="name", size=0.75);
// &n88 @WIRE(mode="straight") {#X1179:3 %t6080:p};
// %t6081 = $IO_PORT @ATTACH &n168 => @PLACE(298, -2968) => @ORIENT("MY");
// %t6081 @TEXT("n168", key="name", size=0.75);
// &n168 @WIRE(mode="straight") {#X1179:4 %t6081:p};
// %t6082 = $SUPPLY @ATTACH &vdd => @PLACE(288, -2955);
// &vdd @WIRE(mode="straight") {#X1179:5 %t6082:p};
// %t6083 = $GROUND @ATTACH &vss => @PLACE(288, -2981);
// &vss @WIRE(mode="straight") {#X1179:6 %t6083:p};
// %t6084 = $IO_PORT @ATTACH &n1374 => @PLACE(158, -2999) => @ORIENT("R0");
// %t6084 @TEXT("n1374", key="name", size=0.75);
// &n1374 @WIRE(mode="straight") {#X1180:1 %t6084:p};
// %t6085 = $IO_PORT @ATTACH &n1370 => @PLACE(158, -3003) => @ORIENT("R0");
// %t6085 @TEXT("n1370", key="name", size=0.75);
// &n1370 @WIRE(mode="straight") {#X1180:2 %t6085:p};
// %t6086 = $IO_PORT @ATTACH &n88 => @PLACE(158, -3007) => @ORIENT("R0");
// %t6086 @TEXT("n88", key="name", size=0.75);
// &n88 @WIRE(mode="straight") {#X1180:3 %t6086:p};
// %t6087 = $IO_PORT @ATTACH &n167 => @PLACE(178, -3003) => @ORIENT("MY");
// %t6087 @TEXT("n167", key="name", size=0.75);
// &n167 @WIRE(mode="straight") {#X1180:4 %t6087:p};
// %t6088 = $SUPPLY @ATTACH &vdd => @PLACE(168, -2990);
// &vdd @WIRE(mode="straight") {#X1180:5 %t6088:p};
// %t6089 = $GROUND @ATTACH &vss => @PLACE(168, -3016);
// &vss @WIRE(mode="straight") {#X1180:6 %t6089:p};
// %t6090 = $IO_PORT @ATTACH &n1375 => @PLACE(198, -2999) => @ORIENT("R0");
// %t6090 @TEXT("n1375", key="name", size=0.75);
// &n1375 @WIRE(mode="straight") {#X1181:1 %t6090:p};
// %t6091 = $IO_PORT @ATTACH &n1371 => @PLACE(198, -3003) => @ORIENT("R0");
// %t6091 @TEXT("n1371", key="name", size=0.75);
// &n1371 @WIRE(mode="straight") {#X1181:2 %t6091:p};
// %t6092 = $IO_PORT @ATTACH &n88 => @PLACE(198, -3007) => @ORIENT("R0");
// %t6092 @TEXT("n88", key="name", size=0.75);
// &n88 @WIRE(mode="straight") {#X1181:3 %t6092:p};
// %t6093 = $IO_PORT @ATTACH &n166 => @PLACE(218, -3003) => @ORIENT("MY");
// %t6093 @TEXT("n166", key="name", size=0.75);
// &n166 @WIRE(mode="straight") {#X1181:4 %t6093:p};
// %t6094 = $SUPPLY @ATTACH &vdd => @PLACE(208, -2990);
// &vdd @WIRE(mode="straight") {#X1181:5 %t6094:p};
// %t6095 = $GROUND @ATTACH &vss => @PLACE(208, -3016);
// &vss @WIRE(mode="straight") {#X1181:6 %t6095:p};
// %t6096 = $IO_PORT @ATTACH &n1374 => @PLACE(238, -2999) => @ORIENT("R0");
// %t6096 @TEXT("n1374", key="name", size=0.75);
// &n1374 @WIRE(mode="straight") {#X1182:1 %t6096:p};
// %t6097 = $IO_PORT @ATTACH &n1372 => @PLACE(238, -3003) => @ORIENT("R0");
// %t6097 @TEXT("n1372", key="name", size=0.75);
// &n1372 @WIRE(mode="straight") {#X1182:2 %t6097:p};
// %t6098 = $IO_PORT @ATTACH &n88 => @PLACE(238, -3007) => @ORIENT("R0");
// %t6098 @TEXT("n88", key="name", size=0.75);
// &n88 @WIRE(mode="straight") {#X1182:3 %t6098:p};
// %t6099 = $IO_PORT @ATTACH &n164 => @PLACE(258, -3003) => @ORIENT("MY");
// %t6099 @TEXT("n164", key="name", size=0.75);
// &n164 @WIRE(mode="straight") {#X1182:4 %t6099:p};
// %t6100 = $SUPPLY @ATTACH &vdd => @PLACE(248, -2990);
// &vdd @WIRE(mode="straight") {#X1182:5 %t6100:p};
// %t6101 = $GROUND @ATTACH &vss => @PLACE(248, -3016);
// &vss @WIRE(mode="straight") {#X1182:6 %t6101:p};
// %t6102 = $IO_PORT @ATTACH &n1374 => @PLACE(278, -2999) => @ORIENT("R0");
// %t6102 @TEXT("n1374", key="name", size=0.75);
// &n1374 @WIRE(mode="straight") {#X1183:1 %t6102:p};
// %t6103 = $IO_PORT @ATTACH &n1373 => @PLACE(278, -3003) => @ORIENT("R0");
// %t6103 @TEXT("n1373", key="name", size=0.75);
// &n1373 @WIRE(mode="straight") {#X1183:2 %t6103:p};
// %t6104 = $IO_PORT @ATTACH &n88 => @PLACE(278, -3007) => @ORIENT("R0");
// %t6104 @TEXT("n88", key="name", size=0.75);
// &n88 @WIRE(mode="straight") {#X1183:3 %t6104:p};
// %t6105 = $IO_PORT @ATTACH &n181 => @PLACE(298, -3003) => @ORIENT("MY");
// %t6105 @TEXT("n181", key="name", size=0.75);
// &n181 @WIRE(mode="straight") {#X1183:4 %t6105:p};
// %t6106 = $SUPPLY @ATTACH &vdd => @PLACE(288, -2990);
// &vdd @WIRE(mode="straight") {#X1183:5 %t6106:p};
// %t6107 = $GROUND @ATTACH &vss => @PLACE(288, -3016);
// &vss @WIRE(mode="straight") {#X1183:6 %t6107:p};
// %t6108 = $IO_PORT @ATTACH &vdd => @PLACE(158, -3034) => @ORIENT("R0");
// %t6108 @TEXT("vdd", key="name", size=0.75);
// &vdd @WIRE(mode="straight") {#X1184:1 %t6108:p};
// %t6109 = $IO_PORT @ATTACH &vss => @PLACE(158, -3038) => @ORIENT("R0");
// %t6109 @TEXT("vss", key="name", size=0.75);
// &vss @WIRE(mode="straight") {#X1184:2 %t6109:p};
// %t6110 = $IO_PORT @ATTACH &n980 => @PLACE(158, -3042) => @ORIENT("R0");
// %t6110 @TEXT("n980", key="name", size=0.75);
// &n980 @WIRE(mode="straight") {#X1184:3 %t6110:p};
// %t6111 = $IO_PORT @ATTACH &n1374 => @PLACE(178, -3038) => @ORIENT("MY");
// %t6111 @TEXT("n1374", key="name", size=0.75);
// &n1374 @WIRE(mode="straight") {#X1184:4 %t6111:p};
// %t6112 = $SUPPLY @ATTACH &vdd => @PLACE(168, -3025);
// &vdd @WIRE(mode="straight") {#X1184:5 %t6112:p};
// %t6113 = $GROUND @ATTACH &vss => @PLACE(168, -3051);
// &vss @WIRE(mode="straight") {#X1184:6 %t6113:p};
// %t6114 = $IO_PORT @ATTACH &n267 => @PLACE(198, -3034) => @ORIENT("R0");
// %t6114 @TEXT("n267", key="name", size=0.75);
// &n267 @WIRE(mode="straight") {#X1185:1 %t6114:p};
// %t6115 = $IO_PORT @ATTACH &vss => @PLACE(198, -3038) => @ORIENT("R0");
// %t6115 @TEXT("vss", key="name", size=0.75);
// &vss @WIRE(mode="straight") {#X1185:2 %t6115:p};
// %t6116 = $IO_PORT @ATTACH &n240 => @PLACE(198, -3042) => @ORIENT("R0");
// %t6116 @TEXT("n240", key="name", size=0.75);
// &n240 @WIRE(mode="straight") {#X1185:3 %t6116:p};
// %t6117 = $IO_PORT @ATTACH &n1376 => @PLACE(218, -3038) => @ORIENT("MY");
// %t6117 @TEXT("n1376", key="name", size=0.75);
// &n1376 @WIRE(mode="straight") {#X1185:4 %t6117:p};
// %t6118 = $SUPPLY @ATTACH &vdd => @PLACE(208, -3025);
// &vdd @WIRE(mode="straight") {#X1185:5 %t6118:p};
// %t6119 = $GROUND @ATTACH &vss => @PLACE(208, -3051);
// &vss @WIRE(mode="straight") {#X1185:6 %t6119:p};
// %t6120 = $IO_PORT @ATTACH &n355 => @PLACE(238, -3034) => @ORIENT("R0");
// %t6120 @TEXT("n355", key="name", size=0.75);
// &n355 @WIRE(mode="straight") {#X1186:1 %t6120:p};
// %t6121 = $IO_PORT @ATTACH &vss => @PLACE(238, -3038) => @ORIENT("R0");
// %t6121 @TEXT("vss", key="name", size=0.75);
// &vss @WIRE(mode="straight") {#X1186:2 %t6121:p};
// %t6122 = $IO_PORT @ATTACH &n240 => @PLACE(238, -3042) => @ORIENT("R0");
// %t6122 @TEXT("n240", key="name", size=0.75);
// &n240 @WIRE(mode="straight") {#X1186:3 %t6122:p};
// %t6123 = $IO_PORT @ATTACH &n1377 => @PLACE(258, -3038) => @ORIENT("MY");
// %t6123 @TEXT("n1377", key="name", size=0.75);
// &n1377 @WIRE(mode="straight") {#X1186:4 %t6123:p};
// %t6124 = $SUPPLY @ATTACH &vdd => @PLACE(248, -3025);
// &vdd @WIRE(mode="straight") {#X1186:5 %t6124:p};
// %t6125 = $GROUND @ATTACH &vss => @PLACE(248, -3051);
// &vss @WIRE(mode="straight") {#X1186:6 %t6125:p};
// %t6126 = $IO_PORT @ATTACH &n357 => @PLACE(278, -3034) => @ORIENT("R0");
// %t6126 @TEXT("n357", key="name", size=0.75);
// &n357 @WIRE(mode="straight") {#X1187:1 %t6126:p};
// %t6127 = $IO_PORT @ATTACH &vss => @PLACE(278, -3038) => @ORIENT("R0");
// %t6127 @TEXT("vss", key="name", size=0.75);
// &vss @WIRE(mode="straight") {#X1187:2 %t6127:p};
// %t6128 = $IO_PORT @ATTACH &n240 => @PLACE(278, -3042) => @ORIENT("R0");
// %t6128 @TEXT("n240", key="name", size=0.75);
// &n240 @WIRE(mode="straight") {#X1187:3 %t6128:p};
// %t6129 = $IO_PORT @ATTACH &n1378 => @PLACE(298, -3038) => @ORIENT("MY");
// %t6129 @TEXT("n1378", key="name", size=0.75);
// &n1378 @WIRE(mode="straight") {#X1187:4 %t6129:p};
// %t6130 = $SUPPLY @ATTACH &vdd => @PLACE(288, -3025);
// &vdd @WIRE(mode="straight") {#X1187:5 %t6130:p};
// %t6131 = $GROUND @ATTACH &vss => @PLACE(288, -3051);
// &vss @WIRE(mode="straight") {#X1187:6 %t6131:p};
// %t6132 = $IO_PORT @ATTACH &n582 => @PLACE(158, -3069) => @ORIENT("R0");
// %t6132 @TEXT("n582", key="name", size=0.75);
// &n582 @WIRE(mode="straight") {#X1188:1 %t6132:p};
// %t6133 = $IO_PORT @ATTACH &vss => @PLACE(158, -3073) => @ORIENT("R0");
// %t6133 @TEXT("vss", key="name", size=0.75);
// &vss @WIRE(mode="straight") {#X1188:2 %t6133:p};
// %t6134 = $IO_PORT @ATTACH &n240 => @PLACE(158, -3077) => @ORIENT("R0");
// %t6134 @TEXT("n240", key="name", size=0.75);
// &n240 @WIRE(mode="straight") {#X1188:3 %t6134:p};
// %t6135 = $IO_PORT @ATTACH &n1379 => @PLACE(178, -3073) => @ORIENT("MY");
// %t6135 @TEXT("n1379", key="name", size=0.75);
// &n1379 @WIRE(mode="straight") {#X1188:4 %t6135:p};
// %t6136 = $SUPPLY @ATTACH &vdd => @PLACE(168, -3060);
// &vdd @WIRE(mode="straight") {#X1188:5 %t6136:p};
// %t6137 = $GROUND @ATTACH &vss => @PLACE(168, -3086);
// &vss @WIRE(mode="straight") {#X1188:6 %t6137:p};
// %t6138 = $IO_PORT @ATTACH &n359 => @PLACE(198, -3069) => @ORIENT("R0");
// %t6138 @TEXT("n359", key="name", size=0.75);
// &n359 @WIRE(mode="straight") {#X1189:1 %t6138:p};
// %t6139 = $IO_PORT @ATTACH &vss => @PLACE(198, -3073) => @ORIENT("R0");
// %t6139 @TEXT("vss", key="name", size=0.75);
// &vss @WIRE(mode="straight") {#X1189:2 %t6139:p};
// %t6140 = $IO_PORT @ATTACH &n240 => @PLACE(198, -3077) => @ORIENT("R0");
// %t6140 @TEXT("n240", key="name", size=0.75);
// &n240 @WIRE(mode="straight") {#X1189:3 %t6140:p};
// %t6141 = $IO_PORT @ATTACH &n1380 => @PLACE(218, -3073) => @ORIENT("MY");
// %t6141 @TEXT("n1380", key="name", size=0.75);
// &n1380 @WIRE(mode="straight") {#X1189:4 %t6141:p};
// %t6142 = $SUPPLY @ATTACH &vdd => @PLACE(208, -3060);
// &vdd @WIRE(mode="straight") {#X1189:5 %t6142:p};
// %t6143 = $GROUND @ATTACH &vss => @PLACE(208, -3086);
// &vss @WIRE(mode="straight") {#X1189:6 %t6143:p};
// %t6144 = $IO_PORT @ATTACH &n361 => @PLACE(238, -3069) => @ORIENT("R0");
// %t6144 @TEXT("n361", key="name", size=0.75);
// &n361 @WIRE(mode="straight") {#X1190:1 %t6144:p};
// %t6145 = $IO_PORT @ATTACH &vss => @PLACE(238, -3073) => @ORIENT("R0");
// %t6145 @TEXT("vss", key="name", size=0.75);
// &vss @WIRE(mode="straight") {#X1190:2 %t6145:p};
// %t6146 = $IO_PORT @ATTACH &n240 => @PLACE(238, -3077) => @ORIENT("R0");
// %t6146 @TEXT("n240", key="name", size=0.75);
// &n240 @WIRE(mode="straight") {#X1190:3 %t6146:p};
// %t6147 = $IO_PORT @ATTACH &n1381 => @PLACE(258, -3073) => @ORIENT("MY");
// %t6147 @TEXT("n1381", key="name", size=0.75);
// &n1381 @WIRE(mode="straight") {#X1190:4 %t6147:p};
// %t6148 = $SUPPLY @ATTACH &vdd => @PLACE(248, -3060);
// &vdd @WIRE(mode="straight") {#X1190:5 %t6148:p};
// %t6149 = $GROUND @ATTACH &vss => @PLACE(248, -3086);
// &vss @WIRE(mode="straight") {#X1190:6 %t6149:p};
// %t6150 = $IO_PORT @ATTACH &vss => @PLACE(278, -3069) => @ORIENT("R0");
// %t6150 @TEXT("vss", key="name", size=0.75);
// &vss @WIRE(mode="straight") {#X1191:1 %t6150:p};
// %t6151 = $IO_PORT @ATTACH &n1376 => @PLACE(278, -3073) => @ORIENT("R0");
// %t6151 @TEXT("n1376", key="name", size=0.75);
// &n1376 @WIRE(mode="straight") {#X1191:2 %t6151:p};
// %t6152 = $IO_PORT @ATTACH &n351 => @PLACE(278, -3077) => @ORIENT("R0");
// %t6152 @TEXT("n351", key="name", size=0.75);
// &n351 @WIRE(mode="straight") {#X1191:3 %t6152:p};
// %t6153 = $IO_PORT @ATTACH &n1382 => @PLACE(298, -3073) => @ORIENT("MY");
// %t6153 @TEXT("n1382", key="name", size=0.75);
// &n1382 @WIRE(mode="straight") {#X1191:4 %t6153:p};
// %t6154 = $SUPPLY @ATTACH &vdd => @PLACE(288, -3060);
// &vdd @WIRE(mode="straight") {#X1191:5 %t6154:p};
// %t6155 = $GROUND @ATTACH &vss => @PLACE(288, -3086);
// &vss @WIRE(mode="straight") {#X1191:6 %t6155:p};
// %t6156 = $IO_PORT @ATTACH &vss => @PLACE(158, -3104) => @ORIENT("R0");
// %t6156 @TEXT("vss", key="name", size=0.75);
// &vss @WIRE(mode="straight") {#X1192:1 %t6156:p};
// %t6157 = $IO_PORT @ATTACH &n1377 => @PLACE(158, -3108) => @ORIENT("R0");
// %t6157 @TEXT("n1377", key="name", size=0.75);
// &n1377 @WIRE(mode="straight") {#X1192:2 %t6157:p};
// %t6158 = $IO_PORT @ATTACH &n351 => @PLACE(158, -3112) => @ORIENT("R0");
// %t6158 @TEXT("n351", key="name", size=0.75);
// &n351 @WIRE(mode="straight") {#X1192:3 %t6158:p};
// %t6159 = $IO_PORT @ATTACH &n1383 => @PLACE(178, -3108) => @ORIENT("MY");
// %t6159 @TEXT("n1383", key="name", size=0.75);
// &n1383 @WIRE(mode="straight") {#X1192:4 %t6159:p};
// %t6160 = $SUPPLY @ATTACH &vdd => @PLACE(168, -3095);
// &vdd @WIRE(mode="straight") {#X1192:5 %t6160:p};
// %t6161 = $GROUND @ATTACH &vss => @PLACE(168, -3121);
// &vss @WIRE(mode="straight") {#X1192:6 %t6161:p};
// %t6162 = $IO_PORT @ATTACH &vss => @PLACE(198, -3104) => @ORIENT("R0");
// %t6162 @TEXT("vss", key="name", size=0.75);
// &vss @WIRE(mode="straight") {#X1193:1 %t6162:p};
// %t6163 = $IO_PORT @ATTACH &n1378 => @PLACE(198, -3108) => @ORIENT("R0");
// %t6163 @TEXT("n1378", key="name", size=0.75);
// &n1378 @WIRE(mode="straight") {#X1193:2 %t6163:p};
// %t6164 = $IO_PORT @ATTACH &n351 => @PLACE(198, -3112) => @ORIENT("R0");
// %t6164 @TEXT("n351", key="name", size=0.75);
// &n351 @WIRE(mode="straight") {#X1193:3 %t6164:p};
// %t6165 = $IO_PORT @ATTACH &n1384 => @PLACE(218, -3108) => @ORIENT("MY");
// %t6165 @TEXT("n1384", key="name", size=0.75);
// &n1384 @WIRE(mode="straight") {#X1193:4 %t6165:p};
// %t6166 = $SUPPLY @ATTACH &vdd => @PLACE(208, -3095);
// &vdd @WIRE(mode="straight") {#X1193:5 %t6166:p};
// %t6167 = $GROUND @ATTACH &vss => @PLACE(208, -3121);
// &vss @WIRE(mode="straight") {#X1193:6 %t6167:p};
// %t6168 = $IO_PORT @ATTACH &vss => @PLACE(238, -3104) => @ORIENT("R0");
// %t6168 @TEXT("vss", key="name", size=0.75);
// &vss @WIRE(mode="straight") {#X1194:1 %t6168:p};
// %t6169 = $IO_PORT @ATTACH &n1379 => @PLACE(238, -3108) => @ORIENT("R0");
// %t6169 @TEXT("n1379", key="name", size=0.75);
// &n1379 @WIRE(mode="straight") {#X1194:2 %t6169:p};
// %t6170 = $IO_PORT @ATTACH &n351 => @PLACE(238, -3112) => @ORIENT("R0");
// %t6170 @TEXT("n351", key="name", size=0.75);
// &n351 @WIRE(mode="straight") {#X1194:3 %t6170:p};
// %t6171 = $IO_PORT @ATTACH &n1385 => @PLACE(258, -3108) => @ORIENT("MY");
// %t6171 @TEXT("n1385", key="name", size=0.75);
// &n1385 @WIRE(mode="straight") {#X1194:4 %t6171:p};
// %t6172 = $SUPPLY @ATTACH &vdd => @PLACE(248, -3095);
// &vdd @WIRE(mode="straight") {#X1194:5 %t6172:p};
// %t6173 = $GROUND @ATTACH &vss => @PLACE(248, -3121);
// &vss @WIRE(mode="straight") {#X1194:6 %t6173:p};
// %t6174 = $IO_PORT @ATTACH &vss => @PLACE(278, -3104) => @ORIENT("R0");
// %t6174 @TEXT("vss", key="name", size=0.75);
// &vss @WIRE(mode="straight") {#X1195:1 %t6174:p};
// %t6175 = $IO_PORT @ATTACH &n1380 => @PLACE(278, -3108) => @ORIENT("R0");
// %t6175 @TEXT("n1380", key="name", size=0.75);
// &n1380 @WIRE(mode="straight") {#X1195:2 %t6175:p};
// %t6176 = $IO_PORT @ATTACH &n351 => @PLACE(278, -3112) => @ORIENT("R0");
// %t6176 @TEXT("n351", key="name", size=0.75);
// &n351 @WIRE(mode="straight") {#X1195:3 %t6176:p};
// %t6177 = $IO_PORT @ATTACH &n1386 => @PLACE(298, -3108) => @ORIENT("MY");
// %t6177 @TEXT("n1386", key="name", size=0.75);
// &n1386 @WIRE(mode="straight") {#X1195:4 %t6177:p};
// %t6178 = $SUPPLY @ATTACH &vdd => @PLACE(288, -3095);
// &vdd @WIRE(mode="straight") {#X1195:5 %t6178:p};
// %t6179 = $GROUND @ATTACH &vss => @PLACE(288, -3121);
// &vss @WIRE(mode="straight") {#X1195:6 %t6179:p};
// %t6180 = $IO_PORT @ATTACH &vss => @PLACE(158, -3139) => @ORIENT("R0");
// %t6180 @TEXT("vss", key="name", size=0.75);
// &vss @WIRE(mode="straight") {#X1196:1 %t6180:p};
// %t6181 = $IO_PORT @ATTACH &n1381 => @PLACE(158, -3143) => @ORIENT("R0");
// %t6181 @TEXT("n1381", key="name", size=0.75);
// &n1381 @WIRE(mode="straight") {#X1196:2 %t6181:p};
// %t6182 = $IO_PORT @ATTACH &n351 => @PLACE(158, -3147) => @ORIENT("R0");
// %t6182 @TEXT("n351", key="name", size=0.75);
// &n351 @WIRE(mode="straight") {#X1196:3 %t6182:p};
// %t6183 = $IO_PORT @ATTACH &n1387 => @PLACE(178, -3143) => @ORIENT("MY");
// %t6183 @TEXT("n1387", key="name", size=0.75);
// &n1387 @WIRE(mode="straight") {#X1196:4 %t6183:p};
// %t6184 = $SUPPLY @ATTACH &vdd => @PLACE(168, -3130);
// &vdd @WIRE(mode="straight") {#X1196:5 %t6184:p};
// %t6185 = $GROUND @ATTACH &vss => @PLACE(168, -3156);
// &vss @WIRE(mode="straight") {#X1196:6 %t6185:p};
// %t6186 = $IO_PORT @ATTACH &n1382 => @PLACE(198, -3139) => @ORIENT("R0");
// %t6186 @TEXT("n1382", key="name", size=0.75);
// &n1382 @WIRE(mode="straight") {#X1197:1 %t6186:p};
// %t6187 = $IO_PORT @ATTACH &vss => @PLACE(198, -3143) => @ORIENT("R0");
// %t6187 @TEXT("vss", key="name", size=0.75);
// &vss @WIRE(mode="straight") {#X1197:2 %t6187:p};
// %t6188 = $IO_PORT @ATTACH &n236 => @PLACE(198, -3147) => @ORIENT("R0");
// %t6188 @TEXT("n236", key="name", size=0.75);
// &n236 @WIRE(mode="straight") {#X1197:3 %t6188:p};
// %t6189 = $IO_PORT @ATTACH &n1388 => @PLACE(218, -3143) => @ORIENT("MY");
// %t6189 @TEXT("n1388", key="name", size=0.75);
// &n1388 @WIRE(mode="straight") {#X1197:4 %t6189:p};
// %t6190 = $SUPPLY @ATTACH &vdd => @PLACE(208, -3130);
// &vdd @WIRE(mode="straight") {#X1197:5 %t6190:p};
// %t6191 = $GROUND @ATTACH &vss => @PLACE(208, -3156);
// &vss @WIRE(mode="straight") {#X1197:6 %t6191:p};
// %t6192 = $IO_PORT @ATTACH &n1383 => @PLACE(238, -3139) => @ORIENT("R0");
// %t6192 @TEXT("n1383", key="name", size=0.75);
// &n1383 @WIRE(mode="straight") {#X1198:1 %t6192:p};
// %t6193 = $IO_PORT @ATTACH &vss => @PLACE(238, -3143) => @ORIENT("R0");
// %t6193 @TEXT("vss", key="name", size=0.75);
// &vss @WIRE(mode="straight") {#X1198:2 %t6193:p};
// %t6194 = $IO_PORT @ATTACH &n236 => @PLACE(238, -3147) => @ORIENT("R0");
// %t6194 @TEXT("n236", key="name", size=0.75);
// &n236 @WIRE(mode="straight") {#X1198:3 %t6194:p};
// %t6195 = $IO_PORT @ATTACH &n1389 => @PLACE(258, -3143) => @ORIENT("MY");
// %t6195 @TEXT("n1389", key="name", size=0.75);
// &n1389 @WIRE(mode="straight") {#X1198:4 %t6195:p};
// %t6196 = $SUPPLY @ATTACH &vdd => @PLACE(248, -3130);
// &vdd @WIRE(mode="straight") {#X1198:5 %t6196:p};
// %t6197 = $GROUND @ATTACH &vss => @PLACE(248, -3156);
// &vss @WIRE(mode="straight") {#X1198:6 %t6197:p};
// %t6198 = $IO_PORT @ATTACH &n1384 => @PLACE(278, -3139) => @ORIENT("R0");
// %t6198 @TEXT("n1384", key="name", size=0.75);
// &n1384 @WIRE(mode="straight") {#X1199:1 %t6198:p};
// %t6199 = $IO_PORT @ATTACH &vss => @PLACE(278, -3143) => @ORIENT("R0");
// %t6199 @TEXT("vss", key="name", size=0.75);
// &vss @WIRE(mode="straight") {#X1199:2 %t6199:p};
// %t6200 = $IO_PORT @ATTACH &n236 => @PLACE(278, -3147) => @ORIENT("R0");
// %t6200 @TEXT("n236", key="name", size=0.75);
// &n236 @WIRE(mode="straight") {#X1199:3 %t6200:p};
// %t6201 = $IO_PORT @ATTACH &n1390 => @PLACE(298, -3143) => @ORIENT("MY");
// %t6201 @TEXT("n1390", key="name", size=0.75);
// &n1390 @WIRE(mode="straight") {#X1199:4 %t6201:p};
// %t6202 = $SUPPLY @ATTACH &vdd => @PLACE(288, -3130);
// &vdd @WIRE(mode="straight") {#X1199:5 %t6202:p};
// %t6203 = $GROUND @ATTACH &vss => @PLACE(288, -3156);
// &vss @WIRE(mode="straight") {#X1199:6 %t6203:p};
// %t6204 = $IO_PORT @ATTACH &n1385 => @PLACE(326, -2964) => @ORIENT("R0");
// %t6204 @TEXT("n1385", key="name", size=0.75);
// &n1385 @WIRE(mode="straight") {#X1200:1 %t6204:p};
// %t6205 = $IO_PORT @ATTACH &vss => @PLACE(326, -2968) => @ORIENT("R0");
// %t6205 @TEXT("vss", key="name", size=0.75);
// &vss @WIRE(mode="straight") {#X1200:2 %t6205:p};
// %t6206 = $IO_PORT @ATTACH &n236 => @PLACE(326, -2972) => @ORIENT("R0");
// %t6206 @TEXT("n236", key="name", size=0.75);
// &n236 @WIRE(mode="straight") {#X1200:3 %t6206:p};
// %t6207 = $IO_PORT @ATTACH &n1391 => @PLACE(346, -2968) => @ORIENT("MY");
// %t6207 @TEXT("n1391", key="name", size=0.75);
// &n1391 @WIRE(mode="straight") {#X1200:4 %t6207:p};
// %t6208 = $SUPPLY @ATTACH &vdd => @PLACE(336, -2955);
// &vdd @WIRE(mode="straight") {#X1200:5 %t6208:p};
// %t6209 = $GROUND @ATTACH &vss => @PLACE(336, -2981);
// &vss @WIRE(mode="straight") {#X1200:6 %t6209:p};
// %t6210 = $IO_PORT @ATTACH &n1386 => @PLACE(366, -2964) => @ORIENT("R0");
// %t6210 @TEXT("n1386", key="name", size=0.75);
// &n1386 @WIRE(mode="straight") {#X1201:1 %t6210:p};
// %t6211 = $IO_PORT @ATTACH &vss => @PLACE(366, -2968) => @ORIENT("R0");
// %t6211 @TEXT("vss", key="name", size=0.75);
// &vss @WIRE(mode="straight") {#X1201:2 %t6211:p};
// %t6212 = $IO_PORT @ATTACH &n236 => @PLACE(366, -2972) => @ORIENT("R0");
// %t6212 @TEXT("n236", key="name", size=0.75);
// &n236 @WIRE(mode="straight") {#X1201:3 %t6212:p};
// %t6213 = $IO_PORT @ATTACH &n1392 => @PLACE(386, -2968) => @ORIENT("MY");
// %t6213 @TEXT("n1392", key="name", size=0.75);
// &n1392 @WIRE(mode="straight") {#X1201:4 %t6213:p};
// %t6214 = $SUPPLY @ATTACH &vdd => @PLACE(376, -2955);
// &vdd @WIRE(mode="straight") {#X1201:5 %t6214:p};
// %t6215 = $GROUND @ATTACH &vss => @PLACE(376, -2981);
// &vss @WIRE(mode="straight") {#X1201:6 %t6215:p};
// %t6216 = $IO_PORT @ATTACH &n1387 => @PLACE(406, -2964) => @ORIENT("R0");
// %t6216 @TEXT("n1387", key="name", size=0.75);
// &n1387 @WIRE(mode="straight") {#X1202:1 %t6216:p};
// %t6217 = $IO_PORT @ATTACH &vss => @PLACE(406, -2968) => @ORIENT("R0");
// %t6217 @TEXT("vss", key="name", size=0.75);
// &vss @WIRE(mode="straight") {#X1202:2 %t6217:p};
// %t6218 = $IO_PORT @ATTACH &n236 => @PLACE(406, -2972) => @ORIENT("R0");
// %t6218 @TEXT("n236", key="name", size=0.75);
// &n236 @WIRE(mode="straight") {#X1202:3 %t6218:p};
// %t6219 = $IO_PORT @ATTACH &n1393 => @PLACE(426, -2968) => @ORIENT("MY");
// %t6219 @TEXT("n1393", key="name", size=0.75);
// &n1393 @WIRE(mode="straight") {#X1202:4 %t6219:p};
// %t6220 = $SUPPLY @ATTACH &vdd => @PLACE(416, -2955);
// &vdd @WIRE(mode="straight") {#X1202:5 %t6220:p};
// %t6221 = $GROUND @ATTACH &vss => @PLACE(416, -2981);
// &vss @WIRE(mode="straight") {#X1202:6 %t6221:p};
// %t6222 = $IO_PORT @ATTACH &vss => @PLACE(446, -2964) => @ORIENT("R0");
// %t6222 @TEXT("vss", key="name", size=0.75);
// &vss @WIRE(mode="straight") {#X1203:1 %t6222:p};
// %t6223 = $IO_PORT @ATTACH &n1388 => @PLACE(446, -2968) => @ORIENT("R0");
// %t6223 @TEXT("n1388", key="name", size=0.75);
// &n1388 @WIRE(mode="straight") {#X1203:2 %t6223:p};
// %t6224 = $IO_PORT @ATTACH &n960 => @PLACE(446, -2972) => @ORIENT("R0");
// %t6224 @TEXT("n960", key="name", size=0.75);
// &n960 @WIRE(mode="straight") {#X1203:3 %t6224:p};
// %t6225 = $IO_PORT @ATTACH &n1394 => @PLACE(466, -2968) => @ORIENT("MY");
// %t6225 @TEXT("n1394", key="name", size=0.75);
// &n1394 @WIRE(mode="straight") {#X1203:4 %t6225:p};
// %t6226 = $SUPPLY @ATTACH &vdd => @PLACE(456, -2955);
// &vdd @WIRE(mode="straight") {#X1203:5 %t6226:p};
// %t6227 = $GROUND @ATTACH &vss => @PLACE(456, -2981);
// &vss @WIRE(mode="straight") {#X1203:6 %t6227:p};
// %t6228 = $IO_PORT @ATTACH &vss => @PLACE(326, -2999) => @ORIENT("R0");
// %t6228 @TEXT("vss", key="name", size=0.75);
// &vss @WIRE(mode="straight") {#X1204:1 %t6228:p};
// %t6229 = $IO_PORT @ATTACH &n1389 => @PLACE(326, -3003) => @ORIENT("R0");
// %t6229 @TEXT("n1389", key="name", size=0.75);
// &n1389 @WIRE(mode="straight") {#X1204:2 %t6229:p};
// %t6230 = $IO_PORT @ATTACH &n960 => @PLACE(326, -3007) => @ORIENT("R0");
// %t6230 @TEXT("n960", key="name", size=0.75);
// &n960 @WIRE(mode="straight") {#X1204:3 %t6230:p};
// %t6231 = $IO_PORT @ATTACH &n1395 => @PLACE(346, -3003) => @ORIENT("MY");
// %t6231 @TEXT("n1395", key="name", size=0.75);
// &n1395 @WIRE(mode="straight") {#X1204:4 %t6231:p};
// %t6232 = $SUPPLY @ATTACH &vdd => @PLACE(336, -2990);
// &vdd @WIRE(mode="straight") {#X1204:5 %t6232:p};
// %t6233 = $GROUND @ATTACH &vss => @PLACE(336, -3016);
// &vss @WIRE(mode="straight") {#X1204:6 %t6233:p};
// %t6234 = $IO_PORT @ATTACH &vss => @PLACE(366, -2999) => @ORIENT("R0");
// %t6234 @TEXT("vss", key="name", size=0.75);
// &vss @WIRE(mode="straight") {#X1205:1 %t6234:p};
// %t6235 = $IO_PORT @ATTACH &n1390 => @PLACE(366, -3003) => @ORIENT("R0");
// %t6235 @TEXT("n1390", key="name", size=0.75);
// &n1390 @WIRE(mode="straight") {#X1205:2 %t6235:p};
// %t6236 = $IO_PORT @ATTACH &n960 => @PLACE(366, -3007) => @ORIENT("R0");
// %t6236 @TEXT("n960", key="name", size=0.75);
// &n960 @WIRE(mode="straight") {#X1205:3 %t6236:p};
// %t6237 = $IO_PORT @ATTACH &n1396 => @PLACE(386, -3003) => @ORIENT("MY");
// %t6237 @TEXT("n1396", key="name", size=0.75);
// &n1396 @WIRE(mode="straight") {#X1205:4 %t6237:p};
// %t6238 = $SUPPLY @ATTACH &vdd => @PLACE(376, -2990);
// &vdd @WIRE(mode="straight") {#X1205:5 %t6238:p};
// %t6239 = $GROUND @ATTACH &vss => @PLACE(376, -3016);
// &vss @WIRE(mode="straight") {#X1205:6 %t6239:p};
// %t6240 = $IO_PORT @ATTACH &vss => @PLACE(406, -2999) => @ORIENT("R0");
// %t6240 @TEXT("vss", key="name", size=0.75);
// &vss @WIRE(mode="straight") {#X1206:1 %t6240:p};
// %t6241 = $IO_PORT @ATTACH &n1391 => @PLACE(406, -3003) => @ORIENT("R0");
// %t6241 @TEXT("n1391", key="name", size=0.75);
// &n1391 @WIRE(mode="straight") {#X1206:2 %t6241:p};
// %t6242 = $IO_PORT @ATTACH &n960 => @PLACE(406, -3007) => @ORIENT("R0");
// %t6242 @TEXT("n960", key="name", size=0.75);
// &n960 @WIRE(mode="straight") {#X1206:3 %t6242:p};
// %t6243 = $IO_PORT @ATTACH &n1397 => @PLACE(426, -3003) => @ORIENT("MY");
// %t6243 @TEXT("n1397", key="name", size=0.75);
// &n1397 @WIRE(mode="straight") {#X1206:4 %t6243:p};
// %t6244 = $SUPPLY @ATTACH &vdd => @PLACE(416, -2990);
// &vdd @WIRE(mode="straight") {#X1206:5 %t6244:p};
// %t6245 = $GROUND @ATTACH &vss => @PLACE(416, -3016);
// &vss @WIRE(mode="straight") {#X1206:6 %t6245:p};
// %t6246 = $IO_PORT @ATTACH &vss => @PLACE(446, -2999) => @ORIENT("R0");
// %t6246 @TEXT("vss", key="name", size=0.75);
// &vss @WIRE(mode="straight") {#X1207:1 %t6246:p};
// %t6247 = $IO_PORT @ATTACH &n1392 => @PLACE(446, -3003) => @ORIENT("R0");
// %t6247 @TEXT("n1392", key="name", size=0.75);
// &n1392 @WIRE(mode="straight") {#X1207:2 %t6247:p};
// %t6248 = $IO_PORT @ATTACH &n960 => @PLACE(446, -3007) => @ORIENT("R0");
// %t6248 @TEXT("n960", key="name", size=0.75);
// &n960 @WIRE(mode="straight") {#X1207:3 %t6248:p};
// %t6249 = $IO_PORT @ATTACH &n1398 => @PLACE(466, -3003) => @ORIENT("MY");
// %t6249 @TEXT("n1398", key="name", size=0.75);
// &n1398 @WIRE(mode="straight") {#X1207:4 %t6249:p};
// %t6250 = $SUPPLY @ATTACH &vdd => @PLACE(456, -2990);
// &vdd @WIRE(mode="straight") {#X1207:5 %t6250:p};
// %t6251 = $GROUND @ATTACH &vss => @PLACE(456, -3016);
// &vss @WIRE(mode="straight") {#X1207:6 %t6251:p};
// %t6252 = $IO_PORT @ATTACH &vss => @PLACE(326, -3034) => @ORIENT("R0");
// %t6252 @TEXT("vss", key="name", size=0.75);
// &vss @WIRE(mode="straight") {#X1208:1 %t6252:p};
// %t6253 = $IO_PORT @ATTACH &n1393 => @PLACE(326, -3038) => @ORIENT("R0");
// %t6253 @TEXT("n1393", key="name", size=0.75);
// &n1393 @WIRE(mode="straight") {#X1208:2 %t6253:p};
// %t6254 = $IO_PORT @ATTACH &n960 => @PLACE(326, -3042) => @ORIENT("R0");
// %t6254 @TEXT("n960", key="name", size=0.75);
// &n960 @WIRE(mode="straight") {#X1208:3 %t6254:p};
// %t6255 = $IO_PORT @ATTACH &n1399 => @PLACE(346, -3038) => @ORIENT("MY");
// %t6255 @TEXT("n1399", key="name", size=0.75);
// &n1399 @WIRE(mode="straight") {#X1208:4 %t6255:p};
// %t6256 = $SUPPLY @ATTACH &vdd => @PLACE(336, -3025);
// &vdd @WIRE(mode="straight") {#X1208:5 %t6256:p};
// %t6257 = $GROUND @ATTACH &vss => @PLACE(336, -3051);
// &vss @WIRE(mode="straight") {#X1208:6 %t6257:p};
// %t6258 = $IO_PORT @ATTACH &n1394 => @PLACE(366, -3034) => @ORIENT("R0");
// %t6258 @TEXT("n1394", key="name", size=0.75);
// &n1394 @WIRE(mode="straight") {#X1209:1 %t6258:p};
// %t6259 = $IO_PORT @ATTACH &vss => @PLACE(366, -3038) => @ORIENT("R0");
// %t6259 @TEXT("vss", key="name", size=0.75);
// &vss @WIRE(mode="straight") {#X1209:2 %t6259:p};
// %t6260 = $IO_PORT @ATTACH &n234 => @PLACE(366, -3042) => @ORIENT("R0");
// %t6260 @TEXT("n234", key="name", size=0.75);
// &n234 @WIRE(mode="straight") {#X1209:3 %t6260:p};
// %t6261 = $IO_PORT @ATTACH &n1400 => @PLACE(386, -3038) => @ORIENT("MY");
// %t6261 @TEXT("n1400", key="name", size=0.75);
// &n1400 @WIRE(mode="straight") {#X1209:4 %t6261:p};
// %t6262 = $SUPPLY @ATTACH &vdd => @PLACE(376, -3025);
// &vdd @WIRE(mode="straight") {#X1209:5 %t6262:p};
// %t6263 = $GROUND @ATTACH &vss => @PLACE(376, -3051);
// &vss @WIRE(mode="straight") {#X1209:6 %t6263:p};
// %t6264 = $IO_PORT @ATTACH &n1395 => @PLACE(406, -3034) => @ORIENT("R0");
// %t6264 @TEXT("n1395", key="name", size=0.75);
// &n1395 @WIRE(mode="straight") {#X1210:1 %t6264:p};
// %t6265 = $IO_PORT @ATTACH &vss => @PLACE(406, -3038) => @ORIENT("R0");
// %t6265 @TEXT("vss", key="name", size=0.75);
// &vss @WIRE(mode="straight") {#X1210:2 %t6265:p};
// %t6266 = $IO_PORT @ATTACH &n234 => @PLACE(406, -3042) => @ORIENT("R0");
// %t6266 @TEXT("n234", key="name", size=0.75);
// &n234 @WIRE(mode="straight") {#X1210:3 %t6266:p};
// %t6267 = $IO_PORT @ATTACH &n1401 => @PLACE(426, -3038) => @ORIENT("MY");
// %t6267 @TEXT("n1401", key="name", size=0.75);
// &n1401 @WIRE(mode="straight") {#X1210:4 %t6267:p};
// %t6268 = $SUPPLY @ATTACH &vdd => @PLACE(416, -3025);
// &vdd @WIRE(mode="straight") {#X1210:5 %t6268:p};
// %t6269 = $GROUND @ATTACH &vss => @PLACE(416, -3051);
// &vss @WIRE(mode="straight") {#X1210:6 %t6269:p};
// %t6270 = $IO_PORT @ATTACH &n1396 => @PLACE(446, -3034) => @ORIENT("R0");
// %t6270 @TEXT("n1396", key="name", size=0.75);
// &n1396 @WIRE(mode="straight") {#X1211:1 %t6270:p};
// %t6271 = $IO_PORT @ATTACH &vss => @PLACE(446, -3038) => @ORIENT("R0");
// %t6271 @TEXT("vss", key="name", size=0.75);
// &vss @WIRE(mode="straight") {#X1211:2 %t6271:p};
// %t6272 = $IO_PORT @ATTACH &n234 => @PLACE(446, -3042) => @ORIENT("R0");
// %t6272 @TEXT("n234", key="name", size=0.75);
// &n234 @WIRE(mode="straight") {#X1211:3 %t6272:p};
// %t6273 = $IO_PORT @ATTACH &n1402 => @PLACE(466, -3038) => @ORIENT("MY");
// %t6273 @TEXT("n1402", key="name", size=0.75);
// &n1402 @WIRE(mode="straight") {#X1211:4 %t6273:p};
// %t6274 = $SUPPLY @ATTACH &vdd => @PLACE(456, -3025);
// &vdd @WIRE(mode="straight") {#X1211:5 %t6274:p};
// %t6275 = $GROUND @ATTACH &vss => @PLACE(456, -3051);
// &vss @WIRE(mode="straight") {#X1211:6 %t6275:p};
// %t6276 = $IO_PORT @ATTACH &n1397 => @PLACE(326, -3069) => @ORIENT("R0");
// %t6276 @TEXT("n1397", key="name", size=0.75);
// &n1397 @WIRE(mode="straight") {#X1212:1 %t6276:p};
// %t6277 = $IO_PORT @ATTACH &vss => @PLACE(326, -3073) => @ORIENT("R0");
// %t6277 @TEXT("vss", key="name", size=0.75);
// &vss @WIRE(mode="straight") {#X1212:2 %t6277:p};
// %t6278 = $IO_PORT @ATTACH &n234 => @PLACE(326, -3077) => @ORIENT("R0");
// %t6278 @TEXT("n234", key="name", size=0.75);
// &n234 @WIRE(mode="straight") {#X1212:3 %t6278:p};
// %t6279 = $IO_PORT @ATTACH &n1403 => @PLACE(346, -3073) => @ORIENT("MY");
// %t6279 @TEXT("n1403", key="name", size=0.75);
// &n1403 @WIRE(mode="straight") {#X1212:4 %t6279:p};
// %t6280 = $SUPPLY @ATTACH &vdd => @PLACE(336, -3060);
// &vdd @WIRE(mode="straight") {#X1212:5 %t6280:p};
// %t6281 = $GROUND @ATTACH &vss => @PLACE(336, -3086);
// &vss @WIRE(mode="straight") {#X1212:6 %t6281:p};
// %t6282 = $IO_PORT @ATTACH &n1398 => @PLACE(366, -3069) => @ORIENT("R0");
// %t6282 @TEXT("n1398", key="name", size=0.75);
// &n1398 @WIRE(mode="straight") {#X1213:1 %t6282:p};
// %t6283 = $IO_PORT @ATTACH &vss => @PLACE(366, -3073) => @ORIENT("R0");
// %t6283 @TEXT("vss", key="name", size=0.75);
// &vss @WIRE(mode="straight") {#X1213:2 %t6283:p};
// %t6284 = $IO_PORT @ATTACH &n234 => @PLACE(366, -3077) => @ORIENT("R0");
// %t6284 @TEXT("n234", key="name", size=0.75);
// &n234 @WIRE(mode="straight") {#X1213:3 %t6284:p};
// %t6285 = $IO_PORT @ATTACH &n1404 => @PLACE(386, -3073) => @ORIENT("MY");
// %t6285 @TEXT("n1404", key="name", size=0.75);
// &n1404 @WIRE(mode="straight") {#X1213:4 %t6285:p};
// %t6286 = $SUPPLY @ATTACH &vdd => @PLACE(376, -3060);
// &vdd @WIRE(mode="straight") {#X1213:5 %t6286:p};
// %t6287 = $GROUND @ATTACH &vss => @PLACE(376, -3086);
// &vss @WIRE(mode="straight") {#X1213:6 %t6287:p};
// %t6288 = $IO_PORT @ATTACH &n1399 => @PLACE(406, -3069) => @ORIENT("R0");
// %t6288 @TEXT("n1399", key="name", size=0.75);
// &n1399 @WIRE(mode="straight") {#X1214:1 %t6288:p};
// %t6289 = $IO_PORT @ATTACH &vss => @PLACE(406, -3073) => @ORIENT("R0");
// %t6289 @TEXT("vss", key="name", size=0.75);
// &vss @WIRE(mode="straight") {#X1214:2 %t6289:p};
// %t6290 = $IO_PORT @ATTACH &n234 => @PLACE(406, -3077) => @ORIENT("R0");
// %t6290 @TEXT("n234", key="name", size=0.75);
// &n234 @WIRE(mode="straight") {#X1214:3 %t6290:p};
// %t6291 = $IO_PORT @ATTACH &n1405 => @PLACE(426, -3073) => @ORIENT("MY");
// %t6291 @TEXT("n1405", key="name", size=0.75);
// &n1405 @WIRE(mode="straight") {#X1214:4 %t6291:p};
// %t6292 = $SUPPLY @ATTACH &vdd => @PLACE(416, -3060);
// &vdd @WIRE(mode="straight") {#X1214:5 %t6292:p};
// %t6293 = $GROUND @ATTACH &vss => @PLACE(416, -3086);
// &vss @WIRE(mode="straight") {#X1214:6 %t6293:p};
// %t6294 = $IO_PORT @ATTACH &vdd => @PLACE(446, -3069) => @ORIENT("R0");
// %t6294 @TEXT("vdd", key="name", size=0.75);
// &vdd @WIRE(mode="straight") {#X1215:1 %t6294:p};
// %t6295 = $IO_PORT @ATTACH &vss => @PLACE(446, -3073) => @ORIENT("R0");
// %t6295 @TEXT("vss", key="name", size=0.75);
// &vss @WIRE(mode="straight") {#X1215:2 %t6295:p};
// %t6296 = $IO_PORT @ATTACH &n232 => @PLACE(446, -3077) => @ORIENT("R0");
// %t6296 @TEXT("n232", key="name", size=0.75);
// &n232 @WIRE(mode="straight") {#X1215:3 %t6296:p};
// %t6297 = $IO_PORT @ATTACH &n1366 => @PLACE(466, -3073) => @ORIENT("MY");
// %t6297 @TEXT("n1366", key="name", size=0.75);
// &n1366 @WIRE(mode="straight") {#X1215:4 %t6297:p};
// %t6298 = $SUPPLY @ATTACH &vdd => @PLACE(456, -3060);
// &vdd @WIRE(mode="straight") {#X1215:5 %t6298:p};
// %t6299 = $GROUND @ATTACH &vss => @PLACE(456, -3086);
// &vss @WIRE(mode="straight") {#X1215:6 %t6299:p};
// %t6300 = $IO_PORT @ATTACH &n1400 => @PLACE(326, -3104) => @ORIENT("R0");
// %t6300 @TEXT("n1400", key="name", size=0.75);
// &n1400 @WIRE(mode="straight") {#X1216:1 %t6300:p};
// %t6301 = $IO_PORT @ATTACH &n1366 => @PLACE(326, -3108) => @ORIENT("R0");
// %t6301 @TEXT("n1366", key="name", size=0.75);
// &n1366 @WIRE(mode="straight") {#X1216:2 %t6301:p};
// %t6302 = $IO_PORT @ATTACH &n238 => @PLACE(326, -3112) => @ORIENT("R0");
// %t6302 @TEXT("n238", key="name", size=0.75);
// &n238 @WIRE(mode="straight") {#X1216:3 %t6302:p};
// %t6303 = $IO_PORT @ATTACH &n1406 => @PLACE(346, -3108) => @ORIENT("MY");
// %t6303 @TEXT("n1406", key="name", size=0.75);
// &n1406 @WIRE(mode="straight") {#X1216:4 %t6303:p};
// %t6304 = $SUPPLY @ATTACH &vdd => @PLACE(336, -3095);
// &vdd @WIRE(mode="straight") {#X1216:5 %t6304:p};
// %t6305 = $GROUND @ATTACH &vss => @PLACE(336, -3121);
// &vss @WIRE(mode="straight") {#X1216:6 %t6305:p};
// %t6306 = $IO_PORT @ATTACH &n1401 => @PLACE(366, -3104) => @ORIENT("R0");
// %t6306 @TEXT("n1401", key="name", size=0.75);
// &n1401 @WIRE(mode="straight") {#X1217:1 %t6306:p};
// %t6307 = $IO_PORT @ATTACH &n1366 => @PLACE(366, -3108) => @ORIENT("R0");
// %t6307 @TEXT("n1366", key="name", size=0.75);
// &n1366 @WIRE(mode="straight") {#X1217:2 %t6307:p};
// %t6308 = $IO_PORT @ATTACH &n238 => @PLACE(366, -3112) => @ORIENT("R0");
// %t6308 @TEXT("n238", key="name", size=0.75);
// &n238 @WIRE(mode="straight") {#X1217:3 %t6308:p};
// %t6309 = $IO_PORT @ATTACH &n1407 => @PLACE(386, -3108) => @ORIENT("MY");
// %t6309 @TEXT("n1407", key="name", size=0.75);
// &n1407 @WIRE(mode="straight") {#X1217:4 %t6309:p};
// %t6310 = $SUPPLY @ATTACH &vdd => @PLACE(376, -3095);
// &vdd @WIRE(mode="straight") {#X1217:5 %t6310:p};
// %t6311 = $GROUND @ATTACH &vss => @PLACE(376, -3121);
// &vss @WIRE(mode="straight") {#X1217:6 %t6311:p};
// %t6312 = $IO_PORT @ATTACH &n1402 => @PLACE(406, -3104) => @ORIENT("R0");
// %t6312 @TEXT("n1402", key="name", size=0.75);
// &n1402 @WIRE(mode="straight") {#X1218:1 %t6312:p};
// %t6313 = $IO_PORT @ATTACH &n1368 => @PLACE(406, -3108) => @ORIENT("R0");
// %t6313 @TEXT("n1368", key="name", size=0.75);
// &n1368 @WIRE(mode="straight") {#X1218:2 %t6313:p};
// %t6314 = $IO_PORT @ATTACH &n238 => @PLACE(406, -3112) => @ORIENT("R0");
// %t6314 @TEXT("n238", key="name", size=0.75);
// &n238 @WIRE(mode="straight") {#X1218:3 %t6314:p};
// %t6315 = $IO_PORT @ATTACH &n1408 => @PLACE(426, -3108) => @ORIENT("MY");
// %t6315 @TEXT("n1408", key="name", size=0.75);
// &n1408 @WIRE(mode="straight") {#X1218:4 %t6315:p};
// %t6316 = $SUPPLY @ATTACH &vdd => @PLACE(416, -3095);
// &vdd @WIRE(mode="straight") {#X1218:5 %t6316:p};
// %t6317 = $GROUND @ATTACH &vss => @PLACE(416, -3121);
// &vss @WIRE(mode="straight") {#X1218:6 %t6317:p};
// %t6318 = $IO_PORT @ATTACH &n1403 => @PLACE(446, -3104) => @ORIENT("R0");
// %t6318 @TEXT("n1403", key="name", size=0.75);
// &n1403 @WIRE(mode="straight") {#X1219:1 %t6318:p};
// %t6319 = $IO_PORT @ATTACH &n1366 => @PLACE(446, -3108) => @ORIENT("R0");
// %t6319 @TEXT("n1366", key="name", size=0.75);
// &n1366 @WIRE(mode="straight") {#X1219:2 %t6319:p};
// %t6320 = $IO_PORT @ATTACH &n238 => @PLACE(446, -3112) => @ORIENT("R0");
// %t6320 @TEXT("n238", key="name", size=0.75);
// &n238 @WIRE(mode="straight") {#X1219:3 %t6320:p};
// %t6321 = $IO_PORT @ATTACH &n1409 => @PLACE(466, -3108) => @ORIENT("MY");
// %t6321 @TEXT("n1409", key="name", size=0.75);
// &n1409 @WIRE(mode="straight") {#X1219:4 %t6321:p};
// %t6322 = $SUPPLY @ATTACH &vdd => @PLACE(456, -3095);
// &vdd @WIRE(mode="straight") {#X1219:5 %t6322:p};
// %t6323 = $GROUND @ATTACH &vss => @PLACE(456, -3121);
// &vss @WIRE(mode="straight") {#X1219:6 %t6323:p};
// %t6324 = $IO_PORT @ATTACH &n1404 => @PLACE(326, -3139) => @ORIENT("R0");
// %t6324 @TEXT("n1404", key="name", size=0.75);
// &n1404 @WIRE(mode="straight") {#X1220:1 %t6324:p};
// %t6325 = $IO_PORT @ATTACH &n1368 => @PLACE(326, -3143) => @ORIENT("R0");
// %t6325 @TEXT("n1368", key="name", size=0.75);
// &n1368 @WIRE(mode="straight") {#X1220:2 %t6325:p};
// %t6326 = $IO_PORT @ATTACH &n238 => @PLACE(326, -3147) => @ORIENT("R0");
// %t6326 @TEXT("n238", key="name", size=0.75);
// &n238 @WIRE(mode="straight") {#X1220:3 %t6326:p};
// %t6327 = $IO_PORT @ATTACH &n1410 => @PLACE(346, -3143) => @ORIENT("MY");
// %t6327 @TEXT("n1410", key="name", size=0.75);
// &n1410 @WIRE(mode="straight") {#X1220:4 %t6327:p};
// %t6328 = $SUPPLY @ATTACH &vdd => @PLACE(336, -3130);
// &vdd @WIRE(mode="straight") {#X1220:5 %t6328:p};
// %t6329 = $GROUND @ATTACH &vss => @PLACE(336, -3156);
// &vss @WIRE(mode="straight") {#X1220:6 %t6329:p};
// %t6330 = $IO_PORT @ATTACH &n1405 => @PLACE(366, -3139) => @ORIENT("R0");
// %t6330 @TEXT("n1405", key="name", size=0.75);
// &n1405 @WIRE(mode="straight") {#X1221:1 %t6330:p};
// %t6331 = $IO_PORT @ATTACH &n1368 => @PLACE(366, -3143) => @ORIENT("R0");
// %t6331 @TEXT("n1368", key="name", size=0.75);
// &n1368 @WIRE(mode="straight") {#X1221:2 %t6331:p};
// %t6332 = $IO_PORT @ATTACH &n238 => @PLACE(366, -3147) => @ORIENT("R0");
// %t6332 @TEXT("n238", key="name", size=0.75);
// &n238 @WIRE(mode="straight") {#X1221:3 %t6332:p};
// %t6333 = $IO_PORT @ATTACH &n1411 => @PLACE(386, -3143) => @ORIENT("MY");
// %t6333 @TEXT("n1411", key="name", size=0.75);
// &n1411 @WIRE(mode="straight") {#X1221:4 %t6333:p};
// %t6334 = $SUPPLY @ATTACH &vdd => @PLACE(376, -3130);
// &vdd @WIRE(mode="straight") {#X1221:5 %t6334:p};
// %t6335 = $GROUND @ATTACH &vss => @PLACE(376, -3156);
// &vss @WIRE(mode="straight") {#X1221:6 %t6335:p};
// %t6336 = $IO_PORT @ATTACH &n1374 => @PLACE(406, -3139) => @ORIENT("R0");
// %t6336 @TEXT("n1374", key="name", size=0.75);
// &n1374 @WIRE(mode="straight") {#X1222:1 %t6336:p};
// %t6337 = $IO_PORT @ATTACH &n1406 => @PLACE(406, -3143) => @ORIENT("R0");
// %t6337 @TEXT("n1406", key="name", size=0.75);
// &n1406 @WIRE(mode="straight") {#X1222:2 %t6337:p};
// %t6338 = $IO_PORT @ATTACH &n88 => @PLACE(406, -3147) => @ORIENT("R0");
// %t6338 @TEXT("n88", key="name", size=0.75);
// &n88 @WIRE(mode="straight") {#X1222:3 %t6338:p};
// %t6339 = $IO_PORT @ATTACH &n149 => @PLACE(426, -3143) => @ORIENT("MY");
// %t6339 @TEXT("n149", key="name", size=0.75);
// &n149 @WIRE(mode="straight") {#X1222:4 %t6339:p};
// %t6340 = $SUPPLY @ATTACH &vdd => @PLACE(416, -3130);
// &vdd @WIRE(mode="straight") {#X1222:5 %t6340:p};
// %t6341 = $GROUND @ATTACH &vss => @PLACE(416, -3156);
// &vss @WIRE(mode="straight") {#X1222:6 %t6341:p};
// %t6342 = $IO_PORT @ATTACH &n1374 => @PLACE(446, -3139) => @ORIENT("R0");
// %t6342 @TEXT("n1374", key="name", size=0.75);
// &n1374 @WIRE(mode="straight") {#X1223:1 %t6342:p};
// %t6343 = $IO_PORT @ATTACH &n1407 => @PLACE(446, -3143) => @ORIENT("R0");
// %t6343 @TEXT("n1407", key="name", size=0.75);
// &n1407 @WIRE(mode="straight") {#X1223:2 %t6343:p};
// %t6344 = $IO_PORT @ATTACH &n88 => @PLACE(446, -3147) => @ORIENT("R0");
// %t6344 @TEXT("n88", key="name", size=0.75);
// &n88 @WIRE(mode="straight") {#X1223:3 %t6344:p};
// %t6345 = $IO_PORT @ATTACH &n148 => @PLACE(466, -3143) => @ORIENT("MY");
// %t6345 @TEXT("n148", key="name", size=0.75);
// &n148 @WIRE(mode="straight") {#X1223:4 %t6345:p};
// %t6346 = $SUPPLY @ATTACH &vdd => @PLACE(456, -3130);
// &vdd @WIRE(mode="straight") {#X1223:5 %t6346:p};
// %t6347 = $GROUND @ATTACH &vss => @PLACE(456, -3156);
// &vss @WIRE(mode="straight") {#X1223:6 %t6347:p};
// %t6348 = $IO_PORT @ATTACH &n1375 => @PLACE(494, -2964) => @ORIENT("R0");
// %t6348 @TEXT("n1375", key="name", size=0.75);
// &n1375 @WIRE(mode="straight") {#X1224:1 %t6348:p};
// %t6349 = $IO_PORT @ATTACH &n1408 => @PLACE(494, -2968) => @ORIENT("R0");
// %t6349 @TEXT("n1408", key="name", size=0.75);
// &n1408 @WIRE(mode="straight") {#X1224:2 %t6349:p};
// %t6350 = $IO_PORT @ATTACH &n88 => @PLACE(494, -2972) => @ORIENT("R0");
// %t6350 @TEXT("n88", key="name", size=0.75);
// &n88 @WIRE(mode="straight") {#X1224:3 %t6350:p};
// %t6351 = $IO_PORT @ATTACH &n147 => @PLACE(514, -2968) => @ORIENT("MY");
// %t6351 @TEXT("n147", key="name", size=0.75);
// &n147 @WIRE(mode="straight") {#X1224:4 %t6351:p};
// %t6352 = $SUPPLY @ATTACH &vdd => @PLACE(504, -2955);
// &vdd @WIRE(mode="straight") {#X1224:5 %t6352:p};
// %t6353 = $GROUND @ATTACH &vss => @PLACE(504, -2981);
// &vss @WIRE(mode="straight") {#X1224:6 %t6353:p};
// %t6354 = $IO_PORT @ATTACH &n1374 => @PLACE(534, -2964) => @ORIENT("R0");
// %t6354 @TEXT("n1374", key="name", size=0.75);
// &n1374 @WIRE(mode="straight") {#X1225:1 %t6354:p};
// %t6355 = $IO_PORT @ATTACH &n1409 => @PLACE(534, -2968) => @ORIENT("R0");
// %t6355 @TEXT("n1409", key="name", size=0.75);
// &n1409 @WIRE(mode="straight") {#X1225:2 %t6355:p};
// %t6356 = $IO_PORT @ATTACH &n88 => @PLACE(534, -2972) => @ORIENT("R0");
// %t6356 @TEXT("n88", key="name", size=0.75);
// &n88 @WIRE(mode="straight") {#X1225:3 %t6356:p};
// %t6357 = $IO_PORT @ATTACH &n146 => @PLACE(554, -2968) => @ORIENT("MY");
// %t6357 @TEXT("n146", key="name", size=0.75);
// &n146 @WIRE(mode="straight") {#X1225:4 %t6357:p};
// %t6358 = $SUPPLY @ATTACH &vdd => @PLACE(544, -2955);
// &vdd @WIRE(mode="straight") {#X1225:5 %t6358:p};
// %t6359 = $GROUND @ATTACH &vss => @PLACE(544, -2981);
// &vss @WIRE(mode="straight") {#X1225:6 %t6359:p};
// %t6360 = $IO_PORT @ATTACH &n1375 => @PLACE(574, -2964) => @ORIENT("R0");
// %t6360 @TEXT("n1375", key="name", size=0.75);
// &n1375 @WIRE(mode="straight") {#X1226:1 %t6360:p};
// %t6361 = $IO_PORT @ATTACH &n1410 => @PLACE(574, -2968) => @ORIENT("R0");
// %t6361 @TEXT("n1410", key="name", size=0.75);
// &n1410 @WIRE(mode="straight") {#X1226:2 %t6361:p};
// %t6362 = $IO_PORT @ATTACH &n88 => @PLACE(574, -2972) => @ORIENT("R0");
// %t6362 @TEXT("n88", key="name", size=0.75);
// &n88 @WIRE(mode="straight") {#X1226:3 %t6362:p};
// %t6363 = $IO_PORT @ATTACH &n144 => @PLACE(594, -2968) => @ORIENT("MY");
// %t6363 @TEXT("n144", key="name", size=0.75);
// &n144 @WIRE(mode="straight") {#X1226:4 %t6363:p};
// %t6364 = $SUPPLY @ATTACH &vdd => @PLACE(584, -2955);
// &vdd @WIRE(mode="straight") {#X1226:5 %t6364:p};
// %t6365 = $GROUND @ATTACH &vss => @PLACE(584, -2981);
// &vss @WIRE(mode="straight") {#X1226:6 %t6365:p};
// %t6366 = $IO_PORT @ATTACH &n1375 => @PLACE(614, -2964) => @ORIENT("R0");
// %t6366 @TEXT("n1375", key="name", size=0.75);
// &n1375 @WIRE(mode="straight") {#X1227:1 %t6366:p};
// %t6367 = $IO_PORT @ATTACH &n1411 => @PLACE(614, -2968) => @ORIENT("R0");
// %t6367 @TEXT("n1411", key="name", size=0.75);
// &n1411 @WIRE(mode="straight") {#X1227:2 %t6367:p};
// %t6368 = $IO_PORT @ATTACH &n88 => @PLACE(614, -2972) => @ORIENT("R0");
// %t6368 @TEXT("n88", key="name", size=0.75);
// &n88 @WIRE(mode="straight") {#X1227:3 %t6368:p};
// %t6369 = $IO_PORT @ATTACH &n193 => @PLACE(635, -2968) => @ORIENT("MY");
// %t6369 @TEXT("n193", key="name", size=0.75);
// &n193 @WIRE(mode="straight") {#X1227:4 %t6369:p};
// %t6370 = $SUPPLY @ATTACH &vdd => @PLACE(624, -2955);
// &vdd @WIRE(mode="straight") {#X1227:5 %t6370:p};
// %t6371 = $GROUND @ATTACH &vss => @PLACE(624, -2981);
// &vss @WIRE(mode="straight") {#X1227:6 %t6371:p};
// %t6372 = $IO_PORT @ATTACH &vss => @PLACE(494, -2999) => @ORIENT("R0");
// %t6372 @TEXT("vss", key="name", size=0.75);
// &vss @WIRE(mode="straight") {#X1228:1 %t6372:p};
// %t6373 = $IO_PORT @ATTACH &n1089 => @PLACE(494, -3003) => @ORIENT("R0");
// %t6373 @TEXT("n1089", key="name", size=0.75);
// &n1089 @WIRE(mode="straight") {#X1228:2 %t6373:p};
// %t6374 = $IO_PORT @ATTACH &n960 => @PLACE(494, -3007) => @ORIENT("R0");
// %t6374 @TEXT("n960", key="name", size=0.75);
// &n960 @WIRE(mode="straight") {#X1228:3 %t6374:p};
// %t6375 = $IO_PORT @ATTACH &n1412 => @PLACE(514, -3003) => @ORIENT("MY");
// %t6375 @TEXT("n1412", key="name", size=0.75);
// &n1412 @WIRE(mode="straight") {#X1228:4 %t6375:p};
// %t6376 = $SUPPLY @ATTACH &vdd => @PLACE(504, -2990);
// &vdd @WIRE(mode="straight") {#X1228:5 %t6376:p};
// %t6377 = $GROUND @ATTACH &vss => @PLACE(504, -3016);
// &vss @WIRE(mode="straight") {#X1228:6 %t6377:p};
// %t6378 = $IO_PORT @ATTACH &vss => @PLACE(534, -2999) => @ORIENT("R0");
// %t6378 @TEXT("vss", key="name", size=0.75);
// &vss @WIRE(mode="straight") {#X1229:1 %t6378:p};
// %t6379 = $IO_PORT @ATTACH &n557 => @PLACE(534, -3003) => @ORIENT("R0");
// %t6379 @TEXT("n557", key="name", size=0.75);
// &n557 @WIRE(mode="straight") {#X1229:2 %t6379:p};
// %t6380 = $IO_PORT @ATTACH &n960 => @PLACE(534, -3007) => @ORIENT("R0");
// %t6380 @TEXT("n960", key="name", size=0.75);
// &n960 @WIRE(mode="straight") {#X1229:3 %t6380:p};
// %t6381 = $IO_PORT @ATTACH &n1413 => @PLACE(554, -3003) => @ORIENT("MY");
// %t6381 @TEXT("n1413", key="name", size=0.75);
// &n1413 @WIRE(mode="straight") {#X1229:4 %t6381:p};
// %t6382 = $SUPPLY @ATTACH &vdd => @PLACE(544, -2990);
// &vdd @WIRE(mode="straight") {#X1229:5 %t6382:p};
// %t6383 = $GROUND @ATTACH &vss => @PLACE(544, -3016);
// &vss @WIRE(mode="straight") {#X1229:6 %t6383:p};
// %t6384 = $IO_PORT @ATTACH &vss => @PLACE(574, -2999) => @ORIENT("R0");
// %t6384 @TEXT("vss", key="name", size=0.75);
// &vss @WIRE(mode="straight") {#X1230:1 %t6384:p};
// %t6385 = $IO_PORT @ATTACH &n559 => @PLACE(574, -3003) => @ORIENT("R0");
// %t6385 @TEXT("n559", key="name", size=0.75);
// &n559 @WIRE(mode="straight") {#X1230:2 %t6385:p};
// %t6386 = $IO_PORT @ATTACH &n960 => @PLACE(574, -3007) => @ORIENT("R0");
// %t6386 @TEXT("n960", key="name", size=0.75);
// &n960 @WIRE(mode="straight") {#X1230:3 %t6386:p};
// %t6387 = $IO_PORT @ATTACH &n1414 => @PLACE(594, -3003) => @ORIENT("MY");
// %t6387 @TEXT("n1414", key="name", size=0.75);
// &n1414 @WIRE(mode="straight") {#X1230:4 %t6387:p};
// %t6388 = $SUPPLY @ATTACH &vdd => @PLACE(584, -2990);
// &vdd @WIRE(mode="straight") {#X1230:5 %t6388:p};
// %t6389 = $GROUND @ATTACH &vss => @PLACE(584, -3016);
// &vss @WIRE(mode="straight") {#X1230:6 %t6389:p};
// %t6390 = $IO_PORT @ATTACH &n1412 => @PLACE(614, -2999) => @ORIENT("R0");
// %t6390 @TEXT("n1412", key="name", size=0.75);
// &n1412 @WIRE(mode="straight") {#X1231:1 %t6390:p};
// %t6391 = $IO_PORT @ATTACH &vss => @PLACE(614, -3003) => @ORIENT("R0");
// %t6391 @TEXT("vss", key="name", size=0.75);
// &vss @WIRE(mode="straight") {#X1231:2 %t6391:p};
// %t6392 = $IO_PORT @ATTACH &n234 => @PLACE(614, -3007) => @ORIENT("R0");
// %t6392 @TEXT("n234", key="name", size=0.75);
// &n234 @WIRE(mode="straight") {#X1231:3 %t6392:p};
// %t6393 = $IO_PORT @ATTACH &n1415 => @PLACE(635, -3003) => @ORIENT("MY");
// %t6393 @TEXT("n1415", key="name", size=0.75);
// &n1415 @WIRE(mode="straight") {#X1231:4 %t6393:p};
// %t6394 = $SUPPLY @ATTACH &vdd => @PLACE(624, -2990);
// &vdd @WIRE(mode="straight") {#X1231:5 %t6394:p};
// %t6395 = $GROUND @ATTACH &vss => @PLACE(624, -3016);
// &vss @WIRE(mode="straight") {#X1231:6 %t6395:p};
// %t6396 = $IO_PORT @ATTACH &n1413 => @PLACE(494, -3034) => @ORIENT("R0");
// %t6396 @TEXT("n1413", key="name", size=0.75);
// &n1413 @WIRE(mode="straight") {#X1232:1 %t6396:p};
// %t6397 = $IO_PORT @ATTACH &vss => @PLACE(494, -3038) => @ORIENT("R0");
// %t6397 @TEXT("vss", key="name", size=0.75);
// &vss @WIRE(mode="straight") {#X1232:2 %t6397:p};
// %t6398 = $IO_PORT @ATTACH &n234 => @PLACE(494, -3042) => @ORIENT("R0");
// %t6398 @TEXT("n234", key="name", size=0.75);
// &n234 @WIRE(mode="straight") {#X1232:3 %t6398:p};
// %t6399 = $IO_PORT @ATTACH &n1416 => @PLACE(514, -3038) => @ORIENT("MY");
// %t6399 @TEXT("n1416", key="name", size=0.75);
// &n1416 @WIRE(mode="straight") {#X1232:4 %t6399:p};
// %t6400 = $SUPPLY @ATTACH &vdd => @PLACE(504, -3025);
// &vdd @WIRE(mode="straight") {#X1232:5 %t6400:p};
// %t6401 = $GROUND @ATTACH &vss => @PLACE(504, -3051);
// &vss @WIRE(mode="straight") {#X1232:6 %t6401:p};
// %t6402 = $IO_PORT @ATTACH &n1414 => @PLACE(534, -3034) => @ORIENT("R0");
// %t6402 @TEXT("n1414", key="name", size=0.75);
// &n1414 @WIRE(mode="straight") {#X1233:1 %t6402:p};
// %t6403 = $IO_PORT @ATTACH &vss => @PLACE(534, -3038) => @ORIENT("R0");
// %t6403 @TEXT("vss", key="name", size=0.75);
// &vss @WIRE(mode="straight") {#X1233:2 %t6403:p};
// %t6404 = $IO_PORT @ATTACH &n234 => @PLACE(534, -3042) => @ORIENT("R0");
// %t6404 @TEXT("n234", key="name", size=0.75);
// &n234 @WIRE(mode="straight") {#X1233:3 %t6404:p};
// %t6405 = $IO_PORT @ATTACH &n1417 => @PLACE(554, -3038) => @ORIENT("MY");
// %t6405 @TEXT("n1417", key="name", size=0.75);
// &n1417 @WIRE(mode="straight") {#X1233:4 %t6405:p};
// %t6406 = $SUPPLY @ATTACH &vdd => @PLACE(544, -3025);
// &vdd @WIRE(mode="straight") {#X1233:5 %t6406:p};
// %t6407 = $GROUND @ATTACH &vss => @PLACE(544, -3051);
// &vss @WIRE(mode="straight") {#X1233:6 %t6407:p};
// %t6408 = $IO_PORT @ATTACH &n1089 => @PLACE(574, -3034) => @ORIENT("R0");
// %t6408 @TEXT("n1089", key="name", size=0.75);
// &n1089 @WIRE(mode="straight") {#X1234:1 %t6408:p};
// %t6409 = $IO_PORT @ATTACH &vss => @PLACE(574, -3038) => @ORIENT("R0");
// %t6409 @TEXT("vss", key="name", size=0.75);
// &vss @WIRE(mode="straight") {#X1234:2 %t6409:p};
// %t6410 = $IO_PORT @ATTACH &n232 => @PLACE(574, -3042) => @ORIENT("R0");
// %t6410 @TEXT("n232", key="name", size=0.75);
// &n232 @WIRE(mode="straight") {#X1234:3 %t6410:p};
// %t6411 = $IO_PORT @ATTACH &n1418 => @PLACE(594, -3038) => @ORIENT("MY");
// %t6411 @TEXT("n1418", key="name", size=0.75);
// &n1418 @WIRE(mode="straight") {#X1234:4 %t6411:p};
// %t6412 = $SUPPLY @ATTACH &vdd => @PLACE(584, -3025);
// &vdd @WIRE(mode="straight") {#X1234:5 %t6412:p};
// %t6413 = $GROUND @ATTACH &vss => @PLACE(584, -3051);
// &vss @WIRE(mode="straight") {#X1234:6 %t6413:p};
// %t6414 = $IO_PORT @ATTACH &n557 => @PLACE(614, -3034) => @ORIENT("R0");
// %t6414 @TEXT("n557", key="name", size=0.75);
// &n557 @WIRE(mode="straight") {#X1235:1 %t6414:p};
// %t6415 = $IO_PORT @ATTACH &vss => @PLACE(614, -3038) => @ORIENT("R0");
// %t6415 @TEXT("vss", key="name", size=0.75);
// &vss @WIRE(mode="straight") {#X1235:2 %t6415:p};
// %t6416 = $IO_PORT @ATTACH &n232 => @PLACE(614, -3042) => @ORIENT("R0");
// %t6416 @TEXT("n232", key="name", size=0.75);
// &n232 @WIRE(mode="straight") {#X1235:3 %t6416:p};
// %t6417 = $IO_PORT @ATTACH &n1419 => @PLACE(635, -3038) => @ORIENT("MY");
// %t6417 @TEXT("n1419", key="name", size=0.75);
// &n1419 @WIRE(mode="straight") {#X1235:4 %t6417:p};
// %t6418 = $SUPPLY @ATTACH &vdd => @PLACE(624, -3025);
// &vdd @WIRE(mode="straight") {#X1235:5 %t6418:p};
// %t6419 = $GROUND @ATTACH &vss => @PLACE(624, -3051);
// &vss @WIRE(mode="straight") {#X1235:6 %t6419:p};
// %t6420 = $IO_PORT @ATTACH &n559 => @PLACE(494, -3069) => @ORIENT("R0");
// %t6420 @TEXT("n559", key="name", size=0.75);
// &n559 @WIRE(mode="straight") {#X1236:1 %t6420:p};
// %t6421 = $IO_PORT @ATTACH &vss => @PLACE(494, -3073) => @ORIENT("R0");
// %t6421 @TEXT("vss", key="name", size=0.75);
// &vss @WIRE(mode="straight") {#X1236:2 %t6421:p};
// %t6422 = $IO_PORT @ATTACH &n232 => @PLACE(494, -3077) => @ORIENT("R0");
// %t6422 @TEXT("n232", key="name", size=0.75);
// &n232 @WIRE(mode="straight") {#X1236:3 %t6422:p};
// %t6423 = $IO_PORT @ATTACH &n1420 => @PLACE(514, -3073) => @ORIENT("MY");
// %t6423 @TEXT("n1420", key="name", size=0.75);
// &n1420 @WIRE(mode="straight") {#X1236:4 %t6423:p};
// %t6424 = $SUPPLY @ATTACH &vdd => @PLACE(504, -3060);
// &vdd @WIRE(mode="straight") {#X1236:5 %t6424:p};
// %t6425 = $GROUND @ATTACH &vss => @PLACE(504, -3086);
// &vss @WIRE(mode="straight") {#X1236:6 %t6425:p};
// %t6426 = $IO_PORT @ATTACH &n1415 => @PLACE(534, -3069) => @ORIENT("R0");
// %t6426 @TEXT("n1415", key="name", size=0.75);
// &n1415 @WIRE(mode="straight") {#X1237:1 %t6426:p};
// %t6427 = $IO_PORT @ATTACH &n1418 => @PLACE(534, -3073) => @ORIENT("R0");
// %t6427 @TEXT("n1418", key="name", size=0.75);
// &n1418 @WIRE(mode="straight") {#X1237:2 %t6427:p};
// %t6428 = $IO_PORT @ATTACH &n238 => @PLACE(534, -3077) => @ORIENT("R0");
// %t6428 @TEXT("n238", key="name", size=0.75);
// &n238 @WIRE(mode="straight") {#X1237:3 %t6428:p};
// %t6429 = $IO_PORT @ATTACH &n1421 => @PLACE(554, -3073) => @ORIENT("MY");
// %t6429 @TEXT("n1421", key="name", size=0.75);
// &n1421 @WIRE(mode="straight") {#X1237:4 %t6429:p};
// %t6430 = $SUPPLY @ATTACH &vdd => @PLACE(544, -3060);
// &vdd @WIRE(mode="straight") {#X1237:5 %t6430:p};
// %t6431 = $GROUND @ATTACH &vss => @PLACE(544, -3086);
// &vss @WIRE(mode="straight") {#X1237:6 %t6431:p};
// %t6432 = $IO_PORT @ATTACH &n1416 => @PLACE(574, -3069) => @ORIENT("R0");
// %t6432 @TEXT("n1416", key="name", size=0.75);
// &n1416 @WIRE(mode="straight") {#X1238:1 %t6432:p};
// %t6433 = $IO_PORT @ATTACH &n1419 => @PLACE(574, -3073) => @ORIENT("R0");
// %t6433 @TEXT("n1419", key="name", size=0.75);
// &n1419 @WIRE(mode="straight") {#X1238:2 %t6433:p};
// %t6434 = $IO_PORT @ATTACH &n238 => @PLACE(574, -3077) => @ORIENT("R0");
// %t6434 @TEXT("n238", key="name", size=0.75);
// &n238 @WIRE(mode="straight") {#X1238:3 %t6434:p};
// %t6435 = $IO_PORT @ATTACH &n1422 => @PLACE(594, -3073) => @ORIENT("MY");
// %t6435 @TEXT("n1422", key="name", size=0.75);
// &n1422 @WIRE(mode="straight") {#X1238:4 %t6435:p};
// %t6436 = $SUPPLY @ATTACH &vdd => @PLACE(584, -3060);
// &vdd @WIRE(mode="straight") {#X1238:5 %t6436:p};
// %t6437 = $GROUND @ATTACH &vss => @PLACE(584, -3086);
// &vss @WIRE(mode="straight") {#X1238:6 %t6437:p};
// %t6438 = $IO_PORT @ATTACH &n1417 => @PLACE(614, -3069) => @ORIENT("R0");
// %t6438 @TEXT("n1417", key="name", size=0.75);
// &n1417 @WIRE(mode="straight") {#X1239:1 %t6438:p};
// %t6439 = $IO_PORT @ATTACH &n1420 => @PLACE(614, -3073) => @ORIENT("R0");
// %t6439 @TEXT("n1420", key="name", size=0.75);
// &n1420 @WIRE(mode="straight") {#X1239:2 %t6439:p};
// %t6440 = $IO_PORT @ATTACH &n238 => @PLACE(614, -3077) => @ORIENT("R0");
// %t6440 @TEXT("n238", key="name", size=0.75);
// &n238 @WIRE(mode="straight") {#X1239:3 %t6440:p};
// %t6441 = $IO_PORT @ATTACH &n1423 => @PLACE(635, -3073) => @ORIENT("MY");
// %t6441 @TEXT("n1423", key="name", size=0.75);
// &n1423 @WIRE(mode="straight") {#X1239:4 %t6441:p};
// %t6442 = $SUPPLY @ATTACH &vdd => @PLACE(624, -3060);
// &vdd @WIRE(mode="straight") {#X1239:5 %t6442:p};
// %t6443 = $GROUND @ATTACH &vss => @PLACE(624, -3086);
// &vss @WIRE(mode="straight") {#X1239:6 %t6443:p};
// %t6444 = $IO_PORT @ATTACH &n1375 => @PLACE(494, -3104) => @ORIENT("R0");
// %t6444 @TEXT("n1375", key="name", size=0.75);
// &n1375 @WIRE(mode="straight") {#X1240:1 %t6444:p};
// %t6445 = $IO_PORT @ATTACH &n1421 => @PLACE(494, -3108) => @ORIENT("R0");
// %t6445 @TEXT("n1421", key="name", size=0.75);
// &n1421 @WIRE(mode="straight") {#X1240:2 %t6445:p};
// %t6446 = $IO_PORT @ATTACH &n88 => @PLACE(494, -3112) => @ORIENT("R0");
// %t6446 @TEXT("n88", key="name", size=0.75);
// &n88 @WIRE(mode="straight") {#X1240:3 %t6446:p};
// %t6447 = $IO_PORT @ATTACH &n140 => @PLACE(514, -3108) => @ORIENT("MY");
// %t6447 @TEXT("n140", key="name", size=0.75);
// &n140 @WIRE(mode="straight") {#X1240:4 %t6447:p};
// %t6448 = $SUPPLY @ATTACH &vdd => @PLACE(504, -3095);
// &vdd @WIRE(mode="straight") {#X1240:5 %t6448:p};
// %t6449 = $GROUND @ATTACH &vss => @PLACE(504, -3121);
// &vss @WIRE(mode="straight") {#X1240:6 %t6449:p};
// %t6450 = $IO_PORT @ATTACH &n1375 => @PLACE(534, -3104) => @ORIENT("R0");
// %t6450 @TEXT("n1375", key="name", size=0.75);
// &n1375 @WIRE(mode="straight") {#X1241:1 %t6450:p};
// %t6451 = $IO_PORT @ATTACH &n1422 => @PLACE(534, -3108) => @ORIENT("R0");
// %t6451 @TEXT("n1422", key="name", size=0.75);
// &n1422 @WIRE(mode="straight") {#X1241:2 %t6451:p};
// %t6452 = $IO_PORT @ATTACH &n88 => @PLACE(534, -3112) => @ORIENT("R0");
// %t6452 @TEXT("n88", key="name", size=0.75);
// &n88 @WIRE(mode="straight") {#X1241:3 %t6452:p};
// %t6453 = $IO_PORT @ATTACH &n138 => @PLACE(554, -3108) => @ORIENT("MY");
// %t6453 @TEXT("n138", key="name", size=0.75);
// &n138 @WIRE(mode="straight") {#X1241:4 %t6453:p};
// %t6454 = $SUPPLY @ATTACH &vdd => @PLACE(544, -3095);
// &vdd @WIRE(mode="straight") {#X1241:5 %t6454:p};
// %t6455 = $GROUND @ATTACH &vss => @PLACE(544, -3121);
// &vss @WIRE(mode="straight") {#X1241:6 %t6455:p};
// %t6456 = $IO_PORT @ATTACH &n1375 => @PLACE(574, -3104) => @ORIENT("R0");
// %t6456 @TEXT("n1375", key="name", size=0.75);
// &n1375 @WIRE(mode="straight") {#X1242:1 %t6456:p};
// %t6457 = $IO_PORT @ATTACH &n1423 => @PLACE(574, -3108) => @ORIENT("R0");
// %t6457 @TEXT("n1423", key="name", size=0.75);
// &n1423 @WIRE(mode="straight") {#X1242:2 %t6457:p};
// %t6458 = $IO_PORT @ATTACH &n88 => @PLACE(574, -3112) => @ORIENT("R0");
// %t6458 @TEXT("n88", key="name", size=0.75);
// &n88 @WIRE(mode="straight") {#X1242:3 %t6458:p};
// %t6459 = $IO_PORT @ATTACH &n199 => @PLACE(594, -3108) => @ORIENT("MY");
// %t6459 @TEXT("n199", key="name", size=0.75);
// &n199 @WIRE(mode="straight") {#X1242:4 %t6459:p};
// %t6460 = $SUPPLY @ATTACH &vdd => @PLACE(584, -3095);
// &vdd @WIRE(mode="straight") {#X1242:5 %t6460:p};
// %t6461 = $GROUND @ATTACH &vss => @PLACE(584, -3121);
// &vss @WIRE(mode="straight") {#X1242:6 %t6461:p};
// %t6462 = $IO_PORT @ATTACH &vss => @PLACE(614, -3104) => @ORIENT("R0");
// %t6462 @TEXT("vss", key="name", size=0.75);
// &vss @WIRE(mode="straight") {#X1243:1 %t6462:p};
// %t6463 = $IO_PORT @ATTACH &n236 => @PLACE(614, -3108) => @ORIENT("R0");
// %t6463 @TEXT("n236", key="name", size=0.75);
// &n236 @WIRE(mode="straight") {#X1243:2 %t6463:p};
// %t6464 = $IO_PORT @ATTACH &n960 => @PLACE(614, -3112) => @ORIENT("R0");
// %t6464 @TEXT("n960", key="name", size=0.75);
// &n960 @WIRE(mode="straight") {#X1243:3 %t6464:p};
// %t6465 = $IO_PORT @ATTACH &n1424 => @PLACE(635, -3108) => @ORIENT("MY");
// %t6465 @TEXT("n1424", key="name", size=0.75);
// &n1424 @WIRE(mode="straight") {#X1243:4 %t6465:p};
// %t6466 = $SUPPLY @ATTACH &vdd => @PLACE(624, -3095);
// &vdd @WIRE(mode="straight") {#X1243:5 %t6466:p};
// %t6467 = $GROUND @ATTACH &vss => @PLACE(624, -3121);
// &vss @WIRE(mode="straight") {#X1243:6 %t6467:p};
// %t6468 = $IO_PORT @ATTACH &n1424 => @PLACE(494, -3139) => @ORIENT("R0");
// %t6468 @TEXT("n1424", key="name", size=0.75);
// &n1424 @WIRE(mode="straight") {#X1244:1 %t6468:p};
// %t6469 = $IO_PORT @ATTACH &vss => @PLACE(494, -3143) => @ORIENT("R0");
// %t6469 @TEXT("vss", key="name", size=0.75);
// &vss @WIRE(mode="straight") {#X1244:2 %t6469:p};
// %t6470 = $IO_PORT @ATTACH &n234 => @PLACE(494, -3147) => @ORIENT("R0");
// %t6470 @TEXT("n234", key="name", size=0.75);
// &n234 @WIRE(mode="straight") {#X1244:3 %t6470:p};
// %t6471 = $IO_PORT @ATTACH &n1425 => @PLACE(514, -3143) => @ORIENT("MY");
// %t6471 @TEXT("n1425", key="name", size=0.75);
// &n1425 @WIRE(mode="straight") {#X1244:4 %t6471:p};
// %t6472 = $SUPPLY @ATTACH &vdd => @PLACE(504, -3130);
// &vdd @WIRE(mode="straight") {#X1244:5 %t6472:p};
// %t6473 = $GROUND @ATTACH &vss => @PLACE(504, -3156);
// &vss @WIRE(mode="straight") {#X1244:6 %t6473:p};
// %t6474 = $IO_PORT @ATTACH &n1425 => @PLACE(534, -3139) => @ORIENT("R0");
// %t6474 @TEXT("n1425", key="name", size=0.75);
// &n1425 @WIRE(mode="straight") {#X1245:1 %t6474:p};
// %t6475 = $IO_PORT @ATTACH &vss => @PLACE(534, -3143) => @ORIENT("R0");
// %t6475 @TEXT("vss", key="name", size=0.75);
// &vss @WIRE(mode="straight") {#X1245:2 %t6475:p};
// %t6476 = $IO_PORT @ATTACH &n238 => @PLACE(534, -3147) => @ORIENT("R0");
// %t6476 @TEXT("n238", key="name", size=0.75);
// &n238 @WIRE(mode="straight") {#X1245:3 %t6476:p};
// %t6477 = $IO_PORT @ATTACH &n1426 => @PLACE(554, -3143) => @ORIENT("MY");
// %t6477 @TEXT("n1426", key="name", size=0.75);
// &n1426 @WIRE(mode="straight") {#X1245:4 %t6477:p};
// %t6478 = $SUPPLY @ATTACH &vdd => @PLACE(544, -3130);
// &vdd @WIRE(mode="straight") {#X1245:5 %t6478:p};
// %t6479 = $GROUND @ATTACH &vss => @PLACE(544, -3156);
// &vss @WIRE(mode="straight") {#X1245:6 %t6479:p};
// %t6480 = $IO_PORT @ATTACH &n1375 => @PLACE(574, -3139) => @ORIENT("R0");
// %t6480 @TEXT("n1375", key="name", size=0.75);
// &n1375 @WIRE(mode="straight") {#X1246:1 %t6480:p};
// %t6481 = $IO_PORT @ATTACH &n1426 => @PLACE(574, -3143) => @ORIENT("R0");
// %t6481 @TEXT("n1426", key="name", size=0.75);
// &n1426 @WIRE(mode="straight") {#X1246:2 %t6481:p};
// %t6482 = $IO_PORT @ATTACH &n88 => @PLACE(574, -3147) => @ORIENT("R0");
// %t6482 @TEXT("n88", key="name", size=0.75);
// &n88 @WIRE(mode="straight") {#X1246:3 %t6482:p};
// %t6483 = $IO_PORT @ATTACH &n200 => @PLACE(594, -3143) => @ORIENT("MY");
// %t6483 @TEXT("n200", key="name", size=0.75);
// &n200 @WIRE(mode="straight") {#X1246:4 %t6483:p};
// %t6484 = $SUPPLY @ATTACH &vdd => @PLACE(584, -3130);
// &vdd @WIRE(mode="straight") {#X1246:5 %t6484:p};
// %t6485 = $GROUND @ATTACH &vss => @PLACE(584, -3156);
// &vss @WIRE(mode="straight") {#X1246:6 %t6485:p};
// %t6486 = $IO_PORT @ATTACH &n966 => @PLACE(614, -3139) => @ORIENT("R0");
// %t6486 @TEXT("n966", key="name", size=0.75);
// &n966 @WIRE(mode="straight") {#X1247:1 %t6486:p};
// %t6487 = $IO_PORT @ATTACH &vdd => @PLACE(614, -3143) => @ORIENT("R0");
// %t6487 @TEXT("vdd", key="name", size=0.75);
// &vdd @WIRE(mode="straight") {#X1247:2 %t6487:p};
// %t6488 = $IO_PORT @ATTACH &n88 => @PLACE(614, -3147) => @ORIENT("R0");
// %t6488 @TEXT("n88", key="name", size=0.75);
// &n88 @WIRE(mode="straight") {#X1247:3 %t6488:p};
// %t6489 = $IO_PORT @ATTACH &n196 => @PLACE(635, -3143) => @ORIENT("MY");
// %t6489 @TEXT("n196", key="name", size=0.75);
// &n196 @WIRE(mode="straight") {#X1247:4 %t6489:p};
// %t6490 = $SUPPLY @ATTACH &vdd => @PLACE(624, -3130);
// &vdd @WIRE(mode="straight") {#X1247:5 %t6490:p};
// %t6491 = $GROUND @ATTACH &vss => @PLACE(624, -3156);
// &vss @WIRE(mode="straight") {#X1247:6 %t6491:p};
// %t6492 = $IO_PORT @ATTACH &vss => @PLACE(-11, -3184) => @ORIENT("R0");
// %t6492 @TEXT("vss", key="name", size=0.75);
// &vss @WIRE(mode="straight") {#X1248:1 %t6492:p};
// %t6493 = $IO_PORT @ATTACH &n60 => @PLACE(-11, -3188) => @ORIENT("R0");
// %t6493 @TEXT("n60", key="name", size=0.75);
// &n60 @WIRE(mode="straight") {#X1248:2 %t6493:p};
// %t6494 = $IO_PORT @ATTACH &n980 => @PLACE(-11, -3192) => @ORIENT("R0");
// %t6494 @TEXT("n980", key="name", size=0.75);
// &n980 @WIRE(mode="straight") {#X1248:3 %t6494:p};
// %t6495 = $IO_PORT @ATTACH &n1427 => @PLACE(10, -3188) => @ORIENT("MY");
// %t6495 @TEXT("n1427", key="name", size=0.75);
// &n1427 @WIRE(mode="straight") {#X1248:4 %t6495:p};
// %t6496 = $SUPPLY @ATTACH &vdd => @PLACE(0, -3175);
// &vdd @WIRE(mode="straight") {#X1248:5 %t6496:p};
// %t6497 = $GROUND @ATTACH &vss => @PLACE(0, -3201);
// &vss @WIRE(mode="straight") {#X1248:6 %t6497:p};
// %t6498 = $IO_PORT @ATTACH &vss => @PLACE(30, -3184) => @ORIENT("R0");
// %t6498 @TEXT("vss", key="name", size=0.75);
// &vss @WIRE(mode="straight") {#X1249:1 %t6498:p};
// %t6499 = $IO_PORT @ATTACH &n62 => @PLACE(30, -3188) => @ORIENT("R0");
// %t6499 @TEXT("n62", key="name", size=0.75);
// &n62 @WIRE(mode="straight") {#X1249:2 %t6499:p};
// %t6500 = $IO_PORT @ATTACH &n980 => @PLACE(30, -3192) => @ORIENT("R0");
// %t6500 @TEXT("n980", key="name", size=0.75);
// &n980 @WIRE(mode="straight") {#X1249:3 %t6500:p};
// %t6501 = $IO_PORT @ATTACH &n1428 => @PLACE(50, -3188) => @ORIENT("MY");
// %t6501 @TEXT("n1428", key="name", size=0.75);
// &n1428 @WIRE(mode="straight") {#X1249:4 %t6501:p};
// %t6502 = $SUPPLY @ATTACH &vdd => @PLACE(40, -3175);
// &vdd @WIRE(mode="straight") {#X1249:5 %t6502:p};
// %t6503 = $GROUND @ATTACH &vss => @PLACE(40, -3201);
// &vss @WIRE(mode="straight") {#X1249:6 %t6503:p};
// %t6504 = $IO_PORT @ATTACH &vss => @PLACE(70, -3184) => @ORIENT("R0");
// %t6504 @TEXT("vss", key="name", size=0.75);
// &vss @WIRE(mode="straight") {#X1250:1 %t6504:p};
// %t6505 = $IO_PORT @ATTACH &n64 => @PLACE(70, -3188) => @ORIENT("R0");
// %t6505 @TEXT("n64", key="name", size=0.75);
// &n64 @WIRE(mode="straight") {#X1250:2 %t6505:p};
// %t6506 = $IO_PORT @ATTACH &n980 => @PLACE(70, -3192) => @ORIENT("R0");
// %t6506 @TEXT("n980", key="name", size=0.75);
// &n980 @WIRE(mode="straight") {#X1250:3 %t6506:p};
// %t6507 = $IO_PORT @ATTACH &n1429 => @PLACE(90, -3188) => @ORIENT("MY");
// %t6507 @TEXT("n1429", key="name", size=0.75);
// &n1429 @WIRE(mode="straight") {#X1250:4 %t6507:p};
// %t6508 = $SUPPLY @ATTACH &vdd => @PLACE(80, -3175);
// &vdd @WIRE(mode="straight") {#X1250:5 %t6508:p};
// %t6509 = $GROUND @ATTACH &vss => @PLACE(80, -3201);
// &vss @WIRE(mode="straight") {#X1250:6 %t6509:p};
// %t6510 = $IO_PORT @ATTACH &vss => @PLACE(110, -3184) => @ORIENT("R0");
// %t6510 @TEXT("vss", key="name", size=0.75);
// &vss @WIRE(mode="straight") {#X1251:1 %t6510:p};
// %t6511 = $IO_PORT @ATTACH &n66 => @PLACE(110, -3188) => @ORIENT("R0");
// %t6511 @TEXT("n66", key="name", size=0.75);
// &n66 @WIRE(mode="straight") {#X1251:2 %t6511:p};
// %t6512 = $IO_PORT @ATTACH &n980 => @PLACE(110, -3192) => @ORIENT("R0");
// %t6512 @TEXT("n980", key="name", size=0.75);
// &n980 @WIRE(mode="straight") {#X1251:3 %t6512:p};
// %t6513 = $IO_PORT @ATTACH &n1430 => @PLACE(130, -3188) => @ORIENT("MY");
// %t6513 @TEXT("n1430", key="name", size=0.75);
// &n1430 @WIRE(mode="straight") {#X1251:4 %t6513:p};
// %t6514 = $SUPPLY @ATTACH &vdd => @PLACE(120, -3175);
// &vdd @WIRE(mode="straight") {#X1251:5 %t6514:p};
// %t6515 = $GROUND @ATTACH &vss => @PLACE(120, -3201);
// &vss @WIRE(mode="straight") {#X1251:6 %t6515:p};
// %t6516 = $IO_PORT @ATTACH &vss => @PLACE(-11, -3219) => @ORIENT("R0");
// %t6516 @TEXT("vss", key="name", size=0.75);
// &vss @WIRE(mode="straight") {#X1252:1 %t6516:p};
// %t6517 = $IO_PORT @ATTACH &n68 => @PLACE(-11, -3223) => @ORIENT("R0");
// %t6517 @TEXT("n68", key="name", size=0.75);
// &n68 @WIRE(mode="straight") {#X1252:2 %t6517:p};
// %t6518 = $IO_PORT @ATTACH &n980 => @PLACE(-11, -3227) => @ORIENT("R0");
// %t6518 @TEXT("n980", key="name", size=0.75);
// &n980 @WIRE(mode="straight") {#X1252:3 %t6518:p};
// %t6519 = $IO_PORT @ATTACH &n1431 => @PLACE(10, -3223) => @ORIENT("MY");
// %t6519 @TEXT("n1431", key="name", size=0.75);
// &n1431 @WIRE(mode="straight") {#X1252:4 %t6519:p};
// %t6520 = $SUPPLY @ATTACH &vdd => @PLACE(0, -3210);
// &vdd @WIRE(mode="straight") {#X1252:5 %t6520:p};
// %t6521 = $GROUND @ATTACH &vss => @PLACE(0, -3236);
// &vss @WIRE(mode="straight") {#X1252:6 %t6521:p};
// %t6522 = $IO_PORT @ATTACH &vss => @PLACE(30, -3219) => @ORIENT("R0");
// %t6522 @TEXT("vss", key="name", size=0.75);
// &vss @WIRE(mode="straight") {#X1253:1 %t6522:p};
// %t6523 = $IO_PORT @ATTACH &n70 => @PLACE(30, -3223) => @ORIENT("R0");
// %t6523 @TEXT("n70", key="name", size=0.75);
// &n70 @WIRE(mode="straight") {#X1253:2 %t6523:p};
// %t6524 = $IO_PORT @ATTACH &n980 => @PLACE(30, -3227) => @ORIENT("R0");
// %t6524 @TEXT("n980", key="name", size=0.75);
// &n980 @WIRE(mode="straight") {#X1253:3 %t6524:p};
// %t6525 = $IO_PORT @ATTACH &n1432 => @PLACE(50, -3223) => @ORIENT("MY");
// %t6525 @TEXT("n1432", key="name", size=0.75);
// &n1432 @WIRE(mode="straight") {#X1253:4 %t6525:p};
// %t6526 = $SUPPLY @ATTACH &vdd => @PLACE(40, -3210);
// &vdd @WIRE(mode="straight") {#X1253:5 %t6526:p};
// %t6527 = $GROUND @ATTACH &vss => @PLACE(40, -3236);
// &vss @WIRE(mode="straight") {#X1253:6 %t6527:p};
// %t6528 = $IO_PORT @ATTACH &vss => @PLACE(70, -3219) => @ORIENT("R0");
// %t6528 @TEXT("vss", key="name", size=0.75);
// &vss @WIRE(mode="straight") {#X1254:1 %t6528:p};
// %t6529 = $IO_PORT @ATTACH &n72 => @PLACE(70, -3223) => @ORIENT("R0");
// %t6529 @TEXT("n72", key="name", size=0.75);
// &n72 @WIRE(mode="straight") {#X1254:2 %t6529:p};
// %t6530 = $IO_PORT @ATTACH &n980 => @PLACE(70, -3227) => @ORIENT("R0");
// %t6530 @TEXT("n980", key="name", size=0.75);
// &n980 @WIRE(mode="straight") {#X1254:3 %t6530:p};
// %t6531 = $IO_PORT @ATTACH &n1433 => @PLACE(90, -3223) => @ORIENT("MY");
// %t6531 @TEXT("n1433", key="name", size=0.75);
// &n1433 @WIRE(mode="straight") {#X1254:4 %t6531:p};
// %t6532 = $SUPPLY @ATTACH &vdd => @PLACE(80, -3210);
// &vdd @WIRE(mode="straight") {#X1254:5 %t6532:p};
// %t6533 = $GROUND @ATTACH &vss => @PLACE(80, -3236);
// &vss @WIRE(mode="straight") {#X1254:6 %t6533:p};
// %t6534 = $IO_PORT @ATTACH &vss => @PLACE(110, -3219) => @ORIENT("R0");
// %t6534 @TEXT("vss", key="name", size=0.75);
// &vss @WIRE(mode="straight") {#X1255:1 %t6534:p};
// %t6535 = $IO_PORT @ATTACH &vss => @PLACE(110, -3223) => @ORIENT("R0");
// %t6535 @TEXT("vss", key="name", size=0.75);
// &vss @WIRE(mode="straight") {#X1255:2 %t6535:p};
// %t6536 = $IO_PORT @ATTACH &n980 => @PLACE(110, -3227) => @ORIENT("R0");
// %t6536 @TEXT("n980", key="name", size=0.75);
// &n980 @WIRE(mode="straight") {#X1255:3 %t6536:p};
// %t6537 = $IO_PORT @ATTACH &n1434 => @PLACE(130, -3223) => @ORIENT("MY");
// %t6537 @TEXT("n1434", key="name", size=0.75);
// &n1434 @WIRE(mode="straight") {#X1255:4 %t6537:p};
// %t6538 = $SUPPLY @ATTACH &vdd => @PLACE(120, -3210);
// &vdd @WIRE(mode="straight") {#X1255:5 %t6538:p};
// %t6539 = $GROUND @ATTACH &vss => @PLACE(120, -3236);
// &vss @WIRE(mode="straight") {#X1255:6 %t6539:p};
// %t6540 = $IO_PORT @ATTACH &n1427 => @PLACE(-11, -3254) => @ORIENT("R0");
// %t6540 @TEXT("n1427", key="name", size=0.75);
// &n1427 @WIRE(mode="straight") {#X1256:1 %t6540:p};
// %t6541 = $IO_PORT @ATTACH &vss => @PLACE(-11, -3258) => @ORIENT("R0");
// %t6541 @TEXT("vss", key="name", size=0.75);
// &vss @WIRE(mode="straight") {#X1256:2 %t6541:p};
// %t6542 = $IO_PORT @ATTACH &n88 => @PLACE(-11, -3262) => @ORIENT("R0");
// %t6542 @TEXT("n88", key="name", size=0.75);
// &n88 @WIRE(mode="straight") {#X1256:3 %t6542:p};
// %t6543 = $IO_PORT @ATTACH &n1435 => @PLACE(10, -3258) => @ORIENT("MY");
// %t6543 @TEXT("n1435", key="name", size=0.75);
// &n1435 @WIRE(mode="straight") {#X1256:4 %t6543:p};
// %t6544 = $SUPPLY @ATTACH &vdd => @PLACE(0, -3245);
// &vdd @WIRE(mode="straight") {#X1256:5 %t6544:p};
// %t6545 = $GROUND @ATTACH &vss => @PLACE(0, -3271);
// &vss @WIRE(mode="straight") {#X1256:6 %t6545:p};
// %t6546 = $IO_PORT @ATTACH &n1428 => @PLACE(30, -3254) => @ORIENT("R0");
// %t6546 @TEXT("n1428", key="name", size=0.75);
// &n1428 @WIRE(mode="straight") {#X1257:1 %t6546:p};
// %t6547 = $IO_PORT @ATTACH &vss => @PLACE(30, -3258) => @ORIENT("R0");
// %t6547 @TEXT("vss", key="name", size=0.75);
// &vss @WIRE(mode="straight") {#X1257:2 %t6547:p};
// %t6548 = $IO_PORT @ATTACH &n88 => @PLACE(30, -3262) => @ORIENT("R0");
// %t6548 @TEXT("n88", key="name", size=0.75);
// &n88 @WIRE(mode="straight") {#X1257:3 %t6548:p};
// %t6549 = $IO_PORT @ATTACH &n1436 => @PLACE(50, -3258) => @ORIENT("MY");
// %t6549 @TEXT("n1436", key="name", size=0.75);
// &n1436 @WIRE(mode="straight") {#X1257:4 %t6549:p};
// %t6550 = $SUPPLY @ATTACH &vdd => @PLACE(40, -3245);
// &vdd @WIRE(mode="straight") {#X1257:5 %t6550:p};
// %t6551 = $GROUND @ATTACH &vss => @PLACE(40, -3271);
// &vss @WIRE(mode="straight") {#X1257:6 %t6551:p};
// %t6552 = $IO_PORT @ATTACH &n1429 => @PLACE(70, -3254) => @ORIENT("R0");
// %t6552 @TEXT("n1429", key="name", size=0.75);
// &n1429 @WIRE(mode="straight") {#X1258:1 %t6552:p};
// %t6553 = $IO_PORT @ATTACH &vss => @PLACE(70, -3258) => @ORIENT("R0");
// %t6553 @TEXT("vss", key="name", size=0.75);
// &vss @WIRE(mode="straight") {#X1258:2 %t6553:p};
// %t6554 = $IO_PORT @ATTACH &n88 => @PLACE(70, -3262) => @ORIENT("R0");
// %t6554 @TEXT("n88", key="name", size=0.75);
// &n88 @WIRE(mode="straight") {#X1258:3 %t6554:p};
// %t6555 = $IO_PORT @ATTACH &n1437 => @PLACE(90, -3258) => @ORIENT("MY");
// %t6555 @TEXT("n1437", key="name", size=0.75);
// &n1437 @WIRE(mode="straight") {#X1258:4 %t6555:p};
// %t6556 = $SUPPLY @ATTACH &vdd => @PLACE(80, -3245);
// &vdd @WIRE(mode="straight") {#X1258:5 %t6556:p};
// %t6557 = $GROUND @ATTACH &vss => @PLACE(80, -3271);
// &vss @WIRE(mode="straight") {#X1258:6 %t6557:p};
// %t6558 = $IO_PORT @ATTACH &n1430 => @PLACE(110, -3254) => @ORIENT("R0");
// %t6558 @TEXT("n1430", key="name", size=0.75);
// &n1430 @WIRE(mode="straight") {#X1259:1 %t6558:p};
// %t6559 = $IO_PORT @ATTACH &vss => @PLACE(110, -3258) => @ORIENT("R0");
// %t6559 @TEXT("vss", key="name", size=0.75);
// &vss @WIRE(mode="straight") {#X1259:2 %t6559:p};
// %t6560 = $IO_PORT @ATTACH &n88 => @PLACE(110, -3262) => @ORIENT("R0");
// %t6560 @TEXT("n88", key="name", size=0.75);
// &n88 @WIRE(mode="straight") {#X1259:3 %t6560:p};
// %t6561 = $IO_PORT @ATTACH &n1438 => @PLACE(130, -3258) => @ORIENT("MY");
// %t6561 @TEXT("n1438", key="name", size=0.75);
// &n1438 @WIRE(mode="straight") {#X1259:4 %t6561:p};
// %t6562 = $SUPPLY @ATTACH &vdd => @PLACE(120, -3245);
// &vdd @WIRE(mode="straight") {#X1259:5 %t6562:p};
// %t6563 = $GROUND @ATTACH &vss => @PLACE(120, -3271);
// &vss @WIRE(mode="straight") {#X1259:6 %t6563:p};
// %t6564 = $IO_PORT @ATTACH &n1431 => @PLACE(-11, -3289) => @ORIENT("R0");
// %t6564 @TEXT("n1431", key="name", size=0.75);
// &n1431 @WIRE(mode="straight") {#X1260:1 %t6564:p};
// %t6565 = $IO_PORT @ATTACH &vss => @PLACE(-11, -3293) => @ORIENT("R0");
// %t6565 @TEXT("vss", key="name", size=0.75);
// &vss @WIRE(mode="straight") {#X1260:2 %t6565:p};
// %t6566 = $IO_PORT @ATTACH &n88 => @PLACE(-11, -3297) => @ORIENT("R0");
// %t6566 @TEXT("n88", key="name", size=0.75);
// &n88 @WIRE(mode="straight") {#X1260:3 %t6566:p};
// %t6567 = $IO_PORT @ATTACH &n1439 => @PLACE(10, -3293) => @ORIENT("MY");
// %t6567 @TEXT("n1439", key="name", size=0.75);
// &n1439 @WIRE(mode="straight") {#X1260:4 %t6567:p};
// %t6568 = $SUPPLY @ATTACH &vdd => @PLACE(0, -3280);
// &vdd @WIRE(mode="straight") {#X1260:5 %t6568:p};
// %t6569 = $GROUND @ATTACH &vss => @PLACE(0, -3306);
// &vss @WIRE(mode="straight") {#X1260:6 %t6569:p};
// %t6570 = $IO_PORT @ATTACH &n1432 => @PLACE(30, -3289) => @ORIENT("R0");
// %t6570 @TEXT("n1432", key="name", size=0.75);
// &n1432 @WIRE(mode="straight") {#X1261:1 %t6570:p};
// %t6571 = $IO_PORT @ATTACH &vss => @PLACE(30, -3293) => @ORIENT("R0");
// %t6571 @TEXT("vss", key="name", size=0.75);
// &vss @WIRE(mode="straight") {#X1261:2 %t6571:p};
// %t6572 = $IO_PORT @ATTACH &n88 => @PLACE(30, -3297) => @ORIENT("R0");
// %t6572 @TEXT("n88", key="name", size=0.75);
// &n88 @WIRE(mode="straight") {#X1261:3 %t6572:p};
// %t6573 = $IO_PORT @ATTACH &n1440 => @PLACE(50, -3293) => @ORIENT("MY");
// %t6573 @TEXT("n1440", key="name", size=0.75);
// &n1440 @WIRE(mode="straight") {#X1261:4 %t6573:p};
// %t6574 = $SUPPLY @ATTACH &vdd => @PLACE(40, -3280);
// &vdd @WIRE(mode="straight") {#X1261:5 %t6574:p};
// %t6575 = $GROUND @ATTACH &vss => @PLACE(40, -3306);
// &vss @WIRE(mode="straight") {#X1261:6 %t6575:p};
// %t6576 = $IO_PORT @ATTACH &n1433 => @PLACE(70, -3289) => @ORIENT("R0");
// %t6576 @TEXT("n1433", key="name", size=0.75);
// &n1433 @WIRE(mode="straight") {#X1262:1 %t6576:p};
// %t6577 = $IO_PORT @ATTACH &vss => @PLACE(70, -3293) => @ORIENT("R0");
// %t6577 @TEXT("vss", key="name", size=0.75);
// &vss @WIRE(mode="straight") {#X1262:2 %t6577:p};
// %t6578 = $IO_PORT @ATTACH &n88 => @PLACE(70, -3297) => @ORIENT("R0");
// %t6578 @TEXT("n88", key="name", size=0.75);
// &n88 @WIRE(mode="straight") {#X1262:3 %t6578:p};
// %t6579 = $IO_PORT @ATTACH &n1441 => @PLACE(90, -3293) => @ORIENT("MY");
// %t6579 @TEXT("n1441", key="name", size=0.75);
// &n1441 @WIRE(mode="straight") {#X1262:4 %t6579:p};
// %t6580 = $SUPPLY @ATTACH &vdd => @PLACE(80, -3280);
// &vdd @WIRE(mode="straight") {#X1262:5 %t6580:p};
// %t6581 = $GROUND @ATTACH &vss => @PLACE(80, -3306);
// &vss @WIRE(mode="straight") {#X1262:6 %t6581:p};
// %t6582 = $IO_PORT @ATTACH &n1434 => @PLACE(110, -3289) => @ORIENT("R0");
// %t6582 @TEXT("n1434", key="name", size=0.75);
// &n1434 @WIRE(mode="straight") {#X1263:1 %t6582:p};
// %t6583 = $IO_PORT @ATTACH &vss => @PLACE(110, -3293) => @ORIENT("R0");
// %t6583 @TEXT("vss", key="name", size=0.75);
// &vss @WIRE(mode="straight") {#X1263:2 %t6583:p};
// %t6584 = $IO_PORT @ATTACH &n88 => @PLACE(110, -3297) => @ORIENT("R0");
// %t6584 @TEXT("n88", key="name", size=0.75);
// &n88 @WIRE(mode="straight") {#X1263:3 %t6584:p};
// %t6585 = $IO_PORT @ATTACH &n1442 => @PLACE(130, -3293) => @ORIENT("MY");
// %t6585 @TEXT("n1442", key="name", size=0.75);
// &n1442 @WIRE(mode="straight") {#X1263:4 %t6585:p};
// %t6586 = $SUPPLY @ATTACH &vdd => @PLACE(120, -3280);
// &vdd @WIRE(mode="straight") {#X1263:5 %t6586:p};
// %t6587 = $GROUND @ATTACH &vss => @PLACE(120, -3306);
// &vss @WIRE(mode="straight") {#X1263:6 %t6587:p};
// %t6588 = $IO_PORT @ATTACH &vss => @PLACE(-11, -3324) => @ORIENT("R0");
// %t6588 @TEXT("vss", key="name", size=0.75);
// &vss @WIRE(mode="straight") {#X1264:1 %t6588:p};
// %t6589 = $IO_PORT @ATTACH &n60 => @PLACE(-11, -3328) => @ORIENT("R0");
// %t6589 @TEXT("n60", key="name", size=0.75);
// &n60 @WIRE(mode="straight") {#X1264:2 %t6589:p};
// %t6590 = $IO_PORT @ATTACH &n980 => @PLACE(-11, -3332) => @ORIENT("R0");
// %t6590 @TEXT("n980", key="name", size=0.75);
// &n980 @WIRE(mode="straight") {#X1264:3 %t6590:p};
// %t6591 = $IO_PORT @ATTACH &n1443 => @PLACE(10, -3328) => @ORIENT("MY");
// %t6591 @TEXT("n1443", key="name", size=0.75);
// &n1443 @WIRE(mode="straight") {#X1264:4 %t6591:p};
// %t6592 = $SUPPLY @ATTACH &vdd => @PLACE(0, -3315);
// &vdd @WIRE(mode="straight") {#X1264:5 %t6592:p};
// %t6593 = $GROUND @ATTACH &vss => @PLACE(0, -3341);
// &vss @WIRE(mode="straight") {#X1264:6 %t6593:p};
// %t6594 = $IO_PORT @ATTACH &vss => @PLACE(30, -3324) => @ORIENT("R0");
// %t6594 @TEXT("vss", key="name", size=0.75);
// &vss @WIRE(mode="straight") {#X1265:1 %t6594:p};
// %t6595 = $IO_PORT @ATTACH &n62 => @PLACE(30, -3328) => @ORIENT("R0");
// %t6595 @TEXT("n62", key="name", size=0.75);
// &n62 @WIRE(mode="straight") {#X1265:2 %t6595:p};
// %t6596 = $IO_PORT @ATTACH &n980 => @PLACE(30, -3332) => @ORIENT("R0");
// %t6596 @TEXT("n980", key="name", size=0.75);
// &n980 @WIRE(mode="straight") {#X1265:3 %t6596:p};
// %t6597 = $IO_PORT @ATTACH &n1444 => @PLACE(50, -3328) => @ORIENT("MY");
// %t6597 @TEXT("n1444", key="name", size=0.75);
// &n1444 @WIRE(mode="straight") {#X1265:4 %t6597:p};
// %t6598 = $SUPPLY @ATTACH &vdd => @PLACE(40, -3315);
// &vdd @WIRE(mode="straight") {#X1265:5 %t6598:p};
// %t6599 = $GROUND @ATTACH &vss => @PLACE(40, -3341);
// &vss @WIRE(mode="straight") {#X1265:6 %t6599:p};
// %t6600 = $IO_PORT @ATTACH &vss => @PLACE(70, -3324) => @ORIENT("R0");
// %t6600 @TEXT("vss", key="name", size=0.75);
// &vss @WIRE(mode="straight") {#X1266:1 %t6600:p};
// %t6601 = $IO_PORT @ATTACH &n64 => @PLACE(70, -3328) => @ORIENT("R0");
// %t6601 @TEXT("n64", key="name", size=0.75);
// &n64 @WIRE(mode="straight") {#X1266:2 %t6601:p};
// %t6602 = $IO_PORT @ATTACH &n980 => @PLACE(70, -3332) => @ORIENT("R0");
// %t6602 @TEXT("n980", key="name", size=0.75);
// &n980 @WIRE(mode="straight") {#X1266:3 %t6602:p};
// %t6603 = $IO_PORT @ATTACH &n1445 => @PLACE(90, -3328) => @ORIENT("MY");
// %t6603 @TEXT("n1445", key="name", size=0.75);
// &n1445 @WIRE(mode="straight") {#X1266:4 %t6603:p};
// %t6604 = $SUPPLY @ATTACH &vdd => @PLACE(80, -3315);
// &vdd @WIRE(mode="straight") {#X1266:5 %t6604:p};
// %t6605 = $GROUND @ATTACH &vss => @PLACE(80, -3341);
// &vss @WIRE(mode="straight") {#X1266:6 %t6605:p};
// %t6606 = $IO_PORT @ATTACH &vss => @PLACE(110, -3324) => @ORIENT("R0");
// %t6606 @TEXT("vss", key="name", size=0.75);
// &vss @WIRE(mode="straight") {#X1267:1 %t6606:p};
// %t6607 = $IO_PORT @ATTACH &n66 => @PLACE(110, -3328) => @ORIENT("R0");
// %t6607 @TEXT("n66", key="name", size=0.75);
// &n66 @WIRE(mode="straight") {#X1267:2 %t6607:p};
// %t6608 = $IO_PORT @ATTACH &n980 => @PLACE(110, -3332) => @ORIENT("R0");
// %t6608 @TEXT("n980", key="name", size=0.75);
// &n980 @WIRE(mode="straight") {#X1267:3 %t6608:p};
// %t6609 = $IO_PORT @ATTACH &n1446 => @PLACE(130, -3328) => @ORIENT("MY");
// %t6609 @TEXT("n1446", key="name", size=0.75);
// &n1446 @WIRE(mode="straight") {#X1267:4 %t6609:p};
// %t6610 = $SUPPLY @ATTACH &vdd => @PLACE(120, -3315);
// &vdd @WIRE(mode="straight") {#X1267:5 %t6610:p};
// %t6611 = $GROUND @ATTACH &vss => @PLACE(120, -3341);
// &vss @WIRE(mode="straight") {#X1267:6 %t6611:p};
// %t6612 = $IO_PORT @ATTACH &vss => @PLACE(-11, -3359) => @ORIENT("R0");
// %t6612 @TEXT("vss", key="name", size=0.75);
// &vss @WIRE(mode="straight") {#X1268:1 %t6612:p};
// %t6613 = $IO_PORT @ATTACH &n68 => @PLACE(-11, -3363) => @ORIENT("R0");
// %t6613 @TEXT("n68", key="name", size=0.75);
// &n68 @WIRE(mode="straight") {#X1268:2 %t6613:p};
// %t6614 = $IO_PORT @ATTACH &n980 => @PLACE(-11, -3367) => @ORIENT("R0");
// %t6614 @TEXT("n980", key="name", size=0.75);
// &n980 @WIRE(mode="straight") {#X1268:3 %t6614:p};
// %t6615 = $IO_PORT @ATTACH &n1447 => @PLACE(10, -3363) => @ORIENT("MY");
// %t6615 @TEXT("n1447", key="name", size=0.75);
// &n1447 @WIRE(mode="straight") {#X1268:4 %t6615:p};
// %t6616 = $SUPPLY @ATTACH &vdd => @PLACE(0, -3350);
// &vdd @WIRE(mode="straight") {#X1268:5 %t6616:p};
// %t6617 = $GROUND @ATTACH &vss => @PLACE(0, -3376);
// &vss @WIRE(mode="straight") {#X1268:6 %t6617:p};
// %t6618 = $IO_PORT @ATTACH &vdd => @PLACE(30, -3359) => @ORIENT("R0");
// %t6618 @TEXT("vdd", key="name", size=0.75);
// &vdd @WIRE(mode="straight") {#X1269:1 %t6618:p};
// %t6619 = $IO_PORT @ATTACH &n70 => @PLACE(30, -3363) => @ORIENT("R0");
// %t6619 @TEXT("n70", key="name", size=0.75);
// &n70 @WIRE(mode="straight") {#X1269:2 %t6619:p};
// %t6620 = $IO_PORT @ATTACH &n980 => @PLACE(30, -3367) => @ORIENT("R0");
// %t6620 @TEXT("n980", key="name", size=0.75);
// &n980 @WIRE(mode="straight") {#X1269:3 %t6620:p};
// %t6621 = $IO_PORT @ATTACH &n1448 => @PLACE(50, -3363) => @ORIENT("MY");
// %t6621 @TEXT("n1448", key="name", size=0.75);
// &n1448 @WIRE(mode="straight") {#X1269:4 %t6621:p};
// %t6622 = $SUPPLY @ATTACH &vdd => @PLACE(40, -3350);
// &vdd @WIRE(mode="straight") {#X1269:5 %t6622:p};
// %t6623 = $GROUND @ATTACH &vss => @PLACE(40, -3376);
// &vss @WIRE(mode="straight") {#X1269:6 %t6623:p};
// %t6624 = $IO_PORT @ATTACH &vss => @PLACE(70, -3359) => @ORIENT("R0");
// %t6624 @TEXT("vss", key="name", size=0.75);
// &vss @WIRE(mode="straight") {#X1270:1 %t6624:p};
// %t6625 = $IO_PORT @ATTACH &n72 => @PLACE(70, -3363) => @ORIENT("R0");
// %t6625 @TEXT("n72", key="name", size=0.75);
// &n72 @WIRE(mode="straight") {#X1270:2 %t6625:p};
// %t6626 = $IO_PORT @ATTACH &n980 => @PLACE(70, -3367) => @ORIENT("R0");
// %t6626 @TEXT("n980", key="name", size=0.75);
// &n980 @WIRE(mode="straight") {#X1270:3 %t6626:p};
// %t6627 = $IO_PORT @ATTACH &n1449 => @PLACE(90, -3363) => @ORIENT("MY");
// %t6627 @TEXT("n1449", key="name", size=0.75);
// &n1449 @WIRE(mode="straight") {#X1270:4 %t6627:p};
// %t6628 = $SUPPLY @ATTACH &vdd => @PLACE(80, -3350);
// &vdd @WIRE(mode="straight") {#X1270:5 %t6628:p};
// %t6629 = $GROUND @ATTACH &vss => @PLACE(80, -3376);
// &vss @WIRE(mode="straight") {#X1270:6 %t6629:p};
// %t6630 = $IO_PORT @ATTACH &n1443 => @PLACE(110, -3359) => @ORIENT("R0");
// %t6630 @TEXT("n1443", key="name", size=0.75);
// &n1443 @WIRE(mode="straight") {#X1271:1 %t6630:p};
// %t6631 = $IO_PORT @ATTACH &n1435 => @PLACE(110, -3363) => @ORIENT("R0");
// %t6631 @TEXT("n1435", key="name", size=0.75);
// &n1435 @WIRE(mode="straight") {#X1271:2 %t6631:p};
// %t6632 = $IO_PORT @ATTACH &n117 => @PLACE(110, -3367) => @ORIENT("R0");
// %t6632 @TEXT("n117", key="name", size=0.75);
// &n117 @WIRE(mode="straight") {#X1271:3 %t6632:p};
// %t6633 = $IO_PORT @ATTACH &n1450 => @PLACE(130, -3363) => @ORIENT("MY");
// %t6633 @TEXT("n1450", key="name", size=0.75);
// &n1450 @WIRE(mode="straight") {#X1271:4 %t6633:p};
// %t6634 = $SUPPLY @ATTACH &vdd => @PLACE(120, -3350);
// &vdd @WIRE(mode="straight") {#X1271:5 %t6634:p};
// %t6635 = $GROUND @ATTACH &vss => @PLACE(120, -3376);
// &vss @WIRE(mode="straight") {#X1271:6 %t6635:p};
// %t6636 = $IO_PORT @ATTACH &n1444 => @PLACE(158, -3184) => @ORIENT("R0");
// %t6636 @TEXT("n1444", key="name", size=0.75);
// &n1444 @WIRE(mode="straight") {#X1272:1 %t6636:p};
// %t6637 = $IO_PORT @ATTACH &n1436 => @PLACE(158, -3188) => @ORIENT("R0");
// %t6637 @TEXT("n1436", key="name", size=0.75);
// &n1436 @WIRE(mode="straight") {#X1272:2 %t6637:p};
// %t6638 = $IO_PORT @ATTACH &n117 => @PLACE(158, -3192) => @ORIENT("R0");
// %t6638 @TEXT("n117", key="name", size=0.75);
// &n117 @WIRE(mode="straight") {#X1272:3 %t6638:p};
// %t6639 = $IO_PORT @ATTACH &n1451 => @PLACE(178, -3188) => @ORIENT("MY");
// %t6639 @TEXT("n1451", key="name", size=0.75);
// &n1451 @WIRE(mode="straight") {#X1272:4 %t6639:p};
// %t6640 = $SUPPLY @ATTACH &vdd => @PLACE(168, -3175);
// &vdd @WIRE(mode="straight") {#X1272:5 %t6640:p};
// %t6641 = $GROUND @ATTACH &vss => @PLACE(168, -3201);
// &vss @WIRE(mode="straight") {#X1272:6 %t6641:p};
// %t6642 = $IO_PORT @ATTACH &n1445 => @PLACE(198, -3184) => @ORIENT("R0");
// %t6642 @TEXT("n1445", key="name", size=0.75);
// &n1445 @WIRE(mode="straight") {#X1273:1 %t6642:p};
// %t6643 = $IO_PORT @ATTACH &n1437 => @PLACE(198, -3188) => @ORIENT("R0");
// %t6643 @TEXT("n1437", key="name", size=0.75);
// &n1437 @WIRE(mode="straight") {#X1273:2 %t6643:p};
// %t6644 = $IO_PORT @ATTACH &n117 => @PLACE(198, -3192) => @ORIENT("R0");
// %t6644 @TEXT("n117", key="name", size=0.75);
// &n117 @WIRE(mode="straight") {#X1273:3 %t6644:p};
// %t6645 = $IO_PORT @ATTACH &n1452 => @PLACE(218, -3188) => @ORIENT("MY");
// %t6645 @TEXT("n1452", key="name", size=0.75);
// &n1452 @WIRE(mode="straight") {#X1273:4 %t6645:p};
// %t6646 = $SUPPLY @ATTACH &vdd => @PLACE(208, -3175);
// &vdd @WIRE(mode="straight") {#X1273:5 %t6646:p};
// %t6647 = $GROUND @ATTACH &vss => @PLACE(208, -3201);
// &vss @WIRE(mode="straight") {#X1273:6 %t6647:p};
// %t6648 = $IO_PORT @ATTACH &n1446 => @PLACE(238, -3184) => @ORIENT("R0");
// %t6648 @TEXT("n1446", key="name", size=0.75);
// &n1446 @WIRE(mode="straight") {#X1274:1 %t6648:p};
// %t6649 = $IO_PORT @ATTACH &n1438 => @PLACE(238, -3188) => @ORIENT("R0");
// %t6649 @TEXT("n1438", key="name", size=0.75);
// &n1438 @WIRE(mode="straight") {#X1274:2 %t6649:p};
// %t6650 = $IO_PORT @ATTACH &n117 => @PLACE(238, -3192) => @ORIENT("R0");
// %t6650 @TEXT("n117", key="name", size=0.75);
// &n117 @WIRE(mode="straight") {#X1274:3 %t6650:p};
// %t6651 = $IO_PORT @ATTACH &n1453 => @PLACE(258, -3188) => @ORIENT("MY");
// %t6651 @TEXT("n1453", key="name", size=0.75);
// &n1453 @WIRE(mode="straight") {#X1274:4 %t6651:p};
// %t6652 = $SUPPLY @ATTACH &vdd => @PLACE(248, -3175);
// &vdd @WIRE(mode="straight") {#X1274:5 %t6652:p};
// %t6653 = $GROUND @ATTACH &vss => @PLACE(248, -3201);
// &vss @WIRE(mode="straight") {#X1274:6 %t6653:p};
// %t6654 = $IO_PORT @ATTACH &n1447 => @PLACE(278, -3184) => @ORIENT("R0");
// %t6654 @TEXT("n1447", key="name", size=0.75);
// &n1447 @WIRE(mode="straight") {#X1275:1 %t6654:p};
// %t6655 = $IO_PORT @ATTACH &n1439 => @PLACE(278, -3188) => @ORIENT("R0");
// %t6655 @TEXT("n1439", key="name", size=0.75);
// &n1439 @WIRE(mode="straight") {#X1275:2 %t6655:p};
// %t6656 = $IO_PORT @ATTACH &n117 => @PLACE(278, -3192) => @ORIENT("R0");
// %t6656 @TEXT("n117", key="name", size=0.75);
// &n117 @WIRE(mode="straight") {#X1275:3 %t6656:p};
// %t6657 = $IO_PORT @ATTACH &n1454 => @PLACE(298, -3188) => @ORIENT("MY");
// %t6657 @TEXT("n1454", key="name", size=0.75);
// &n1454 @WIRE(mode="straight") {#X1275:4 %t6657:p};
// %t6658 = $SUPPLY @ATTACH &vdd => @PLACE(288, -3175);
// &vdd @WIRE(mode="straight") {#X1275:5 %t6658:p};
// %t6659 = $GROUND @ATTACH &vss => @PLACE(288, -3201);
// &vss @WIRE(mode="straight") {#X1275:6 %t6659:p};
// %t6660 = $IO_PORT @ATTACH &n1448 => @PLACE(158, -3219) => @ORIENT("R0");
// %t6660 @TEXT("n1448", key="name", size=0.75);
// &n1448 @WIRE(mode="straight") {#X1276:1 %t6660:p};
// %t6661 = $IO_PORT @ATTACH &n1440 => @PLACE(158, -3223) => @ORIENT("R0");
// %t6661 @TEXT("n1440", key="name", size=0.75);
// &n1440 @WIRE(mode="straight") {#X1276:2 %t6661:p};
// %t6662 = $IO_PORT @ATTACH &n117 => @PLACE(158, -3227) => @ORIENT("R0");
// %t6662 @TEXT("n117", key="name", size=0.75);
// &n117 @WIRE(mode="straight") {#X1276:3 %t6662:p};
// %t6663 = $IO_PORT @ATTACH &n1455 => @PLACE(178, -3223) => @ORIENT("MY");
// %t6663 @TEXT("n1455", key="name", size=0.75);
// &n1455 @WIRE(mode="straight") {#X1276:4 %t6663:p};
// %t6664 = $SUPPLY @ATTACH &vdd => @PLACE(168, -3210);
// &vdd @WIRE(mode="straight") {#X1276:5 %t6664:p};
// %t6665 = $GROUND @ATTACH &vss => @PLACE(168, -3236);
// &vss @WIRE(mode="straight") {#X1276:6 %t6665:p};
// %t6666 = $IO_PORT @ATTACH &n1449 => @PLACE(198, -3219) => @ORIENT("R0");
// %t6666 @TEXT("n1449", key="name", size=0.75);
// &n1449 @WIRE(mode="straight") {#X1277:1 %t6666:p};
// %t6667 = $IO_PORT @ATTACH &n1441 => @PLACE(198, -3223) => @ORIENT("R0");
// %t6667 @TEXT("n1441", key="name", size=0.75);
// &n1441 @WIRE(mode="straight") {#X1277:2 %t6667:p};
// %t6668 = $IO_PORT @ATTACH &n117 => @PLACE(198, -3227) => @ORIENT("R0");
// %t6668 @TEXT("n117", key="name", size=0.75);
// &n117 @WIRE(mode="straight") {#X1277:3 %t6668:p};
// %t6669 = $IO_PORT @ATTACH &n1456 => @PLACE(218, -3223) => @ORIENT("MY");
// %t6669 @TEXT("n1456", key="name", size=0.75);
// &n1456 @WIRE(mode="straight") {#X1277:4 %t6669:p};
// %t6670 = $SUPPLY @ATTACH &vdd => @PLACE(208, -3210);
// &vdd @WIRE(mode="straight") {#X1277:5 %t6670:p};
// %t6671 = $GROUND @ATTACH &vss => @PLACE(208, -3236);
// &vss @WIRE(mode="straight") {#X1277:6 %t6671:p};
// %t6672 = $IO_PORT @ATTACH &vss => @PLACE(238, -3219) => @ORIENT("R0");
// %t6672 @TEXT("vss", key="name", size=0.75);
// &vss @WIRE(mode="straight") {#X1278:1 %t6672:p};
// %t6673 = $IO_PORT @ATTACH &n1442 => @PLACE(238, -3223) => @ORIENT("R0");
// %t6673 @TEXT("n1442", key="name", size=0.75);
// &n1442 @WIRE(mode="straight") {#X1278:2 %t6673:p};
// %t6674 = $IO_PORT @ATTACH &n117 => @PLACE(238, -3227) => @ORIENT("R0");
// %t6674 @TEXT("n117", key="name", size=0.75);
// &n117 @WIRE(mode="straight") {#X1278:3 %t6674:p};
// %t6675 = $IO_PORT @ATTACH &n1457 => @PLACE(258, -3223) => @ORIENT("MY");
// %t6675 @TEXT("n1457", key="name", size=0.75);
// &n1457 @WIRE(mode="straight") {#X1278:4 %t6675:p};
// %t6676 = $SUPPLY @ATTACH &vdd => @PLACE(248, -3210);
// &vdd @WIRE(mode="straight") {#X1278:5 %t6676:p};
// %t6677 = $GROUND @ATTACH &vss => @PLACE(248, -3236);
// &vss @WIRE(mode="straight") {#X1278:6 %t6677:p};
// %t6678 = $IO_PORT @ATTACH &n978 => @PLACE(278, -3223) => @ORIENT("R0");
// %t6678 @TEXT("n978", key="name", size=0.75);
// &n978 @WIRE(mode="straight") {#X1279:1 %t6678:p};
// %t6679 = $IO_PORT @ATTACH &n1165 => @PLACE(298, -3223) => @ORIENT("MY");
// %t6679 @TEXT("n1165", key="name", size=0.75);
// &n1165 @WIRE(mode="straight") {#X1279:2 %t6679:p};
// %t6680 = $SUPPLY @ATTACH &vdd => @PLACE(288, -3214);
// &vdd @WIRE(mode="straight") {#X1279:3 %t6680:p};
// %t6681 = $GROUND @ATTACH &vss => @PLACE(288, -3232);
// &vss @WIRE(mode="straight") {#X1279:4 %t6681:p};
// %t6682 = $IO_PORT @ATTACH &vss => @PLACE(158, -3254) => @ORIENT("R0");
// %t6682 @TEXT("vss", key="name", size=0.75);
// &vss @WIRE(mode="straight") {#X1280:1 %t6682:p};
// %t6683 = $IO_PORT @ATTACH &n1450 => @PLACE(158, -3258) => @ORIENT("R0");
// %t6683 @TEXT("n1450", key="name", size=0.75);
// &n1450 @WIRE(mode="straight") {#X1280:2 %t6683:p};
// %t6684 = $IO_PORT @ATTACH &n51 => @PLACE(158, -3262) => @ORIENT("R0");
// %t6684 @TEXT("n51", key="name", size=0.75);
// &n51 @WIRE(mode="straight") {#X1280:3 %t6684:p};
// %t6685 = $IO_PORT @ATTACH &n157 => @PLACE(178, -3258) => @ORIENT("MY");
// %t6685 @TEXT("n157", key="name", size=0.75);
// &n157 @WIRE(mode="straight") {#X1280:4 %t6685:p};
// %t6686 = $SUPPLY @ATTACH &vdd => @PLACE(168, -3245);
// &vdd @WIRE(mode="straight") {#X1280:5 %t6686:p};
// %t6687 = $GROUND @ATTACH &vss => @PLACE(168, -3271);
// &vss @WIRE(mode="straight") {#X1280:6 %t6687:p};
// %t6688 = $IO_PORT @ATTACH &vss => @PLACE(198, -3254) => @ORIENT("R0");
// %t6688 @TEXT("vss", key="name", size=0.75);
// &vss @WIRE(mode="straight") {#X1281:1 %t6688:p};
// %t6689 = $IO_PORT @ATTACH &n1451 => @PLACE(198, -3258) => @ORIENT("R0");
// %t6689 @TEXT("n1451", key="name", size=0.75);
// &n1451 @WIRE(mode="straight") {#X1281:2 %t6689:p};
// %t6690 = $IO_PORT @ATTACH &n51 => @PLACE(198, -3262) => @ORIENT("R0");
// %t6690 @TEXT("n51", key="name", size=0.75);
// &n51 @WIRE(mode="straight") {#X1281:3 %t6690:p};
// %t6691 = $IO_PORT @ATTACH &n156 => @PLACE(218, -3258) => @ORIENT("MY");
// %t6691 @TEXT("n156", key="name", size=0.75);
// &n156 @WIRE(mode="straight") {#X1281:4 %t6691:p};
// %t6692 = $SUPPLY @ATTACH &vdd => @PLACE(208, -3245);
// &vdd @WIRE(mode="straight") {#X1281:5 %t6692:p};
// %t6693 = $GROUND @ATTACH &vss => @PLACE(208, -3271);
// &vss @WIRE(mode="straight") {#X1281:6 %t6693:p};
// %t6694 = $IO_PORT @ATTACH &vss => @PLACE(238, -3254) => @ORIENT("R0");
// %t6694 @TEXT("vss", key="name", size=0.75);
// &vss @WIRE(mode="straight") {#X1282:1 %t6694:p};
// %t6695 = $IO_PORT @ATTACH &n1452 => @PLACE(238, -3258) => @ORIENT("R0");
// %t6695 @TEXT("n1452", key="name", size=0.75);
// &n1452 @WIRE(mode="straight") {#X1282:2 %t6695:p};
// %t6696 = $IO_PORT @ATTACH &n51 => @PLACE(238, -3262) => @ORIENT("R0");
// %t6696 @TEXT("n51", key="name", size=0.75);
// &n51 @WIRE(mode="straight") {#X1282:3 %t6696:p};
// %t6697 = $IO_PORT @ATTACH &n155 => @PLACE(258, -3258) => @ORIENT("MY");
// %t6697 @TEXT("n155", key="name", size=0.75);
// &n155 @WIRE(mode="straight") {#X1282:4 %t6697:p};
// %t6698 = $SUPPLY @ATTACH &vdd => @PLACE(248, -3245);
// &vdd @WIRE(mode="straight") {#X1282:5 %t6698:p};
// %t6699 = $GROUND @ATTACH &vss => @PLACE(248, -3271);
// &vss @WIRE(mode="straight") {#X1282:6 %t6699:p};
// %t6700 = $IO_PORT @ATTACH &vss => @PLACE(278, -3254) => @ORIENT("R0");
// %t6700 @TEXT("vss", key="name", size=0.75);
// &vss @WIRE(mode="straight") {#X1283:1 %t6700:p};
// %t6701 = $IO_PORT @ATTACH &n1453 => @PLACE(278, -3258) => @ORIENT("R0");
// %t6701 @TEXT("n1453", key="name", size=0.75);
// &n1453 @WIRE(mode="straight") {#X1283:2 %t6701:p};
// %t6702 = $IO_PORT @ATTACH &n51 => @PLACE(278, -3262) => @ORIENT("R0");
// %t6702 @TEXT("n51", key="name", size=0.75);
// &n51 @WIRE(mode="straight") {#X1283:3 %t6702:p};
// %t6703 = $IO_PORT @ATTACH &n154 => @PLACE(298, -3258) => @ORIENT("MY");
// %t6703 @TEXT("n154", key="name", size=0.75);
// &n154 @WIRE(mode="straight") {#X1283:4 %t6703:p};
// %t6704 = $SUPPLY @ATTACH &vdd => @PLACE(288, -3245);
// &vdd @WIRE(mode="straight") {#X1283:5 %t6704:p};
// %t6705 = $GROUND @ATTACH &vss => @PLACE(288, -3271);
// &vss @WIRE(mode="straight") {#X1283:6 %t6705:p};
// %t6706 = $IO_PORT @ATTACH &vss => @PLACE(158, -3289) => @ORIENT("R0");
// %t6706 @TEXT("vss", key="name", size=0.75);
// &vss @WIRE(mode="straight") {#X1284:1 %t6706:p};
// %t6707 = $IO_PORT @ATTACH &n1454 => @PLACE(158, -3293) => @ORIENT("R0");
// %t6707 @TEXT("n1454", key="name", size=0.75);
// &n1454 @WIRE(mode="straight") {#X1284:2 %t6707:p};
// %t6708 = $IO_PORT @ATTACH &n51 => @PLACE(158, -3297) => @ORIENT("R0");
// %t6708 @TEXT("n51", key="name", size=0.75);
// &n51 @WIRE(mode="straight") {#X1284:3 %t6708:p};
// %t6709 = $IO_PORT @ATTACH &n153 => @PLACE(178, -3293) => @ORIENT("MY");
// %t6709 @TEXT("n153", key="name", size=0.75);
// &n153 @WIRE(mode="straight") {#X1284:4 %t6709:p};
// %t6710 = $SUPPLY @ATTACH &vdd => @PLACE(168, -3280);
// &vdd @WIRE(mode="straight") {#X1284:5 %t6710:p};
// %t6711 = $GROUND @ATTACH &vss => @PLACE(168, -3306);
// &vss @WIRE(mode="straight") {#X1284:6 %t6711:p};
// %t6712 = $IO_PORT @ATTACH &n1165 => @PLACE(198, -3289) => @ORIENT("R0");
// %t6712 @TEXT("n1165", key="name", size=0.75);
// &n1165 @WIRE(mode="straight") {#X1285:1 %t6712:p};
// %t6713 = $IO_PORT @ATTACH &n1455 => @PLACE(198, -3293) => @ORIENT("R0");
// %t6713 @TEXT("n1455", key="name", size=0.75);
// &n1455 @WIRE(mode="straight") {#X1285:2 %t6713:p};
// %t6714 = $IO_PORT @ATTACH &n51 => @PLACE(198, -3297) => @ORIENT("R0");
// %t6714 @TEXT("n51", key="name", size=0.75);
// &n51 @WIRE(mode="straight") {#X1285:3 %t6714:p};
// %t6715 = $IO_PORT @ATTACH &n152 => @PLACE(218, -3293) => @ORIENT("MY");
// %t6715 @TEXT("n152", key="name", size=0.75);
// &n152 @WIRE(mode="straight") {#X1285:4 %t6715:p};
// %t6716 = $SUPPLY @ATTACH &vdd => @PLACE(208, -3280);
// &vdd @WIRE(mode="straight") {#X1285:5 %t6716:p};
// %t6717 = $GROUND @ATTACH &vss => @PLACE(208, -3306);
// &vss @WIRE(mode="straight") {#X1285:6 %t6717:p};
// %t6718 = $IO_PORT @ATTACH &vss => @PLACE(238, -3289) => @ORIENT("R0");
// %t6718 @TEXT("vss", key="name", size=0.75);
// &vss @WIRE(mode="straight") {#X1286:1 %t6718:p};
// %t6719 = $IO_PORT @ATTACH &n1456 => @PLACE(238, -3293) => @ORIENT("R0");
// %t6719 @TEXT("n1456", key="name", size=0.75);
// &n1456 @WIRE(mode="straight") {#X1286:2 %t6719:p};
// %t6720 = $IO_PORT @ATTACH &n51 => @PLACE(238, -3297) => @ORIENT("R0");
// %t6720 @TEXT("n51", key="name", size=0.75);
// &n51 @WIRE(mode="straight") {#X1286:3 %t6720:p};
// %t6721 = $IO_PORT @ATTACH &n150 => @PLACE(258, -3293) => @ORIENT("MY");
// %t6721 @TEXT("n150", key="name", size=0.75);
// &n150 @WIRE(mode="straight") {#X1286:4 %t6721:p};
// %t6722 = $SUPPLY @ATTACH &vdd => @PLACE(248, -3280);
// &vdd @WIRE(mode="straight") {#X1286:5 %t6722:p};
// %t6723 = $GROUND @ATTACH &vss => @PLACE(248, -3306);
// &vss @WIRE(mode="straight") {#X1286:6 %t6723:p};
// %t6724 = $IO_PORT @ATTACH &n978 => @PLACE(278, -3289) => @ORIENT("R0");
// %t6724 @TEXT("n978", key="name", size=0.75);
// &n978 @WIRE(mode="straight") {#X1287:1 %t6724:p};
// %t6725 = $IO_PORT @ATTACH &n1457 => @PLACE(278, -3293) => @ORIENT("R0");
// %t6725 @TEXT("n1457", key="name", size=0.75);
// &n1457 @WIRE(mode="straight") {#X1287:2 %t6725:p};
// %t6726 = $IO_PORT @ATTACH &n51 => @PLACE(278, -3297) => @ORIENT("R0");
// %t6726 @TEXT("n51", key="name", size=0.75);
// &n51 @WIRE(mode="straight") {#X1287:3 %t6726:p};
// %t6727 = $IO_PORT @ATTACH &n190 => @PLACE(298, -3293) => @ORIENT("MY");
// %t6727 @TEXT("n190", key="name", size=0.75);
// &n190 @WIRE(mode="straight") {#X1287:4 %t6727:p};
// %t6728 = $SUPPLY @ATTACH &vdd => @PLACE(288, -3280);
// &vdd @WIRE(mode="straight") {#X1287:5 %t6728:p};
// %t6729 = $GROUND @ATTACH &vss => @PLACE(288, -3306);
// &vss @WIRE(mode="straight") {#X1287:6 %t6729:p};
// %t6730 = $IO_PORT @ATTACH &n980 => @PLACE(158, -3328) => @ORIENT("R0");
// %t6730 @TEXT("n980", key="name", size=0.75);
// &n980 @WIRE(mode="straight") {#X1288:1 %t6730:p};
// %t6731 = $IO_PORT @ATTACH &n966 => @PLACE(178, -3328) => @ORIENT("MY");
// %t6731 @TEXT("n966", key="name", size=0.75);
// &n966 @WIRE(mode="straight") {#X1288:2 %t6731:p};
// %t6732 = $SUPPLY @ATTACH &vdd => @PLACE(168, -3319);
// &vdd @WIRE(mode="straight") {#X1288:3 %t6732:p};
// %t6733 = $GROUND @ATTACH &vss => @PLACE(168, -3337);
// &vss @WIRE(mode="straight") {#X1288:4 %t6733:p};
// %t6734 = $IO_PORT @ATTACH &n966 => @PLACE(198, -3324) => @ORIENT("R0");
// %t6734 @TEXT("n966", key="name", size=0.75);
// &n966 @WIRE(mode="straight") {#X1289:1 %t6734:p};
// %t6735 = $IO_PORT @ATTACH &vdd => @PLACE(198, -3328) => @ORIENT("R0");
// %t6735 @TEXT("vdd", key="name", size=0.75);
// &vdd @WIRE(mode="straight") {#X1289:2 %t6735:p};
// %t6736 = $IO_PORT @ATTACH &n117 => @PLACE(198, -3332) => @ORIENT("R0");
// %t6736 @TEXT("n117", key="name", size=0.75);
// &n117 @WIRE(mode="straight") {#X1289:3 %t6736:p};
// %t6737 = $IO_PORT @ATTACH &n1458 => @PLACE(218, -3328) => @ORIENT("MY");
// %t6737 @TEXT("n1458", key="name", size=0.75);
// &n1458 @WIRE(mode="straight") {#X1289:4 %t6737:p};
// %t6738 = $SUPPLY @ATTACH &vdd => @PLACE(208, -3315);
// &vdd @WIRE(mode="straight") {#X1289:5 %t6738:p};
// %t6739 = $GROUND @ATTACH &vss => @PLACE(208, -3341);
// &vss @WIRE(mode="straight") {#X1289:6 %t6739:p};
// %t6740 = $IO_PORT @ATTACH &n1459 => @PLACE(238, -3324) => @ORIENT("R0");
// %t6740 @TEXT("n1459", key="name", size=0.75);
// &n1459 @WIRE(mode="straight") {#X1290:1 %t6740:p};
// %t6741 = $IO_PORT @ATTACH &n1458 => @PLACE(238, -3328) => @ORIENT("R0");
// %t6741 @TEXT("n1458", key="name", size=0.75);
// &n1458 @WIRE(mode="straight") {#X1290:2 %t6741:p};
// %t6742 = $IO_PORT @ATTACH &n51 => @PLACE(238, -3332) => @ORIENT("R0");
// %t6742 @TEXT("n51", key="name", size=0.75);
// &n51 @WIRE(mode="straight") {#X1290:3 %t6742:p};
// %t6743 = $IO_PORT @ATTACH &n178 => @PLACE(258, -3328) => @ORIENT("MY");
// %t6743 @TEXT("n178", key="name", size=0.75);
// &n178 @WIRE(mode="straight") {#X1290:4 %t6743:p};
// %t6744 = $SUPPLY @ATTACH &vdd => @PLACE(248, -3315);
// &vdd @WIRE(mode="straight") {#X1290:5 %t6744:p};
// %t6745 = $GROUND @ATTACH &vss => @PLACE(248, -3341);
// &vss @WIRE(mode="straight") {#X1290:6 %t6745:p};
// %t6746 = $IO_PORT @ATTACH &vss => @PLACE(278, -3324) => @ORIENT("R0");
// %t6746 @TEXT("vss", key="name", size=0.75);
// &vss @WIRE(mode="straight") {#X1291:1 %t6746:p};
// %t6747 = $IO_PORT @ATTACH &n266 => @PLACE(278, -3328) => @ORIENT("R0");
// %t6747 @TEXT("n266", key="name", size=0.75);
// &n266 @WIRE(mode="straight") {#X1291:2 %t6747:p};
// %t6748 = $IO_PORT @ATTACH &n1102 => @PLACE(278, -3332) => @ORIENT("R0");
// %t6748 @TEXT("n1102", key="name", size=0.75);
// &n1102 @WIRE(mode="straight") {#X1291:3 %t6748:p};
// %t6749 = $IO_PORT @ATTACH &n1460 => @PLACE(298, -3328) => @ORIENT("MY");
// %t6749 @TEXT("n1460", key="name", size=0.75);
// &n1460 @WIRE(mode="straight") {#X1291:4 %t6749:p};
// %t6750 = $SUPPLY @ATTACH &vdd => @PLACE(288, -3315);
// &vdd @WIRE(mode="straight") {#X1291:5 %t6750:p};
// %t6751 = $GROUND @ATTACH &vss => @PLACE(288, -3341);
// &vss @WIRE(mode="straight") {#X1291:6 %t6751:p};
// %t6752 = $IO_PORT @ATTACH &vss => @PLACE(158, -3359) => @ORIENT("R0");
// %t6752 @TEXT("vss", key="name", size=0.75);
// &vss @WIRE(mode="straight") {#X1292:1 %t6752:p};
// %t6753 = $IO_PORT @ATTACH &n583 => @PLACE(158, -3363) => @ORIENT("R0");
// %t6753 @TEXT("n583", key="name", size=0.75);
// &n583 @WIRE(mode="straight") {#X1292:2 %t6753:p};
// %t6754 = $IO_PORT @ATTACH &n1102 => @PLACE(158, -3367) => @ORIENT("R0");
// %t6754 @TEXT("n1102", key="name", size=0.75);
// &n1102 @WIRE(mode="straight") {#X1292:3 %t6754:p};
// %t6755 = $IO_PORT @ATTACH &n1461 => @PLACE(178, -3363) => @ORIENT("MY");
// %t6755 @TEXT("n1461", key="name", size=0.75);
// &n1461 @WIRE(mode="straight") {#X1292:4 %t6755:p};
// %t6756 = $SUPPLY @ATTACH &vdd => @PLACE(168, -3350);
// &vdd @WIRE(mode="straight") {#X1292:5 %t6756:p};
// %t6757 = $GROUND @ATTACH &vss => @PLACE(168, -3376);
// &vss @WIRE(mode="straight") {#X1292:6 %t6757:p};
// %t6758 = $IO_PORT @ATTACH &vss => @PLACE(198, -3359) => @ORIENT("R0");
// %t6758 @TEXT("vss", key="name", size=0.75);
// &vss @WIRE(mode="straight") {#X1293:1 %t6758:p};
// %t6759 = $IO_PORT @ATTACH &n585 => @PLACE(198, -3363) => @ORIENT("R0");
// %t6759 @TEXT("n585", key="name", size=0.75);
// &n585 @WIRE(mode="straight") {#X1293:2 %t6759:p};
// %t6760 = $IO_PORT @ATTACH &n1102 => @PLACE(198, -3367) => @ORIENT("R0");
// %t6760 @TEXT("n1102", key="name", size=0.75);
// &n1102 @WIRE(mode="straight") {#X1293:3 %t6760:p};
// %t6761 = $IO_PORT @ATTACH &n1462 => @PLACE(218, -3363) => @ORIENT("MY");
// %t6761 @TEXT("n1462", key="name", size=0.75);
// &n1462 @WIRE(mode="straight") {#X1293:4 %t6761:p};
// %t6762 = $SUPPLY @ATTACH &vdd => @PLACE(208, -3350);
// &vdd @WIRE(mode="straight") {#X1293:5 %t6762:p};
// %t6763 = $GROUND @ATTACH &vss => @PLACE(208, -3376);
// &vss @WIRE(mode="straight") {#X1293:6 %t6763:p};
// %t6764 = $IO_PORT @ATTACH &vss => @PLACE(238, -3359) => @ORIENT("R0");
// %t6764 @TEXT("vss", key="name", size=0.75);
// &vss @WIRE(mode="straight") {#X1294:1 %t6764:p};
// %t6765 = $IO_PORT @ATTACH &n587 => @PLACE(238, -3363) => @ORIENT("R0");
// %t6765 @TEXT("n587", key="name", size=0.75);
// &n587 @WIRE(mode="straight") {#X1294:2 %t6765:p};
// %t6766 = $IO_PORT @ATTACH &n1102 => @PLACE(238, -3367) => @ORIENT("R0");
// %t6766 @TEXT("n1102", key="name", size=0.75);
// &n1102 @WIRE(mode="straight") {#X1294:3 %t6766:p};
// %t6767 = $IO_PORT @ATTACH &n1463 => @PLACE(258, -3363) => @ORIENT("MY");
// %t6767 @TEXT("n1463", key="name", size=0.75);
// &n1463 @WIRE(mode="straight") {#X1294:4 %t6767:p};
// %t6768 = $SUPPLY @ATTACH &vdd => @PLACE(248, -3350);
// &vdd @WIRE(mode="straight") {#X1294:5 %t6768:p};
// %t6769 = $GROUND @ATTACH &vss => @PLACE(248, -3376);
// &vss @WIRE(mode="straight") {#X1294:6 %t6769:p};
// %t6770 = $IO_PORT @ATTACH &vss => @PLACE(278, -3359) => @ORIENT("R0");
// %t6770 @TEXT("vss", key="name", size=0.75);
// &vss @WIRE(mode="straight") {#X1295:1 %t6770:p};
// %t6771 = $IO_PORT @ATTACH &n589 => @PLACE(278, -3363) => @ORIENT("R0");
// %t6771 @TEXT("n589", key="name", size=0.75);
// &n589 @WIRE(mode="straight") {#X1295:2 %t6771:p};
// %t6772 = $IO_PORT @ATTACH &n1102 => @PLACE(278, -3367) => @ORIENT("R0");
// %t6772 @TEXT("n1102", key="name", size=0.75);
// &n1102 @WIRE(mode="straight") {#X1295:3 %t6772:p};
// %t6773 = $IO_PORT @ATTACH &n1464 => @PLACE(298, -3363) => @ORIENT("MY");
// %t6773 @TEXT("n1464", key="name", size=0.75);
// &n1464 @WIRE(mode="straight") {#X1295:4 %t6773:p};
// %t6774 = $SUPPLY @ATTACH &vdd => @PLACE(288, -3350);
// &vdd @WIRE(mode="straight") {#X1295:5 %t6774:p};
// %t6775 = $GROUND @ATTACH &vss => @PLACE(288, -3376);
// &vss @WIRE(mode="straight") {#X1295:6 %t6775:p};
// %t6776 = $IO_PORT @ATTACH &vss => @PLACE(326, -3184) => @ORIENT("R0");
// %t6776 @TEXT("vss", key="name", size=0.75);
// &vss @WIRE(mode="straight") {#X1296:1 %t6776:p};
// %t6777 = $IO_PORT @ATTACH &n591 => @PLACE(326, -3188) => @ORIENT("R0");
// %t6777 @TEXT("n591", key="name", size=0.75);
// &n591 @WIRE(mode="straight") {#X1296:2 %t6777:p};
// %t6778 = $IO_PORT @ATTACH &n1102 => @PLACE(326, -3192) => @ORIENT("R0");
// %t6778 @TEXT("n1102", key="name", size=0.75);
// &n1102 @WIRE(mode="straight") {#X1296:3 %t6778:p};
// %t6779 = $IO_PORT @ATTACH &n1465 => @PLACE(346, -3188) => @ORIENT("MY");
// %t6779 @TEXT("n1465", key="name", size=0.75);
// &n1465 @WIRE(mode="straight") {#X1296:4 %t6779:p};
// %t6780 = $SUPPLY @ATTACH &vdd => @PLACE(336, -3175);
// &vdd @WIRE(mode="straight") {#X1296:5 %t6780:p};
// %t6781 = $GROUND @ATTACH &vss => @PLACE(336, -3201);
// &vss @WIRE(mode="straight") {#X1296:6 %t6781:p};
// %t6782 = $IO_PORT @ATTACH &vss => @PLACE(366, -3184) => @ORIENT("R0");
// %t6782 @TEXT("vss", key="name", size=0.75);
// &vss @WIRE(mode="straight") {#X1297:1 %t6782:p};
// %t6783 = $IO_PORT @ATTACH &n593 => @PLACE(366, -3188) => @ORIENT("R0");
// %t6783 @TEXT("n593", key="name", size=0.75);
// &n593 @WIRE(mode="straight") {#X1297:2 %t6783:p};
// %t6784 = $IO_PORT @ATTACH &n1102 => @PLACE(366, -3192) => @ORIENT("R0");
// %t6784 @TEXT("n1102", key="name", size=0.75);
// &n1102 @WIRE(mode="straight") {#X1297:3 %t6784:p};
// %t6785 = $IO_PORT @ATTACH &n1466 => @PLACE(386, -3188) => @ORIENT("MY");
// %t6785 @TEXT("n1466", key="name", size=0.75);
// &n1466 @WIRE(mode="straight") {#X1297:4 %t6785:p};
// %t6786 = $SUPPLY @ATTACH &vdd => @PLACE(376, -3175);
// &vdd @WIRE(mode="straight") {#X1297:5 %t6786:p};
// %t6787 = $GROUND @ATTACH &vss => @PLACE(376, -3201);
// &vss @WIRE(mode="straight") {#X1297:6 %t6787:p};
// %t6788 = $IO_PORT @ATTACH &vss => @PLACE(406, -3184) => @ORIENT("R0");
// %t6788 @TEXT("vss", key="name", size=0.75);
// &vss @WIRE(mode="straight") {#X1298:1 %t6788:p};
// %t6789 = $IO_PORT @ATTACH &n595 => @PLACE(406, -3188) => @ORIENT("R0");
// %t6789 @TEXT("n595", key="name", size=0.75);
// &n595 @WIRE(mode="straight") {#X1298:2 %t6789:p};
// %t6790 = $IO_PORT @ATTACH &n1102 => @PLACE(406, -3192) => @ORIENT("R0");
// %t6790 @TEXT("n1102", key="name", size=0.75);
// &n1102 @WIRE(mode="straight") {#X1298:3 %t6790:p};
// %t6791 = $IO_PORT @ATTACH &n1467 => @PLACE(426, -3188) => @ORIENT("MY");
// %t6791 @TEXT("n1467", key="name", size=0.75);
// &n1467 @WIRE(mode="straight") {#X1298:4 %t6791:p};
// %t6792 = $SUPPLY @ATTACH &vdd => @PLACE(416, -3175);
// &vdd @WIRE(mode="straight") {#X1298:5 %t6792:p};
// %t6793 = $GROUND @ATTACH &vss => @PLACE(416, -3201);
// &vss @WIRE(mode="straight") {#X1298:6 %t6793:p};
// %t6794 = $IO_PORT @ATTACH &vss => @PLACE(446, -3184) => @ORIENT("R0");
// %t6794 @TEXT("vss", key="name", size=0.75);
// &vss @WIRE(mode="straight") {#X1299:1 %t6794:p};
// %t6795 = $IO_PORT @ATTACH &n266 => @PLACE(446, -3188) => @ORIENT("R0");
// %t6795 @TEXT("n266", key="name", size=0.75);
// &n266 @WIRE(mode="straight") {#X1299:2 %t6795:p};
// %t6796 = $IO_PORT @ATTACH &n1081 => @PLACE(446, -3192) => @ORIENT("R0");
// %t6796 @TEXT("n1081", key="name", size=0.75);
// &n1081 @WIRE(mode="straight") {#X1299:3 %t6796:p};
// %t6797 = $IO_PORT @ATTACH &n1468 => @PLACE(466, -3188) => @ORIENT("MY");
// %t6797 @TEXT("n1468", key="name", size=0.75);
// &n1468 @WIRE(mode="straight") {#X1299:4 %t6797:p};
// %t6798 = $SUPPLY @ATTACH &vdd => @PLACE(456, -3175);
// &vdd @WIRE(mode="straight") {#X1299:5 %t6798:p};
// %t6799 = $GROUND @ATTACH &vss => @PLACE(456, -3201);
// &vss @WIRE(mode="straight") {#X1299:6 %t6799:p};
// %t6800 = $IO_PORT @ATTACH &vss => @PLACE(326, -3219) => @ORIENT("R0");
// %t6800 @TEXT("vss", key="name", size=0.75);
// &vss @WIRE(mode="straight") {#X1300:1 %t6800:p};
// %t6801 = $IO_PORT @ATTACH &n583 => @PLACE(326, -3223) => @ORIENT("R0");
// %t6801 @TEXT("n583", key="name", size=0.75);
// &n583 @WIRE(mode="straight") {#X1300:2 %t6801:p};
// %t6802 = $IO_PORT @ATTACH &n1081 => @PLACE(326, -3227) => @ORIENT("R0");
// %t6802 @TEXT("n1081", key="name", size=0.75);
// &n1081 @WIRE(mode="straight") {#X1300:3 %t6802:p};
// %t6803 = $IO_PORT @ATTACH &n1469 => @PLACE(346, -3223) => @ORIENT("MY");
// %t6803 @TEXT("n1469", key="name", size=0.75);
// &n1469 @WIRE(mode="straight") {#X1300:4 %t6803:p};
// %t6804 = $SUPPLY @ATTACH &vdd => @PLACE(336, -3210);
// &vdd @WIRE(mode="straight") {#X1300:5 %t6804:p};
// %t6805 = $GROUND @ATTACH &vss => @PLACE(336, -3236);
// &vss @WIRE(mode="straight") {#X1300:6 %t6805:p};
// %t6806 = $IO_PORT @ATTACH &vss => @PLACE(366, -3219) => @ORIENT("R0");
// %t6806 @TEXT("vss", key="name", size=0.75);
// &vss @WIRE(mode="straight") {#X1301:1 %t6806:p};
// %t6807 = $IO_PORT @ATTACH &n585 => @PLACE(366, -3223) => @ORIENT("R0");
// %t6807 @TEXT("n585", key="name", size=0.75);
// &n585 @WIRE(mode="straight") {#X1301:2 %t6807:p};
// %t6808 = $IO_PORT @ATTACH &n1081 => @PLACE(366, -3227) => @ORIENT("R0");
// %t6808 @TEXT("n1081", key="name", size=0.75);
// &n1081 @WIRE(mode="straight") {#X1301:3 %t6808:p};
// %t6809 = $IO_PORT @ATTACH &n1470 => @PLACE(386, -3223) => @ORIENT("MY");
// %t6809 @TEXT("n1470", key="name", size=0.75);
// &n1470 @WIRE(mode="straight") {#X1301:4 %t6809:p};
// %t6810 = $SUPPLY @ATTACH &vdd => @PLACE(376, -3210);
// &vdd @WIRE(mode="straight") {#X1301:5 %t6810:p};
// %t6811 = $GROUND @ATTACH &vss => @PLACE(376, -3236);
// &vss @WIRE(mode="straight") {#X1301:6 %t6811:p};
// %t6812 = $IO_PORT @ATTACH &vss => @PLACE(406, -3219) => @ORIENT("R0");
// %t6812 @TEXT("vss", key="name", size=0.75);
// &vss @WIRE(mode="straight") {#X1302:1 %t6812:p};
// %t6813 = $IO_PORT @ATTACH &n587 => @PLACE(406, -3223) => @ORIENT("R0");
// %t6813 @TEXT("n587", key="name", size=0.75);
// &n587 @WIRE(mode="straight") {#X1302:2 %t6813:p};
// %t6814 = $IO_PORT @ATTACH &n1081 => @PLACE(406, -3227) => @ORIENT("R0");
// %t6814 @TEXT("n1081", key="name", size=0.75);
// &n1081 @WIRE(mode="straight") {#X1302:3 %t6814:p};
// %t6815 = $IO_PORT @ATTACH &n1471 => @PLACE(426, -3223) => @ORIENT("MY");
// %t6815 @TEXT("n1471", key="name", size=0.75);
// &n1471 @WIRE(mode="straight") {#X1302:4 %t6815:p};
// %t6816 = $SUPPLY @ATTACH &vdd => @PLACE(416, -3210);
// &vdd @WIRE(mode="straight") {#X1302:5 %t6816:p};
// %t6817 = $GROUND @ATTACH &vss => @PLACE(416, -3236);
// &vss @WIRE(mode="straight") {#X1302:6 %t6817:p};
// %t6818 = $IO_PORT @ATTACH &vss => @PLACE(446, -3219) => @ORIENT("R0");
// %t6818 @TEXT("vss", key="name", size=0.75);
// &vss @WIRE(mode="straight") {#X1303:1 %t6818:p};
// %t6819 = $IO_PORT @ATTACH &n589 => @PLACE(446, -3223) => @ORIENT("R0");
// %t6819 @TEXT("n589", key="name", size=0.75);
// &n589 @WIRE(mode="straight") {#X1303:2 %t6819:p};
// %t6820 = $IO_PORT @ATTACH &n1081 => @PLACE(446, -3227) => @ORIENT("R0");
// %t6820 @TEXT("n1081", key="name", size=0.75);
// &n1081 @WIRE(mode="straight") {#X1303:3 %t6820:p};
// %t6821 = $IO_PORT @ATTACH &n1472 => @PLACE(466, -3223) => @ORIENT("MY");
// %t6821 @TEXT("n1472", key="name", size=0.75);
// &n1472 @WIRE(mode="straight") {#X1303:4 %t6821:p};
// %t6822 = $SUPPLY @ATTACH &vdd => @PLACE(456, -3210);
// &vdd @WIRE(mode="straight") {#X1303:5 %t6822:p};
// %t6823 = $GROUND @ATTACH &vss => @PLACE(456, -3236);
// &vss @WIRE(mode="straight") {#X1303:6 %t6823:p};
// %t6824 = $IO_PORT @ATTACH &vss => @PLACE(326, -3254) => @ORIENT("R0");
// %t6824 @TEXT("vss", key="name", size=0.75);
// &vss @WIRE(mode="straight") {#X1304:1 %t6824:p};
// %t6825 = $IO_PORT @ATTACH &n591 => @PLACE(326, -3258) => @ORIENT("R0");
// %t6825 @TEXT("n591", key="name", size=0.75);
// &n591 @WIRE(mode="straight") {#X1304:2 %t6825:p};
// %t6826 = $IO_PORT @ATTACH &n1081 => @PLACE(326, -3262) => @ORIENT("R0");
// %t6826 @TEXT("n1081", key="name", size=0.75);
// &n1081 @WIRE(mode="straight") {#X1304:3 %t6826:p};
// %t6827 = $IO_PORT @ATTACH &n1473 => @PLACE(346, -3258) => @ORIENT("MY");
// %t6827 @TEXT("n1473", key="name", size=0.75);
// &n1473 @WIRE(mode="straight") {#X1304:4 %t6827:p};
// %t6828 = $SUPPLY @ATTACH &vdd => @PLACE(336, -3245);
// &vdd @WIRE(mode="straight") {#X1304:5 %t6828:p};
// %t6829 = $GROUND @ATTACH &vss => @PLACE(336, -3271);
// &vss @WIRE(mode="straight") {#X1304:6 %t6829:p};
// %t6830 = $IO_PORT @ATTACH &vss => @PLACE(366, -3254) => @ORIENT("R0");
// %t6830 @TEXT("vss", key="name", size=0.75);
// &vss @WIRE(mode="straight") {#X1305:1 %t6830:p};
// %t6831 = $IO_PORT @ATTACH &n593 => @PLACE(366, -3258) => @ORIENT("R0");
// %t6831 @TEXT("n593", key="name", size=0.75);
// &n593 @WIRE(mode="straight") {#X1305:2 %t6831:p};
// %t6832 = $IO_PORT @ATTACH &n1081 => @PLACE(366, -3262) => @ORIENT("R0");
// %t6832 @TEXT("n1081", key="name", size=0.75);
// &n1081 @WIRE(mode="straight") {#X1305:3 %t6832:p};
// %t6833 = $IO_PORT @ATTACH &n1474 => @PLACE(386, -3258) => @ORIENT("MY");
// %t6833 @TEXT("n1474", key="name", size=0.75);
// &n1474 @WIRE(mode="straight") {#X1305:4 %t6833:p};
// %t6834 = $SUPPLY @ATTACH &vdd => @PLACE(376, -3245);
// &vdd @WIRE(mode="straight") {#X1305:5 %t6834:p};
// %t6835 = $GROUND @ATTACH &vss => @PLACE(376, -3271);
// &vss @WIRE(mode="straight") {#X1305:6 %t6835:p};
// %t6836 = $IO_PORT @ATTACH &vss => @PLACE(406, -3254) => @ORIENT("R0");
// %t6836 @TEXT("vss", key="name", size=0.75);
// &vss @WIRE(mode="straight") {#X1306:1 %t6836:p};
// %t6837 = $IO_PORT @ATTACH &n595 => @PLACE(406, -3258) => @ORIENT("R0");
// %t6837 @TEXT("n595", key="name", size=0.75);
// &n595 @WIRE(mode="straight") {#X1306:2 %t6837:p};
// %t6838 = $IO_PORT @ATTACH &n1081 => @PLACE(406, -3262) => @ORIENT("R0");
// %t6838 @TEXT("n1081", key="name", size=0.75);
// &n1081 @WIRE(mode="straight") {#X1306:3 %t6838:p};
// %t6839 = $IO_PORT @ATTACH &n1475 => @PLACE(426, -3258) => @ORIENT("MY");
// %t6839 @TEXT("n1475", key="name", size=0.75);
// &n1475 @WIRE(mode="straight") {#X1306:4 %t6839:p};
// %t6840 = $SUPPLY @ATTACH &vdd => @PLACE(416, -3245);
// &vdd @WIRE(mode="straight") {#X1306:5 %t6840:p};
// %t6841 = $GROUND @ATTACH &vss => @PLACE(416, -3271);
// &vss @WIRE(mode="straight") {#X1306:6 %t6841:p};
// %t6842 = $IO_PORT @ATTACH &vss => @PLACE(446, -3254) => @ORIENT("R0");
// %t6842 @TEXT("vss", key="name", size=0.75);
// &vss @WIRE(mode="straight") {#X1307:1 %t6842:p};
// %t6843 = $IO_PORT @ATTACH &n266 => @PLACE(446, -3258) => @ORIENT("R0");
// %t6843 @TEXT("n266", key="name", size=0.75);
// &n266 @WIRE(mode="straight") {#X1307:2 %t6843:p};
// %t6844 = $IO_PORT @ATTACH &n1074 => @PLACE(446, -3262) => @ORIENT("R0");
// %t6844 @TEXT("n1074", key="name", size=0.75);
// &n1074 @WIRE(mode="straight") {#X1307:3 %t6844:p};
// %t6845 = $IO_PORT @ATTACH &n1476 => @PLACE(466, -3258) => @ORIENT("MY");
// %t6845 @TEXT("n1476", key="name", size=0.75);
// &n1476 @WIRE(mode="straight") {#X1307:4 %t6845:p};
// %t6846 = $SUPPLY @ATTACH &vdd => @PLACE(456, -3245);
// &vdd @WIRE(mode="straight") {#X1307:5 %t6846:p};
// %t6847 = $GROUND @ATTACH &vss => @PLACE(456, -3271);
// &vss @WIRE(mode="straight") {#X1307:6 %t6847:p};
// %t6848 = $IO_PORT @ATTACH &vss => @PLACE(326, -3289) => @ORIENT("R0");
// %t6848 @TEXT("vss", key="name", size=0.75);
// &vss @WIRE(mode="straight") {#X1308:1 %t6848:p};
// %t6849 = $IO_PORT @ATTACH &n583 => @PLACE(326, -3293) => @ORIENT("R0");
// %t6849 @TEXT("n583", key="name", size=0.75);
// &n583 @WIRE(mode="straight") {#X1308:2 %t6849:p};
// %t6850 = $IO_PORT @ATTACH &n1074 => @PLACE(326, -3297) => @ORIENT("R0");
// %t6850 @TEXT("n1074", key="name", size=0.75);
// &n1074 @WIRE(mode="straight") {#X1308:3 %t6850:p};
// %t6851 = $IO_PORT @ATTACH &n1477 => @PLACE(346, -3293) => @ORIENT("MY");
// %t6851 @TEXT("n1477", key="name", size=0.75);
// &n1477 @WIRE(mode="straight") {#X1308:4 %t6851:p};
// %t6852 = $SUPPLY @ATTACH &vdd => @PLACE(336, -3280);
// &vdd @WIRE(mode="straight") {#X1308:5 %t6852:p};
// %t6853 = $GROUND @ATTACH &vss => @PLACE(336, -3306);
// &vss @WIRE(mode="straight") {#X1308:6 %t6853:p};
// %t6854 = $IO_PORT @ATTACH &vss => @PLACE(366, -3289) => @ORIENT("R0");
// %t6854 @TEXT("vss", key="name", size=0.75);
// &vss @WIRE(mode="straight") {#X1309:1 %t6854:p};
// %t6855 = $IO_PORT @ATTACH &n585 => @PLACE(366, -3293) => @ORIENT("R0");
// %t6855 @TEXT("n585", key="name", size=0.75);
// &n585 @WIRE(mode="straight") {#X1309:2 %t6855:p};
// %t6856 = $IO_PORT @ATTACH &n1074 => @PLACE(366, -3297) => @ORIENT("R0");
// %t6856 @TEXT("n1074", key="name", size=0.75);
// &n1074 @WIRE(mode="straight") {#X1309:3 %t6856:p};
// %t6857 = $IO_PORT @ATTACH &n1478 => @PLACE(386, -3293) => @ORIENT("MY");
// %t6857 @TEXT("n1478", key="name", size=0.75);
// &n1478 @WIRE(mode="straight") {#X1309:4 %t6857:p};
// %t6858 = $SUPPLY @ATTACH &vdd => @PLACE(376, -3280);
// &vdd @WIRE(mode="straight") {#X1309:5 %t6858:p};
// %t6859 = $GROUND @ATTACH &vss => @PLACE(376, -3306);
// &vss @WIRE(mode="straight") {#X1309:6 %t6859:p};
// %t6860 = $IO_PORT @ATTACH &vss => @PLACE(406, -3289) => @ORIENT("R0");
// %t6860 @TEXT("vss", key="name", size=0.75);
// &vss @WIRE(mode="straight") {#X1310:1 %t6860:p};
// %t6861 = $IO_PORT @ATTACH &n587 => @PLACE(406, -3293) => @ORIENT("R0");
// %t6861 @TEXT("n587", key="name", size=0.75);
// &n587 @WIRE(mode="straight") {#X1310:2 %t6861:p};
// %t6862 = $IO_PORT @ATTACH &n1074 => @PLACE(406, -3297) => @ORIENT("R0");
// %t6862 @TEXT("n1074", key="name", size=0.75);
// &n1074 @WIRE(mode="straight") {#X1310:3 %t6862:p};
// %t6863 = $IO_PORT @ATTACH &n1479 => @PLACE(426, -3293) => @ORIENT("MY");
// %t6863 @TEXT("n1479", key="name", size=0.75);
// &n1479 @WIRE(mode="straight") {#X1310:4 %t6863:p};
// %t6864 = $SUPPLY @ATTACH &vdd => @PLACE(416, -3280);
// &vdd @WIRE(mode="straight") {#X1310:5 %t6864:p};
// %t6865 = $GROUND @ATTACH &vss => @PLACE(416, -3306);
// &vss @WIRE(mode="straight") {#X1310:6 %t6865:p};
// %t6866 = $IO_PORT @ATTACH &vss => @PLACE(446, -3289) => @ORIENT("R0");
// %t6866 @TEXT("vss", key="name", size=0.75);
// &vss @WIRE(mode="straight") {#X1311:1 %t6866:p};
// %t6867 = $IO_PORT @ATTACH &n589 => @PLACE(446, -3293) => @ORIENT("R0");
// %t6867 @TEXT("n589", key="name", size=0.75);
// &n589 @WIRE(mode="straight") {#X1311:2 %t6867:p};
// %t6868 = $IO_PORT @ATTACH &n1074 => @PLACE(446, -3297) => @ORIENT("R0");
// %t6868 @TEXT("n1074", key="name", size=0.75);
// &n1074 @WIRE(mode="straight") {#X1311:3 %t6868:p};
// %t6869 = $IO_PORT @ATTACH &n1480 => @PLACE(466, -3293) => @ORIENT("MY");
// %t6869 @TEXT("n1480", key="name", size=0.75);
// &n1480 @WIRE(mode="straight") {#X1311:4 %t6869:p};
// %t6870 = $SUPPLY @ATTACH &vdd => @PLACE(456, -3280);
// &vdd @WIRE(mode="straight") {#X1311:5 %t6870:p};
// %t6871 = $GROUND @ATTACH &vss => @PLACE(456, -3306);
// &vss @WIRE(mode="straight") {#X1311:6 %t6871:p};
// %t6872 = $IO_PORT @ATTACH &vss => @PLACE(326, -3324) => @ORIENT("R0");
// %t6872 @TEXT("vss", key="name", size=0.75);
// &vss @WIRE(mode="straight") {#X1312:1 %t6872:p};
// %t6873 = $IO_PORT @ATTACH &n591 => @PLACE(326, -3328) => @ORIENT("R0");
// %t6873 @TEXT("n591", key="name", size=0.75);
// &n591 @WIRE(mode="straight") {#X1312:2 %t6873:p};
// %t6874 = $IO_PORT @ATTACH &n1074 => @PLACE(326, -3332) => @ORIENT("R0");
// %t6874 @TEXT("n1074", key="name", size=0.75);
// &n1074 @WIRE(mode="straight") {#X1312:3 %t6874:p};
// %t6875 = $IO_PORT @ATTACH &n1481 => @PLACE(346, -3328) => @ORIENT("MY");
// %t6875 @TEXT("n1481", key="name", size=0.75);
// &n1481 @WIRE(mode="straight") {#X1312:4 %t6875:p};
// %t6876 = $SUPPLY @ATTACH &vdd => @PLACE(336, -3315);
// &vdd @WIRE(mode="straight") {#X1312:5 %t6876:p};
// %t6877 = $GROUND @ATTACH &vss => @PLACE(336, -3341);
// &vss @WIRE(mode="straight") {#X1312:6 %t6877:p};
// %t6878 = $IO_PORT @ATTACH &vss => @PLACE(366, -3324) => @ORIENT("R0");
// %t6878 @TEXT("vss", key="name", size=0.75);
// &vss @WIRE(mode="straight") {#X1313:1 %t6878:p};
// %t6879 = $IO_PORT @ATTACH &n593 => @PLACE(366, -3328) => @ORIENT("R0");
// %t6879 @TEXT("n593", key="name", size=0.75);
// &n593 @WIRE(mode="straight") {#X1313:2 %t6879:p};
// %t6880 = $IO_PORT @ATTACH &n1074 => @PLACE(366, -3332) => @ORIENT("R0");
// %t6880 @TEXT("n1074", key="name", size=0.75);
// &n1074 @WIRE(mode="straight") {#X1313:3 %t6880:p};
// %t6881 = $IO_PORT @ATTACH &n1482 => @PLACE(386, -3328) => @ORIENT("MY");
// %t6881 @TEXT("n1482", key="name", size=0.75);
// &n1482 @WIRE(mode="straight") {#X1313:4 %t6881:p};
// %t6882 = $SUPPLY @ATTACH &vdd => @PLACE(376, -3315);
// &vdd @WIRE(mode="straight") {#X1313:5 %t6882:p};
// %t6883 = $GROUND @ATTACH &vss => @PLACE(376, -3341);
// &vss @WIRE(mode="straight") {#X1313:6 %t6883:p};
// %t6884 = $IO_PORT @ATTACH &vss => @PLACE(406, -3324) => @ORIENT("R0");
// %t6884 @TEXT("vss", key="name", size=0.75);
// &vss @WIRE(mode="straight") {#X1314:1 %t6884:p};
// %t6885 = $IO_PORT @ATTACH &n595 => @PLACE(406, -3328) => @ORIENT("R0");
// %t6885 @TEXT("n595", key="name", size=0.75);
// &n595 @WIRE(mode="straight") {#X1314:2 %t6885:p};
// %t6886 = $IO_PORT @ATTACH &n1074 => @PLACE(406, -3332) => @ORIENT("R0");
// %t6886 @TEXT("n1074", key="name", size=0.75);
// &n1074 @WIRE(mode="straight") {#X1314:3 %t6886:p};
// %t6887 = $IO_PORT @ATTACH &n1483 => @PLACE(426, -3328) => @ORIENT("MY");
// %t6887 @TEXT("n1483", key="name", size=0.75);
// &n1483 @WIRE(mode="straight") {#X1314:4 %t6887:p};
// %t6888 = $SUPPLY @ATTACH &vdd => @PLACE(416, -3315);
// &vdd @WIRE(mode="straight") {#X1314:5 %t6888:p};
// %t6889 = $GROUND @ATTACH &vss => @PLACE(416, -3341);
// &vss @WIRE(mode="straight") {#X1314:6 %t6889:p};
// %t6890 = $IO_PORT @ATTACH &vss => @PLACE(446, -3324) => @ORIENT("R0");
// %t6890 @TEXT("vss", key="name", size=0.75);
// &vss @WIRE(mode="straight") {#X1315:1 %t6890:p};
// %t6891 = $IO_PORT @ATTACH &n266 => @PLACE(446, -3328) => @ORIENT("R0");
// %t6891 @TEXT("n266", key="name", size=0.75);
// &n266 @WIRE(mode="straight") {#X1315:2 %t6891:p};
// %t6892 = $IO_PORT @ATTACH &n1069 => @PLACE(446, -3332) => @ORIENT("R0");
// %t6892 @TEXT("n1069", key="name", size=0.75);
// &n1069 @WIRE(mode="straight") {#X1315:3 %t6892:p};
// %t6893 = $IO_PORT @ATTACH &n1484 => @PLACE(466, -3328) => @ORIENT("MY");
// %t6893 @TEXT("n1484", key="name", size=0.75);
// &n1484 @WIRE(mode="straight") {#X1315:4 %t6893:p};
// %t6894 = $SUPPLY @ATTACH &vdd => @PLACE(456, -3315);
// &vdd @WIRE(mode="straight") {#X1315:5 %t6894:p};
// %t6895 = $GROUND @ATTACH &vss => @PLACE(456, -3341);
// &vss @WIRE(mode="straight") {#X1315:6 %t6895:p};
// %t6896 = $IO_PORT @ATTACH &vss => @PLACE(326, -3359) => @ORIENT("R0");
// %t6896 @TEXT("vss", key="name", size=0.75);
// &vss @WIRE(mode="straight") {#X1316:1 %t6896:p};
// %t6897 = $IO_PORT @ATTACH &n583 => @PLACE(326, -3363) => @ORIENT("R0");
// %t6897 @TEXT("n583", key="name", size=0.75);
// &n583 @WIRE(mode="straight") {#X1316:2 %t6897:p};
// %t6898 = $IO_PORT @ATTACH &n1069 => @PLACE(326, -3367) => @ORIENT("R0");
// %t6898 @TEXT("n1069", key="name", size=0.75);
// &n1069 @WIRE(mode="straight") {#X1316:3 %t6898:p};
// %t6899 = $IO_PORT @ATTACH &n1485 => @PLACE(346, -3363) => @ORIENT("MY");
// %t6899 @TEXT("n1485", key="name", size=0.75);
// &n1485 @WIRE(mode="straight") {#X1316:4 %t6899:p};
// %t6900 = $SUPPLY @ATTACH &vdd => @PLACE(336, -3350);
// &vdd @WIRE(mode="straight") {#X1316:5 %t6900:p};
// %t6901 = $GROUND @ATTACH &vss => @PLACE(336, -3376);
// &vss @WIRE(mode="straight") {#X1316:6 %t6901:p};
// %t6902 = $IO_PORT @ATTACH &vss => @PLACE(366, -3359) => @ORIENT("R0");
// %t6902 @TEXT("vss", key="name", size=0.75);
// &vss @WIRE(mode="straight") {#X1317:1 %t6902:p};
// %t6903 = $IO_PORT @ATTACH &n585 => @PLACE(366, -3363) => @ORIENT("R0");
// %t6903 @TEXT("n585", key="name", size=0.75);
// &n585 @WIRE(mode="straight") {#X1317:2 %t6903:p};
// %t6904 = $IO_PORT @ATTACH &n1069 => @PLACE(366, -3367) => @ORIENT("R0");
// %t6904 @TEXT("n1069", key="name", size=0.75);
// &n1069 @WIRE(mode="straight") {#X1317:3 %t6904:p};
// %t6905 = $IO_PORT @ATTACH &n1486 => @PLACE(386, -3363) => @ORIENT("MY");
// %t6905 @TEXT("n1486", key="name", size=0.75);
// &n1486 @WIRE(mode="straight") {#X1317:4 %t6905:p};
// %t6906 = $SUPPLY @ATTACH &vdd => @PLACE(376, -3350);
// &vdd @WIRE(mode="straight") {#X1317:5 %t6906:p};
// %t6907 = $GROUND @ATTACH &vss => @PLACE(376, -3376);
// &vss @WIRE(mode="straight") {#X1317:6 %t6907:p};
// %t6908 = $IO_PORT @ATTACH &vss => @PLACE(406, -3359) => @ORIENT("R0");
// %t6908 @TEXT("vss", key="name", size=0.75);
// &vss @WIRE(mode="straight") {#X1318:1 %t6908:p};
// %t6909 = $IO_PORT @ATTACH &n587 => @PLACE(406, -3363) => @ORIENT("R0");
// %t6909 @TEXT("n587", key="name", size=0.75);
// &n587 @WIRE(mode="straight") {#X1318:2 %t6909:p};
// %t6910 = $IO_PORT @ATTACH &n1069 => @PLACE(406, -3367) => @ORIENT("R0");
// %t6910 @TEXT("n1069", key="name", size=0.75);
// &n1069 @WIRE(mode="straight") {#X1318:3 %t6910:p};
// %t6911 = $IO_PORT @ATTACH &n1487 => @PLACE(426, -3363) => @ORIENT("MY");
// %t6911 @TEXT("n1487", key="name", size=0.75);
// &n1487 @WIRE(mode="straight") {#X1318:4 %t6911:p};
// %t6912 = $SUPPLY @ATTACH &vdd => @PLACE(416, -3350);
// &vdd @WIRE(mode="straight") {#X1318:5 %t6912:p};
// %t6913 = $GROUND @ATTACH &vss => @PLACE(416, -3376);
// &vss @WIRE(mode="straight") {#X1318:6 %t6913:p};
// %t6914 = $IO_PORT @ATTACH &vss => @PLACE(446, -3359) => @ORIENT("R0");
// %t6914 @TEXT("vss", key="name", size=0.75);
// &vss @WIRE(mode="straight") {#X1319:1 %t6914:p};
// %t6915 = $IO_PORT @ATTACH &n589 => @PLACE(446, -3363) => @ORIENT("R0");
// %t6915 @TEXT("n589", key="name", size=0.75);
// &n589 @WIRE(mode="straight") {#X1319:2 %t6915:p};
// %t6916 = $IO_PORT @ATTACH &n1069 => @PLACE(446, -3367) => @ORIENT("R0");
// %t6916 @TEXT("n1069", key="name", size=0.75);
// &n1069 @WIRE(mode="straight") {#X1319:3 %t6916:p};
// %t6917 = $IO_PORT @ATTACH &n1488 => @PLACE(466, -3363) => @ORIENT("MY");
// %t6917 @TEXT("n1488", key="name", size=0.75);
// &n1488 @WIRE(mode="straight") {#X1319:4 %t6917:p};
// %t6918 = $SUPPLY @ATTACH &vdd => @PLACE(456, -3350);
// &vdd @WIRE(mode="straight") {#X1319:5 %t6918:p};
// %t6919 = $GROUND @ATTACH &vss => @PLACE(456, -3376);
// &vss @WIRE(mode="straight") {#X1319:6 %t6919:p};
// %t6920 = $IO_PORT @ATTACH &vss => @PLACE(494, -3184) => @ORIENT("R0");
// %t6920 @TEXT("vss", key="name", size=0.75);
// &vss @WIRE(mode="straight") {#X1320:1 %t6920:p};
// %t6921 = $IO_PORT @ATTACH &n591 => @PLACE(494, -3188) => @ORIENT("R0");
// %t6921 @TEXT("n591", key="name", size=0.75);
// &n591 @WIRE(mode="straight") {#X1320:2 %t6921:p};
// %t6922 = $IO_PORT @ATTACH &n1069 => @PLACE(494, -3192) => @ORIENT("R0");
// %t6922 @TEXT("n1069", key="name", size=0.75);
// &n1069 @WIRE(mode="straight") {#X1320:3 %t6922:p};
// %t6923 = $IO_PORT @ATTACH &n1489 => @PLACE(514, -3188) => @ORIENT("MY");
// %t6923 @TEXT("n1489", key="name", size=0.75);
// &n1489 @WIRE(mode="straight") {#X1320:4 %t6923:p};
// %t6924 = $SUPPLY @ATTACH &vdd => @PLACE(504, -3175);
// &vdd @WIRE(mode="straight") {#X1320:5 %t6924:p};
// %t6925 = $GROUND @ATTACH &vss => @PLACE(504, -3201);
// &vss @WIRE(mode="straight") {#X1320:6 %t6925:p};
// %t6926 = $IO_PORT @ATTACH &vss => @PLACE(534, -3184) => @ORIENT("R0");
// %t6926 @TEXT("vss", key="name", size=0.75);
// &vss @WIRE(mode="straight") {#X1321:1 %t6926:p};
// %t6927 = $IO_PORT @ATTACH &n593 => @PLACE(534, -3188) => @ORIENT("R0");
// %t6927 @TEXT("n593", key="name", size=0.75);
// &n593 @WIRE(mode="straight") {#X1321:2 %t6927:p};
// %t6928 = $IO_PORT @ATTACH &n1069 => @PLACE(534, -3192) => @ORIENT("R0");
// %t6928 @TEXT("n1069", key="name", size=0.75);
// &n1069 @WIRE(mode="straight") {#X1321:3 %t6928:p};
// %t6929 = $IO_PORT @ATTACH &n1490 => @PLACE(554, -3188) => @ORIENT("MY");
// %t6929 @TEXT("n1490", key="name", size=0.75);
// &n1490 @WIRE(mode="straight") {#X1321:4 %t6929:p};
// %t6930 = $SUPPLY @ATTACH &vdd => @PLACE(544, -3175);
// &vdd @WIRE(mode="straight") {#X1321:5 %t6930:p};
// %t6931 = $GROUND @ATTACH &vss => @PLACE(544, -3201);
// &vss @WIRE(mode="straight") {#X1321:6 %t6931:p};
// %t6932 = $IO_PORT @ATTACH &vss => @PLACE(574, -3184) => @ORIENT("R0");
// %t6932 @TEXT("vss", key="name", size=0.75);
// &vss @WIRE(mode="straight") {#X1322:1 %t6932:p};
// %t6933 = $IO_PORT @ATTACH &n595 => @PLACE(574, -3188) => @ORIENT("R0");
// %t6933 @TEXT("n595", key="name", size=0.75);
// &n595 @WIRE(mode="straight") {#X1322:2 %t6933:p};
// %t6934 = $IO_PORT @ATTACH &n1069 => @PLACE(574, -3192) => @ORIENT("R0");
// %t6934 @TEXT("n1069", key="name", size=0.75);
// &n1069 @WIRE(mode="straight") {#X1322:3 %t6934:p};
// %t6935 = $IO_PORT @ATTACH &n1491 => @PLACE(594, -3188) => @ORIENT("MY");
// %t6935 @TEXT("n1491", key="name", size=0.75);
// &n1491 @WIRE(mode="straight") {#X1322:4 %t6935:p};
// %t6936 = $SUPPLY @ATTACH &vdd => @PLACE(584, -3175);
// &vdd @WIRE(mode="straight") {#X1322:5 %t6936:p};
// %t6937 = $GROUND @ATTACH &vss => @PLACE(584, -3201);
// &vss @WIRE(mode="straight") {#X1322:6 %t6937:p};
// %t6938 = $IO_PORT @ATTACH &vdd => @PLACE(614, -3184) => @ORIENT("R0");
// %t6938 @TEXT("vdd", key="name", size=0.75);
// &vdd @WIRE(mode="straight") {#X1323:1 %t6938:p};
// %t6939 = $IO_PORT @ATTACH &vss => @PLACE(614, -3188) => @ORIENT("R0");
// %t6939 @TEXT("vss", key="name", size=0.75);
// &vss @WIRE(mode="straight") {#X1323:2 %t6939:p};
// %t6940 = $IO_PORT @ATTACH &n1102 => @PLACE(614, -3192) => @ORIENT("R0");
// %t6940 @TEXT("n1102", key="name", size=0.75);
// &n1102 @WIRE(mode="straight") {#X1323:3 %t6940:p};
// %t6941 = $IO_PORT @ATTACH &n1492 => @PLACE(635, -3188) => @ORIENT("MY");
// %t6941 @TEXT("n1492", key="name", size=0.75);
// &n1492 @WIRE(mode="straight") {#X1323:4 %t6941:p};
// %t6942 = $SUPPLY @ATTACH &vdd => @PLACE(624, -3175);
// &vdd @WIRE(mode="straight") {#X1323:5 %t6942:p};
// %t6943 = $GROUND @ATTACH &vss => @PLACE(624, -3201);
// &vss @WIRE(mode="straight") {#X1323:6 %t6943:p};
// %t6944 = $IO_PORT @ATTACH &vss => @PLACE(494, -3219) => @ORIENT("R0");
// %t6944 @TEXT("vss", key="name", size=0.75);
// &vss @WIRE(mode="straight") {#X1324:1 %t6944:p};
// %t6945 = $IO_PORT @ATTACH &vss => @PLACE(494, -3223) => @ORIENT("R0");
// %t6945 @TEXT("vss", key="name", size=0.75);
// &vss @WIRE(mode="straight") {#X1324:2 %t6945:p};
// %t6946 = $IO_PORT @ATTACH &n1102 => @PLACE(494, -3227) => @ORIENT("R0");
// %t6946 @TEXT("n1102", key="name", size=0.75);
// &n1102 @WIRE(mode="straight") {#X1324:3 %t6946:p};
// %t6947 = $IO_PORT @ATTACH &n1493 => @PLACE(514, -3223) => @ORIENT("MY");
// %t6947 @TEXT("n1493", key="name", size=0.75);
// &n1493 @WIRE(mode="straight") {#X1324:4 %t6947:p};
// %t6948 = $SUPPLY @ATTACH &vdd => @PLACE(504, -3210);
// &vdd @WIRE(mode="straight") {#X1324:5 %t6948:p};
// %t6949 = $GROUND @ATTACH &vss => @PLACE(504, -3236);
// &vss @WIRE(mode="straight") {#X1324:6 %t6949:p};
// %t6950 = $IO_PORT @ATTACH &n243 => @PLACE(534, -3219) => @ORIENT("R0");
// %t6950 @TEXT("n243", key="name", size=0.75);
// &n243 @WIRE(mode="straight") {#X1325:1 %t6950:p};
// %t6951 = $IO_PORT @ATTACH &n240 => @PLACE(534, -3223) => @ORIENT("R0");
// %t6951 @TEXT("n240", key="name", size=0.75);
// &n240 @WIRE(mode="straight") {#X1325:2 %t6951:p};
// %t6952 = $IO_PORT @ATTACH &n351 => @PLACE(534, -3227) => @ORIENT("R0");
// %t6952 @TEXT("n351", key="name", size=0.75);
// &n351 @WIRE(mode="straight") {#X1325:3 %t6952:p};
// %t6953 = $IO_PORT @ATTACH &n1494 => @PLACE(554, -3223) => @ORIENT("MY");
// %t6953 @TEXT("n1494", key="name", size=0.75);
// &n1494 @WIRE(mode="straight") {#X1325:4 %t6953:p};
// %t6954 = $SUPPLY @ATTACH &vdd => @PLACE(544, -3210);
// &vdd @WIRE(mode="straight") {#X1325:5 %t6954:p};
// %t6955 = $GROUND @ATTACH &vss => @PLACE(544, -3236);
// &vss @WIRE(mode="straight") {#X1325:6 %t6955:p};
// %t6956 = $IO_PORT @ATTACH &n1494 => @PLACE(574, -3219) => @ORIENT("R0");
// %t6956 @TEXT("n1494", key="name", size=0.75);
// &n1494 @WIRE(mode="straight") {#X1326:1 %t6956:p};
// %t6957 = $IO_PORT @ATTACH &vss => @PLACE(574, -3223) => @ORIENT("R0");
// %t6957 @TEXT("vss", key="name", size=0.75);
// &vss @WIRE(mode="straight") {#X1326:2 %t6957:p};
// %t6958 = $IO_PORT @ATTACH &n236 => @PLACE(574, -3227) => @ORIENT("R0");
// %t6958 @TEXT("n236", key="name", size=0.75);
// &n236 @WIRE(mode="straight") {#X1326:3 %t6958:p};
// %t6959 = $IO_PORT @ATTACH &n1495 => @PLACE(594, -3223) => @ORIENT("MY");
// %t6959 @TEXT("n1495", key="name", size=0.75);
// &n1495 @WIRE(mode="straight") {#X1326:4 %t6959:p};
// %t6960 = $SUPPLY @ATTACH &vdd => @PLACE(584, -3210);
// &vdd @WIRE(mode="straight") {#X1326:5 %t6960:p};
// %t6961 = $GROUND @ATTACH &vss => @PLACE(584, -3236);
// &vss @WIRE(mode="straight") {#X1326:6 %t6961:p};
// %t6962 = $IO_PORT @ATTACH &vdd => @PLACE(614, -3219) => @ORIENT("R0");
// %t6962 @TEXT("vdd", key="name", size=0.75);
// &vdd @WIRE(mode="straight") {#X1327:1 %t6962:p};
// %t6963 = $IO_PORT @ATTACH &n1495 => @PLACE(614, -3223) => @ORIENT("R0");
// %t6963 @TEXT("n1495", key="name", size=0.75);
// &n1495 @WIRE(mode="straight") {#X1327:2 %t6963:p};
// %t6964 = $IO_PORT @ATTACH &n960 => @PLACE(614, -3227) => @ORIENT("R0");
// %t6964 @TEXT("n960", key="name", size=0.75);
// &n960 @WIRE(mode="straight") {#X1327:3 %t6964:p};
// %t6965 = $IO_PORT @ATTACH &n1496 => @PLACE(635, -3223) => @ORIENT("MY");
// %t6965 @TEXT("n1496", key="name", size=0.75);
// &n1496 @WIRE(mode="straight") {#X1327:4 %t6965:p};
// %t6966 = $SUPPLY @ATTACH &vdd => @PLACE(624, -3210);
// &vdd @WIRE(mode="straight") {#X1327:5 %t6966:p};
// %t6967 = $GROUND @ATTACH &vss => @PLACE(624, -3236);
// &vss @WIRE(mode="straight") {#X1327:6 %t6967:p};
// %t6968 = $IO_PORT @ATTACH &n1496 => @PLACE(494, -3254) => @ORIENT("R0");
// %t6968 @TEXT("n1496", key="name", size=0.75);
// &n1496 @WIRE(mode="straight") {#X1328:1 %t6968:p};
// %t6969 = $IO_PORT @ATTACH &vss => @PLACE(494, -3258) => @ORIENT("R0");
// %t6969 @TEXT("vss", key="name", size=0.75);
// &vss @WIRE(mode="straight") {#X1328:2 %t6969:p};
// %t6970 = $IO_PORT @ATTACH &n234 => @PLACE(494, -3262) => @ORIENT("R0");
// %t6970 @TEXT("n234", key="name", size=0.75);
// &n234 @WIRE(mode="straight") {#X1328:3 %t6970:p};
// %t6971 = $IO_PORT @ATTACH &n1497 => @PLACE(514, -3258) => @ORIENT("MY");
// %t6971 @TEXT("n1497", key="name", size=0.75);
// &n1497 @WIRE(mode="straight") {#X1328:4 %t6971:p};
// %t6972 = $SUPPLY @ATTACH &vdd => @PLACE(504, -3245);
// &vdd @WIRE(mode="straight") {#X1328:5 %t6972:p};
// %t6973 = $GROUND @ATTACH &vss => @PLACE(504, -3271);
// &vss @WIRE(mode="straight") {#X1328:6 %t6973:p};
// %t6974 = $IO_PORT @ATTACH &n1496 => @PLACE(534, -3254) => @ORIENT("R0");
// %t6974 @TEXT("n1496", key="name", size=0.75);
// &n1496 @WIRE(mode="straight") {#X1329:1 %t6974:p};
// %t6975 = $IO_PORT @ATTACH &vdd => @PLACE(534, -3258) => @ORIENT("R0");
// %t6975 @TEXT("vdd", key="name", size=0.75);
// &vdd @WIRE(mode="straight") {#X1329:2 %t6975:p};
// %t6976 = $IO_PORT @ATTACH &n234 => @PLACE(534, -3262) => @ORIENT("R0");
// %t6976 @TEXT("n234", key="name", size=0.75);
// &n234 @WIRE(mode="straight") {#X1329:3 %t6976:p};
// %t6977 = $IO_PORT @ATTACH &n1498 => @PLACE(554, -3258) => @ORIENT("MY");
// %t6977 @TEXT("n1498", key="name", size=0.75);
// &n1498 @WIRE(mode="straight") {#X1329:4 %t6977:p};
// %t6978 = $SUPPLY @ATTACH &vdd => @PLACE(544, -3245);
// &vdd @WIRE(mode="straight") {#X1329:5 %t6978:p};
// %t6979 = $GROUND @ATTACH &vss => @PLACE(544, -3271);
// &vss @WIRE(mode="straight") {#X1329:6 %t6979:p};
// %t6980 = $IO_PORT @ATTACH &n1497 => @PLACE(574, -3254) => @ORIENT("R0");
// %t6980 @TEXT("n1497", key="name", size=0.75);
// &n1497 @WIRE(mode="straight") {#X1330:1 %t6980:p};
// %t6981 = $IO_PORT @ATTACH &n232 => @PLACE(574, -3258) => @ORIENT("R0");
// %t6981 @TEXT("n232", key="name", size=0.75);
// &n232 @WIRE(mode="straight") {#X1330:2 %t6981:p};
// %t6982 = $IO_PORT @ATTACH &n238 => @PLACE(574, -3262) => @ORIENT("R0");
// %t6982 @TEXT("n238", key="name", size=0.75);
// &n238 @WIRE(mode="straight") {#X1330:3 %t6982:p};
// %t6983 = $IO_PORT @ATTACH &n1499 => @PLACE(594, -3258) => @ORIENT("MY");
// %t6983 @TEXT("n1499", key="name", size=0.75);
// &n1499 @WIRE(mode="straight") {#X1330:4 %t6983:p};
// %t6984 = $SUPPLY @ATTACH &vdd => @PLACE(584, -3245);
// &vdd @WIRE(mode="straight") {#X1330:5 %t6984:p};
// %t6985 = $GROUND @ATTACH &vss => @PLACE(584, -3271);
// &vss @WIRE(mode="straight") {#X1330:6 %t6985:p};
// %t6986 = $IO_PORT @ATTACH &n1498 => @PLACE(614, -3254) => @ORIENT("R0");
// %t6986 @TEXT("n1498", key="name", size=0.75);
// &n1498 @WIRE(mode="straight") {#X1331:1 %t6986:p};
// %t6987 = $IO_PORT @ATTACH &n232 => @PLACE(614, -3258) => @ORIENT("R0");
// %t6987 @TEXT("n232", key="name", size=0.75);
// &n232 @WIRE(mode="straight") {#X1331:2 %t6987:p};
// %t6988 = $IO_PORT @ATTACH &n238 => @PLACE(614, -3262) => @ORIENT("R0");
// %t6988 @TEXT("n238", key="name", size=0.75);
// &n238 @WIRE(mode="straight") {#X1331:3 %t6988:p};
// %t6989 = $IO_PORT @ATTACH &n1500 => @PLACE(635, -3258) => @ORIENT("MY");
// %t6989 @TEXT("n1500", key="name", size=0.75);
// &n1500 @WIRE(mode="straight") {#X1331:4 %t6989:p};
// %t6990 = $SUPPLY @ATTACH &vdd => @PLACE(624, -3245);
// &vdd @WIRE(mode="straight") {#X1331:5 %t6990:p};
// %t6991 = $GROUND @ATTACH &vss => @PLACE(624, -3271);
// &vss @WIRE(mode="straight") {#X1331:6 %t6991:p};
// %t6992 = $IO_PORT @ATTACH &vss => @PLACE(494, -3289) => @ORIENT("R0");
// %t6992 @TEXT("vss", key="name", size=0.75);
// &vss @WIRE(mode="straight") {#X1332:1 %t6992:p};
// %t6993 = $IO_PORT @ATTACH &n1499 => @PLACE(494, -3293) => @ORIENT("R0");
// %t6993 @TEXT("n1499", key="name", size=0.75);
// &n1499 @WIRE(mode="straight") {#X1332:2 %t6993:p};
// %t6994 = $IO_PORT @ATTACH &n88 => @PLACE(494, -3297) => @ORIENT("R0");
// %t6994 @TEXT("n88", key="name", size=0.75);
// &n88 @WIRE(mode="straight") {#X1332:3 %t6994:p};
// %t6995 = $IO_PORT @ATTACH &n1501 => @PLACE(514, -3293) => @ORIENT("MY");
// %t6995 @TEXT("n1501", key="name", size=0.75);
// &n1501 @WIRE(mode="straight") {#X1332:4 %t6995:p};
// %t6996 = $SUPPLY @ATTACH &vdd => @PLACE(504, -3280);
// &vdd @WIRE(mode="straight") {#X1332:5 %t6996:p};
// %t6997 = $GROUND @ATTACH &vss => @PLACE(504, -3306);
// &vss @WIRE(mode="straight") {#X1332:6 %t6997:p};
// %t6998 = $IO_PORT @ATTACH &vss => @PLACE(534, -3289) => @ORIENT("R0");
// %t6998 @TEXT("vss", key="name", size=0.75);
// &vss @WIRE(mode="straight") {#X1333:1 %t6998:p};
// %t6999 = $IO_PORT @ATTACH &n1500 => @PLACE(534, -3293) => @ORIENT("R0");
// %t6999 @TEXT("n1500", key="name", size=0.75);
// &n1500 @WIRE(mode="straight") {#X1333:2 %t6999:p};
// %t7000 = $IO_PORT @ATTACH &n88 => @PLACE(534, -3297) => @ORIENT("R0");
// %t7000 @TEXT("n88", key="name", size=0.75);
// &n88 @WIRE(mode="straight") {#X1333:3 %t7000:p};
// %t7001 = $IO_PORT @ATTACH &n1502 => @PLACE(554, -3293) => @ORIENT("MY");
// %t7001 @TEXT("n1502", key="name", size=0.75);
// &n1502 @WIRE(mode="straight") {#X1333:4 %t7001:p};
// %t7002 = $SUPPLY @ATTACH &vdd => @PLACE(544, -3280);
// &vdd @WIRE(mode="straight") {#X1333:5 %t7002:p};
// %t7003 = $GROUND @ATTACH &vss => @PLACE(544, -3306);
// &vss @WIRE(mode="straight") {#X1333:6 %t7003:p};
// %t7004 = $IO_PORT @ATTACH &vss => @PLACE(574, -3289) => @ORIENT("R0");
// %t7004 @TEXT("vss", key="name", size=0.75);
// &vss @WIRE(mode="straight") {#X1334:1 %t7004:p};
// %t7005 = $IO_PORT @ATTACH &n1501 => @PLACE(574, -3293) => @ORIENT("R0");
// %t7005 @TEXT("n1501", key="name", size=0.75);
// &n1501 @WIRE(mode="straight") {#X1334:2 %t7005:p};
// %t7006 = $IO_PORT @ATTACH &n117 => @PLACE(574, -3297) => @ORIENT("R0");
// %t7006 @TEXT("n117", key="name", size=0.75);
// &n117 @WIRE(mode="straight") {#X1334:3 %t7006:p};
// %t7007 = $IO_PORT @ATTACH &n1503 => @PLACE(594, -3293) => @ORIENT("MY");
// %t7007 @TEXT("n1503", key="name", size=0.75);
// &n1503 @WIRE(mode="straight") {#X1334:4 %t7007:p};
// %t7008 = $SUPPLY @ATTACH &vdd => @PLACE(584, -3280);
// &vdd @WIRE(mode="straight") {#X1334:5 %t7008:p};
// %t7009 = $GROUND @ATTACH &vss => @PLACE(584, -3306);
// &vss @WIRE(mode="straight") {#X1334:6 %t7009:p};
// %t7010 = $IO_PORT @ATTACH &vss => @PLACE(614, -3289) => @ORIENT("R0");
// %t7010 @TEXT("vss", key="name", size=0.75);
// &vss @WIRE(mode="straight") {#X1335:1 %t7010:p};
// %t7011 = $IO_PORT @ATTACH &n1502 => @PLACE(614, -3293) => @ORIENT("R0");
// %t7011 @TEXT("n1502", key="name", size=0.75);
// &n1502 @WIRE(mode="straight") {#X1335:2 %t7011:p};
// %t7012 = $IO_PORT @ATTACH &n117 => @PLACE(614, -3297) => @ORIENT("R0");
// %t7012 @TEXT("n117", key="name", size=0.75);
// &n117 @WIRE(mode="straight") {#X1335:3 %t7012:p};
// %t7013 = $IO_PORT @ATTACH &n1504 => @PLACE(635, -3293) => @ORIENT("MY");
// %t7013 @TEXT("n1504", key="name", size=0.75);
// &n1504 @WIRE(mode="straight") {#X1335:4 %t7013:p};
// %t7014 = $SUPPLY @ATTACH &vdd => @PLACE(624, -3280);
// &vdd @WIRE(mode="straight") {#X1335:5 %t7014:p};
// %t7015 = $GROUND @ATTACH &vss => @PLACE(624, -3306);
// &vss @WIRE(mode="straight") {#X1335:6 %t7015:p};
// %t7016 = $IO_PORT @ATTACH &vss => @PLACE(494, -3324) => @ORIENT("R0");
// %t7016 @TEXT("vss", key="name", size=0.75);
// &vss @WIRE(mode="straight") {#X1336:1 %t7016:p};
// %t7017 = $IO_PORT @ATTACH &n1503 => @PLACE(494, -3328) => @ORIENT("R0");
// %t7017 @TEXT("n1503", key="name", size=0.75);
// &n1503 @WIRE(mode="straight") {#X1336:2 %t7017:p};
// %t7018 = $IO_PORT @ATTACH &n51 => @PLACE(494, -3332) => @ORIENT("R0");
// %t7018 @TEXT("n51", key="name", size=0.75);
// &n51 @WIRE(mode="straight") {#X1336:3 %t7018:p};
// %t7019 = $IO_PORT @ATTACH &n1505 => @PLACE(514, -3328) => @ORIENT("MY");
// %t7019 @TEXT("n1505", key="name", size=0.75);
// &n1505 @WIRE(mode="straight") {#X1336:4 %t7019:p};
// %t7020 = $SUPPLY @ATTACH &vdd => @PLACE(504, -3315);
// &vdd @WIRE(mode="straight") {#X1336:5 %t7020:p};
// %t7021 = $GROUND @ATTACH &vss => @PLACE(504, -3341);
// &vss @WIRE(mode="straight") {#X1336:6 %t7021:p};
// %t7022 = $IO_PORT @ATTACH &vss => @PLACE(534, -3324) => @ORIENT("R0");
// %t7022 @TEXT("vss", key="name", size=0.75);
// &vss @WIRE(mode="straight") {#X1337:1 %t7022:p};
// %t7023 = $IO_PORT @ATTACH &n1504 => @PLACE(534, -3328) => @ORIENT("R0");
// %t7023 @TEXT("n1504", key="name", size=0.75);
// &n1504 @WIRE(mode="straight") {#X1337:2 %t7023:p};
// %t7024 = $IO_PORT @ATTACH &n51 => @PLACE(534, -3332) => @ORIENT("R0");
// %t7024 @TEXT("n51", key="name", size=0.75);
// &n51 @WIRE(mode="straight") {#X1337:3 %t7024:p};
// %t7025 = $IO_PORT @ATTACH &n1506 => @PLACE(554, -3328) => @ORIENT("MY");
// %t7025 @TEXT("n1506", key="name", size=0.75);
// &n1506 @WIRE(mode="straight") {#X1337:4 %t7025:p};
// %t7026 = $SUPPLY @ATTACH &vdd => @PLACE(544, -3315);
// &vdd @WIRE(mode="straight") {#X1337:5 %t7026:p};
// %t7027 = $GROUND @ATTACH &vss => @PLACE(544, -3341);
// &vss @WIRE(mode="straight") {#X1337:6 %t7027:p};
// %t7028 = $IO_PORT @ATTACH &vdd => @PLACE(574, -3324) => @ORIENT("R0");
// %t7028 @TEXT("vdd", key="name", size=0.75);
// &vdd @WIRE(mode="straight") {#X1338:1 %t7028:p};
// %t7029 = $IO_PORT @ATTACH &vss => @PLACE(574, -3328) => @ORIENT("R0");
// %t7029 @TEXT("vss", key="name", size=0.75);
// &vss @WIRE(mode="straight") {#X1338:2 %t7029:p};
// %t7030 = $IO_PORT @ATTACH &n1081 => @PLACE(574, -3332) => @ORIENT("R0");
// %t7030 @TEXT("n1081", key="name", size=0.75);
// &n1081 @WIRE(mode="straight") {#X1338:3 %t7030:p};
// %t7031 = $IO_PORT @ATTACH &n1507 => @PLACE(594, -3328) => @ORIENT("MY");
// %t7031 @TEXT("n1507", key="name", size=0.75);
// &n1507 @WIRE(mode="straight") {#X1338:4 %t7031:p};
// %t7032 = $SUPPLY @ATTACH &vdd => @PLACE(584, -3315);
// &vdd @WIRE(mode="straight") {#X1338:5 %t7032:p};
// %t7033 = $GROUND @ATTACH &vss => @PLACE(584, -3341);
// &vss @WIRE(mode="straight") {#X1338:6 %t7033:p};
// %t7034 = $IO_PORT @ATTACH &vss => @PLACE(614, -3324) => @ORIENT("R0");
// %t7034 @TEXT("vss", key="name", size=0.75);
// &vss @WIRE(mode="straight") {#X1339:1 %t7034:p};
// %t7035 = $IO_PORT @ATTACH &vss => @PLACE(614, -3328) => @ORIENT("R0");
// %t7035 @TEXT("vss", key="name", size=0.75);
// &vss @WIRE(mode="straight") {#X1339:2 %t7035:p};
// %t7036 = $IO_PORT @ATTACH &n1081 => @PLACE(614, -3332) => @ORIENT("R0");
// %t7036 @TEXT("n1081", key="name", size=0.75);
// &n1081 @WIRE(mode="straight") {#X1339:3 %t7036:p};
// %t7037 = $IO_PORT @ATTACH &n1508 => @PLACE(635, -3328) => @ORIENT("MY");
// %t7037 @TEXT("n1508", key="name", size=0.75);
// &n1508 @WIRE(mode="straight") {#X1339:4 %t7037:p};
// %t7038 = $SUPPLY @ATTACH &vdd => @PLACE(624, -3315);
// &vdd @WIRE(mode="straight") {#X1339:5 %t7038:p};
// %t7039 = $GROUND @ATTACH &vss => @PLACE(624, -3341);
// &vss @WIRE(mode="straight") {#X1339:6 %t7039:p};
// %t7040 = $IO_PORT @ATTACH &vss => @PLACE(494, -3359) => @ORIENT("R0");
// %t7040 @TEXT("vss", key="name", size=0.75);
// &vss @WIRE(mode="straight") {#X1340:1 %t7040:p};
// %t7041 = $IO_PORT @ATTACH &vss => @PLACE(494, -3363) => @ORIENT("R0");
// %t7041 @TEXT("vss", key="name", size=0.75);
// &vss @WIRE(mode="straight") {#X1340:2 %t7041:p};
// %t7042 = $IO_PORT @ATTACH &n1074 => @PLACE(494, -3367) => @ORIENT("R0");
// %t7042 @TEXT("n1074", key="name", size=0.75);
// &n1074 @WIRE(mode="straight") {#X1340:3 %t7042:p};
// %t7043 = $IO_PORT @ATTACH &n1509 => @PLACE(514, -3363) => @ORIENT("MY");
// %t7043 @TEXT("n1509", key="name", size=0.75);
// &n1509 @WIRE(mode="straight") {#X1340:4 %t7043:p};
// %t7044 = $SUPPLY @ATTACH &vdd => @PLACE(504, -3350);
// &vdd @WIRE(mode="straight") {#X1340:5 %t7044:p};
// %t7045 = $GROUND @ATTACH &vss => @PLACE(504, -3376);
// &vss @WIRE(mode="straight") {#X1340:6 %t7045:p};
// %t7046 = $IO_PORT @ATTACH &vdd => @PLACE(534, -3359) => @ORIENT("R0");
// %t7046 @TEXT("vdd", key="name", size=0.75);
// &vdd @WIRE(mode="straight") {#X1341:1 %t7046:p};
// %t7047 = $IO_PORT @ATTACH &vss => @PLACE(534, -3363) => @ORIENT("R0");
// %t7047 @TEXT("vss", key="name", size=0.75);
// &vss @WIRE(mode="straight") {#X1341:2 %t7047:p};
// %t7048 = $IO_PORT @ATTACH &n1074 => @PLACE(534, -3367) => @ORIENT("R0");
// %t7048 @TEXT("n1074", key="name", size=0.75);
// &n1074 @WIRE(mode="straight") {#X1341:3 %t7048:p};
// %t7049 = $IO_PORT @ATTACH &n1510 => @PLACE(554, -3363) => @ORIENT("MY");
// %t7049 @TEXT("n1510", key="name", size=0.75);
// &n1510 @WIRE(mode="straight") {#X1341:4 %t7049:p};
// %t7050 = $SUPPLY @ATTACH &vdd => @PLACE(544, -3350);
// &vdd @WIRE(mode="straight") {#X1341:5 %t7050:p};
// %t7051 = $GROUND @ATTACH &vss => @PLACE(544, -3376);
// &vss @WIRE(mode="straight") {#X1341:6 %t7051:p};
// %t7052 = $IO_PORT @ATTACH &vdd => @PLACE(574, -3359) => @ORIENT("R0");
// %t7052 @TEXT("vdd", key="name", size=0.75);
// &vdd @WIRE(mode="straight") {#X1342:1 %t7052:p};
// %t7053 = $IO_PORT @ATTACH &vss => @PLACE(574, -3363) => @ORIENT("R0");
// %t7053 @TEXT("vss", key="name", size=0.75);
// &vss @WIRE(mode="straight") {#X1342:2 %t7053:p};
// %t7054 = $IO_PORT @ATTACH &n1069 => @PLACE(574, -3367) => @ORIENT("R0");
// %t7054 @TEXT("n1069", key="name", size=0.75);
// &n1069 @WIRE(mode="straight") {#X1342:3 %t7054:p};
// %t7055 = $IO_PORT @ATTACH &n1511 => @PLACE(594, -3363) => @ORIENT("MY");
// %t7055 @TEXT("n1511", key="name", size=0.75);
// &n1511 @WIRE(mode="straight") {#X1342:4 %t7055:p};
// %t7056 = $SUPPLY @ATTACH &vdd => @PLACE(584, -3350);
// &vdd @WIRE(mode="straight") {#X1342:5 %t7056:p};
// %t7057 = $GROUND @ATTACH &vss => @PLACE(584, -3376);
// &vss @WIRE(mode="straight") {#X1342:6 %t7057:p};
// %t7058 = $IO_PORT @ATTACH &vss => @PLACE(614, -3359) => @ORIENT("R0");
// %t7058 @TEXT("vss", key="name", size=0.75);
// &vss @WIRE(mode="straight") {#X1343:1 %t7058:p};
// %t7059 = $IO_PORT @ATTACH &vss => @PLACE(614, -3363) => @ORIENT("R0");
// %t7059 @TEXT("vss", key="name", size=0.75);
// &vss @WIRE(mode="straight") {#X1343:2 %t7059:p};
// %t7060 = $IO_PORT @ATTACH &n1069 => @PLACE(614, -3367) => @ORIENT("R0");
// %t7060 @TEXT("n1069", key="name", size=0.75);
// &n1069 @WIRE(mode="straight") {#X1343:3 %t7060:p};
// %t7061 = $IO_PORT @ATTACH &n1512 => @PLACE(635, -3363) => @ORIENT("MY");
// %t7061 @TEXT("n1512", key="name", size=0.75);
// &n1512 @WIRE(mode="straight") {#X1343:4 %t7061:p};
// %t7062 = $SUPPLY @ATTACH &vdd => @PLACE(624, -3350);
// &vdd @WIRE(mode="straight") {#X1343:5 %t7062:p};
// %t7063 = $GROUND @ATTACH &vss => @PLACE(624, -3376);
// &vss @WIRE(mode="straight") {#X1343:6 %t7063:p};
// %t7064 = $IO_PORT @ATTACH &vss => @PLACE(-11, -3404) => @ORIENT("R0");
// %t7064 @TEXT("vss", key="name", size=0.75);
// &vss @WIRE(mode="straight") {#X1344:1 %t7064:p};
// %t7065 = $IO_PORT @ATTACH &vdd => @PLACE(-11, -3408) => @ORIENT("R0");
// %t7065 @TEXT("vdd", key="name", size=0.75);
// &vdd @WIRE(mode="straight") {#X1344:2 %t7065:p};
// %t7066 = $IO_PORT @ATTACH &n240 => @PLACE(-11, -3412) => @ORIENT("R0");
// %t7066 @TEXT("n240", key="name", size=0.75);
// &n240 @WIRE(mode="straight") {#X1344:3 %t7066:p};
// %t7067 = $IO_PORT @ATTACH &n1513 => @PLACE(10, -3408) => @ORIENT("MY");
// %t7067 @TEXT("n1513", key="name", size=0.75);
// &n1513 @WIRE(mode="straight") {#X1344:4 %t7067:p};
// %t7068 = $SUPPLY @ATTACH &vdd => @PLACE(0, -3395);
// &vdd @WIRE(mode="straight") {#X1344:5 %t7068:p};
// %t7069 = $GROUND @ATTACH &vss => @PLACE(0, -3421);
// &vss @WIRE(mode="straight") {#X1344:6 %t7069:p};
// %t7070 = $IO_PORT @ATTACH &vss => @PLACE(30, -3404) => @ORIENT("R0");
// %t7070 @TEXT("vss", key="name", size=0.75);
// &vss @WIRE(mode="straight") {#X1345:1 %t7070:p};
// %t7071 = $IO_PORT @ATTACH &vdd => @PLACE(30, -3408) => @ORIENT("R0");
// %t7071 @TEXT("vdd", key="name", size=0.75);
// &vdd @WIRE(mode="straight") {#X1345:2 %t7071:p};
// %t7072 = $IO_PORT @ATTACH &n243 => @PLACE(30, -3412) => @ORIENT("R0");
// %t7072 @TEXT("n243", key="name", size=0.75);
// &n243 @WIRE(mode="straight") {#X1345:3 %t7072:p};
// %t7073 = $IO_PORT @ATTACH &n1514 => @PLACE(50, -3408) => @ORIENT("MY");
// %t7073 @TEXT("n1514", key="name", size=0.75);
// &n1514 @WIRE(mode="straight") {#X1345:4 %t7073:p};
// %t7074 = $SUPPLY @ATTACH &vdd => @PLACE(40, -3395);
// &vdd @WIRE(mode="straight") {#X1345:5 %t7074:p};
// %t7075 = $GROUND @ATTACH &vss => @PLACE(40, -3421);
// &vss @WIRE(mode="straight") {#X1345:6 %t7075:p};
// %t7076 = $IO_PORT @ATTACH &n1514 => @PLACE(70, -3404) => @ORIENT("R0");
// %t7076 @TEXT("n1514", key="name", size=0.75);
// &n1514 @WIRE(mode="straight") {#X1346:1 %t7076:p};
// %t7077 = $IO_PORT @ATTACH &n1513 => @PLACE(70, -3408) => @ORIENT("R0");
// %t7077 @TEXT("n1513", key="name", size=0.75);
// &n1513 @WIRE(mode="straight") {#X1346:2 %t7077:p};
// %t7078 = $IO_PORT @ATTACH &n351 => @PLACE(70, -3412) => @ORIENT("R0");
// %t7078 @TEXT("n351", key="name", size=0.75);
// &n351 @WIRE(mode="straight") {#X1346:3 %t7078:p};
// %t7079 = $IO_PORT @ATTACH &n1515 => @PLACE(90, -3408) => @ORIENT("MY");
// %t7079 @TEXT("n1515", key="name", size=0.75);
// &n1515 @WIRE(mode="straight") {#X1346:4 %t7079:p};
// %t7080 = $SUPPLY @ATTACH &vdd => @PLACE(80, -3395);
// &vdd @WIRE(mode="straight") {#X1346:5 %t7080:p};
// %t7081 = $GROUND @ATTACH &vss => @PLACE(80, -3421);
// &vss @WIRE(mode="straight") {#X1346:6 %t7081:p};
// %t7082 = $IO_PORT @ATTACH &n1515 => @PLACE(110, -3404) => @ORIENT("R0");
// %t7082 @TEXT("n1515", key="name", size=0.75);
// &n1515 @WIRE(mode="straight") {#X1347:1 %t7082:p};
// %t7083 = $IO_PORT @ATTACH &vss => @PLACE(110, -3408) => @ORIENT("R0");
// %t7083 @TEXT("vss", key="name", size=0.75);
// &vss @WIRE(mode="straight") {#X1347:2 %t7083:p};
// %t7084 = $IO_PORT @ATTACH &n236 => @PLACE(110, -3412) => @ORIENT("R0");
// %t7084 @TEXT("n236", key="name", size=0.75);
// &n236 @WIRE(mode="straight") {#X1347:3 %t7084:p};
// %t7085 = $IO_PORT @ATTACH &n1516 => @PLACE(130, -3408) => @ORIENT("MY");
// %t7085 @TEXT("n1516", key="name", size=0.75);
// &n1516 @WIRE(mode="straight") {#X1347:4 %t7085:p};
// %t7086 = $SUPPLY @ATTACH &vdd => @PLACE(120, -3395);
// &vdd @WIRE(mode="straight") {#X1347:5 %t7086:p};
// %t7087 = $GROUND @ATTACH &vss => @PLACE(120, -3421);
// &vss @WIRE(mode="straight") {#X1347:6 %t7087:p};
// %t7088 = $IO_PORT @ATTACH &vdd => @PLACE(-11, -3439) => @ORIENT("R0");
// %t7088 @TEXT("vdd", key="name", size=0.75);
// &vdd @WIRE(mode="straight") {#X1348:1 %t7088:p};
// %t7089 = $IO_PORT @ATTACH &n1516 => @PLACE(-11, -3443) => @ORIENT("R0");
// %t7089 @TEXT("n1516", key="name", size=0.75);
// &n1516 @WIRE(mode="straight") {#X1348:2 %t7089:p};
// %t7090 = $IO_PORT @ATTACH &n960 => @PLACE(-11, -3447) => @ORIENT("R0");
// %t7090 @TEXT("n960", key="name", size=0.75);
// &n960 @WIRE(mode="straight") {#X1348:3 %t7090:p};
// %t7091 = $IO_PORT @ATTACH &n1517 => @PLACE(10, -3443) => @ORIENT("MY");
// %t7091 @TEXT("n1517", key="name", size=0.75);
// &n1517 @WIRE(mode="straight") {#X1348:4 %t7091:p};
// %t7092 = $SUPPLY @ATTACH &vdd => @PLACE(0, -3430);
// &vdd @WIRE(mode="straight") {#X1348:5 %t7092:p};
// %t7093 = $GROUND @ATTACH &vss => @PLACE(0, -3456);
// &vss @WIRE(mode="straight") {#X1348:6 %t7093:p};
// %t7094 = $IO_PORT @ATTACH &n1517 => @PLACE(30, -3439) => @ORIENT("R0");
// %t7094 @TEXT("n1517", key="name", size=0.75);
// &n1517 @WIRE(mode="straight") {#X1349:1 %t7094:p};
// %t7095 = $IO_PORT @ATTACH &vss => @PLACE(30, -3443) => @ORIENT("R0");
// %t7095 @TEXT("vss", key="name", size=0.75);
// &vss @WIRE(mode="straight") {#X1349:2 %t7095:p};
// %t7096 = $IO_PORT @ATTACH &n234 => @PLACE(30, -3447) => @ORIENT("R0");
// %t7096 @TEXT("n234", key="name", size=0.75);
// &n234 @WIRE(mode="straight") {#X1349:3 %t7096:p};
// %t7097 = $IO_PORT @ATTACH &n1518 => @PLACE(50, -3443) => @ORIENT("MY");
// %t7097 @TEXT("n1518", key="name", size=0.75);
// &n1518 @WIRE(mode="straight") {#X1349:4 %t7097:p};
// %t7098 = $SUPPLY @ATTACH &vdd => @PLACE(40, -3430);
// &vdd @WIRE(mode="straight") {#X1349:5 %t7098:p};
// %t7099 = $GROUND @ATTACH &vss => @PLACE(40, -3456);
// &vss @WIRE(mode="straight") {#X1349:6 %t7099:p};
// %t7100 = $IO_PORT @ATTACH &vss => @PLACE(70, -3439) => @ORIENT("R0");
// %t7100 @TEXT("vss", key="name", size=0.75);
// &vss @WIRE(mode="straight") {#X1350:1 %t7100:p};
// %t7101 = $IO_PORT @ATTACH &vdd => @PLACE(70, -3443) => @ORIENT("R0");
// %t7101 @TEXT("vdd", key="name", size=0.75);
// &vdd @WIRE(mode="straight") {#X1350:2 %t7101:p};
// %t7102 = $IO_PORT @ATTACH &n232 => @PLACE(70, -3447) => @ORIENT("R0");
// %t7102 @TEXT("n232", key="name", size=0.75);
// &n232 @WIRE(mode="straight") {#X1350:3 %t7102:p};
// %t7103 = $IO_PORT @ATTACH &n1519 => @PLACE(90, -3443) => @ORIENT("MY");
// %t7103 @TEXT("n1519", key="name", size=0.75);
// &n1519 @WIRE(mode="straight") {#X1350:4 %t7103:p};
// %t7104 = $SUPPLY @ATTACH &vdd => @PLACE(80, -3430);
// &vdd @WIRE(mode="straight") {#X1350:5 %t7104:p};
// %t7105 = $GROUND @ATTACH &vss => @PLACE(80, -3456);
// &vss @WIRE(mode="straight") {#X1350:6 %t7105:p};
// %t7106 = $IO_PORT @ATTACH &n1518 => @PLACE(110, -3439) => @ORIENT("R0");
// %t7106 @TEXT("n1518", key="name", size=0.75);
// &n1518 @WIRE(mode="straight") {#X1351:1 %t7106:p};
// %t7107 = $IO_PORT @ATTACH &n1519 => @PLACE(110, -3443) => @ORIENT("R0");
// %t7107 @TEXT("n1519", key="name", size=0.75);
// &n1519 @WIRE(mode="straight") {#X1351:2 %t7107:p};
// %t7108 = $IO_PORT @ATTACH &n238 => @PLACE(110, -3447) => @ORIENT("R0");
// %t7108 @TEXT("n238", key="name", size=0.75);
// &n238 @WIRE(mode="straight") {#X1351:3 %t7108:p};
// %t7109 = $IO_PORT @ATTACH &n194 => @PLACE(130, -3443) => @ORIENT("MY");
// %t7109 @TEXT("n194", key="name", size=0.75);
// &n194 @WIRE(mode="straight") {#X1351:4 %t7109:p};
// %t7110 = $SUPPLY @ATTACH &vdd => @PLACE(120, -3430);
// &vdd @WIRE(mode="straight") {#X1351:5 %t7110:p};
// %t7111 = $GROUND @ATTACH &vss => @PLACE(120, -3456);
// &vss @WIRE(mode="straight") {#X1351:6 %t7111:p};
// %t7112 = $IO_PORT @ATTACH &n1269 => @PLACE(-11, -3474) => @ORIENT("R0");
// %t7112 @TEXT("n1269", key="name", size=0.75);
// &n1269 @WIRE(mode="straight") {#X1352:1 %t7112:p};
// %t7113 = $IO_PORT @ATTACH &vss => @PLACE(-11, -3478) => @ORIENT("R0");
// %t7113 @TEXT("vss", key="name", size=0.75);
// &vss @WIRE(mode="straight") {#X1352:2 %t7113:p};
// %t7114 = $IO_PORT @ATTACH &n1102 => @PLACE(-11, -3482) => @ORIENT("R0");
// %t7114 @TEXT("n1102", key="name", size=0.75);
// &n1102 @WIRE(mode="straight") {#X1352:3 %t7114:p};
// %t7115 = $IO_PORT @ATTACH &n1520 => @PLACE(10, -3478) => @ORIENT("MY");
// %t7115 @TEXT("n1520", key="name", size=0.75);
// &n1520 @WIRE(mode="straight") {#X1352:4 %t7115:p};
// %t7116 = $SUPPLY @ATTACH &vdd => @PLACE(0, -3465);
// &vdd @WIRE(mode="straight") {#X1352:5 %t7116:p};
// %t7117 = $GROUND @ATTACH &vss => @PLACE(0, -3491);
// &vss @WIRE(mode="straight") {#X1352:6 %t7117:p};
// %t7118 = $IO_PORT @ATTACH &vss => @PLACE(30, -3474) => @ORIENT("R0");
// %t7118 @TEXT("vss", key="name", size=0.75);
// &vss @WIRE(mode="straight") {#X1353:1 %t7118:p};
// %t7119 = $IO_PORT @ATTACH &vss => @PLACE(30, -3478) => @ORIENT("R0");
// %t7119 @TEXT("vss", key="name", size=0.75);
// &vss @WIRE(mode="straight") {#X1353:2 %t7119:p};
// %t7120 = $IO_PORT @ATTACH &n240 => @PLACE(30, -3482) => @ORIENT("R0");
// %t7120 @TEXT("n240", key="name", size=0.75);
// &n240 @WIRE(mode="straight") {#X1353:3 %t7120:p};
// %t7121 = $IO_PORT @ATTACH &n1521 => @PLACE(50, -3478) => @ORIENT("MY");
// %t7121 @TEXT("n1521", key="name", size=0.75);
// &n1521 @WIRE(mode="straight") {#X1353:4 %t7121:p};
// %t7122 = $SUPPLY @ATTACH &vdd => @PLACE(40, -3465);
// &vdd @WIRE(mode="straight") {#X1353:5 %t7122:p};
// %t7123 = $GROUND @ATTACH &vss => @PLACE(40, -3491);
// &vss @WIRE(mode="straight") {#X1353:6 %t7123:p};
// %t7124 = $IO_PORT @ATTACH &vss => @PLACE(70, -3474) => @ORIENT("R0");
// %t7124 @TEXT("vss", key="name", size=0.75);
// &vss @WIRE(mode="straight") {#X1354:1 %t7124:p};
// %t7125 = $IO_PORT @ATTACH &vss => @PLACE(70, -3478) => @ORIENT("R0");
// %t7125 @TEXT("vss", key="name", size=0.75);
// &vss @WIRE(mode="straight") {#X1354:2 %t7125:p};
// %t7126 = $IO_PORT @ATTACH &n243 => @PLACE(70, -3482) => @ORIENT("R0");
// %t7126 @TEXT("n243", key="name", size=0.75);
// &n243 @WIRE(mode="straight") {#X1354:3 %t7126:p};
// %t7127 = $IO_PORT @ATTACH &n1522 => @PLACE(90, -3478) => @ORIENT("MY");
// %t7127 @TEXT("n1522", key="name", size=0.75);
// &n1522 @WIRE(mode="straight") {#X1354:4 %t7127:p};
// %t7128 = $SUPPLY @ATTACH &vdd => @PLACE(80, -3465);
// &vdd @WIRE(mode="straight") {#X1354:5 %t7128:p};
// %t7129 = $GROUND @ATTACH &vss => @PLACE(80, -3491);
// &vss @WIRE(mode="straight") {#X1354:6 %t7129:p};
// %t7130 = $IO_PORT @ATTACH &n1522 => @PLACE(110, -3474) => @ORIENT("R0");
// %t7130 @TEXT("n1522", key="name", size=0.75);
// &n1522 @WIRE(mode="straight") {#X1355:1 %t7130:p};
// %t7131 = $IO_PORT @ATTACH &n1521 => @PLACE(110, -3478) => @ORIENT("R0");
// %t7131 @TEXT("n1521", key="name", size=0.75);
// &n1521 @WIRE(mode="straight") {#X1355:2 %t7131:p};
// %t7132 = $IO_PORT @ATTACH &n351 => @PLACE(110, -3482) => @ORIENT("R0");
// %t7132 @TEXT("n351", key="name", size=0.75);
// &n351 @WIRE(mode="straight") {#X1355:3 %t7132:p};
// %t7133 = $IO_PORT @ATTACH &n1523 => @PLACE(130, -3478) => @ORIENT("MY");
// %t7133 @TEXT("n1523", key="name", size=0.75);
// &n1523 @WIRE(mode="straight") {#X1355:4 %t7133:p};
// %t7134 = $SUPPLY @ATTACH &vdd => @PLACE(120, -3465);
// &vdd @WIRE(mode="straight") {#X1355:5 %t7134:p};
// %t7135 = $GROUND @ATTACH &vss => @PLACE(120, -3491);
// &vss @WIRE(mode="straight") {#X1355:6 %t7135:p};
// %t7136 = $IO_PORT @ATTACH &n1523 => @PLACE(-11, -3509) => @ORIENT("R0");
// %t7136 @TEXT("n1523", key="name", size=0.75);
// &n1523 @WIRE(mode="straight") {#X1356:1 %t7136:p};
// %t7137 = $IO_PORT @ATTACH &vss => @PLACE(-11, -3513) => @ORIENT("R0");
// %t7137 @TEXT("vss", key="name", size=0.75);
// &vss @WIRE(mode="straight") {#X1356:2 %t7137:p};
// %t7138 = $IO_PORT @ATTACH &n236 => @PLACE(-11, -3517) => @ORIENT("R0");
// %t7138 @TEXT("n236", key="name", size=0.75);
// &n236 @WIRE(mode="straight") {#X1356:3 %t7138:p};
// %t7139 = $IO_PORT @ATTACH &n1524 => @PLACE(10, -3513) => @ORIENT("MY");
// %t7139 @TEXT("n1524", key="name", size=0.75);
// &n1524 @WIRE(mode="straight") {#X1356:4 %t7139:p};
// %t7140 = $SUPPLY @ATTACH &vdd => @PLACE(0, -3500);
// &vdd @WIRE(mode="straight") {#X1356:5 %t7140:p};
// %t7141 = $GROUND @ATTACH &vss => @PLACE(0, -3526);
// &vss @WIRE(mode="straight") {#X1356:6 %t7141:p};
// %t7142 = $IO_PORT @ATTACH &vss => @PLACE(30, -3509) => @ORIENT("R0");
// %t7142 @TEXT("vss", key="name", size=0.75);
// &vss @WIRE(mode="straight") {#X1357:1 %t7142:p};
// %t7143 = $IO_PORT @ATTACH &n1524 => @PLACE(30, -3513) => @ORIENT("R0");
// %t7143 @TEXT("n1524", key="name", size=0.75);
// &n1524 @WIRE(mode="straight") {#X1357:2 %t7143:p};
// %t7144 = $IO_PORT @ATTACH &n960 => @PLACE(30, -3517) => @ORIENT("R0");
// %t7144 @TEXT("n960", key="name", size=0.75);
// &n960 @WIRE(mode="straight") {#X1357:3 %t7144:p};
// %t7145 = $IO_PORT @ATTACH &n1525 => @PLACE(50, -3513) => @ORIENT("MY");
// %t7145 @TEXT("n1525", key="name", size=0.75);
// &n1525 @WIRE(mode="straight") {#X1357:4 %t7145:p};
// %t7146 = $SUPPLY @ATTACH &vdd => @PLACE(40, -3500);
// &vdd @WIRE(mode="straight") {#X1357:5 %t7146:p};
// %t7147 = $GROUND @ATTACH &vss => @PLACE(40, -3526);
// &vss @WIRE(mode="straight") {#X1357:6 %t7147:p};
// %t7148 = $IO_PORT @ATTACH &n1525 => @PLACE(70, -3509) => @ORIENT("R0");
// %t7148 @TEXT("n1525", key="name", size=0.75);
// &n1525 @WIRE(mode="straight") {#X1358:1 %t7148:p};
// %t7149 = $IO_PORT @ATTACH &vss => @PLACE(70, -3513) => @ORIENT("R0");
// %t7149 @TEXT("vss", key="name", size=0.75);
// &vss @WIRE(mode="straight") {#X1358:2 %t7149:p};
// %t7150 = $IO_PORT @ATTACH &n234 => @PLACE(70, -3517) => @ORIENT("R0");
// %t7150 @TEXT("n234", key="name", size=0.75);
// &n234 @WIRE(mode="straight") {#X1358:3 %t7150:p};
// %t7151 = $IO_PORT @ATTACH &n1526 => @PLACE(90, -3513) => @ORIENT("MY");
// %t7151 @TEXT("n1526", key="name", size=0.75);
// &n1526 @WIRE(mode="straight") {#X1358:4 %t7151:p};
// %t7152 = $SUPPLY @ATTACH &vdd => @PLACE(80, -3500);
// &vdd @WIRE(mode="straight") {#X1358:5 %t7152:p};
// %t7153 = $GROUND @ATTACH &vss => @PLACE(80, -3526);
// &vss @WIRE(mode="straight") {#X1358:6 %t7153:p};
// %t7154 = $IO_PORT @ATTACH &vss => @PLACE(110, -3509) => @ORIENT("R0");
// %t7154 @TEXT("vss", key="name", size=0.75);
// &vss @WIRE(mode="straight") {#X1359:1 %t7154:p};
// %t7155 = $IO_PORT @ATTACH &vss => @PLACE(110, -3513) => @ORIENT("R0");
// %t7155 @TEXT("vss", key="name", size=0.75);
// &vss @WIRE(mode="straight") {#X1359:2 %t7155:p};
// %t7156 = $IO_PORT @ATTACH &n232 => @PLACE(110, -3517) => @ORIENT("R0");
// %t7156 @TEXT("n232", key="name", size=0.75);
// &n232 @WIRE(mode="straight") {#X1359:3 %t7156:p};
// %t7157 = $IO_PORT @ATTACH &n1527 => @PLACE(130, -3513) => @ORIENT("MY");
// %t7157 @TEXT("n1527", key="name", size=0.75);
// &n1527 @WIRE(mode="straight") {#X1359:4 %t7157:p};
// %t7158 = $SUPPLY @ATTACH &vdd => @PLACE(120, -3500);
// &vdd @WIRE(mode="straight") {#X1359:5 %t7158:p};
// %t7159 = $GROUND @ATTACH &vss => @PLACE(120, -3526);
// &vss @WIRE(mode="straight") {#X1359:6 %t7159:p};
// %t7160 = $IO_PORT @ATTACH &n1526 => @PLACE(-11, -3544) => @ORIENT("R0");
// %t7160 @TEXT("n1526", key="name", size=0.75);
// &n1526 @WIRE(mode="straight") {#X1360:1 %t7160:p};
// %t7161 = $IO_PORT @ATTACH &n1527 => @PLACE(-11, -3548) => @ORIENT("R0");
// %t7161 @TEXT("n1527", key="name", size=0.75);
// &n1527 @WIRE(mode="straight") {#X1360:2 %t7161:p};
// %t7162 = $IO_PORT @ATTACH &n238 => @PLACE(-11, -3552) => @ORIENT("R0");
// %t7162 @TEXT("n238", key="name", size=0.75);
// &n238 @WIRE(mode="straight") {#X1360:3 %t7162:p};
// %t7163 = $IO_PORT @ATTACH &n1528 => @PLACE(10, -3548) => @ORIENT("MY");
// %t7163 @TEXT("n1528", key="name", size=0.75);
// &n1528 @WIRE(mode="straight") {#X1360:4 %t7163:p};
// %t7164 = $SUPPLY @ATTACH &vdd => @PLACE(0, -3535);
// &vdd @WIRE(mode="straight") {#X1360:5 %t7164:p};
// %t7165 = $GROUND @ATTACH &vss => @PLACE(0, -3561);
// &vss @WIRE(mode="straight") {#X1360:6 %t7165:p};
// %t7166 = $IO_PORT @ATTACH &vss => @PLACE(30, -3544) => @ORIENT("R0");
// %t7166 @TEXT("vss", key="name", size=0.75);
// &vss @WIRE(mode="straight") {#X1361:1 %t7166:p};
// %t7167 = $IO_PORT @ATTACH &n1528 => @PLACE(30, -3548) => @ORIENT("R0");
// %t7167 @TEXT("n1528", key="name", size=0.75);
// &n1528 @WIRE(mode="straight") {#X1361:2 %t7167:p};
// %t7168 = $IO_PORT @ATTACH &n88 => @PLACE(30, -3552) => @ORIENT("R0");
// %t7168 @TEXT("n88", key="name", size=0.75);
// &n88 @WIRE(mode="straight") {#X1361:3 %t7168:p};
// %t7169 = $IO_PORT @ATTACH &n1529 => @PLACE(50, -3548) => @ORIENT("MY");
// %t7169 @TEXT("n1529", key="name", size=0.75);
// &n1529 @WIRE(mode="straight") {#X1361:4 %t7169:p};
// %t7170 = $SUPPLY @ATTACH &vdd => @PLACE(40, -3535);
// &vdd @WIRE(mode="straight") {#X1361:5 %t7170:p};
// %t7171 = $GROUND @ATTACH &vss => @PLACE(40, -3561);
// &vss @WIRE(mode="straight") {#X1361:6 %t7171:p};
// %t7172 = $IO_PORT @ATTACH &vss => @PLACE(70, -3544) => @ORIENT("R0");
// %t7172 @TEXT("vss", key="name", size=0.75);
// &vss @WIRE(mode="straight") {#X1362:1 %t7172:p};
// %t7173 = $IO_PORT @ATTACH &n1529 => @PLACE(70, -3548) => @ORIENT("R0");
// %t7173 @TEXT("n1529", key="name", size=0.75);
// &n1529 @WIRE(mode="straight") {#X1362:2 %t7173:p};
// %t7174 = $IO_PORT @ATTACH &n117 => @PLACE(70, -3552) => @ORIENT("R0");
// %t7174 @TEXT("n117", key="name", size=0.75);
// &n117 @WIRE(mode="straight") {#X1362:3 %t7174:p};
// %t7175 = $IO_PORT @ATTACH &n1530 => @PLACE(90, -3548) => @ORIENT("MY");
// %t7175 @TEXT("n1530", key="name", size=0.75);
// &n1530 @WIRE(mode="straight") {#X1362:4 %t7175:p};
// %t7176 = $SUPPLY @ATTACH &vdd => @PLACE(80, -3535);
// &vdd @WIRE(mode="straight") {#X1362:5 %t7176:p};
// %t7177 = $GROUND @ATTACH &vss => @PLACE(80, -3561);
// &vss @WIRE(mode="straight") {#X1362:6 %t7177:p};
// %t7178 = $IO_PORT @ATTACH &vss => @PLACE(110, -3544) => @ORIENT("R0");
// %t7178 @TEXT("vss", key="name", size=0.75);
// &vss @WIRE(mode="straight") {#X1363:1 %t7178:p};
// %t7179 = $IO_PORT @ATTACH &n1530 => @PLACE(110, -3548) => @ORIENT("R0");
// %t7179 @TEXT("n1530", key="name", size=0.75);
// &n1530 @WIRE(mode="straight") {#X1363:2 %t7179:p};
// %t7180 = $IO_PORT @ATTACH &n51 => @PLACE(110, -3552) => @ORIENT("R0");
// %t7180 @TEXT("n51", key="name", size=0.75);
// &n51 @WIRE(mode="straight") {#X1363:3 %t7180:p};
// %t7181 = $IO_PORT @ATTACH &n1531 => @PLACE(130, -3548) => @ORIENT("MY");
// %t7181 @TEXT("n1531", key="name", size=0.75);
// &n1531 @WIRE(mode="straight") {#X1363:4 %t7181:p};
// %t7182 = $SUPPLY @ATTACH &vdd => @PLACE(120, -3535);
// &vdd @WIRE(mode="straight") {#X1363:5 %t7182:p};
// %t7183 = $GROUND @ATTACH &vss => @PLACE(120, -3561);
// &vss @WIRE(mode="straight") {#X1363:6 %t7183:p};
// %t7184 = $IO_PORT @ATTACH &vss => @PLACE(-11, -3579) => @ORIENT("R0");
// %t7184 @TEXT("vss", key="name", size=0.75);
// &vss @WIRE(mode="straight") {#X1364:1 %t7184:p};
// %t7185 = $IO_PORT @ATTACH &n336 => @PLACE(-11, -3583) => @ORIENT("R0");
// %t7185 @TEXT("n336", key="name", size=0.75);
// &n336 @WIRE(mode="straight") {#X1364:2 %t7185:p};
// %t7186 = $IO_PORT @ATTACH &n980 => @PLACE(-11, -3587) => @ORIENT("R0");
// %t7186 @TEXT("n980", key="name", size=0.75);
// &n980 @WIRE(mode="straight") {#X1364:3 %t7186:p};
// %t7187 = $IO_PORT @ATTACH &n1532 => @PLACE(10, -3583) => @ORIENT("MY");
// %t7187 @TEXT("n1532", key="name", size=0.75);
// &n1532 @WIRE(mode="straight") {#X1364:4 %t7187:p};
// %t7188 = $SUPPLY @ATTACH &vdd => @PLACE(0, -3570);
// &vdd @WIRE(mode="straight") {#X1364:5 %t7188:p};
// %t7189 = $GROUND @ATTACH &vss => @PLACE(0, -3596);
// &vss @WIRE(mode="straight") {#X1364:6 %t7189:p};
// %t7190 = $IO_PORT @ATTACH &vss => @PLACE(30, -3579) => @ORIENT("R0");
// %t7190 @TEXT("vss", key="name", size=0.75);
// &vss @WIRE(mode="straight") {#X1365:1 %t7190:p};
// %t7191 = $IO_PORT @ATTACH &n338 => @PLACE(30, -3583) => @ORIENT("R0");
// %t7191 @TEXT("n338", key="name", size=0.75);
// &n338 @WIRE(mode="straight") {#X1365:2 %t7191:p};
// %t7192 = $IO_PORT @ATTACH &n980 => @PLACE(30, -3587) => @ORIENT("R0");
// %t7192 @TEXT("n980", key="name", size=0.75);
// &n980 @WIRE(mode="straight") {#X1365:3 %t7192:p};
// %t7193 = $IO_PORT @ATTACH &n1533 => @PLACE(50, -3583) => @ORIENT("MY");
// %t7193 @TEXT("n1533", key="name", size=0.75);
// &n1533 @WIRE(mode="straight") {#X1365:4 %t7193:p};
// %t7194 = $SUPPLY @ATTACH &vdd => @PLACE(40, -3570);
// &vdd @WIRE(mode="straight") {#X1365:5 %t7194:p};
// %t7195 = $GROUND @ATTACH &vss => @PLACE(40, -3596);
// &vss @WIRE(mode="straight") {#X1365:6 %t7195:p};
// %t7196 = $IO_PORT @ATTACH &vss => @PLACE(70, -3579) => @ORIENT("R0");
// %t7196 @TEXT("vss", key="name", size=0.75);
// &vss @WIRE(mode="straight") {#X1366:1 %t7196:p};
// %t7197 = $IO_PORT @ATTACH &n340 => @PLACE(70, -3583) => @ORIENT("R0");
// %t7197 @TEXT("n340", key="name", size=0.75);
// &n340 @WIRE(mode="straight") {#X1366:2 %t7197:p};
// %t7198 = $IO_PORT @ATTACH &n980 => @PLACE(70, -3587) => @ORIENT("R0");
// %t7198 @TEXT("n980", key="name", size=0.75);
// &n980 @WIRE(mode="straight") {#X1366:3 %t7198:p};
// %t7199 = $IO_PORT @ATTACH &n1534 => @PLACE(90, -3583) => @ORIENT("MY");
// %t7199 @TEXT("n1534", key="name", size=0.75);
// &n1534 @WIRE(mode="straight") {#X1366:4 %t7199:p};
// %t7200 = $SUPPLY @ATTACH &vdd => @PLACE(80, -3570);
// &vdd @WIRE(mode="straight") {#X1366:5 %t7200:p};
// %t7201 = $GROUND @ATTACH &vss => @PLACE(80, -3596);
// &vss @WIRE(mode="straight") {#X1366:6 %t7201:p};
// %t7202 = $IO_PORT @ATTACH &vss => @PLACE(110, -3579) => @ORIENT("R0");
// %t7202 @TEXT("vss", key="name", size=0.75);
// &vss @WIRE(mode="straight") {#X1367:1 %t7202:p};
// %t7203 = $IO_PORT @ATTACH &n342 => @PLACE(110, -3583) => @ORIENT("R0");
// %t7203 @TEXT("n342", key="name", size=0.75);
// &n342 @WIRE(mode="straight") {#X1367:2 %t7203:p};
// %t7204 = $IO_PORT @ATTACH &n980 => @PLACE(110, -3587) => @ORIENT("R0");
// %t7204 @TEXT("n980", key="name", size=0.75);
// &n980 @WIRE(mode="straight") {#X1367:3 %t7204:p};
// %t7205 = $IO_PORT @ATTACH &n1535 => @PLACE(130, -3583) => @ORIENT("MY");
// %t7205 @TEXT("n1535", key="name", size=0.75);
// &n1535 @WIRE(mode="straight") {#X1367:4 %t7205:p};
// %t7206 = $SUPPLY @ATTACH &vdd => @PLACE(120, -3570);
// &vdd @WIRE(mode="straight") {#X1367:5 %t7206:p};
// %t7207 = $GROUND @ATTACH &vss => @PLACE(120, -3596);
// &vss @WIRE(mode="straight") {#X1367:6 %t7207:p};
// %t7208 = $IO_PORT @ATTACH &vss => @PLACE(158, -3404) => @ORIENT("R0");
// %t7208 @TEXT("vss", key="name", size=0.75);
// &vss @WIRE(mode="straight") {#X1368:1 %t7208:p};
// %t7209 = $IO_PORT @ATTACH &n344 => @PLACE(158, -3408) => @ORIENT("R0");
// %t7209 @TEXT("n344", key="name", size=0.75);
// &n344 @WIRE(mode="straight") {#X1368:2 %t7209:p};
// %t7210 = $IO_PORT @ATTACH &n980 => @PLACE(158, -3412) => @ORIENT("R0");
// %t7210 @TEXT("n980", key="name", size=0.75);
// &n980 @WIRE(mode="straight") {#X1368:3 %t7210:p};
// %t7211 = $IO_PORT @ATTACH &n1536 => @PLACE(178, -3408) => @ORIENT("MY");
// %t7211 @TEXT("n1536", key="name", size=0.75);
// &n1536 @WIRE(mode="straight") {#X1368:4 %t7211:p};
// %t7212 = $SUPPLY @ATTACH &vdd => @PLACE(168, -3395);
// &vdd @WIRE(mode="straight") {#X1368:5 %t7212:p};
// %t7213 = $GROUND @ATTACH &vss => @PLACE(168, -3421);
// &vss @WIRE(mode="straight") {#X1368:6 %t7213:p};
// %t7214 = $IO_PORT @ATTACH &vdd => @PLACE(198, -3404) => @ORIENT("R0");
// %t7214 @TEXT("vdd", key="name", size=0.75);
// &vdd @WIRE(mode="straight") {#X1369:1 %t7214:p};
// %t7215 = $IO_PORT @ATTACH &n1320 => @PLACE(198, -3408) => @ORIENT("R0");
// %t7215 @TEXT("n1320", key="name", size=0.75);
// &n1320 @WIRE(mode="straight") {#X1369:2 %t7215:p};
// %t7216 = $IO_PORT @ATTACH &n980 => @PLACE(198, -3412) => @ORIENT("R0");
// %t7216 @TEXT("n980", key="name", size=0.75);
// &n980 @WIRE(mode="straight") {#X1369:3 %t7216:p};
// %t7217 = $IO_PORT @ATTACH &n1537 => @PLACE(218, -3408) => @ORIENT("MY");
// %t7217 @TEXT("n1537", key="name", size=0.75);
// &n1537 @WIRE(mode="straight") {#X1369:4 %t7217:p};
// %t7218 = $SUPPLY @ATTACH &vdd => @PLACE(208, -3395);
// &vdd @WIRE(mode="straight") {#X1369:5 %t7218:p};
// %t7219 = $GROUND @ATTACH &vss => @PLACE(208, -3421);
// &vss @WIRE(mode="straight") {#X1369:6 %t7219:p};
// %t7220 = $IO_PORT @ATTACH &n364 => @PLACE(238, -3404) => @ORIENT("R0");
// %t7220 @TEXT("n364", key="name", size=0.75);
// &n364 @WIRE(mode="straight") {#X1370:1 %t7220:p};
// %t7221 = $IO_PORT @ATTACH &vss => @PLACE(238, -3408) => @ORIENT("R0");
// %t7221 @TEXT("vss", key="name", size=0.75);
// &vss @WIRE(mode="straight") {#X1370:2 %t7221:p};
// %t7222 = $IO_PORT @ATTACH &n240 => @PLACE(238, -3412) => @ORIENT("R0");
// %t7222 @TEXT("n240", key="name", size=0.75);
// &n240 @WIRE(mode="straight") {#X1370:3 %t7222:p};
// %t7223 = $IO_PORT @ATTACH &n1538 => @PLACE(258, -3408) => @ORIENT("MY");
// %t7223 @TEXT("n1538", key="name", size=0.75);
// &n1538 @WIRE(mode="straight") {#X1370:4 %t7223:p};
// %t7224 = $SUPPLY @ATTACH &vdd => @PLACE(248, -3395);
// &vdd @WIRE(mode="straight") {#X1370:5 %t7224:p};
// %t7225 = $GROUND @ATTACH &vss => @PLACE(248, -3421);
// &vss @WIRE(mode="straight") {#X1370:6 %t7225:p};
// %t7226 = $IO_PORT @ATTACH &n367 => @PLACE(278, -3404) => @ORIENT("R0");
// %t7226 @TEXT("n367", key="name", size=0.75);
// &n367 @WIRE(mode="straight") {#X1371:1 %t7226:p};
// %t7227 = $IO_PORT @ATTACH &vss => @PLACE(278, -3408) => @ORIENT("R0");
// %t7227 @TEXT("vss", key="name", size=0.75);
// &vss @WIRE(mode="straight") {#X1371:2 %t7227:p};
// %t7228 = $IO_PORT @ATTACH &n240 => @PLACE(278, -3412) => @ORIENT("R0");
// %t7228 @TEXT("n240", key="name", size=0.75);
// &n240 @WIRE(mode="straight") {#X1371:3 %t7228:p};
// %t7229 = $IO_PORT @ATTACH &n1539 => @PLACE(298, -3408) => @ORIENT("MY");
// %t7229 @TEXT("n1539", key="name", size=0.75);
// &n1539 @WIRE(mode="straight") {#X1371:4 %t7229:p};
// %t7230 = $SUPPLY @ATTACH &vdd => @PLACE(288, -3395);
// &vdd @WIRE(mode="straight") {#X1371:5 %t7230:p};
// %t7231 = $GROUND @ATTACH &vss => @PLACE(288, -3421);
// &vss @WIRE(mode="straight") {#X1371:6 %t7231:p};
// %t7232 = $IO_PORT @ATTACH &n370 => @PLACE(158, -3439) => @ORIENT("R0");
// %t7232 @TEXT("n370", key="name", size=0.75);
// &n370 @WIRE(mode="straight") {#X1372:1 %t7232:p};
// %t7233 = $IO_PORT @ATTACH &vss => @PLACE(158, -3443) => @ORIENT("R0");
// %t7233 @TEXT("vss", key="name", size=0.75);
// &vss @WIRE(mode="straight") {#X1372:2 %t7233:p};
// %t7234 = $IO_PORT @ATTACH &n240 => @PLACE(158, -3447) => @ORIENT("R0");
// %t7234 @TEXT("n240", key="name", size=0.75);
// &n240 @WIRE(mode="straight") {#X1372:3 %t7234:p};
// %t7235 = $IO_PORT @ATTACH &n1540 => @PLACE(178, -3443) => @ORIENT("MY");
// %t7235 @TEXT("n1540", key="name", size=0.75);
// &n1540 @WIRE(mode="straight") {#X1372:4 %t7235:p};
// %t7236 = $SUPPLY @ATTACH &vdd => @PLACE(168, -3430);
// &vdd @WIRE(mode="straight") {#X1372:5 %t7236:p};
// %t7237 = $GROUND @ATTACH &vss => @PLACE(168, -3456);
// &vss @WIRE(mode="straight") {#X1372:6 %t7237:p};
// %t7238 = $IO_PORT @ATTACH &n373 => @PLACE(198, -3439) => @ORIENT("R0");
// %t7238 @TEXT("n373", key="name", size=0.75);
// &n373 @WIRE(mode="straight") {#X1373:1 %t7238:p};
// %t7239 = $IO_PORT @ATTACH &vss => @PLACE(198, -3443) => @ORIENT("R0");
// %t7239 @TEXT("vss", key="name", size=0.75);
// &vss @WIRE(mode="straight") {#X1373:2 %t7239:p};
// %t7240 = $IO_PORT @ATTACH &n240 => @PLACE(198, -3447) => @ORIENT("R0");
// %t7240 @TEXT("n240", key="name", size=0.75);
// &n240 @WIRE(mode="straight") {#X1373:3 %t7240:p};
// %t7241 = $IO_PORT @ATTACH &n1541 => @PLACE(218, -3443) => @ORIENT("MY");
// %t7241 @TEXT("n1541", key="name", size=0.75);
// &n1541 @WIRE(mode="straight") {#X1373:4 %t7241:p};
// %t7242 = $SUPPLY @ATTACH &vdd => @PLACE(208, -3430);
// &vdd @WIRE(mode="straight") {#X1373:5 %t7242:p};
// %t7243 = $GROUND @ATTACH &vss => @PLACE(208, -3456);
// &vss @WIRE(mode="straight") {#X1373:6 %t7243:p};
// %t7244 = $IO_PORT @ATTACH &n376 => @PLACE(238, -3439) => @ORIENT("R0");
// %t7244 @TEXT("n376", key="name", size=0.75);
// &n376 @WIRE(mode="straight") {#X1374:1 %t7244:p};
// %t7245 = $IO_PORT @ATTACH &vss => @PLACE(238, -3443) => @ORIENT("R0");
// %t7245 @TEXT("vss", key="name", size=0.75);
// &vss @WIRE(mode="straight") {#X1374:2 %t7245:p};
// %t7246 = $IO_PORT @ATTACH &n240 => @PLACE(238, -3447) => @ORIENT("R0");
// %t7246 @TEXT("n240", key="name", size=0.75);
// &n240 @WIRE(mode="straight") {#X1374:3 %t7246:p};
// %t7247 = $IO_PORT @ATTACH &n1542 => @PLACE(258, -3443) => @ORIENT("MY");
// %t7247 @TEXT("n1542", key="name", size=0.75);
// &n1542 @WIRE(mode="straight") {#X1374:4 %t7247:p};
// %t7248 = $SUPPLY @ATTACH &vdd => @PLACE(248, -3430);
// &vdd @WIRE(mode="straight") {#X1374:5 %t7248:p};
// %t7249 = $GROUND @ATTACH &vss => @PLACE(248, -3456);
// &vss @WIRE(mode="straight") {#X1374:6 %t7249:p};
// %t7250 = $IO_PORT @ATTACH &n379 => @PLACE(278, -3439) => @ORIENT("R0");
// %t7250 @TEXT("n379", key="name", size=0.75);
// &n379 @WIRE(mode="straight") {#X1375:1 %t7250:p};
// %t7251 = $IO_PORT @ATTACH &vss => @PLACE(278, -3443) => @ORIENT("R0");
// %t7251 @TEXT("vss", key="name", size=0.75);
// &vss @WIRE(mode="straight") {#X1375:2 %t7251:p};
// %t7252 = $IO_PORT @ATTACH &n240 => @PLACE(278, -3447) => @ORIENT("R0");
// %t7252 @TEXT("n240", key="name", size=0.75);
// &n240 @WIRE(mode="straight") {#X1375:3 %t7252:p};
// %t7253 = $IO_PORT @ATTACH &n1543 => @PLACE(298, -3443) => @ORIENT("MY");
// %t7253 @TEXT("n1543", key="name", size=0.75);
// &n1543 @WIRE(mode="straight") {#X1375:4 %t7253:p};
// %t7254 = $SUPPLY @ATTACH &vdd => @PLACE(288, -3430);
// &vdd @WIRE(mode="straight") {#X1375:5 %t7254:p};
// %t7255 = $GROUND @ATTACH &vss => @PLACE(288, -3456);
// &vss @WIRE(mode="straight") {#X1375:6 %t7255:p};
// %t7256 = $IO_PORT @ATTACH &n391 => @PLACE(158, -3474) => @ORIENT("R0");
// %t7256 @TEXT("n391", key="name", size=0.75);
// &n391 @WIRE(mode="straight") {#X1376:1 %t7256:p};
// %t7257 = $IO_PORT @ATTACH &vss => @PLACE(158, -3478) => @ORIENT("R0");
// %t7257 @TEXT("vss", key="name", size=0.75);
// &vss @WIRE(mode="straight") {#X1376:2 %t7257:p};
// %t7258 = $IO_PORT @ATTACH &n243 => @PLACE(158, -3482) => @ORIENT("R0");
// %t7258 @TEXT("n243", key="name", size=0.75);
// &n243 @WIRE(mode="straight") {#X1376:3 %t7258:p};
// %t7259 = $IO_PORT @ATTACH &n1544 => @PLACE(178, -3478) => @ORIENT("MY");
// %t7259 @TEXT("n1544", key="name", size=0.75);
// &n1544 @WIRE(mode="straight") {#X1376:4 %t7259:p};
// %t7260 = $SUPPLY @ATTACH &vdd => @PLACE(168, -3465);
// &vdd @WIRE(mode="straight") {#X1376:5 %t7260:p};
// %t7261 = $GROUND @ATTACH &vss => @PLACE(168, -3491);
// &vss @WIRE(mode="straight") {#X1376:6 %t7261:p};
// %t7262 = $IO_PORT @ATTACH &n393 => @PLACE(198, -3474) => @ORIENT("R0");
// %t7262 @TEXT("n393", key="name", size=0.75);
// &n393 @WIRE(mode="straight") {#X1377:1 %t7262:p};
// %t7263 = $IO_PORT @ATTACH &vss => @PLACE(198, -3478) => @ORIENT("R0");
// %t7263 @TEXT("vss", key="name", size=0.75);
// &vss @WIRE(mode="straight") {#X1377:2 %t7263:p};
// %t7264 = $IO_PORT @ATTACH &n243 => @PLACE(198, -3482) => @ORIENT("R0");
// %t7264 @TEXT("n243", key="name", size=0.75);
// &n243 @WIRE(mode="straight") {#X1377:3 %t7264:p};
// %t7265 = $IO_PORT @ATTACH &n1545 => @PLACE(218, -3478) => @ORIENT("MY");
// %t7265 @TEXT("n1545", key="name", size=0.75);
// &n1545 @WIRE(mode="straight") {#X1377:4 %t7265:p};
// %t7266 = $SUPPLY @ATTACH &vdd => @PLACE(208, -3465);
// &vdd @WIRE(mode="straight") {#X1377:5 %t7266:p};
// %t7267 = $GROUND @ATTACH &vss => @PLACE(208, -3491);
// &vss @WIRE(mode="straight") {#X1377:6 %t7267:p};
// %t7268 = $IO_PORT @ATTACH &n395 => @PLACE(238, -3474) => @ORIENT("R0");
// %t7268 @TEXT("n395", key="name", size=0.75);
// &n395 @WIRE(mode="straight") {#X1378:1 %t7268:p};
// %t7269 = $IO_PORT @ATTACH &vss => @PLACE(238, -3478) => @ORIENT("R0");
// %t7269 @TEXT("vss", key="name", size=0.75);
// &vss @WIRE(mode="straight") {#X1378:2 %t7269:p};
// %t7270 = $IO_PORT @ATTACH &n243 => @PLACE(238, -3482) => @ORIENT("R0");
// %t7270 @TEXT("n243", key="name", size=0.75);
// &n243 @WIRE(mode="straight") {#X1378:3 %t7270:p};
// %t7271 = $IO_PORT @ATTACH &n1546 => @PLACE(258, -3478) => @ORIENT("MY");
// %t7271 @TEXT("n1546", key="name", size=0.75);
// &n1546 @WIRE(mode="straight") {#X1378:4 %t7271:p};
// %t7272 = $SUPPLY @ATTACH &vdd => @PLACE(248, -3465);
// &vdd @WIRE(mode="straight") {#X1378:5 %t7272:p};
// %t7273 = $GROUND @ATTACH &vss => @PLACE(248, -3491);
// &vss @WIRE(mode="straight") {#X1378:6 %t7273:p};
// %t7274 = $IO_PORT @ATTACH &n397 => @PLACE(278, -3474) => @ORIENT("R0");
// %t7274 @TEXT("n397", key="name", size=0.75);
// &n397 @WIRE(mode="straight") {#X1379:1 %t7274:p};
// %t7275 = $IO_PORT @ATTACH &vss => @PLACE(278, -3478) => @ORIENT("R0");
// %t7275 @TEXT("vss", key="name", size=0.75);
// &vss @WIRE(mode="straight") {#X1379:2 %t7275:p};
// %t7276 = $IO_PORT @ATTACH &n243 => @PLACE(278, -3482) => @ORIENT("R0");
// %t7276 @TEXT("n243", key="name", size=0.75);
// &n243 @WIRE(mode="straight") {#X1379:3 %t7276:p};
// %t7277 = $IO_PORT @ATTACH &n1547 => @PLACE(298, -3478) => @ORIENT("MY");
// %t7277 @TEXT("n1547", key="name", size=0.75);
// &n1547 @WIRE(mode="straight") {#X1379:4 %t7277:p};
// %t7278 = $SUPPLY @ATTACH &vdd => @PLACE(288, -3465);
// &vdd @WIRE(mode="straight") {#X1379:5 %t7278:p};
// %t7279 = $GROUND @ATTACH &vss => @PLACE(288, -3491);
// &vss @WIRE(mode="straight") {#X1379:6 %t7279:p};
// %t7280 = $IO_PORT @ATTACH &n399 => @PLACE(158, -3509) => @ORIENT("R0");
// %t7280 @TEXT("n399", key="name", size=0.75);
// &n399 @WIRE(mode="straight") {#X1380:1 %t7280:p};
// %t7281 = $IO_PORT @ATTACH &vss => @PLACE(158, -3513) => @ORIENT("R0");
// %t7281 @TEXT("vss", key="name", size=0.75);
// &vss @WIRE(mode="straight") {#X1380:2 %t7281:p};
// %t7282 = $IO_PORT @ATTACH &n243 => @PLACE(158, -3517) => @ORIENT("R0");
// %t7282 @TEXT("n243", key="name", size=0.75);
// &n243 @WIRE(mode="straight") {#X1380:3 %t7282:p};
// %t7283 = $IO_PORT @ATTACH &n1548 => @PLACE(178, -3513) => @ORIENT("MY");
// %t7283 @TEXT("n1548", key="name", size=0.75);
// &n1548 @WIRE(mode="straight") {#X1380:4 %t7283:p};
// %t7284 = $SUPPLY @ATTACH &vdd => @PLACE(168, -3500);
// &vdd @WIRE(mode="straight") {#X1380:5 %t7284:p};
// %t7285 = $GROUND @ATTACH &vss => @PLACE(168, -3526);
// &vss @WIRE(mode="straight") {#X1380:6 %t7285:p};
// %t7286 = $IO_PORT @ATTACH &n401 => @PLACE(198, -3509) => @ORIENT("R0");
// %t7286 @TEXT("n401", key="name", size=0.75);
// &n401 @WIRE(mode="straight") {#X1381:1 %t7286:p};
// %t7287 = $IO_PORT @ATTACH &vss => @PLACE(198, -3513) => @ORIENT("R0");
// %t7287 @TEXT("vss", key="name", size=0.75);
// &vss @WIRE(mode="straight") {#X1381:2 %t7287:p};
// %t7288 = $IO_PORT @ATTACH &n243 => @PLACE(198, -3517) => @ORIENT("R0");
// %t7288 @TEXT("n243", key="name", size=0.75);
// &n243 @WIRE(mode="straight") {#X1381:3 %t7288:p};
// %t7289 = $IO_PORT @ATTACH &n1549 => @PLACE(218, -3513) => @ORIENT("MY");
// %t7289 @TEXT("n1549", key="name", size=0.75);
// &n1549 @WIRE(mode="straight") {#X1381:4 %t7289:p};
// %t7290 = $SUPPLY @ATTACH &vdd => @PLACE(208, -3500);
// &vdd @WIRE(mode="straight") {#X1381:5 %t7290:p};
// %t7291 = $GROUND @ATTACH &vss => @PLACE(208, -3526);
// &vss @WIRE(mode="straight") {#X1381:6 %t7291:p};
// %t7292 = $IO_PORT @ATTACH &n1544 => @PLACE(238, -3509) => @ORIENT("R0");
// %t7292 @TEXT("n1544", key="name", size=0.75);
// &n1544 @WIRE(mode="straight") {#X1382:1 %t7292:p};
// %t7293 = $IO_PORT @ATTACH &n1538 => @PLACE(238, -3513) => @ORIENT("R0");
// %t7293 @TEXT("n1538", key="name", size=0.75);
// &n1538 @WIRE(mode="straight") {#X1382:2 %t7293:p};
// %t7294 = $IO_PORT @ATTACH &n351 => @PLACE(238, -3517) => @ORIENT("R0");
// %t7294 @TEXT("n351", key="name", size=0.75);
// &n351 @WIRE(mode="straight") {#X1382:3 %t7294:p};
// %t7295 = $IO_PORT @ATTACH &n1550 => @PLACE(258, -3513) => @ORIENT("MY");
// %t7295 @TEXT("n1550", key="name", size=0.75);
// &n1550 @WIRE(mode="straight") {#X1382:4 %t7295:p};
// %t7296 = $SUPPLY @ATTACH &vdd => @PLACE(248, -3500);
// &vdd @WIRE(mode="straight") {#X1382:5 %t7296:p};
// %t7297 = $GROUND @ATTACH &vss => @PLACE(248, -3526);
// &vss @WIRE(mode="straight") {#X1382:6 %t7297:p};
// %t7298 = $IO_PORT @ATTACH &n1545 => @PLACE(278, -3509) => @ORIENT("R0");
// %t7298 @TEXT("n1545", key="name", size=0.75);
// &n1545 @WIRE(mode="straight") {#X1383:1 %t7298:p};
// %t7299 = $IO_PORT @ATTACH &n1539 => @PLACE(278, -3513) => @ORIENT("R0");
// %t7299 @TEXT("n1539", key="name", size=0.75);
// &n1539 @WIRE(mode="straight") {#X1383:2 %t7299:p};
// %t7300 = $IO_PORT @ATTACH &n351 => @PLACE(278, -3517) => @ORIENT("R0");
// %t7300 @TEXT("n351", key="name", size=0.75);
// &n351 @WIRE(mode="straight") {#X1383:3 %t7300:p};
// %t7301 = $IO_PORT @ATTACH &n1551 => @PLACE(298, -3513) => @ORIENT("MY");
// %t7301 @TEXT("n1551", key="name", size=0.75);
// &n1551 @WIRE(mode="straight") {#X1383:4 %t7301:p};
// %t7302 = $SUPPLY @ATTACH &vdd => @PLACE(288, -3500);
// &vdd @WIRE(mode="straight") {#X1383:5 %t7302:p};
// %t7303 = $GROUND @ATTACH &vss => @PLACE(288, -3526);
// &vss @WIRE(mode="straight") {#X1383:6 %t7303:p};
// %t7304 = $IO_PORT @ATTACH &n1546 => @PLACE(158, -3544) => @ORIENT("R0");
// %t7304 @TEXT("n1546", key="name", size=0.75);
// &n1546 @WIRE(mode="straight") {#X1384:1 %t7304:p};
// %t7305 = $IO_PORT @ATTACH &n1540 => @PLACE(158, -3548) => @ORIENT("R0");
// %t7305 @TEXT("n1540", key="name", size=0.75);
// &n1540 @WIRE(mode="straight") {#X1384:2 %t7305:p};
// %t7306 = $IO_PORT @ATTACH &n351 => @PLACE(158, -3552) => @ORIENT("R0");
// %t7306 @TEXT("n351", key="name", size=0.75);
// &n351 @WIRE(mode="straight") {#X1384:3 %t7306:p};
// %t7307 = $IO_PORT @ATTACH &n1552 => @PLACE(178, -3548) => @ORIENT("MY");
// %t7307 @TEXT("n1552", key="name", size=0.75);
// &n1552 @WIRE(mode="straight") {#X1384:4 %t7307:p};
// %t7308 = $SUPPLY @ATTACH &vdd => @PLACE(168, -3535);
// &vdd @WIRE(mode="straight") {#X1384:5 %t7308:p};
// %t7309 = $GROUND @ATTACH &vss => @PLACE(168, -3561);
// &vss @WIRE(mode="straight") {#X1384:6 %t7309:p};
// %t7310 = $IO_PORT @ATTACH &n1547 => @PLACE(198, -3544) => @ORIENT("R0");
// %t7310 @TEXT("n1547", key="name", size=0.75);
// &n1547 @WIRE(mode="straight") {#X1385:1 %t7310:p};
// %t7311 = $IO_PORT @ATTACH &n1541 => @PLACE(198, -3548) => @ORIENT("R0");
// %t7311 @TEXT("n1541", key="name", size=0.75);
// &n1541 @WIRE(mode="straight") {#X1385:2 %t7311:p};
// %t7312 = $IO_PORT @ATTACH &n351 => @PLACE(198, -3552) => @ORIENT("R0");
// %t7312 @TEXT("n351", key="name", size=0.75);
// &n351 @WIRE(mode="straight") {#X1385:3 %t7312:p};
// %t7313 = $IO_PORT @ATTACH &n1553 => @PLACE(218, -3548) => @ORIENT("MY");
// %t7313 @TEXT("n1553", key="name", size=0.75);
// &n1553 @WIRE(mode="straight") {#X1385:4 %t7313:p};
// %t7314 = $SUPPLY @ATTACH &vdd => @PLACE(208, -3535);
// &vdd @WIRE(mode="straight") {#X1385:5 %t7314:p};
// %t7315 = $GROUND @ATTACH &vss => @PLACE(208, -3561);
// &vss @WIRE(mode="straight") {#X1385:6 %t7315:p};
// %t7316 = $IO_PORT @ATTACH &n1548 => @PLACE(238, -3544) => @ORIENT("R0");
// %t7316 @TEXT("n1548", key="name", size=0.75);
// &n1548 @WIRE(mode="straight") {#X1386:1 %t7316:p};
// %t7317 = $IO_PORT @ATTACH &n1542 => @PLACE(238, -3548) => @ORIENT("R0");
// %t7317 @TEXT("n1542", key="name", size=0.75);
// &n1542 @WIRE(mode="straight") {#X1386:2 %t7317:p};
// %t7318 = $IO_PORT @ATTACH &n351 => @PLACE(238, -3552) => @ORIENT("R0");
// %t7318 @TEXT("n351", key="name", size=0.75);
// &n351 @WIRE(mode="straight") {#X1386:3 %t7318:p};
// %t7319 = $IO_PORT @ATTACH &n1554 => @PLACE(258, -3548) => @ORIENT("MY");
// %t7319 @TEXT("n1554", key="name", size=0.75);
// &n1554 @WIRE(mode="straight") {#X1386:4 %t7319:p};
// %t7320 = $SUPPLY @ATTACH &vdd => @PLACE(248, -3535);
// &vdd @WIRE(mode="straight") {#X1386:5 %t7320:p};
// %t7321 = $GROUND @ATTACH &vss => @PLACE(248, -3561);
// &vss @WIRE(mode="straight") {#X1386:6 %t7321:p};
// %t7322 = $IO_PORT @ATTACH &n1549 => @PLACE(278, -3544) => @ORIENT("R0");
// %t7322 @TEXT("n1549", key="name", size=0.75);
// &n1549 @WIRE(mode="straight") {#X1387:1 %t7322:p};
// %t7323 = $IO_PORT @ATTACH &n1543 => @PLACE(278, -3548) => @ORIENT("R0");
// %t7323 @TEXT("n1543", key="name", size=0.75);
// &n1543 @WIRE(mode="straight") {#X1387:2 %t7323:p};
// %t7324 = $IO_PORT @ATTACH &n351 => @PLACE(278, -3552) => @ORIENT("R0");
// %t7324 @TEXT("n351", key="name", size=0.75);
// &n351 @WIRE(mode="straight") {#X1387:3 %t7324:p};
// %t7325 = $IO_PORT @ATTACH &n1555 => @PLACE(298, -3548) => @ORIENT("MY");
// %t7325 @TEXT("n1555", key="name", size=0.75);
// &n1555 @WIRE(mode="straight") {#X1387:4 %t7325:p};
// %t7326 = $SUPPLY @ATTACH &vdd => @PLACE(288, -3535);
// &vdd @WIRE(mode="straight") {#X1387:5 %t7326:p};
// %t7327 = $GROUND @ATTACH &vss => @PLACE(288, -3561);
// &vss @WIRE(mode="straight") {#X1387:6 %t7327:p};
// %t7328 = $IO_PORT @ATTACH &n1550 => @PLACE(158, -3579) => @ORIENT("R0");
// %t7328 @TEXT("n1550", key="name", size=0.75);
// &n1550 @WIRE(mode="straight") {#X1388:1 %t7328:p};
// %t7329 = $IO_PORT @ATTACH &vss => @PLACE(158, -3583) => @ORIENT("R0");
// %t7329 @TEXT("vss", key="name", size=0.75);
// &vss @WIRE(mode="straight") {#X1388:2 %t7329:p};
// %t7330 = $IO_PORT @ATTACH &n236 => @PLACE(158, -3587) => @ORIENT("R0");
// %t7330 @TEXT("n236", key="name", size=0.75);
// &n236 @WIRE(mode="straight") {#X1388:3 %t7330:p};
// %t7331 = $IO_PORT @ATTACH &n1556 => @PLACE(178, -3583) => @ORIENT("MY");
// %t7331 @TEXT("n1556", key="name", size=0.75);
// &n1556 @WIRE(mode="straight") {#X1388:4 %t7331:p};
// %t7332 = $SUPPLY @ATTACH &vdd => @PLACE(168, -3570);
// &vdd @WIRE(mode="straight") {#X1388:5 %t7332:p};
// %t7333 = $GROUND @ATTACH &vss => @PLACE(168, -3596);
// &vss @WIRE(mode="straight") {#X1388:6 %t7333:p};
// %t7334 = $IO_PORT @ATTACH &n1551 => @PLACE(198, -3579) => @ORIENT("R0");
// %t7334 @TEXT("n1551", key="name", size=0.75);
// &n1551 @WIRE(mode="straight") {#X1389:1 %t7334:p};
// %t7335 = $IO_PORT @ATTACH &vss => @PLACE(198, -3583) => @ORIENT("R0");
// %t7335 @TEXT("vss", key="name", size=0.75);
// &vss @WIRE(mode="straight") {#X1389:2 %t7335:p};
// %t7336 = $IO_PORT @ATTACH &n236 => @PLACE(198, -3587) => @ORIENT("R0");
// %t7336 @TEXT("n236", key="name", size=0.75);
// &n236 @WIRE(mode="straight") {#X1389:3 %t7336:p};
// %t7337 = $IO_PORT @ATTACH &n1557 => @PLACE(218, -3583) => @ORIENT("MY");
// %t7337 @TEXT("n1557", key="name", size=0.75);
// &n1557 @WIRE(mode="straight") {#X1389:4 %t7337:p};
// %t7338 = $SUPPLY @ATTACH &vdd => @PLACE(208, -3570);
// &vdd @WIRE(mode="straight") {#X1389:5 %t7338:p};
// %t7339 = $GROUND @ATTACH &vss => @PLACE(208, -3596);
// &vss @WIRE(mode="straight") {#X1389:6 %t7339:p};
// %t7340 = $IO_PORT @ATTACH &n1552 => @PLACE(238, -3579) => @ORIENT("R0");
// %t7340 @TEXT("n1552", key="name", size=0.75);
// &n1552 @WIRE(mode="straight") {#X1390:1 %t7340:p};
// %t7341 = $IO_PORT @ATTACH &vss => @PLACE(238, -3583) => @ORIENT("R0");
// %t7341 @TEXT("vss", key="name", size=0.75);
// &vss @WIRE(mode="straight") {#X1390:2 %t7341:p};
// %t7342 = $IO_PORT @ATTACH &n236 => @PLACE(238, -3587) => @ORIENT("R0");
// %t7342 @TEXT("n236", key="name", size=0.75);
// &n236 @WIRE(mode="straight") {#X1390:3 %t7342:p};
// %t7343 = $IO_PORT @ATTACH &n1558 => @PLACE(258, -3583) => @ORIENT("MY");
// %t7343 @TEXT("n1558", key="name", size=0.75);
// &n1558 @WIRE(mode="straight") {#X1390:4 %t7343:p};
// %t7344 = $SUPPLY @ATTACH &vdd => @PLACE(248, -3570);
// &vdd @WIRE(mode="straight") {#X1390:5 %t7344:p};
// %t7345 = $GROUND @ATTACH &vss => @PLACE(248, -3596);
// &vss @WIRE(mode="straight") {#X1390:6 %t7345:p};
// %t7346 = $IO_PORT @ATTACH &n1553 => @PLACE(278, -3579) => @ORIENT("R0");
// %t7346 @TEXT("n1553", key="name", size=0.75);
// &n1553 @WIRE(mode="straight") {#X1391:1 %t7346:p};
// %t7347 = $IO_PORT @ATTACH &vss => @PLACE(278, -3583) => @ORIENT("R0");
// %t7347 @TEXT("vss", key="name", size=0.75);
// &vss @WIRE(mode="straight") {#X1391:2 %t7347:p};
// %t7348 = $IO_PORT @ATTACH &n236 => @PLACE(278, -3587) => @ORIENT("R0");
// %t7348 @TEXT("n236", key="name", size=0.75);
// &n236 @WIRE(mode="straight") {#X1391:3 %t7348:p};
// %t7349 = $IO_PORT @ATTACH &n1559 => @PLACE(298, -3583) => @ORIENT("MY");
// %t7349 @TEXT("n1559", key="name", size=0.75);
// &n1559 @WIRE(mode="straight") {#X1391:4 %t7349:p};
// %t7350 = $SUPPLY @ATTACH &vdd => @PLACE(288, -3570);
// &vdd @WIRE(mode="straight") {#X1391:5 %t7350:p};
// %t7351 = $GROUND @ATTACH &vss => @PLACE(288, -3596);
// &vss @WIRE(mode="straight") {#X1391:6 %t7351:p};
// %t7352 = $IO_PORT @ATTACH &n1554 => @PLACE(326, -3404) => @ORIENT("R0");
// %t7352 @TEXT("n1554", key="name", size=0.75);
// &n1554 @WIRE(mode="straight") {#X1392:1 %t7352:p};
// %t7353 = $IO_PORT @ATTACH &vss => @PLACE(326, -3408) => @ORIENT("R0");
// %t7353 @TEXT("vss", key="name", size=0.75);
// &vss @WIRE(mode="straight") {#X1392:2 %t7353:p};
// %t7354 = $IO_PORT @ATTACH &n236 => @PLACE(326, -3412) => @ORIENT("R0");
// %t7354 @TEXT("n236", key="name", size=0.75);
// &n236 @WIRE(mode="straight") {#X1392:3 %t7354:p};
// %t7355 = $IO_PORT @ATTACH &n1560 => @PLACE(346, -3408) => @ORIENT("MY");
// %t7355 @TEXT("n1560", key="name", size=0.75);
// &n1560 @WIRE(mode="straight") {#X1392:4 %t7355:p};
// %t7356 = $SUPPLY @ATTACH &vdd => @PLACE(336, -3395);
// &vdd @WIRE(mode="straight") {#X1392:5 %t7356:p};
// %t7357 = $GROUND @ATTACH &vss => @PLACE(336, -3421);
// &vss @WIRE(mode="straight") {#X1392:6 %t7357:p};
// %t7358 = $IO_PORT @ATTACH &n1555 => @PLACE(366, -3404) => @ORIENT("R0");
// %t7358 @TEXT("n1555", key="name", size=0.75);
// &n1555 @WIRE(mode="straight") {#X1393:1 %t7358:p};
// %t7359 = $IO_PORT @ATTACH &vss => @PLACE(366, -3408) => @ORIENT("R0");
// %t7359 @TEXT("vss", key="name", size=0.75);
// &vss @WIRE(mode="straight") {#X1393:2 %t7359:p};
// %t7360 = $IO_PORT @ATTACH &n236 => @PLACE(366, -3412) => @ORIENT("R0");
// %t7360 @TEXT("n236", key="name", size=0.75);
// &n236 @WIRE(mode="straight") {#X1393:3 %t7360:p};
// %t7361 = $IO_PORT @ATTACH &n1561 => @PLACE(386, -3408) => @ORIENT("MY");
// %t7361 @TEXT("n1561", key="name", size=0.75);
// &n1561 @WIRE(mode="straight") {#X1393:4 %t7361:p};
// %t7362 = $SUPPLY @ATTACH &vdd => @PLACE(376, -3395);
// &vdd @WIRE(mode="straight") {#X1393:5 %t7362:p};
// %t7363 = $GROUND @ATTACH &vss => @PLACE(376, -3421);
// &vss @WIRE(mode="straight") {#X1393:6 %t7363:p};
// %t7364 = $IO_PORT @ATTACH &vss => @PLACE(406, -3404) => @ORIENT("R0");
// %t7364 @TEXT("vss", key="name", size=0.75);
// &vss @WIRE(mode="straight") {#X1394:1 %t7364:p};
// %t7365 = $IO_PORT @ATTACH &n1556 => @PLACE(406, -3408) => @ORIENT("R0");
// %t7365 @TEXT("n1556", key="name", size=0.75);
// &n1556 @WIRE(mode="straight") {#X1394:2 %t7365:p};
// %t7366 = $IO_PORT @ATTACH &n960 => @PLACE(406, -3412) => @ORIENT("R0");
// %t7366 @TEXT("n960", key="name", size=0.75);
// &n960 @WIRE(mode="straight") {#X1394:3 %t7366:p};
// %t7367 = $IO_PORT @ATTACH &n1562 => @PLACE(426, -3408) => @ORIENT("MY");
// %t7367 @TEXT("n1562", key="name", size=0.75);
// &n1562 @WIRE(mode="straight") {#X1394:4 %t7367:p};
// %t7368 = $SUPPLY @ATTACH &vdd => @PLACE(416, -3395);
// &vdd @WIRE(mode="straight") {#X1394:5 %t7368:p};
// %t7369 = $GROUND @ATTACH &vss => @PLACE(416, -3421);
// &vss @WIRE(mode="straight") {#X1394:6 %t7369:p};
// %t7370 = $IO_PORT @ATTACH &vss => @PLACE(446, -3404) => @ORIENT("R0");
// %t7370 @TEXT("vss", key="name", size=0.75);
// &vss @WIRE(mode="straight") {#X1395:1 %t7370:p};
// %t7371 = $IO_PORT @ATTACH &n1557 => @PLACE(446, -3408) => @ORIENT("R0");
// %t7371 @TEXT("n1557", key="name", size=0.75);
// &n1557 @WIRE(mode="straight") {#X1395:2 %t7371:p};
// %t7372 = $IO_PORT @ATTACH &n960 => @PLACE(446, -3412) => @ORIENT("R0");
// %t7372 @TEXT("n960", key="name", size=0.75);
// &n960 @WIRE(mode="straight") {#X1395:3 %t7372:p};
// %t7373 = $IO_PORT @ATTACH &n1563 => @PLACE(466, -3408) => @ORIENT("MY");
// %t7373 @TEXT("n1563", key="name", size=0.75);
// &n1563 @WIRE(mode="straight") {#X1395:4 %t7373:p};
// %t7374 = $SUPPLY @ATTACH &vdd => @PLACE(456, -3395);
// &vdd @WIRE(mode="straight") {#X1395:5 %t7374:p};
// %t7375 = $GROUND @ATTACH &vss => @PLACE(456, -3421);
// &vss @WIRE(mode="straight") {#X1395:6 %t7375:p};
// %t7376 = $IO_PORT @ATTACH &vss => @PLACE(326, -3439) => @ORIENT("R0");
// %t7376 @TEXT("vss", key="name", size=0.75);
// &vss @WIRE(mode="straight") {#X1396:1 %t7376:p};
// %t7377 = $IO_PORT @ATTACH &n1558 => @PLACE(326, -3443) => @ORIENT("R0");
// %t7377 @TEXT("n1558", key="name", size=0.75);
// &n1558 @WIRE(mode="straight") {#X1396:2 %t7377:p};
// %t7378 = $IO_PORT @ATTACH &n960 => @PLACE(326, -3447) => @ORIENT("R0");
// %t7378 @TEXT("n960", key="name", size=0.75);
// &n960 @WIRE(mode="straight") {#X1396:3 %t7378:p};
// %t7379 = $IO_PORT @ATTACH &n1564 => @PLACE(346, -3443) => @ORIENT("MY");
// %t7379 @TEXT("n1564", key="name", size=0.75);
// &n1564 @WIRE(mode="straight") {#X1396:4 %t7379:p};
// %t7380 = $SUPPLY @ATTACH &vdd => @PLACE(336, -3430);
// &vdd @WIRE(mode="straight") {#X1396:5 %t7380:p};
// %t7381 = $GROUND @ATTACH &vss => @PLACE(336, -3456);
// &vss @WIRE(mode="straight") {#X1396:6 %t7381:p};
// %t7382 = $IO_PORT @ATTACH &vss => @PLACE(366, -3439) => @ORIENT("R0");
// %t7382 @TEXT("vss", key="name", size=0.75);
// &vss @WIRE(mode="straight") {#X1397:1 %t7382:p};
// %t7383 = $IO_PORT @ATTACH &n1559 => @PLACE(366, -3443) => @ORIENT("R0");
// %t7383 @TEXT("n1559", key="name", size=0.75);
// &n1559 @WIRE(mode="straight") {#X1397:2 %t7383:p};
// %t7384 = $IO_PORT @ATTACH &n960 => @PLACE(366, -3447) => @ORIENT("R0");
// %t7384 @TEXT("n960", key="name", size=0.75);
// &n960 @WIRE(mode="straight") {#X1397:3 %t7384:p};
// %t7385 = $IO_PORT @ATTACH &n1565 => @PLACE(386, -3443) => @ORIENT("MY");
// %t7385 @TEXT("n1565", key="name", size=0.75);
// &n1565 @WIRE(mode="straight") {#X1397:4 %t7385:p};
// %t7386 = $SUPPLY @ATTACH &vdd => @PLACE(376, -3430);
// &vdd @WIRE(mode="straight") {#X1397:5 %t7386:p};
// %t7387 = $GROUND @ATTACH &vss => @PLACE(376, -3456);
// &vss @WIRE(mode="straight") {#X1397:6 %t7387:p};
// %t7388 = $IO_PORT @ATTACH &vss => @PLACE(406, -3439) => @ORIENT("R0");
// %t7388 @TEXT("vss", key="name", size=0.75);
// &vss @WIRE(mode="straight") {#X1398:1 %t7388:p};
// %t7389 = $IO_PORT @ATTACH &n1560 => @PLACE(406, -3443) => @ORIENT("R0");
// %t7389 @TEXT("n1560", key="name", size=0.75);
// &n1560 @WIRE(mode="straight") {#X1398:2 %t7389:p};
// %t7390 = $IO_PORT @ATTACH &n960 => @PLACE(406, -3447) => @ORIENT("R0");
// %t7390 @TEXT("n960", key="name", size=0.75);
// &n960 @WIRE(mode="straight") {#X1398:3 %t7390:p};
// %t7391 = $IO_PORT @ATTACH &n1566 => @PLACE(426, -3443) => @ORIENT("MY");
// %t7391 @TEXT("n1566", key="name", size=0.75);
// &n1566 @WIRE(mode="straight") {#X1398:4 %t7391:p};
// %t7392 = $SUPPLY @ATTACH &vdd => @PLACE(416, -3430);
// &vdd @WIRE(mode="straight") {#X1398:5 %t7392:p};
// %t7393 = $GROUND @ATTACH &vss => @PLACE(416, -3456);
// &vss @WIRE(mode="straight") {#X1398:6 %t7393:p};
// %t7394 = $IO_PORT @ATTACH &vss => @PLACE(446, -3439) => @ORIENT("R0");
// %t7394 @TEXT("vss", key="name", size=0.75);
// &vss @WIRE(mode="straight") {#X1399:1 %t7394:p};
// %t7395 = $IO_PORT @ATTACH &n1561 => @PLACE(446, -3443) => @ORIENT("R0");
// %t7395 @TEXT("n1561", key="name", size=0.75);
// &n1561 @WIRE(mode="straight") {#X1399:2 %t7395:p};
// %t7396 = $IO_PORT @ATTACH &n960 => @PLACE(446, -3447) => @ORIENT("R0");
// %t7396 @TEXT("n960", key="name", size=0.75);
// &n960 @WIRE(mode="straight") {#X1399:3 %t7396:p};
// %t7397 = $IO_PORT @ATTACH &n1567 => @PLACE(466, -3443) => @ORIENT("MY");
// %t7397 @TEXT("n1567", key="name", size=0.75);
// &n1567 @WIRE(mode="straight") {#X1399:4 %t7397:p};
// %t7398 = $SUPPLY @ATTACH &vdd => @PLACE(456, -3430);
// &vdd @WIRE(mode="straight") {#X1399:5 %t7398:p};
// %t7399 = $GROUND @ATTACH &vss => @PLACE(456, -3456);
// &vss @WIRE(mode="straight") {#X1399:6 %t7399:p};
// %t7400 = $IO_PORT @ATTACH &n1562 => @PLACE(326, -3474) => @ORIENT("R0");
// %t7400 @TEXT("n1562", key="name", size=0.75);
// &n1562 @WIRE(mode="straight") {#X1400:1 %t7400:p};
// %t7401 = $IO_PORT @ATTACH &vss => @PLACE(326, -3478) => @ORIENT("R0");
// %t7401 @TEXT("vss", key="name", size=0.75);
// &vss @WIRE(mode="straight") {#X1400:2 %t7401:p};
// %t7402 = $IO_PORT @ATTACH &n234 => @PLACE(326, -3482) => @ORIENT("R0");
// %t7402 @TEXT("n234", key="name", size=0.75);
// &n234 @WIRE(mode="straight") {#X1400:3 %t7402:p};
// %t7403 = $IO_PORT @ATTACH &n1568 => @PLACE(346, -3478) => @ORIENT("MY");
// %t7403 @TEXT("n1568", key="name", size=0.75);
// &n1568 @WIRE(mode="straight") {#X1400:4 %t7403:p};
// %t7404 = $SUPPLY @ATTACH &vdd => @PLACE(336, -3465);
// &vdd @WIRE(mode="straight") {#X1400:5 %t7404:p};
// %t7405 = $GROUND @ATTACH &vss => @PLACE(336, -3491);
// &vss @WIRE(mode="straight") {#X1400:6 %t7405:p};
// %t7406 = $IO_PORT @ATTACH &n1563 => @PLACE(366, -3474) => @ORIENT("R0");
// %t7406 @TEXT("n1563", key="name", size=0.75);
// &n1563 @WIRE(mode="straight") {#X1401:1 %t7406:p};
// %t7407 = $IO_PORT @ATTACH &vss => @PLACE(366, -3478) => @ORIENT("R0");
// %t7407 @TEXT("vss", key="name", size=0.75);
// &vss @WIRE(mode="straight") {#X1401:2 %t7407:p};
// %t7408 = $IO_PORT @ATTACH &n234 => @PLACE(366, -3482) => @ORIENT("R0");
// %t7408 @TEXT("n234", key="name", size=0.75);
// &n234 @WIRE(mode="straight") {#X1401:3 %t7408:p};
// %t7409 = $IO_PORT @ATTACH &n1569 => @PLACE(386, -3478) => @ORIENT("MY");
// %t7409 @TEXT("n1569", key="name", size=0.75);
// &n1569 @WIRE(mode="straight") {#X1401:4 %t7409:p};
// %t7410 = $SUPPLY @ATTACH &vdd => @PLACE(376, -3465);
// &vdd @WIRE(mode="straight") {#X1401:5 %t7410:p};
// %t7411 = $GROUND @ATTACH &vss => @PLACE(376, -3491);
// &vss @WIRE(mode="straight") {#X1401:6 %t7411:p};
// %t7412 = $IO_PORT @ATTACH &n1564 => @PLACE(406, -3474) => @ORIENT("R0");
// %t7412 @TEXT("n1564", key="name", size=0.75);
// &n1564 @WIRE(mode="straight") {#X1402:1 %t7412:p};
// %t7413 = $IO_PORT @ATTACH &vss => @PLACE(406, -3478) => @ORIENT("R0");
// %t7413 @TEXT("vss", key="name", size=0.75);
// &vss @WIRE(mode="straight") {#X1402:2 %t7413:p};
// %t7414 = $IO_PORT @ATTACH &n234 => @PLACE(406, -3482) => @ORIENT("R0");
// %t7414 @TEXT("n234", key="name", size=0.75);
// &n234 @WIRE(mode="straight") {#X1402:3 %t7414:p};
// %t7415 = $IO_PORT @ATTACH &n1570 => @PLACE(426, -3478) => @ORIENT("MY");
// %t7415 @TEXT("n1570", key="name", size=0.75);
// &n1570 @WIRE(mode="straight") {#X1402:4 %t7415:p};
// %t7416 = $SUPPLY @ATTACH &vdd => @PLACE(416, -3465);
// &vdd @WIRE(mode="straight") {#X1402:5 %t7416:p};
// %t7417 = $GROUND @ATTACH &vss => @PLACE(416, -3491);
// &vss @WIRE(mode="straight") {#X1402:6 %t7417:p};
// %t7418 = $IO_PORT @ATTACH &n1565 => @PLACE(446, -3474) => @ORIENT("R0");
// %t7418 @TEXT("n1565", key="name", size=0.75);
// &n1565 @WIRE(mode="straight") {#X1403:1 %t7418:p};
// %t7419 = $IO_PORT @ATTACH &vss => @PLACE(446, -3478) => @ORIENT("R0");
// %t7419 @TEXT("vss", key="name", size=0.75);
// &vss @WIRE(mode="straight") {#X1403:2 %t7419:p};
// %t7420 = $IO_PORT @ATTACH &n234 => @PLACE(446, -3482) => @ORIENT("R0");
// %t7420 @TEXT("n234", key="name", size=0.75);
// &n234 @WIRE(mode="straight") {#X1403:3 %t7420:p};
// %t7421 = $IO_PORT @ATTACH &n1571 => @PLACE(466, -3478) => @ORIENT("MY");
// %t7421 @TEXT("n1571", key="name", size=0.75);
// &n1571 @WIRE(mode="straight") {#X1403:4 %t7421:p};
// %t7422 = $SUPPLY @ATTACH &vdd => @PLACE(456, -3465);
// &vdd @WIRE(mode="straight") {#X1403:5 %t7422:p};
// %t7423 = $GROUND @ATTACH &vss => @PLACE(456, -3491);
// &vss @WIRE(mode="straight") {#X1403:6 %t7423:p};
// %t7424 = $IO_PORT @ATTACH &n1566 => @PLACE(326, -3509) => @ORIENT("R0");
// %t7424 @TEXT("n1566", key="name", size=0.75);
// &n1566 @WIRE(mode="straight") {#X1404:1 %t7424:p};
// %t7425 = $IO_PORT @ATTACH &vss => @PLACE(326, -3513) => @ORIENT("R0");
// %t7425 @TEXT("vss", key="name", size=0.75);
// &vss @WIRE(mode="straight") {#X1404:2 %t7425:p};
// %t7426 = $IO_PORT @ATTACH &n234 => @PLACE(326, -3517) => @ORIENT("R0");
// %t7426 @TEXT("n234", key="name", size=0.75);
// &n234 @WIRE(mode="straight") {#X1404:3 %t7426:p};
// %t7427 = $IO_PORT @ATTACH &n1572 => @PLACE(346, -3513) => @ORIENT("MY");
// %t7427 @TEXT("n1572", key="name", size=0.75);
// &n1572 @WIRE(mode="straight") {#X1404:4 %t7427:p};
// %t7428 = $SUPPLY @ATTACH &vdd => @PLACE(336, -3500);
// &vdd @WIRE(mode="straight") {#X1404:5 %t7428:p};
// %t7429 = $GROUND @ATTACH &vss => @PLACE(336, -3526);
// &vss @WIRE(mode="straight") {#X1404:6 %t7429:p};
// %t7430 = $IO_PORT @ATTACH &n1567 => @PLACE(366, -3509) => @ORIENT("R0");
// %t7430 @TEXT("n1567", key="name", size=0.75);
// &n1567 @WIRE(mode="straight") {#X1405:1 %t7430:p};
// %t7431 = $IO_PORT @ATTACH &vss => @PLACE(366, -3513) => @ORIENT("R0");
// %t7431 @TEXT("vss", key="name", size=0.75);
// &vss @WIRE(mode="straight") {#X1405:2 %t7431:p};
// %t7432 = $IO_PORT @ATTACH &n234 => @PLACE(366, -3517) => @ORIENT("R0");
// %t7432 @TEXT("n234", key="name", size=0.75);
// &n234 @WIRE(mode="straight") {#X1405:3 %t7432:p};
// %t7433 = $IO_PORT @ATTACH &n1573 => @PLACE(386, -3513) => @ORIENT("MY");
// %t7433 @TEXT("n1573", key="name", size=0.75);
// &n1573 @WIRE(mode="straight") {#X1405:4 %t7433:p};
// %t7434 = $SUPPLY @ATTACH &vdd => @PLACE(376, -3500);
// &vdd @WIRE(mode="straight") {#X1405:5 %t7434:p};
// %t7435 = $GROUND @ATTACH &vss => @PLACE(376, -3526);
// &vss @WIRE(mode="straight") {#X1405:6 %t7435:p};
// %t7436 = $IO_PORT @ATTACH &vss => @PLACE(406, -3509) => @ORIENT("R0");
// %t7436 @TEXT("vss", key="name", size=0.75);
// &vss @WIRE(mode="straight") {#X1406:1 %t7436:p};
// %t7437 = $IO_PORT @ATTACH &vss => @PLACE(406, -3513) => @ORIENT("R0");
// %t7437 @TEXT("vss", key="name", size=0.75);
// &vss @WIRE(mode="straight") {#X1406:2 %t7437:p};
// %t7438 = $IO_PORT @ATTACH &n232 => @PLACE(406, -3517) => @ORIENT("R0");
// %t7438 @TEXT("n232", key="name", size=0.75);
// &n232 @WIRE(mode="straight") {#X1406:3 %t7438:p};
// %t7439 = $IO_PORT @ATTACH &n1368 => @PLACE(426, -3513) => @ORIENT("MY");
// %t7439 @TEXT("n1368", key="name", size=0.75);
// &n1368 @WIRE(mode="straight") {#X1406:4 %t7439:p};
// %t7440 = $SUPPLY @ATTACH &vdd => @PLACE(416, -3500);
// &vdd @WIRE(mode="straight") {#X1406:5 %t7440:p};
// %t7441 = $GROUND @ATTACH &vss => @PLACE(416, -3526);
// &vss @WIRE(mode="straight") {#X1406:6 %t7441:p};
// %t7442 = $IO_PORT @ATTACH &n1568 => @PLACE(446, -3509) => @ORIENT("R0");
// %t7442 @TEXT("n1568", key="name", size=0.75);
// &n1568 @WIRE(mode="straight") {#X1407:1 %t7442:p};
// %t7443 = $IO_PORT @ATTACH &n1368 => @PLACE(446, -3513) => @ORIENT("R0");
// %t7443 @TEXT("n1368", key="name", size=0.75);
// &n1368 @WIRE(mode="straight") {#X1407:2 %t7443:p};
// %t7444 = $IO_PORT @ATTACH &n238 => @PLACE(446, -3517) => @ORIENT("R0");
// %t7444 @TEXT("n238", key="name", size=0.75);
// &n238 @WIRE(mode="straight") {#X1407:3 %t7444:p};
// %t7445 = $IO_PORT @ATTACH &n1574 => @PLACE(466, -3513) => @ORIENT("MY");
// %t7445 @TEXT("n1574", key="name", size=0.75);
// &n1574 @WIRE(mode="straight") {#X1407:4 %t7445:p};
// %t7446 = $SUPPLY @ATTACH &vdd => @PLACE(456, -3500);
// &vdd @WIRE(mode="straight") {#X1407:5 %t7446:p};
// %t7447 = $GROUND @ATTACH &vss => @PLACE(456, -3526);
// &vss @WIRE(mode="straight") {#X1407:6 %t7447:p};
// %t7448 = $IO_PORT @ATTACH &n1569 => @PLACE(326, -3544) => @ORIENT("R0");
// %t7448 @TEXT("n1569", key="name", size=0.75);
// &n1569 @WIRE(mode="straight") {#X1408:1 %t7448:p};
// %t7449 = $IO_PORT @ATTACH &n1368 => @PLACE(326, -3548) => @ORIENT("R0");
// %t7449 @TEXT("n1368", key="name", size=0.75);
// &n1368 @WIRE(mode="straight") {#X1408:2 %t7449:p};
// %t7450 = $IO_PORT @ATTACH &n238 => @PLACE(326, -3552) => @ORIENT("R0");
// %t7450 @TEXT("n238", key="name", size=0.75);
// &n238 @WIRE(mode="straight") {#X1408:3 %t7450:p};
// %t7451 = $IO_PORT @ATTACH &n1575 => @PLACE(346, -3548) => @ORIENT("MY");
// %t7451 @TEXT("n1575", key="name", size=0.75);
// &n1575 @WIRE(mode="straight") {#X1408:4 %t7451:p};
// %t7452 = $SUPPLY @ATTACH &vdd => @PLACE(336, -3535);
// &vdd @WIRE(mode="straight") {#X1408:5 %t7452:p};
// %t7453 = $GROUND @ATTACH &vss => @PLACE(336, -3561);
// &vss @WIRE(mode="straight") {#X1408:6 %t7453:p};
// %t7454 = $IO_PORT @ATTACH &n1570 => @PLACE(366, -3544) => @ORIENT("R0");
// %t7454 @TEXT("n1570", key="name", size=0.75);
// &n1570 @WIRE(mode="straight") {#X1409:1 %t7454:p};
// %t7455 = $IO_PORT @ATTACH &n1368 => @PLACE(366, -3548) => @ORIENT("R0");
// %t7455 @TEXT("n1368", key="name", size=0.75);
// &n1368 @WIRE(mode="straight") {#X1409:2 %t7455:p};
// %t7456 = $IO_PORT @ATTACH &n238 => @PLACE(366, -3552) => @ORIENT("R0");
// %t7456 @TEXT("n238", key="name", size=0.75);
// &n238 @WIRE(mode="straight") {#X1409:3 %t7456:p};
// %t7457 = $IO_PORT @ATTACH &n1576 => @PLACE(386, -3548) => @ORIENT("MY");
// %t7457 @TEXT("n1576", key="name", size=0.75);
// &n1576 @WIRE(mode="straight") {#X1409:4 %t7457:p};
// %t7458 = $SUPPLY @ATTACH &vdd => @PLACE(376, -3535);
// &vdd @WIRE(mode="straight") {#X1409:5 %t7458:p};
// %t7459 = $GROUND @ATTACH &vss => @PLACE(376, -3561);
// &vss @WIRE(mode="straight") {#X1409:6 %t7459:p};
// %t7460 = $IO_PORT @ATTACH &n1571 => @PLACE(406, -3544) => @ORIENT("R0");
// %t7460 @TEXT("n1571", key="name", size=0.75);
// &n1571 @WIRE(mode="straight") {#X1410:1 %t7460:p};
// %t7461 = $IO_PORT @ATTACH &n1368 => @PLACE(406, -3548) => @ORIENT("R0");
// %t7461 @TEXT("n1368", key="name", size=0.75);
// &n1368 @WIRE(mode="straight") {#X1410:2 %t7461:p};
// %t7462 = $IO_PORT @ATTACH &n238 => @PLACE(406, -3552) => @ORIENT("R0");
// %t7462 @TEXT("n238", key="name", size=0.75);
// &n238 @WIRE(mode="straight") {#X1410:3 %t7462:p};
// %t7463 = $IO_PORT @ATTACH &n1577 => @PLACE(426, -3548) => @ORIENT("MY");
// %t7463 @TEXT("n1577", key="name", size=0.75);
// &n1577 @WIRE(mode="straight") {#X1410:4 %t7463:p};
// %t7464 = $SUPPLY @ATTACH &vdd => @PLACE(416, -3535);
// &vdd @WIRE(mode="straight") {#X1410:5 %t7464:p};
// %t7465 = $GROUND @ATTACH &vss => @PLACE(416, -3561);
// &vss @WIRE(mode="straight") {#X1410:6 %t7465:p};
// %t7466 = $IO_PORT @ATTACH &n1572 => @PLACE(446, -3544) => @ORIENT("R0");
// %t7466 @TEXT("n1572", key="name", size=0.75);
// &n1572 @WIRE(mode="straight") {#X1411:1 %t7466:p};
// %t7467 = $IO_PORT @ATTACH &n1368 => @PLACE(446, -3548) => @ORIENT("R0");
// %t7467 @TEXT("n1368", key="name", size=0.75);
// &n1368 @WIRE(mode="straight") {#X1411:2 %t7467:p};
// %t7468 = $IO_PORT @ATTACH &n238 => @PLACE(446, -3552) => @ORIENT("R0");
// %t7468 @TEXT("n238", key="name", size=0.75);
// &n238 @WIRE(mode="straight") {#X1411:3 %t7468:p};
// %t7469 = $IO_PORT @ATTACH &n1578 => @PLACE(466, -3548) => @ORIENT("MY");
// %t7469 @TEXT("n1578", key="name", size=0.75);
// &n1578 @WIRE(mode="straight") {#X1411:4 %t7469:p};
// %t7470 = $SUPPLY @ATTACH &vdd => @PLACE(456, -3535);
// &vdd @WIRE(mode="straight") {#X1411:5 %t7470:p};
// %t7471 = $GROUND @ATTACH &vss => @PLACE(456, -3561);
// &vss @WIRE(mode="straight") {#X1411:6 %t7471:p};
// %t7472 = $IO_PORT @ATTACH &n1573 => @PLACE(326, -3579) => @ORIENT("R0");
// %t7472 @TEXT("n1573", key="name", size=0.75);
// &n1573 @WIRE(mode="straight") {#X1412:1 %t7472:p};
// %t7473 = $IO_PORT @ATTACH &n1366 => @PLACE(326, -3583) => @ORIENT("R0");
// %t7473 @TEXT("n1366", key="name", size=0.75);
// &n1366 @WIRE(mode="straight") {#X1412:2 %t7473:p};
// %t7474 = $IO_PORT @ATTACH &n238 => @PLACE(326, -3587) => @ORIENT("R0");
// %t7474 @TEXT("n238", key="name", size=0.75);
// &n238 @WIRE(mode="straight") {#X1412:3 %t7474:p};
// %t7475 = $IO_PORT @ATTACH &n1579 => @PLACE(346, -3583) => @ORIENT("MY");
// %t7475 @TEXT("n1579", key="name", size=0.75);
// &n1579 @WIRE(mode="straight") {#X1412:4 %t7475:p};
// %t7476 = $SUPPLY @ATTACH &vdd => @PLACE(336, -3570);
// &vdd @WIRE(mode="straight") {#X1412:5 %t7476:p};
// %t7477 = $GROUND @ATTACH &vss => @PLACE(336, -3596);
// &vss @WIRE(mode="straight") {#X1412:6 %t7477:p};
// %t7478 = $IO_PORT @ATTACH &n1532 => @PLACE(366, -3579) => @ORIENT("R0");
// %t7478 @TEXT("n1532", key="name", size=0.75);
// &n1532 @WIRE(mode="straight") {#X1413:1 %t7478:p};
// %t7479 = $IO_PORT @ATTACH &n1574 => @PLACE(366, -3583) => @ORIENT("R0");
// %t7479 @TEXT("n1574", key="name", size=0.75);
// &n1574 @WIRE(mode="straight") {#X1413:2 %t7479:p};
// %t7480 = $IO_PORT @ATTACH &n88 => @PLACE(366, -3587) => @ORIENT("R0");
// %t7480 @TEXT("n88", key="name", size=0.75);
// &n88 @WIRE(mode="straight") {#X1413:3 %t7480:p};
// %t7481 = $IO_PORT @ATTACH &n1580 => @PLACE(386, -3583) => @ORIENT("MY");
// %t7481 @TEXT("n1580", key="name", size=0.75);
// &n1580 @WIRE(mode="straight") {#X1413:4 %t7481:p};
// %t7482 = $SUPPLY @ATTACH &vdd => @PLACE(376, -3570);
// &vdd @WIRE(mode="straight") {#X1413:5 %t7482:p};
// %t7483 = $GROUND @ATTACH &vss => @PLACE(376, -3596);
// &vss @WIRE(mode="straight") {#X1413:6 %t7483:p};
// %t7484 = $IO_PORT @ATTACH &n1533 => @PLACE(406, -3579) => @ORIENT("R0");
// %t7484 @TEXT("n1533", key="name", size=0.75);
// &n1533 @WIRE(mode="straight") {#X1414:1 %t7484:p};
// %t7485 = $IO_PORT @ATTACH &n1575 => @PLACE(406, -3583) => @ORIENT("R0");
// %t7485 @TEXT("n1575", key="name", size=0.75);
// &n1575 @WIRE(mode="straight") {#X1414:2 %t7485:p};
// %t7486 = $IO_PORT @ATTACH &n88 => @PLACE(406, -3587) => @ORIENT("R0");
// %t7486 @TEXT("n88", key="name", size=0.75);
// &n88 @WIRE(mode="straight") {#X1414:3 %t7486:p};
// %t7487 = $IO_PORT @ATTACH &n1581 => @PLACE(426, -3583) => @ORIENT("MY");
// %t7487 @TEXT("n1581", key="name", size=0.75);
// &n1581 @WIRE(mode="straight") {#X1414:4 %t7487:p};
// %t7488 = $SUPPLY @ATTACH &vdd => @PLACE(416, -3570);
// &vdd @WIRE(mode="straight") {#X1414:5 %t7488:p};
// %t7489 = $GROUND @ATTACH &vss => @PLACE(416, -3596);
// &vss @WIRE(mode="straight") {#X1414:6 %t7489:p};
// %t7490 = $IO_PORT @ATTACH &n1534 => @PLACE(446, -3579) => @ORIENT("R0");
// %t7490 @TEXT("n1534", key="name", size=0.75);
// &n1534 @WIRE(mode="straight") {#X1415:1 %t7490:p};
// %t7491 = $IO_PORT @ATTACH &n1576 => @PLACE(446, -3583) => @ORIENT("R0");
// %t7491 @TEXT("n1576", key="name", size=0.75);
// &n1576 @WIRE(mode="straight") {#X1415:2 %t7491:p};
// %t7492 = $IO_PORT @ATTACH &n88 => @PLACE(446, -3587) => @ORIENT("R0");
// %t7492 @TEXT("n88", key="name", size=0.75);
// &n88 @WIRE(mode="straight") {#X1415:3 %t7492:p};
// %t7493 = $IO_PORT @ATTACH &n1582 => @PLACE(466, -3583) => @ORIENT("MY");
// %t7493 @TEXT("n1582", key="name", size=0.75);
// &n1582 @WIRE(mode="straight") {#X1415:4 %t7493:p};
// %t7494 = $SUPPLY @ATTACH &vdd => @PLACE(456, -3570);
// &vdd @WIRE(mode="straight") {#X1415:5 %t7494:p};
// %t7495 = $GROUND @ATTACH &vss => @PLACE(456, -3596);
// &vss @WIRE(mode="straight") {#X1415:6 %t7495:p};
// %t7496 = $IO_PORT @ATTACH &n1535 => @PLACE(494, -3404) => @ORIENT("R0");
// %t7496 @TEXT("n1535", key="name", size=0.75);
// &n1535 @WIRE(mode="straight") {#X1416:1 %t7496:p};
// %t7497 = $IO_PORT @ATTACH &n1577 => @PLACE(494, -3408) => @ORIENT("R0");
// %t7497 @TEXT("n1577", key="name", size=0.75);
// &n1577 @WIRE(mode="straight") {#X1416:2 %t7497:p};
// %t7498 = $IO_PORT @ATTACH &n88 => @PLACE(494, -3412) => @ORIENT("R0");
// %t7498 @TEXT("n88", key="name", size=0.75);
// &n88 @WIRE(mode="straight") {#X1416:3 %t7498:p};
// %t7499 = $IO_PORT @ATTACH &n1583 => @PLACE(514, -3408) => @ORIENT("MY");
// %t7499 @TEXT("n1583", key="name", size=0.75);
// &n1583 @WIRE(mode="straight") {#X1416:4 %t7499:p};
// %t7500 = $SUPPLY @ATTACH &vdd => @PLACE(504, -3395);
// &vdd @WIRE(mode="straight") {#X1416:5 %t7500:p};
// %t7501 = $GROUND @ATTACH &vss => @PLACE(504, -3421);
// &vss @WIRE(mode="straight") {#X1416:6 %t7501:p};
// %t7502 = $IO_PORT @ATTACH &n1536 => @PLACE(534, -3404) => @ORIENT("R0");
// %t7502 @TEXT("n1536", key="name", size=0.75);
// &n1536 @WIRE(mode="straight") {#X1417:1 %t7502:p};
// %t7503 = $IO_PORT @ATTACH &n1578 => @PLACE(534, -3408) => @ORIENT("R0");
// %t7503 @TEXT("n1578", key="name", size=0.75);
// &n1578 @WIRE(mode="straight") {#X1417:2 %t7503:p};
// %t7504 = $IO_PORT @ATTACH &n88 => @PLACE(534, -3412) => @ORIENT("R0");
// %t7504 @TEXT("n88", key="name", size=0.75);
// &n88 @WIRE(mode="straight") {#X1417:3 %t7504:p};
// %t7505 = $IO_PORT @ATTACH &n1584 => @PLACE(554, -3408) => @ORIENT("MY");
// %t7505 @TEXT("n1584", key="name", size=0.75);
// &n1584 @WIRE(mode="straight") {#X1417:4 %t7505:p};
// %t7506 = $SUPPLY @ATTACH &vdd => @PLACE(544, -3395);
// &vdd @WIRE(mode="straight") {#X1417:5 %t7506:p};
// %t7507 = $GROUND @ATTACH &vss => @PLACE(544, -3421);
// &vss @WIRE(mode="straight") {#X1417:6 %t7507:p};
// %t7508 = $IO_PORT @ATTACH &n1537 => @PLACE(574, -3404) => @ORIENT("R0");
// %t7508 @TEXT("n1537", key="name", size=0.75);
// &n1537 @WIRE(mode="straight") {#X1418:1 %t7508:p};
// %t7509 = $IO_PORT @ATTACH &n1579 => @PLACE(574, -3408) => @ORIENT("R0");
// %t7509 @TEXT("n1579", key="name", size=0.75);
// &n1579 @WIRE(mode="straight") {#X1418:2 %t7509:p};
// %t7510 = $IO_PORT @ATTACH &n88 => @PLACE(574, -3412) => @ORIENT("R0");
// %t7510 @TEXT("n88", key="name", size=0.75);
// &n88 @WIRE(mode="straight") {#X1418:3 %t7510:p};
// %t7511 = $IO_PORT @ATTACH &n1585 => @PLACE(594, -3408) => @ORIENT("MY");
// %t7511 @TEXT("n1585", key="name", size=0.75);
// &n1585 @WIRE(mode="straight") {#X1418:4 %t7511:p};
// %t7512 = $SUPPLY @ATTACH &vdd => @PLACE(584, -3395);
// &vdd @WIRE(mode="straight") {#X1418:5 %t7512:p};
// %t7513 = $GROUND @ATTACH &vss => @PLACE(584, -3421);
// &vss @WIRE(mode="straight") {#X1418:6 %t7513:p};
// %t7514 = $IO_PORT @ATTACH &vss => @PLACE(614, -3404) => @ORIENT("R0");
// %t7514 @TEXT("vss", key="name", size=0.75);
// &vss @WIRE(mode="straight") {#X1419:1 %t7514:p};
// %t7515 = $IO_PORT @ATTACH &vss => @PLACE(614, -3408) => @ORIENT("R0");
// %t7515 @TEXT("vss", key="name", size=0.75);
// &vss @WIRE(mode="straight") {#X1419:2 %t7515:p};
// %t7516 = $IO_PORT @ATTACH &n980 => @PLACE(614, -3412) => @ORIENT("R0");
// %t7516 @TEXT("n980", key="name", size=0.75);
// &n980 @WIRE(mode="straight") {#X1419:3 %t7516:p};
// %t7517 = $IO_PORT @ATTACH &n1375 => @PLACE(635, -3408) => @ORIENT("MY");
// %t7517 @TEXT("n1375", key="name", size=0.75);
// &n1375 @WIRE(mode="straight") {#X1419:4 %t7517:p};
// %t7518 = $SUPPLY @ATTACH &vdd => @PLACE(624, -3395);
// &vdd @WIRE(mode="straight") {#X1419:5 %t7518:p};
// %t7519 = $GROUND @ATTACH &vss => @PLACE(624, -3421);
// &vss @WIRE(mode="straight") {#X1419:6 %t7519:p};
// %t7520 = $IO_PORT @ATTACH &n1375 => @PLACE(494, -3439) => @ORIENT("R0");
// %t7520 @TEXT("n1375", key="name", size=0.75);
// &n1375 @WIRE(mode="straight") {#X1420:1 %t7520:p};
// %t7521 = $IO_PORT @ATTACH &n1580 => @PLACE(494, -3443) => @ORIENT("R0");
// %t7521 @TEXT("n1580", key="name", size=0.75);
// &n1580 @WIRE(mode="straight") {#X1420:2 %t7521:p};
// %t7522 = $IO_PORT @ATTACH &n117 => @PLACE(494, -3447) => @ORIENT("R0");
// %t7522 @TEXT("n117", key="name", size=0.75);
// &n117 @WIRE(mode="straight") {#X1420:3 %t7522:p};
// %t7523 = $IO_PORT @ATTACH &n1586 => @PLACE(514, -3443) => @ORIENT("MY");
// %t7523 @TEXT("n1586", key="name", size=0.75);
// &n1586 @WIRE(mode="straight") {#X1420:4 %t7523:p};
// %t7524 = $SUPPLY @ATTACH &vdd => @PLACE(504, -3430);
// &vdd @WIRE(mode="straight") {#X1420:5 %t7524:p};
// %t7525 = $GROUND @ATTACH &vss => @PLACE(504, -3456);
// &vss @WIRE(mode="straight") {#X1420:6 %t7525:p};
// %t7526 = $IO_PORT @ATTACH &n1375 => @PLACE(534, -3439) => @ORIENT("R0");
// %t7526 @TEXT("n1375", key="name", size=0.75);
// &n1375 @WIRE(mode="straight") {#X1421:1 %t7526:p};
// %t7527 = $IO_PORT @ATTACH &n1581 => @PLACE(534, -3443) => @ORIENT("R0");
// %t7527 @TEXT("n1581", key="name", size=0.75);
// &n1581 @WIRE(mode="straight") {#X1421:2 %t7527:p};
// %t7528 = $IO_PORT @ATTACH &n117 => @PLACE(534, -3447) => @ORIENT("R0");
// %t7528 @TEXT("n117", key="name", size=0.75);
// &n117 @WIRE(mode="straight") {#X1421:3 %t7528:p};
// %t7529 = $IO_PORT @ATTACH &n1587 => @PLACE(554, -3443) => @ORIENT("MY");
// %t7529 @TEXT("n1587", key="name", size=0.75);
// &n1587 @WIRE(mode="straight") {#X1421:4 %t7529:p};
// %t7530 = $SUPPLY @ATTACH &vdd => @PLACE(544, -3430);
// &vdd @WIRE(mode="straight") {#X1421:5 %t7530:p};
// %t7531 = $GROUND @ATTACH &vss => @PLACE(544, -3456);
// &vss @WIRE(mode="straight") {#X1421:6 %t7531:p};
// %t7532 = $IO_PORT @ATTACH &n1375 => @PLACE(574, -3439) => @ORIENT("R0");
// %t7532 @TEXT("n1375", key="name", size=0.75);
// &n1375 @WIRE(mode="straight") {#X1422:1 %t7532:p};
// %t7533 = $IO_PORT @ATTACH &n1582 => @PLACE(574, -3443) => @ORIENT("R0");
// %t7533 @TEXT("n1582", key="name", size=0.75);
// &n1582 @WIRE(mode="straight") {#X1422:2 %t7533:p};
// %t7534 = $IO_PORT @ATTACH &n117 => @PLACE(574, -3447) => @ORIENT("R0");
// %t7534 @TEXT("n117", key="name", size=0.75);
// &n117 @WIRE(mode="straight") {#X1422:3 %t7534:p};
// %t7535 = $IO_PORT @ATTACH &n1588 => @PLACE(594, -3443) => @ORIENT("MY");
// %t7535 @TEXT("n1588", key="name", size=0.75);
// &n1588 @WIRE(mode="straight") {#X1422:4 %t7535:p};
// %t7536 = $SUPPLY @ATTACH &vdd => @PLACE(584, -3430);
// &vdd @WIRE(mode="straight") {#X1422:5 %t7536:p};
// %t7537 = $GROUND @ATTACH &vss => @PLACE(584, -3456);
// &vss @WIRE(mode="straight") {#X1422:6 %t7537:p};
// %t7538 = $IO_PORT @ATTACH &n1375 => @PLACE(614, -3439) => @ORIENT("R0");
// %t7538 @TEXT("n1375", key="name", size=0.75);
// &n1375 @WIRE(mode="straight") {#X1423:1 %t7538:p};
// %t7539 = $IO_PORT @ATTACH &n1583 => @PLACE(614, -3443) => @ORIENT("R0");
// %t7539 @TEXT("n1583", key="name", size=0.75);
// &n1583 @WIRE(mode="straight") {#X1423:2 %t7539:p};
// %t7540 = $IO_PORT @ATTACH &n117 => @PLACE(614, -3447) => @ORIENT("R0");
// %t7540 @TEXT("n117", key="name", size=0.75);
// &n117 @WIRE(mode="straight") {#X1423:3 %t7540:p};
// %t7541 = $IO_PORT @ATTACH &n1589 => @PLACE(635, -3443) => @ORIENT("MY");
// %t7541 @TEXT("n1589", key="name", size=0.75);
// &n1589 @WIRE(mode="straight") {#X1423:4 %t7541:p};
// %t7542 = $SUPPLY @ATTACH &vdd => @PLACE(624, -3430);
// &vdd @WIRE(mode="straight") {#X1423:5 %t7542:p};
// %t7543 = $GROUND @ATTACH &vss => @PLACE(624, -3456);
// &vss @WIRE(mode="straight") {#X1423:6 %t7543:p};
// %t7544 = $IO_PORT @ATTACH &n1375 => @PLACE(494, -3474) => @ORIENT("R0");
// %t7544 @TEXT("n1375", key="name", size=0.75);
// &n1375 @WIRE(mode="straight") {#X1424:1 %t7544:p};
// %t7545 = $IO_PORT @ATTACH &n1584 => @PLACE(494, -3478) => @ORIENT("R0");
// %t7545 @TEXT("n1584", key="name", size=0.75);
// &n1584 @WIRE(mode="straight") {#X1424:2 %t7545:p};
// %t7546 = $IO_PORT @ATTACH &n117 => @PLACE(494, -3482) => @ORIENT("R0");
// %t7546 @TEXT("n117", key="name", size=0.75);
// &n117 @WIRE(mode="straight") {#X1424:3 %t7546:p};
// %t7547 = $IO_PORT @ATTACH &n1590 => @PLACE(514, -3478) => @ORIENT("MY");
// %t7547 @TEXT("n1590", key="name", size=0.75);
// &n1590 @WIRE(mode="straight") {#X1424:4 %t7547:p};
// %t7548 = $SUPPLY @ATTACH &vdd => @PLACE(504, -3465);
// &vdd @WIRE(mode="straight") {#X1424:5 %t7548:p};
// %t7549 = $GROUND @ATTACH &vss => @PLACE(504, -3491);
// &vss @WIRE(mode="straight") {#X1424:6 %t7549:p};
// %t7550 = $IO_PORT @ATTACH &n1374 => @PLACE(534, -3474) => @ORIENT("R0");
// %t7550 @TEXT("n1374", key="name", size=0.75);
// &n1374 @WIRE(mode="straight") {#X1425:1 %t7550:p};
// %t7551 = $IO_PORT @ATTACH &n1585 => @PLACE(534, -3478) => @ORIENT("R0");
// %t7551 @TEXT("n1585", key="name", size=0.75);
// &n1585 @WIRE(mode="straight") {#X1425:2 %t7551:p};
// %t7552 = $IO_PORT @ATTACH &n117 => @PLACE(534, -3482) => @ORIENT("R0");
// %t7552 @TEXT("n117", key="name", size=0.75);
// &n117 @WIRE(mode="straight") {#X1425:3 %t7552:p};
// %t7553 = $IO_PORT @ATTACH &n1591 => @PLACE(554, -3478) => @ORIENT("MY");
// %t7553 @TEXT("n1591", key="name", size=0.75);
// &n1591 @WIRE(mode="straight") {#X1425:4 %t7553:p};
// %t7554 = $SUPPLY @ATTACH &vdd => @PLACE(544, -3465);
// &vdd @WIRE(mode="straight") {#X1425:5 %t7554:p};
// %t7555 = $GROUND @ATTACH &vss => @PLACE(544, -3491);
// &vss @WIRE(mode="straight") {#X1425:6 %t7555:p};
// %t7556 = $IO_PORT @ATTACH &vss => @PLACE(574, -3474) => @ORIENT("R0");
// %t7556 @TEXT("vss", key="name", size=0.75);
// &vss @WIRE(mode="straight") {#X1426:1 %t7556:p};
// %t7557 = $IO_PORT @ATTACH &vss => @PLACE(574, -3478) => @ORIENT("R0");
// %t7557 @TEXT("vss", key="name", size=0.75);
// &vss @WIRE(mode="straight") {#X1426:2 %t7557:p};
// %t7558 = $IO_PORT @ATTACH &n978 => @PLACE(574, -3482) => @ORIENT("R0");
// %t7558 @TEXT("n978", key="name", size=0.75);
// &n978 @WIRE(mode="straight") {#X1426:3 %t7558:p};
// %t7559 = $IO_PORT @ATTACH &n1592 => @PLACE(594, -3478) => @ORIENT("MY");
// %t7559 @TEXT("n1592", key="name", size=0.75);
// &n1592 @WIRE(mode="straight") {#X1426:4 %t7559:p};
// %t7560 = $SUPPLY @ATTACH &vdd => @PLACE(584, -3465);
// &vdd @WIRE(mode="straight") {#X1426:5 %t7560:p};
// %t7561 = $GROUND @ATTACH &vss => @PLACE(584, -3491);
// &vss @WIRE(mode="straight") {#X1426:6 %t7561:p};
// %t7562 = $IO_PORT @ATTACH &vdd => @PLACE(614, -3474) => @ORIENT("R0");
// %t7562 @TEXT("vdd", key="name", size=0.75);
// &vdd @WIRE(mode="straight") {#X1427:1 %t7562:p};
// %t7563 = $IO_PORT @ATTACH &vss => @PLACE(614, -3478) => @ORIENT("R0");
// %t7563 @TEXT("vss", key="name", size=0.75);
// &vss @WIRE(mode="straight") {#X1427:2 %t7563:p};
// %t7564 = $IO_PORT @ATTACH &n978 => @PLACE(614, -3482) => @ORIENT("R0");
// %t7564 @TEXT("n978", key="name", size=0.75);
// &n978 @WIRE(mode="straight") {#X1427:3 %t7564:p};
// %t7565 = $IO_PORT @ATTACH &n1459 => @PLACE(635, -3478) => @ORIENT("MY");
// %t7565 @TEXT("n1459", key="name", size=0.75);
// &n1459 @WIRE(mode="straight") {#X1427:4 %t7565:p};
// %t7566 = $SUPPLY @ATTACH &vdd => @PLACE(624, -3465);
// &vdd @WIRE(mode="straight") {#X1427:5 %t7566:p};
// %t7567 = $GROUND @ATTACH &vss => @PLACE(624, -3491);
// &vss @WIRE(mode="straight") {#X1427:6 %t7567:p};
// %t7568 = $IO_PORT @ATTACH &n1592 => @PLACE(494, -3509) => @ORIENT("R0");
// %t7568 @TEXT("n1592", key="name", size=0.75);
// &n1592 @WIRE(mode="straight") {#X1428:1 %t7568:p};
// %t7569 = $IO_PORT @ATTACH &n1586 => @PLACE(494, -3513) => @ORIENT("R0");
// %t7569 @TEXT("n1586", key="name", size=0.75);
// &n1586 @WIRE(mode="straight") {#X1428:2 %t7569:p};
// %t7570 = $IO_PORT @ATTACH &n51 => @PLACE(494, -3517) => @ORIENT("R0");
// %t7570 @TEXT("n51", key="name", size=0.75);
// &n51 @WIRE(mode="straight") {#X1428:3 %t7570:p};
// %t7571 = $IO_PORT @ATTACH &n163 => @PLACE(514, -3513) => @ORIENT("MY");
// %t7571 @TEXT("n163", key="name", size=0.75);
// &n163 @WIRE(mode="straight") {#X1428:4 %t7571:p};
// %t7572 = $SUPPLY @ATTACH &vdd => @PLACE(504, -3500);
// &vdd @WIRE(mode="straight") {#X1428:5 %t7572:p};
// %t7573 = $GROUND @ATTACH &vss => @PLACE(504, -3526);
// &vss @WIRE(mode="straight") {#X1428:6 %t7573:p};
// %t7574 = $IO_PORT @ATTACH &n1592 => @PLACE(534, -3509) => @ORIENT("R0");
// %t7574 @TEXT("n1592", key="name", size=0.75);
// &n1592 @WIRE(mode="straight") {#X1429:1 %t7574:p};
// %t7575 = $IO_PORT @ATTACH &n1587 => @PLACE(534, -3513) => @ORIENT("R0");
// %t7575 @TEXT("n1587", key="name", size=0.75);
// &n1587 @WIRE(mode="straight") {#X1429:2 %t7575:p};
// %t7576 = $IO_PORT @ATTACH &n51 => @PLACE(534, -3517) => @ORIENT("R0");
// %t7576 @TEXT("n51", key="name", size=0.75);
// &n51 @WIRE(mode="straight") {#X1429:3 %t7576:p};
// %t7577 = $IO_PORT @ATTACH &n162 => @PLACE(554, -3513) => @ORIENT("MY");
// %t7577 @TEXT("n162", key="name", size=0.75);
// &n162 @WIRE(mode="straight") {#X1429:4 %t7577:p};
// %t7578 = $SUPPLY @ATTACH &vdd => @PLACE(544, -3500);
// &vdd @WIRE(mode="straight") {#X1429:5 %t7578:p};
// %t7579 = $GROUND @ATTACH &vss => @PLACE(544, -3526);
// &vss @WIRE(mode="straight") {#X1429:6 %t7579:p};
// %t7580 = $IO_PORT @ATTACH &n1592 => @PLACE(574, -3509) => @ORIENT("R0");
// %t7580 @TEXT("n1592", key="name", size=0.75);
// &n1592 @WIRE(mode="straight") {#X1430:1 %t7580:p};
// %t7581 = $IO_PORT @ATTACH &n1588 => @PLACE(574, -3513) => @ORIENT("R0");
// %t7581 @TEXT("n1588", key="name", size=0.75);
// &n1588 @WIRE(mode="straight") {#X1430:2 %t7581:p};
// %t7582 = $IO_PORT @ATTACH &n51 => @PLACE(574, -3517) => @ORIENT("R0");
// %t7582 @TEXT("n51", key="name", size=0.75);
// &n51 @WIRE(mode="straight") {#X1430:3 %t7582:p};
// %t7583 = $IO_PORT @ATTACH &n161 => @PLACE(594, -3513) => @ORIENT("MY");
// %t7583 @TEXT("n161", key="name", size=0.75);
// &n161 @WIRE(mode="straight") {#X1430:4 %t7583:p};
// %t7584 = $SUPPLY @ATTACH &vdd => @PLACE(584, -3500);
// &vdd @WIRE(mode="straight") {#X1430:5 %t7584:p};
// %t7585 = $GROUND @ATTACH &vss => @PLACE(584, -3526);
// &vss @WIRE(mode="straight") {#X1430:6 %t7585:p};
// %t7586 = $IO_PORT @ATTACH &n1592 => @PLACE(614, -3509) => @ORIENT("R0");
// %t7586 @TEXT("n1592", key="name", size=0.75);
// &n1592 @WIRE(mode="straight") {#X1431:1 %t7586:p};
// %t7587 = $IO_PORT @ATTACH &n1589 => @PLACE(614, -3513) => @ORIENT("R0");
// %t7587 @TEXT("n1589", key="name", size=0.75);
// &n1589 @WIRE(mode="straight") {#X1431:2 %t7587:p};
// %t7588 = $IO_PORT @ATTACH &n51 => @PLACE(614, -3517) => @ORIENT("R0");
// %t7588 @TEXT("n51", key="name", size=0.75);
// &n51 @WIRE(mode="straight") {#X1431:3 %t7588:p};
// %t7589 = $IO_PORT @ATTACH &n160 => @PLACE(635, -3513) => @ORIENT("MY");
// %t7589 @TEXT("n160", key="name", size=0.75);
// &n160 @WIRE(mode="straight") {#X1431:4 %t7589:p};
// %t7590 = $SUPPLY @ATTACH &vdd => @PLACE(624, -3500);
// &vdd @WIRE(mode="straight") {#X1431:5 %t7590:p};
// %t7591 = $GROUND @ATTACH &vss => @PLACE(624, -3526);
// &vss @WIRE(mode="straight") {#X1431:6 %t7591:p};
// %t7592 = $IO_PORT @ATTACH &n1592 => @PLACE(494, -3544) => @ORIENT("R0");
// %t7592 @TEXT("n1592", key="name", size=0.75);
// &n1592 @WIRE(mode="straight") {#X1432:1 %t7592:p};
// %t7593 = $IO_PORT @ATTACH &n1590 => @PLACE(494, -3548) => @ORIENT("R0");
// %t7593 @TEXT("n1590", key="name", size=0.75);
// &n1590 @WIRE(mode="straight") {#X1432:2 %t7593:p};
// %t7594 = $IO_PORT @ATTACH &n51 => @PLACE(494, -3552) => @ORIENT("R0");
// %t7594 @TEXT("n51", key="name", size=0.75);
// &n51 @WIRE(mode="straight") {#X1432:3 %t7594:p};
// %t7595 = $IO_PORT @ATTACH &n158 => @PLACE(514, -3548) => @ORIENT("MY");
// %t7595 @TEXT("n158", key="name", size=0.75);
// &n158 @WIRE(mode="straight") {#X1432:4 %t7595:p};
// %t7596 = $SUPPLY @ATTACH &vdd => @PLACE(504, -3535);
// &vdd @WIRE(mode="straight") {#X1432:5 %t7596:p};
// %t7597 = $GROUND @ATTACH &vss => @PLACE(504, -3561);
// &vss @WIRE(mode="straight") {#X1432:6 %t7597:p};
// %t7598 = $IO_PORT @ATTACH &n1459 => @PLACE(534, -3544) => @ORIENT("R0");
// %t7598 @TEXT("n1459", key="name", size=0.75);
// &n1459 @WIRE(mode="straight") {#X1433:1 %t7598:p};
// %t7599 = $IO_PORT @ATTACH &n1591 => @PLACE(534, -3548) => @ORIENT("R0");
// %t7599 @TEXT("n1591", key="name", size=0.75);
// &n1591 @WIRE(mode="straight") {#X1433:2 %t7599:p};
// %t7600 = $IO_PORT @ATTACH &n51 => @PLACE(534, -3552) => @ORIENT("R0");
// %t7600 @TEXT("n51", key="name", size=0.75);
// &n51 @WIRE(mode="straight") {#X1433:3 %t7600:p};
// %t7601 = $IO_PORT @ATTACH &n182 => @PLACE(554, -3548) => @ORIENT("MY");
// %t7601 @TEXT("n182", key="name", size=0.75);
// &n182 @WIRE(mode="straight") {#X1433:4 %t7601:p};
// %t7602 = $SUPPLY @ATTACH &vdd => @PLACE(544, -3535);
// &vdd @WIRE(mode="straight") {#X1433:5 %t7602:p};
// %t7603 = $GROUND @ATTACH &vss => @PLACE(544, -3561);
// &vss @WIRE(mode="straight") {#X1433:6 %t7603:p};
// %t7604 = $IO_PORT @ATTACH &n296 => @PLACE(574, -3544) => @ORIENT("R0");
// %t7604 @TEXT("n296", key="name", size=0.75);
// &n296 @WIRE(mode="straight") {#X1434:1 %t7604:p};
// %t7605 = $IO_PORT @ATTACH &vss => @PLACE(574, -3548) => @ORIENT("R0");
// %t7605 @TEXT("vss", key="name", size=0.75);
// &vss @WIRE(mode="straight") {#X1434:2 %t7605:p};
// %t7606 = $IO_PORT @ATTACH &n232 => @PLACE(574, -3552) => @ORIENT("R0");
// %t7606 @TEXT("n232", key="name", size=0.75);
// &n232 @WIRE(mode="straight") {#X1434:3 %t7606:p};
// %t7607 = $IO_PORT @ATTACH &n1593 => @PLACE(594, -3548) => @ORIENT("MY");
// %t7607 @TEXT("n1593", key="name", size=0.75);
// &n1593 @WIRE(mode="straight") {#X1434:4 %t7607:p};
// %t7608 = $SUPPLY @ATTACH &vdd => @PLACE(584, -3535);
// &vdd @WIRE(mode="straight") {#X1434:5 %t7608:p};
// %t7609 = $GROUND @ATTACH &vss => @PLACE(584, -3561);
// &vss @WIRE(mode="straight") {#X1434:6 %t7609:p};
// %t7610 = $IO_PORT @ATTACH &n1329 => @PLACE(614, -3544) => @ORIENT("R0");
// %t7610 @TEXT("n1329", key="name", size=0.75);
// &n1329 @WIRE(mode="straight") {#X1435:1 %t7610:p};
// %t7611 = $IO_PORT @ATTACH &vss => @PLACE(614, -3548) => @ORIENT("R0");
// %t7611 @TEXT("vss", key="name", size=0.75);
// &vss @WIRE(mode="straight") {#X1435:2 %t7611:p};
// %t7612 = $IO_PORT @ATTACH &n232 => @PLACE(614, -3552) => @ORIENT("R0");
// %t7612 @TEXT("n232", key="name", size=0.75);
// &n232 @WIRE(mode="straight") {#X1435:3 %t7612:p};
// %t7613 = $IO_PORT @ATTACH &n1594 => @PLACE(635, -3548) => @ORIENT("MY");
// %t7613 @TEXT("n1594", key="name", size=0.75);
// &n1594 @WIRE(mode="straight") {#X1435:4 %t7613:p};
// %t7614 = $SUPPLY @ATTACH &vdd => @PLACE(624, -3535);
// &vdd @WIRE(mode="straight") {#X1435:5 %t7614:p};
// %t7615 = $GROUND @ATTACH &vss => @PLACE(624, -3561);
// &vss @WIRE(mode="straight") {#X1435:6 %t7615:p};
// %t7616 = $IO_PORT @ATTACH &n1330 => @PLACE(494, -3579) => @ORIENT("R0");
// %t7616 @TEXT("n1330", key="name", size=0.75);
// &n1330 @WIRE(mode="straight") {#X1436:1 %t7616:p};
// %t7617 = $IO_PORT @ATTACH &vss => @PLACE(494, -3583) => @ORIENT("R0");
// %t7617 @TEXT("vss", key="name", size=0.75);
// &vss @WIRE(mode="straight") {#X1436:2 %t7617:p};
// %t7618 = $IO_PORT @ATTACH &n232 => @PLACE(494, -3587) => @ORIENT("R0");
// %t7618 @TEXT("n232", key="name", size=0.75);
// &n232 @WIRE(mode="straight") {#X1436:3 %t7618:p};
// %t7619 = $IO_PORT @ATTACH &n1595 => @PLACE(514, -3583) => @ORIENT("MY");
// %t7619 @TEXT("n1595", key="name", size=0.75);
// &n1595 @WIRE(mode="straight") {#X1436:4 %t7619:p};
// %t7620 = $SUPPLY @ATTACH &vdd => @PLACE(504, -3570);
// &vdd @WIRE(mode="straight") {#X1436:5 %t7620:p};
// %t7621 = $GROUND @ATTACH &vss => @PLACE(504, -3596);
// &vss @WIRE(mode="straight") {#X1436:6 %t7621:p};
// %t7622 = $IO_PORT @ATTACH &n1331 => @PLACE(534, -3579) => @ORIENT("R0");
// %t7622 @TEXT("n1331", key="name", size=0.75);
// &n1331 @WIRE(mode="straight") {#X1437:1 %t7622:p};
// %t7623 = $IO_PORT @ATTACH &vss => @PLACE(534, -3583) => @ORIENT("R0");
// %t7623 @TEXT("vss", key="name", size=0.75);
// &vss @WIRE(mode="straight") {#X1437:2 %t7623:p};
// %t7624 = $IO_PORT @ATTACH &n232 => @PLACE(534, -3587) => @ORIENT("R0");
// %t7624 @TEXT("n232", key="name", size=0.75);
// &n232 @WIRE(mode="straight") {#X1437:3 %t7624:p};
// %t7625 = $IO_PORT @ATTACH &n1596 => @PLACE(554, -3583) => @ORIENT("MY");
// %t7625 @TEXT("n1596", key="name", size=0.75);
// &n1596 @WIRE(mode="straight") {#X1437:4 %t7625:p};
// %t7626 = $SUPPLY @ATTACH &vdd => @PLACE(544, -3570);
// &vdd @WIRE(mode="straight") {#X1437:5 %t7626:p};
// %t7627 = $GROUND @ATTACH &vss => @PLACE(544, -3596);
// &vss @WIRE(mode="straight") {#X1437:6 %t7627:p};
// %t7628 = $IO_PORT @ATTACH &n1332 => @PLACE(574, -3579) => @ORIENT("R0");
// %t7628 @TEXT("n1332", key="name", size=0.75);
// &n1332 @WIRE(mode="straight") {#X1438:1 %t7628:p};
// %t7629 = $IO_PORT @ATTACH &vss => @PLACE(574, -3583) => @ORIENT("R0");
// %t7629 @TEXT("vss", key="name", size=0.75);
// &vss @WIRE(mode="straight") {#X1438:2 %t7629:p};
// %t7630 = $IO_PORT @ATTACH &n232 => @PLACE(574, -3587) => @ORIENT("R0");
// %t7630 @TEXT("n232", key="name", size=0.75);
// &n232 @WIRE(mode="straight") {#X1438:3 %t7630:p};
// %t7631 = $IO_PORT @ATTACH &n1597 => @PLACE(594, -3583) => @ORIENT("MY");
// %t7631 @TEXT("n1597", key="name", size=0.75);
// &n1597 @WIRE(mode="straight") {#X1438:4 %t7631:p};
// %t7632 = $SUPPLY @ATTACH &vdd => @PLACE(584, -3570);
// &vdd @WIRE(mode="straight") {#X1438:5 %t7632:p};
// %t7633 = $GROUND @ATTACH &vss => @PLACE(584, -3596);
// &vss @WIRE(mode="straight") {#X1438:6 %t7633:p};
// %t7634 = $IO_PORT @ATTACH &n1333 => @PLACE(614, -3579) => @ORIENT("R0");
// %t7634 @TEXT("n1333", key="name", size=0.75);
// &n1333 @WIRE(mode="straight") {#X1439:1 %t7634:p};
// %t7635 = $IO_PORT @ATTACH &vss => @PLACE(614, -3583) => @ORIENT("R0");
// %t7635 @TEXT("vss", key="name", size=0.75);
// &vss @WIRE(mode="straight") {#X1439:2 %t7635:p};
// %t7636 = $IO_PORT @ATTACH &n232 => @PLACE(614, -3587) => @ORIENT("R0");
// %t7636 @TEXT("n232", key="name", size=0.75);
// &n232 @WIRE(mode="straight") {#X1439:3 %t7636:p};
// %t7637 = $IO_PORT @ATTACH &n1598 => @PLACE(635, -3583) => @ORIENT("MY");
// %t7637 @TEXT("n1598", key="name", size=0.75);
// &n1598 @WIRE(mode="straight") {#X1439:4 %t7637:p};
// %t7638 = $SUPPLY @ATTACH &vdd => @PLACE(624, -3570);
// &vdd @WIRE(mode="straight") {#X1439:5 %t7638:p};
// %t7639 = $GROUND @ATTACH &vss => @PLACE(624, -3596);
// &vss @WIRE(mode="straight") {#X1439:6 %t7639:p};
// %t7640 = $IO_PORT @ATTACH &n1334 => @PLACE(-11, -3624) => @ORIENT("R0");
// %t7640 @TEXT("n1334", key="name", size=0.75);
// &n1334 @WIRE(mode="straight") {#X1440:1 %t7640:p};
// %t7641 = $IO_PORT @ATTACH &vss => @PLACE(-11, -3628) => @ORIENT("R0");
// %t7641 @TEXT("vss", key="name", size=0.75);
// &vss @WIRE(mode="straight") {#X1440:2 %t7641:p};
// %t7642 = $IO_PORT @ATTACH &n232 => @PLACE(-11, -3632) => @ORIENT("R0");
// %t7642 @TEXT("n232", key="name", size=0.75);
// &n232 @WIRE(mode="straight") {#X1440:3 %t7642:p};
// %t7643 = $IO_PORT @ATTACH &n1599 => @PLACE(10, -3628) => @ORIENT("MY");
// %t7643 @TEXT("n1599", key="name", size=0.75);
// &n1599 @WIRE(mode="straight") {#X1440:4 %t7643:p};
// %t7644 = $SUPPLY @ATTACH &vdd => @PLACE(0, -3615);
// &vdd @WIRE(mode="straight") {#X1440:5 %t7644:p};
// %t7645 = $GROUND @ATTACH &vss => @PLACE(0, -3641);
// &vss @WIRE(mode="straight") {#X1440:6 %t7645:p};
// %t7646 = $IO_PORT @ATTACH &n1335 => @PLACE(30, -3624) => @ORIENT("R0");
// %t7646 @TEXT("n1335", key="name", size=0.75);
// &n1335 @WIRE(mode="straight") {#X1441:1 %t7646:p};
// %t7647 = $IO_PORT @ATTACH &vss => @PLACE(30, -3628) => @ORIENT("R0");
// %t7647 @TEXT("vss", key="name", size=0.75);
// &vss @WIRE(mode="straight") {#X1441:2 %t7647:p};
// %t7648 = $IO_PORT @ATTACH &n232 => @PLACE(30, -3632) => @ORIENT("R0");
// %t7648 @TEXT("n232", key="name", size=0.75);
// &n232 @WIRE(mode="straight") {#X1441:3 %t7648:p};
// %t7649 = $IO_PORT @ATTACH &n1600 => @PLACE(50, -3628) => @ORIENT("MY");
// %t7649 @TEXT("n1600", key="name", size=0.75);
// &n1600 @WIRE(mode="straight") {#X1441:4 %t7649:p};
// %t7650 = $SUPPLY @ATTACH &vdd => @PLACE(40, -3615);
// &vdd @WIRE(mode="straight") {#X1441:5 %t7650:p};
// %t7651 = $GROUND @ATTACH &vss => @PLACE(40, -3641);
// &vss @WIRE(mode="straight") {#X1441:6 %t7651:p};
// %t7652 = $IO_PORT @ATTACH &vss => @PLACE(70, -3624) => @ORIENT("R0");
// %t7652 @TEXT("vss", key="name", size=0.75);
// &vss @WIRE(mode="straight") {#X1442:1 %t7652:p};
// %t7653 = $IO_PORT @ATTACH &n1593 => @PLACE(70, -3628) => @ORIENT("R0");
// %t7653 @TEXT("n1593", key="name", size=0.75);
// &n1593 @WIRE(mode="straight") {#X1442:2 %t7653:p};
// %t7654 = $IO_PORT @ATTACH &n238 => @PLACE(70, -3632) => @ORIENT("R0");
// %t7654 @TEXT("n238", key="name", size=0.75);
// &n238 @WIRE(mode="straight") {#X1442:3 %t7654:p};
// %t7655 = $IO_PORT @ATTACH &n1601 => @PLACE(90, -3628) => @ORIENT("MY");
// %t7655 @TEXT("n1601", key="name", size=0.75);
// &n1601 @WIRE(mode="straight") {#X1442:4 %t7655:p};
// %t7656 = $SUPPLY @ATTACH &vdd => @PLACE(80, -3615);
// &vdd @WIRE(mode="straight") {#X1442:5 %t7656:p};
// %t7657 = $GROUND @ATTACH &vss => @PLACE(80, -3641);
// &vss @WIRE(mode="straight") {#X1442:6 %t7657:p};
// %t7658 = $IO_PORT @ATTACH &vss => @PLACE(110, -3624) => @ORIENT("R0");
// %t7658 @TEXT("vss", key="name", size=0.75);
// &vss @WIRE(mode="straight") {#X1443:1 %t7658:p};
// %t7659 = $IO_PORT @ATTACH &n1594 => @PLACE(110, -3628) => @ORIENT("R0");
// %t7659 @TEXT("n1594", key="name", size=0.75);
// &n1594 @WIRE(mode="straight") {#X1443:2 %t7659:p};
// %t7660 = $IO_PORT @ATTACH &n238 => @PLACE(110, -3632) => @ORIENT("R0");
// %t7660 @TEXT("n238", key="name", size=0.75);
// &n238 @WIRE(mode="straight") {#X1443:3 %t7660:p};
// %t7661 = $IO_PORT @ATTACH &n1602 => @PLACE(130, -3628) => @ORIENT("MY");
// %t7661 @TEXT("n1602", key="name", size=0.75);
// &n1602 @WIRE(mode="straight") {#X1443:4 %t7661:p};
// %t7662 = $SUPPLY @ATTACH &vdd => @PLACE(120, -3615);
// &vdd @WIRE(mode="straight") {#X1443:5 %t7662:p};
// %t7663 = $GROUND @ATTACH &vss => @PLACE(120, -3641);
// &vss @WIRE(mode="straight") {#X1443:6 %t7663:p};
// %t7664 = $IO_PORT @ATTACH &vss => @PLACE(-11, -3659) => @ORIENT("R0");
// %t7664 @TEXT("vss", key="name", size=0.75);
// &vss @WIRE(mode="straight") {#X1444:1 %t7664:p};
// %t7665 = $IO_PORT @ATTACH &n1595 => @PLACE(-11, -3663) => @ORIENT("R0");
// %t7665 @TEXT("n1595", key="name", size=0.75);
// &n1595 @WIRE(mode="straight") {#X1444:2 %t7665:p};
// %t7666 = $IO_PORT @ATTACH &n238 => @PLACE(-11, -3667) => @ORIENT("R0");
// %t7666 @TEXT("n238", key="name", size=0.75);
// &n238 @WIRE(mode="straight") {#X1444:3 %t7666:p};
// %t7667 = $IO_PORT @ATTACH &n1603 => @PLACE(10, -3663) => @ORIENT("MY");
// %t7667 @TEXT("n1603", key="name", size=0.75);
// &n1603 @WIRE(mode="straight") {#X1444:4 %t7667:p};
// %t7668 = $SUPPLY @ATTACH &vdd => @PLACE(0, -3650);
// &vdd @WIRE(mode="straight") {#X1444:5 %t7668:p};
// %t7669 = $GROUND @ATTACH &vss => @PLACE(0, -3676);
// &vss @WIRE(mode="straight") {#X1444:6 %t7669:p};
// %t7670 = $IO_PORT @ATTACH &vss => @PLACE(30, -3659) => @ORIENT("R0");
// %t7670 @TEXT("vss", key="name", size=0.75);
// &vss @WIRE(mode="straight") {#X1445:1 %t7670:p};
// %t7671 = $IO_PORT @ATTACH &n1596 => @PLACE(30, -3663) => @ORIENT("R0");
// %t7671 @TEXT("n1596", key="name", size=0.75);
// &n1596 @WIRE(mode="straight") {#X1445:2 %t7671:p};
// %t7672 = $IO_PORT @ATTACH &n238 => @PLACE(30, -3667) => @ORIENT("R0");
// %t7672 @TEXT("n238", key="name", size=0.75);
// &n238 @WIRE(mode="straight") {#X1445:3 %t7672:p};
// %t7673 = $IO_PORT @ATTACH &n1604 => @PLACE(50, -3663) => @ORIENT("MY");
// %t7673 @TEXT("n1604", key="name", size=0.75);
// &n1604 @WIRE(mode="straight") {#X1445:4 %t7673:p};
// %t7674 = $SUPPLY @ATTACH &vdd => @PLACE(40, -3650);
// &vdd @WIRE(mode="straight") {#X1445:5 %t7674:p};
// %t7675 = $GROUND @ATTACH &vss => @PLACE(40, -3676);
// &vss @WIRE(mode="straight") {#X1445:6 %t7675:p};
// %t7676 = $IO_PORT @ATTACH &vss => @PLACE(70, -3659) => @ORIENT("R0");
// %t7676 @TEXT("vss", key="name", size=0.75);
// &vss @WIRE(mode="straight") {#X1446:1 %t7676:p};
// %t7677 = $IO_PORT @ATTACH &n1597 => @PLACE(70, -3663) => @ORIENT("R0");
// %t7677 @TEXT("n1597", key="name", size=0.75);
// &n1597 @WIRE(mode="straight") {#X1446:2 %t7677:p};
// %t7678 = $IO_PORT @ATTACH &n238 => @PLACE(70, -3667) => @ORIENT("R0");
// %t7678 @TEXT("n238", key="name", size=0.75);
// &n238 @WIRE(mode="straight") {#X1446:3 %t7678:p};
// %t7679 = $IO_PORT @ATTACH &n1605 => @PLACE(90, -3663) => @ORIENT("MY");
// %t7679 @TEXT("n1605", key="name", size=0.75);
// &n1605 @WIRE(mode="straight") {#X1446:4 %t7679:p};
// %t7680 = $SUPPLY @ATTACH &vdd => @PLACE(80, -3650);
// &vdd @WIRE(mode="straight") {#X1446:5 %t7680:p};
// %t7681 = $GROUND @ATTACH &vss => @PLACE(80, -3676);
// &vss @WIRE(mode="straight") {#X1446:6 %t7681:p};
// %t7682 = $IO_PORT @ATTACH &vss => @PLACE(110, -3659) => @ORIENT("R0");
// %t7682 @TEXT("vss", key="name", size=0.75);
// &vss @WIRE(mode="straight") {#X1447:1 %t7682:p};
// %t7683 = $IO_PORT @ATTACH &n1598 => @PLACE(110, -3663) => @ORIENT("R0");
// %t7683 @TEXT("n1598", key="name", size=0.75);
// &n1598 @WIRE(mode="straight") {#X1447:2 %t7683:p};
// %t7684 = $IO_PORT @ATTACH &n238 => @PLACE(110, -3667) => @ORIENT("R0");
// %t7684 @TEXT("n238", key="name", size=0.75);
// &n238 @WIRE(mode="straight") {#X1447:3 %t7684:p};
// %t7685 = $IO_PORT @ATTACH &n1606 => @PLACE(130, -3663) => @ORIENT("MY");
// %t7685 @TEXT("n1606", key="name", size=0.75);
// &n1606 @WIRE(mode="straight") {#X1447:4 %t7685:p};
// %t7686 = $SUPPLY @ATTACH &vdd => @PLACE(120, -3650);
// &vdd @WIRE(mode="straight") {#X1447:5 %t7686:p};
// %t7687 = $GROUND @ATTACH &vss => @PLACE(120, -3676);
// &vss @WIRE(mode="straight") {#X1447:6 %t7687:p};
// %t7688 = $IO_PORT @ATTACH &vss => @PLACE(-11, -3694) => @ORIENT("R0");
// %t7688 @TEXT("vss", key="name", size=0.75);
// &vss @WIRE(mode="straight") {#X1448:1 %t7688:p};
// %t7689 = $IO_PORT @ATTACH &n1599 => @PLACE(-11, -3698) => @ORIENT("R0");
// %t7689 @TEXT("n1599", key="name", size=0.75);
// &n1599 @WIRE(mode="straight") {#X1448:2 %t7689:p};
// %t7690 = $IO_PORT @ATTACH &n238 => @PLACE(-11, -3702) => @ORIENT("R0");
// %t7690 @TEXT("n238", key="name", size=0.75);
// &n238 @WIRE(mode="straight") {#X1448:3 %t7690:p};
// %t7691 = $IO_PORT @ATTACH &n1607 => @PLACE(10, -3698) => @ORIENT("MY");
// %t7691 @TEXT("n1607", key="name", size=0.75);
// &n1607 @WIRE(mode="straight") {#X1448:4 %t7691:p};
// %t7692 = $SUPPLY @ATTACH &vdd => @PLACE(0, -3685);
// &vdd @WIRE(mode="straight") {#X1448:5 %t7692:p};
// %t7693 = $GROUND @ATTACH &vss => @PLACE(0, -3711);
// &vss @WIRE(mode="straight") {#X1448:6 %t7693:p};
// %t7694 = $IO_PORT @ATTACH &vss => @PLACE(30, -3694) => @ORIENT("R0");
// %t7694 @TEXT("vss", key="name", size=0.75);
// &vss @WIRE(mode="straight") {#X1449:1 %t7694:p};
// %t7695 = $IO_PORT @ATTACH &n1600 => @PLACE(30, -3698) => @ORIENT("R0");
// %t7695 @TEXT("n1600", key="name", size=0.75);
// &n1600 @WIRE(mode="straight") {#X1449:2 %t7695:p};
// %t7696 = $IO_PORT @ATTACH &n238 => @PLACE(30, -3702) => @ORIENT("R0");
// %t7696 @TEXT("n238", key="name", size=0.75);
// &n238 @WIRE(mode="straight") {#X1449:3 %t7696:p};
// %t7697 = $IO_PORT @ATTACH &n1608 => @PLACE(50, -3698) => @ORIENT("MY");
// %t7697 @TEXT("n1608", key="name", size=0.75);
// &n1608 @WIRE(mode="straight") {#X1449:4 %t7697:p};
// %t7698 = $SUPPLY @ATTACH &vdd => @PLACE(40, -3685);
// &vdd @WIRE(mode="straight") {#X1449:5 %t7698:p};
// %t7699 = $GROUND @ATTACH &vss => @PLACE(40, -3711);
// &vss @WIRE(mode="straight") {#X1449:6 %t7699:p};
// %t7700 = $IO_PORT @ATTACH &vss => @PLACE(70, -3694) => @ORIENT("R0");
// %t7700 @TEXT("vss", key="name", size=0.75);
// &vss @WIRE(mode="straight") {#X1450:1 %t7700:p};
// %t7701 = $IO_PORT @ATTACH &n1601 => @PLACE(70, -3698) => @ORIENT("R0");
// %t7701 @TEXT("n1601", key="name", size=0.75);
// &n1601 @WIRE(mode="straight") {#X1450:2 %t7701:p};
// %t7702 = $IO_PORT @ATTACH &n88 => @PLACE(70, -3702) => @ORIENT("R0");
// %t7702 @TEXT("n88", key="name", size=0.75);
// &n88 @WIRE(mode="straight") {#X1450:3 %t7702:p};
// %t7703 = $IO_PORT @ATTACH &n1609 => @PLACE(90, -3698) => @ORIENT("MY");
// %t7703 @TEXT("n1609", key="name", size=0.75);
// &n1609 @WIRE(mode="straight") {#X1450:4 %t7703:p};
// %t7704 = $SUPPLY @ATTACH &vdd => @PLACE(80, -3685);
// &vdd @WIRE(mode="straight") {#X1450:5 %t7704:p};
// %t7705 = $GROUND @ATTACH &vss => @PLACE(80, -3711);
// &vss @WIRE(mode="straight") {#X1450:6 %t7705:p};
// %t7706 = $IO_PORT @ATTACH &vss => @PLACE(110, -3694) => @ORIENT("R0");
// %t7706 @TEXT("vss", key="name", size=0.75);
// &vss @WIRE(mode="straight") {#X1451:1 %t7706:p};
// %t7707 = $IO_PORT @ATTACH &n1602 => @PLACE(110, -3698) => @ORIENT("R0");
// %t7707 @TEXT("n1602", key="name", size=0.75);
// &n1602 @WIRE(mode="straight") {#X1451:2 %t7707:p};
// %t7708 = $IO_PORT @ATTACH &n88 => @PLACE(110, -3702) => @ORIENT("R0");
// %t7708 @TEXT("n88", key="name", size=0.75);
// &n88 @WIRE(mode="straight") {#X1451:3 %t7708:p};
// %t7709 = $IO_PORT @ATTACH &n1610 => @PLACE(130, -3698) => @ORIENT("MY");
// %t7709 @TEXT("n1610", key="name", size=0.75);
// &n1610 @WIRE(mode="straight") {#X1451:4 %t7709:p};
// %t7710 = $SUPPLY @ATTACH &vdd => @PLACE(120, -3685);
// &vdd @WIRE(mode="straight") {#X1451:5 %t7710:p};
// %t7711 = $GROUND @ATTACH &vss => @PLACE(120, -3711);
// &vss @WIRE(mode="straight") {#X1451:6 %t7711:p};
// %t7712 = $IO_PORT @ATTACH &vss => @PLACE(-11, -3729) => @ORIENT("R0");
// %t7712 @TEXT("vss", key="name", size=0.75);
// &vss @WIRE(mode="straight") {#X1452:1 %t7712:p};
// %t7713 = $IO_PORT @ATTACH &n1603 => @PLACE(-11, -3733) => @ORIENT("R0");
// %t7713 @TEXT("n1603", key="name", size=0.75);
// &n1603 @WIRE(mode="straight") {#X1452:2 %t7713:p};
// %t7714 = $IO_PORT @ATTACH &n88 => @PLACE(-11, -3737) => @ORIENT("R0");
// %t7714 @TEXT("n88", key="name", size=0.75);
// &n88 @WIRE(mode="straight") {#X1452:3 %t7714:p};
// %t7715 = $IO_PORT @ATTACH &n1611 => @PLACE(10, -3733) => @ORIENT("MY");
// %t7715 @TEXT("n1611", key="name", size=0.75);
// &n1611 @WIRE(mode="straight") {#X1452:4 %t7715:p};
// %t7716 = $SUPPLY @ATTACH &vdd => @PLACE(0, -3720);
// &vdd @WIRE(mode="straight") {#X1452:5 %t7716:p};
// %t7717 = $GROUND @ATTACH &vss => @PLACE(0, -3746);
// &vss @WIRE(mode="straight") {#X1452:6 %t7717:p};
// %t7718 = $IO_PORT @ATTACH &vss => @PLACE(30, -3729) => @ORIENT("R0");
// %t7718 @TEXT("vss", key="name", size=0.75);
// &vss @WIRE(mode="straight") {#X1453:1 %t7718:p};
// %t7719 = $IO_PORT @ATTACH &n1604 => @PLACE(30, -3733) => @ORIENT("R0");
// %t7719 @TEXT("n1604", key="name", size=0.75);
// &n1604 @WIRE(mode="straight") {#X1453:2 %t7719:p};
// %t7720 = $IO_PORT @ATTACH &n88 => @PLACE(30, -3737) => @ORIENT("R0");
// %t7720 @TEXT("n88", key="name", size=0.75);
// &n88 @WIRE(mode="straight") {#X1453:3 %t7720:p};
// %t7721 = $IO_PORT @ATTACH &n1612 => @PLACE(50, -3733) => @ORIENT("MY");
// %t7721 @TEXT("n1612", key="name", size=0.75);
// &n1612 @WIRE(mode="straight") {#X1453:4 %t7721:p};
// %t7722 = $SUPPLY @ATTACH &vdd => @PLACE(40, -3720);
// &vdd @WIRE(mode="straight") {#X1453:5 %t7722:p};
// %t7723 = $GROUND @ATTACH &vss => @PLACE(40, -3746);
// &vss @WIRE(mode="straight") {#X1453:6 %t7723:p};
// %t7724 = $IO_PORT @ATTACH &vss => @PLACE(70, -3729) => @ORIENT("R0");
// %t7724 @TEXT("vss", key="name", size=0.75);
// &vss @WIRE(mode="straight") {#X1454:1 %t7724:p};
// %t7725 = $IO_PORT @ATTACH &n1605 => @PLACE(70, -3733) => @ORIENT("R0");
// %t7725 @TEXT("n1605", key="name", size=0.75);
// &n1605 @WIRE(mode="straight") {#X1454:2 %t7725:p};
// %t7726 = $IO_PORT @ATTACH &n88 => @PLACE(70, -3737) => @ORIENT("R0");
// %t7726 @TEXT("n88", key="name", size=0.75);
// &n88 @WIRE(mode="straight") {#X1454:3 %t7726:p};
// %t7727 = $IO_PORT @ATTACH &n1613 => @PLACE(90, -3733) => @ORIENT("MY");
// %t7727 @TEXT("n1613", key="name", size=0.75);
// &n1613 @WIRE(mode="straight") {#X1454:4 %t7727:p};
// %t7728 = $SUPPLY @ATTACH &vdd => @PLACE(80, -3720);
// &vdd @WIRE(mode="straight") {#X1454:5 %t7728:p};
// %t7729 = $GROUND @ATTACH &vss => @PLACE(80, -3746);
// &vss @WIRE(mode="straight") {#X1454:6 %t7729:p};
// %t7730 = $IO_PORT @ATTACH &vss => @PLACE(110, -3729) => @ORIENT("R0");
// %t7730 @TEXT("vss", key="name", size=0.75);
// &vss @WIRE(mode="straight") {#X1455:1 %t7730:p};
// %t7731 = $IO_PORT @ATTACH &n1606 => @PLACE(110, -3733) => @ORIENT("R0");
// %t7731 @TEXT("n1606", key="name", size=0.75);
// &n1606 @WIRE(mode="straight") {#X1455:2 %t7731:p};
// %t7732 = $IO_PORT @ATTACH &n88 => @PLACE(110, -3737) => @ORIENT("R0");
// %t7732 @TEXT("n88", key="name", size=0.75);
// &n88 @WIRE(mode="straight") {#X1455:3 %t7732:p};
// %t7733 = $IO_PORT @ATTACH &n1614 => @PLACE(130, -3733) => @ORIENT("MY");
// %t7733 @TEXT("n1614", key="name", size=0.75);
// &n1614 @WIRE(mode="straight") {#X1455:4 %t7733:p};
// %t7734 = $SUPPLY @ATTACH &vdd => @PLACE(120, -3720);
// &vdd @WIRE(mode="straight") {#X1455:5 %t7734:p};
// %t7735 = $GROUND @ATTACH &vss => @PLACE(120, -3746);
// &vss @WIRE(mode="straight") {#X1455:6 %t7735:p};
// %t7736 = $IO_PORT @ATTACH &vss => @PLACE(-11, -3764) => @ORIENT("R0");
// %t7736 @TEXT("vss", key="name", size=0.75);
// &vss @WIRE(mode="straight") {#X1456:1 %t7736:p};
// %t7737 = $IO_PORT @ATTACH &n1607 => @PLACE(-11, -3768) => @ORIENT("R0");
// %t7737 @TEXT("n1607", key="name", size=0.75);
// &n1607 @WIRE(mode="straight") {#X1456:2 %t7737:p};
// %t7738 = $IO_PORT @ATTACH &n88 => @PLACE(-11, -3772) => @ORIENT("R0");
// %t7738 @TEXT("n88", key="name", size=0.75);
// &n88 @WIRE(mode="straight") {#X1456:3 %t7738:p};
// %t7739 = $IO_PORT @ATTACH &n1615 => @PLACE(10, -3768) => @ORIENT("MY");
// %t7739 @TEXT("n1615", key="name", size=0.75);
// &n1615 @WIRE(mode="straight") {#X1456:4 %t7739:p};
// %t7740 = $SUPPLY @ATTACH &vdd => @PLACE(0, -3755);
// &vdd @WIRE(mode="straight") {#X1456:5 %t7740:p};
// %t7741 = $GROUND @ATTACH &vss => @PLACE(0, -3781);
// &vss @WIRE(mode="straight") {#X1456:6 %t7741:p};
// %t7742 = $IO_PORT @ATTACH &vss => @PLACE(30, -3764) => @ORIENT("R0");
// %t7742 @TEXT("vss", key="name", size=0.75);
// &vss @WIRE(mode="straight") {#X1457:1 %t7742:p};
// %t7743 = $IO_PORT @ATTACH &n1608 => @PLACE(30, -3768) => @ORIENT("R0");
// %t7743 @TEXT("n1608", key="name", size=0.75);
// &n1608 @WIRE(mode="straight") {#X1457:2 %t7743:p};
// %t7744 = $IO_PORT @ATTACH &n88 => @PLACE(30, -3772) => @ORIENT("R0");
// %t7744 @TEXT("n88", key="name", size=0.75);
// &n88 @WIRE(mode="straight") {#X1457:3 %t7744:p};
// %t7745 = $IO_PORT @ATTACH &n1616 => @PLACE(50, -3768) => @ORIENT("MY");
// %t7745 @TEXT("n1616", key="name", size=0.75);
// &n1616 @WIRE(mode="straight") {#X1457:4 %t7745:p};
// %t7746 = $SUPPLY @ATTACH &vdd => @PLACE(40, -3755);
// &vdd @WIRE(mode="straight") {#X1457:5 %t7746:p};
// %t7747 = $GROUND @ATTACH &vss => @PLACE(40, -3781);
// &vss @WIRE(mode="straight") {#X1457:6 %t7747:p};
// %t7748 = $IO_PORT @ATTACH &n1321 => @PLACE(70, -3764) => @ORIENT("R0");
// %t7748 @TEXT("n1321", key="name", size=0.75);
// &n1321 @WIRE(mode="straight") {#X1458:1 %t7748:p};
// %t7749 = $IO_PORT @ATTACH &n323 => @PLACE(70, -3768) => @ORIENT("R0");
// %t7749 @TEXT("n323", key="name", size=0.75);
// &n323 @WIRE(mode="straight") {#X1458:2 %t7749:p};
// %t7750 = $IO_PORT @ATTACH &n980 => @PLACE(70, -3772) => @ORIENT("R0");
// %t7750 @TEXT("n980", key="name", size=0.75);
// &n980 @WIRE(mode="straight") {#X1458:3 %t7750:p};
// %t7751 = $IO_PORT @ATTACH &n1617 => @PLACE(90, -3768) => @ORIENT("MY");
// %t7751 @TEXT("n1617", key="name", size=0.75);
// &n1617 @WIRE(mode="straight") {#X1458:4 %t7751:p};
// %t7752 = $SUPPLY @ATTACH &vdd => @PLACE(80, -3755);
// &vdd @WIRE(mode="straight") {#X1458:5 %t7752:p};
// %t7753 = $GROUND @ATTACH &vss => @PLACE(80, -3781);
// &vss @WIRE(mode="straight") {#X1458:6 %t7753:p};
// %t7754 = $IO_PORT @ATTACH &n1322 => @PLACE(110, -3764) => @ORIENT("R0");
// %t7754 @TEXT("n1322", key="name", size=0.75);
// &n1322 @WIRE(mode="straight") {#X1459:1 %t7754:p};
// %t7755 = $IO_PORT @ATTACH &n324 => @PLACE(110, -3768) => @ORIENT("R0");
// %t7755 @TEXT("n324", key="name", size=0.75);
// &n324 @WIRE(mode="straight") {#X1459:2 %t7755:p};
// %t7756 = $IO_PORT @ATTACH &n980 => @PLACE(110, -3772) => @ORIENT("R0");
// %t7756 @TEXT("n980", key="name", size=0.75);
// &n980 @WIRE(mode="straight") {#X1459:3 %t7756:p};
// %t7757 = $IO_PORT @ATTACH &n1618 => @PLACE(130, -3768) => @ORIENT("MY");
// %t7757 @TEXT("n1618", key="name", size=0.75);
// &n1618 @WIRE(mode="straight") {#X1459:4 %t7757:p};
// %t7758 = $SUPPLY @ATTACH &vdd => @PLACE(120, -3755);
// &vdd @WIRE(mode="straight") {#X1459:5 %t7758:p};
// %t7759 = $GROUND @ATTACH &vss => @PLACE(120, -3781);
// &vss @WIRE(mode="straight") {#X1459:6 %t7759:p};
// %t7760 = $IO_PORT @ATTACH &n1323 => @PLACE(-11, -3799) => @ORIENT("R0");
// %t7760 @TEXT("n1323", key="name", size=0.75);
// &n1323 @WIRE(mode="straight") {#X1460:1 %t7760:p};
// %t7761 = $IO_PORT @ATTACH &n326 => @PLACE(-11, -3803) => @ORIENT("R0");
// %t7761 @TEXT("n326", key="name", size=0.75);
// &n326 @WIRE(mode="straight") {#X1460:2 %t7761:p};
// %t7762 = $IO_PORT @ATTACH &n980 => @PLACE(-11, -3807) => @ORIENT("R0");
// %t7762 @TEXT("n980", key="name", size=0.75);
// &n980 @WIRE(mode="straight") {#X1460:3 %t7762:p};
// %t7763 = $IO_PORT @ATTACH &n1619 => @PLACE(10, -3803) => @ORIENT("MY");
// %t7763 @TEXT("n1619", key="name", size=0.75);
// &n1619 @WIRE(mode="straight") {#X1460:4 %t7763:p};
// %t7764 = $SUPPLY @ATTACH &vdd => @PLACE(0, -3790);
// &vdd @WIRE(mode="straight") {#X1460:5 %t7764:p};
// %t7765 = $GROUND @ATTACH &vss => @PLACE(0, -3816);
// &vss @WIRE(mode="straight") {#X1460:6 %t7765:p};
// %t7766 = $IO_PORT @ATTACH &n1324 => @PLACE(30, -3799) => @ORIENT("R0");
// %t7766 @TEXT("n1324", key="name", size=0.75);
// &n1324 @WIRE(mode="straight") {#X1461:1 %t7766:p};
// %t7767 = $IO_PORT @ATTACH &n328 => @PLACE(30, -3803) => @ORIENT("R0");
// %t7767 @TEXT("n328", key="name", size=0.75);
// &n328 @WIRE(mode="straight") {#X1461:2 %t7767:p};
// %t7768 = $IO_PORT @ATTACH &n980 => @PLACE(30, -3807) => @ORIENT("R0");
// %t7768 @TEXT("n980", key="name", size=0.75);
// &n980 @WIRE(mode="straight") {#X1461:3 %t7768:p};
// %t7769 = $IO_PORT @ATTACH &n1620 => @PLACE(50, -3803) => @ORIENT("MY");
// %t7769 @TEXT("n1620", key="name", size=0.75);
// &n1620 @WIRE(mode="straight") {#X1461:4 %t7769:p};
// %t7770 = $SUPPLY @ATTACH &vdd => @PLACE(40, -3790);
// &vdd @WIRE(mode="straight") {#X1461:5 %t7770:p};
// %t7771 = $GROUND @ATTACH &vss => @PLACE(40, -3816);
// &vss @WIRE(mode="straight") {#X1461:6 %t7771:p};
// %t7772 = $IO_PORT @ATTACH &n1325 => @PLACE(70, -3799) => @ORIENT("R0");
// %t7772 @TEXT("n1325", key="name", size=0.75);
// &n1325 @WIRE(mode="straight") {#X1462:1 %t7772:p};
// %t7773 = $IO_PORT @ATTACH &n330 => @PLACE(70, -3803) => @ORIENT("R0");
// %t7773 @TEXT("n330", key="name", size=0.75);
// &n330 @WIRE(mode="straight") {#X1462:2 %t7773:p};
// %t7774 = $IO_PORT @ATTACH &n980 => @PLACE(70, -3807) => @ORIENT("R0");
// %t7774 @TEXT("n980", key="name", size=0.75);
// &n980 @WIRE(mode="straight") {#X1462:3 %t7774:p};
// %t7775 = $IO_PORT @ATTACH &n1621 => @PLACE(90, -3803) => @ORIENT("MY");
// %t7775 @TEXT("n1621", key="name", size=0.75);
// &n1621 @WIRE(mode="straight") {#X1462:4 %t7775:p};
// %t7776 = $SUPPLY @ATTACH &vdd => @PLACE(80, -3790);
// &vdd @WIRE(mode="straight") {#X1462:5 %t7776:p};
// %t7777 = $GROUND @ATTACH &vss => @PLACE(80, -3816);
// &vss @WIRE(mode="straight") {#X1462:6 %t7777:p};
// %t7778 = $IO_PORT @ATTACH &n1326 => @PLACE(110, -3799) => @ORIENT("R0");
// %t7778 @TEXT("n1326", key="name", size=0.75);
// &n1326 @WIRE(mode="straight") {#X1463:1 %t7778:p};
// %t7779 = $IO_PORT @ATTACH &n332 => @PLACE(110, -3803) => @ORIENT("R0");
// %t7779 @TEXT("n332", key="name", size=0.75);
// &n332 @WIRE(mode="straight") {#X1463:2 %t7779:p};
// %t7780 = $IO_PORT @ATTACH &n980 => @PLACE(110, -3807) => @ORIENT("R0");
// %t7780 @TEXT("n980", key="name", size=0.75);
// &n980 @WIRE(mode="straight") {#X1463:3 %t7780:p};
// %t7781 = $IO_PORT @ATTACH &n1622 => @PLACE(130, -3803) => @ORIENT("MY");
// %t7781 @TEXT("n1622", key="name", size=0.75);
// &n1622 @WIRE(mode="straight") {#X1463:4 %t7781:p};
// %t7782 = $SUPPLY @ATTACH &vdd => @PLACE(120, -3790);
// &vdd @WIRE(mode="straight") {#X1463:5 %t7782:p};
// %t7783 = $GROUND @ATTACH &vss => @PLACE(120, -3816);
// &vss @WIRE(mode="straight") {#X1463:6 %t7783:p};
// %t7784 = $IO_PORT @ATTACH &n1327 => @PLACE(158, -3624) => @ORIENT("R0");
// %t7784 @TEXT("n1327", key="name", size=0.75);
// &n1327 @WIRE(mode="straight") {#X1464:1 %t7784:p};
// %t7785 = $IO_PORT @ATTACH &n334 => @PLACE(158, -3628) => @ORIENT("R0");
// %t7785 @TEXT("n334", key="name", size=0.75);
// &n334 @WIRE(mode="straight") {#X1464:2 %t7785:p};
// %t7786 = $IO_PORT @ATTACH &n980 => @PLACE(158, -3632) => @ORIENT("R0");
// %t7786 @TEXT("n980", key="name", size=0.75);
// &n980 @WIRE(mode="straight") {#X1464:3 %t7786:p};
// %t7787 = $IO_PORT @ATTACH &n1623 => @PLACE(178, -3628) => @ORIENT("MY");
// %t7787 @TEXT("n1623", key="name", size=0.75);
// &n1623 @WIRE(mode="straight") {#X1464:4 %t7787:p};
// %t7788 = $SUPPLY @ATTACH &vdd => @PLACE(168, -3615);
// &vdd @WIRE(mode="straight") {#X1464:5 %t7788:p};
// %t7789 = $GROUND @ATTACH &vss => @PLACE(168, -3641);
// &vss @WIRE(mode="straight") {#X1464:6 %t7789:p};
// %t7790 = $IO_PORT @ATTACH &n1328 => @PLACE(198, -3624) => @ORIENT("R0");
// %t7790 @TEXT("n1328", key="name", size=0.75);
// &n1328 @WIRE(mode="straight") {#X1465:1 %t7790:p};
// %t7791 = $IO_PORT @ATTACH &n522 => @PLACE(198, -3628) => @ORIENT("R0");
// %t7791 @TEXT("n522", key="name", size=0.75);
// &n522 @WIRE(mode="straight") {#X1465:2 %t7791:p};
// %t7792 = $IO_PORT @ATTACH &n980 => @PLACE(198, -3632) => @ORIENT("R0");
// %t7792 @TEXT("n980", key="name", size=0.75);
// &n980 @WIRE(mode="straight") {#X1465:3 %t7792:p};
// %t7793 = $IO_PORT @ATTACH &n1624 => @PLACE(218, -3628) => @ORIENT("MY");
// %t7793 @TEXT("n1624", key="name", size=0.75);
// &n1624 @WIRE(mode="straight") {#X1465:4 %t7793:p};
// %t7794 = $SUPPLY @ATTACH &vdd => @PLACE(208, -3615);
// &vdd @WIRE(mode="straight") {#X1465:5 %t7794:p};
// %t7795 = $GROUND @ATTACH &vss => @PLACE(208, -3641);
// &vss @WIRE(mode="straight") {#X1465:6 %t7795:p};
// %t7796 = $IO_PORT @ATTACH &n1617 => @PLACE(238, -3624) => @ORIENT("R0");
// %t7796 @TEXT("n1617", key="name", size=0.75);
// &n1617 @WIRE(mode="straight") {#X1466:1 %t7796:p};
// %t7797 = $IO_PORT @ATTACH &n1609 => @PLACE(238, -3628) => @ORIENT("R0");
// %t7797 @TEXT("n1609", key="name", size=0.75);
// &n1609 @WIRE(mode="straight") {#X1466:2 %t7797:p};
// %t7798 = $IO_PORT @ATTACH &n117 => @PLACE(238, -3632) => @ORIENT("R0");
// %t7798 @TEXT("n117", key="name", size=0.75);
// &n117 @WIRE(mode="straight") {#X1466:3 %t7798:p};
// %t7799 = $IO_PORT @ATTACH &n1625 => @PLACE(258, -3628) => @ORIENT("MY");
// %t7799 @TEXT("n1625", key="name", size=0.75);
// &n1625 @WIRE(mode="straight") {#X1466:4 %t7799:p};
// %t7800 = $SUPPLY @ATTACH &vdd => @PLACE(248, -3615);
// &vdd @WIRE(mode="straight") {#X1466:5 %t7800:p};
// %t7801 = $GROUND @ATTACH &vss => @PLACE(248, -3641);
// &vss @WIRE(mode="straight") {#X1466:6 %t7801:p};
// %t7802 = $IO_PORT @ATTACH &n1618 => @PLACE(278, -3624) => @ORIENT("R0");
// %t7802 @TEXT("n1618", key="name", size=0.75);
// &n1618 @WIRE(mode="straight") {#X1467:1 %t7802:p};
// %t7803 = $IO_PORT @ATTACH &n1610 => @PLACE(278, -3628) => @ORIENT("R0");
// %t7803 @TEXT("n1610", key="name", size=0.75);
// &n1610 @WIRE(mode="straight") {#X1467:2 %t7803:p};
// %t7804 = $IO_PORT @ATTACH &n117 => @PLACE(278, -3632) => @ORIENT("R0");
// %t7804 @TEXT("n117", key="name", size=0.75);
// &n117 @WIRE(mode="straight") {#X1467:3 %t7804:p};
// %t7805 = $IO_PORT @ATTACH &n1626 => @PLACE(298, -3628) => @ORIENT("MY");
// %t7805 @TEXT("n1626", key="name", size=0.75);
// &n1626 @WIRE(mode="straight") {#X1467:4 %t7805:p};
// %t7806 = $SUPPLY @ATTACH &vdd => @PLACE(288, -3615);
// &vdd @WIRE(mode="straight") {#X1467:5 %t7806:p};
// %t7807 = $GROUND @ATTACH &vss => @PLACE(288, -3641);
// &vss @WIRE(mode="straight") {#X1467:6 %t7807:p};
// %t7808 = $IO_PORT @ATTACH &n1619 => @PLACE(158, -3659) => @ORIENT("R0");
// %t7808 @TEXT("n1619", key="name", size=0.75);
// &n1619 @WIRE(mode="straight") {#X1468:1 %t7808:p};
// %t7809 = $IO_PORT @ATTACH &n1611 => @PLACE(158, -3663) => @ORIENT("R0");
// %t7809 @TEXT("n1611", key="name", size=0.75);
// &n1611 @WIRE(mode="straight") {#X1468:2 %t7809:p};
// %t7810 = $IO_PORT @ATTACH &n117 => @PLACE(158, -3667) => @ORIENT("R0");
// %t7810 @TEXT("n117", key="name", size=0.75);
// &n117 @WIRE(mode="straight") {#X1468:3 %t7810:p};
// %t7811 = $IO_PORT @ATTACH &n1627 => @PLACE(178, -3663) => @ORIENT("MY");
// %t7811 @TEXT("n1627", key="name", size=0.75);
// &n1627 @WIRE(mode="straight") {#X1468:4 %t7811:p};
// %t7812 = $SUPPLY @ATTACH &vdd => @PLACE(168, -3650);
// &vdd @WIRE(mode="straight") {#X1468:5 %t7812:p};
// %t7813 = $GROUND @ATTACH &vss => @PLACE(168, -3676);
// &vss @WIRE(mode="straight") {#X1468:6 %t7813:p};
// %t7814 = $IO_PORT @ATTACH &n1620 => @PLACE(198, -3659) => @ORIENT("R0");
// %t7814 @TEXT("n1620", key="name", size=0.75);
// &n1620 @WIRE(mode="straight") {#X1469:1 %t7814:p};
// %t7815 = $IO_PORT @ATTACH &n1612 => @PLACE(198, -3663) => @ORIENT("R0");
// %t7815 @TEXT("n1612", key="name", size=0.75);
// &n1612 @WIRE(mode="straight") {#X1469:2 %t7815:p};
// %t7816 = $IO_PORT @ATTACH &n117 => @PLACE(198, -3667) => @ORIENT("R0");
// %t7816 @TEXT("n117", key="name", size=0.75);
// &n117 @WIRE(mode="straight") {#X1469:3 %t7816:p};
// %t7817 = $IO_PORT @ATTACH &n1628 => @PLACE(218, -3663) => @ORIENT("MY");
// %t7817 @TEXT("n1628", key="name", size=0.75);
// &n1628 @WIRE(mode="straight") {#X1469:4 %t7817:p};
// %t7818 = $SUPPLY @ATTACH &vdd => @PLACE(208, -3650);
// &vdd @WIRE(mode="straight") {#X1469:5 %t7818:p};
// %t7819 = $GROUND @ATTACH &vss => @PLACE(208, -3676);
// &vss @WIRE(mode="straight") {#X1469:6 %t7819:p};
// %t7820 = $IO_PORT @ATTACH &n1621 => @PLACE(238, -3659) => @ORIENT("R0");
// %t7820 @TEXT("n1621", key="name", size=0.75);
// &n1621 @WIRE(mode="straight") {#X1470:1 %t7820:p};
// %t7821 = $IO_PORT @ATTACH &n1613 => @PLACE(238, -3663) => @ORIENT("R0");
// %t7821 @TEXT("n1613", key="name", size=0.75);
// &n1613 @WIRE(mode="straight") {#X1470:2 %t7821:p};
// %t7822 = $IO_PORT @ATTACH &n117 => @PLACE(238, -3667) => @ORIENT("R0");
// %t7822 @TEXT("n117", key="name", size=0.75);
// &n117 @WIRE(mode="straight") {#X1470:3 %t7822:p};
// %t7823 = $IO_PORT @ATTACH &n1629 => @PLACE(258, -3663) => @ORIENT("MY");
// %t7823 @TEXT("n1629", key="name", size=0.75);
// &n1629 @WIRE(mode="straight") {#X1470:4 %t7823:p};
// %t7824 = $SUPPLY @ATTACH &vdd => @PLACE(248, -3650);
// &vdd @WIRE(mode="straight") {#X1470:5 %t7824:p};
// %t7825 = $GROUND @ATTACH &vss => @PLACE(248, -3676);
// &vss @WIRE(mode="straight") {#X1470:6 %t7825:p};
// %t7826 = $IO_PORT @ATTACH &n1622 => @PLACE(278, -3659) => @ORIENT("R0");
// %t7826 @TEXT("n1622", key="name", size=0.75);
// &n1622 @WIRE(mode="straight") {#X1471:1 %t7826:p};
// %t7827 = $IO_PORT @ATTACH &n1614 => @PLACE(278, -3663) => @ORIENT("R0");
// %t7827 @TEXT("n1614", key="name", size=0.75);
// &n1614 @WIRE(mode="straight") {#X1471:2 %t7827:p};
// %t7828 = $IO_PORT @ATTACH &n117 => @PLACE(278, -3667) => @ORIENT("R0");
// %t7828 @TEXT("n117", key="name", size=0.75);
// &n117 @WIRE(mode="straight") {#X1471:3 %t7828:p};
// %t7829 = $IO_PORT @ATTACH &n1630 => @PLACE(298, -3663) => @ORIENT("MY");
// %t7829 @TEXT("n1630", key="name", size=0.75);
// &n1630 @WIRE(mode="straight") {#X1471:4 %t7829:p};
// %t7830 = $SUPPLY @ATTACH &vdd => @PLACE(288, -3650);
// &vdd @WIRE(mode="straight") {#X1471:5 %t7830:p};
// %t7831 = $GROUND @ATTACH &vss => @PLACE(288, -3676);
// &vss @WIRE(mode="straight") {#X1471:6 %t7831:p};
// %t7832 = $IO_PORT @ATTACH &n1623 => @PLACE(158, -3694) => @ORIENT("R0");
// %t7832 @TEXT("n1623", key="name", size=0.75);
// &n1623 @WIRE(mode="straight") {#X1472:1 %t7832:p};
// %t7833 = $IO_PORT @ATTACH &n1615 => @PLACE(158, -3698) => @ORIENT("R0");
// %t7833 @TEXT("n1615", key="name", size=0.75);
// &n1615 @WIRE(mode="straight") {#X1472:2 %t7833:p};
// %t7834 = $IO_PORT @ATTACH &n117 => @PLACE(158, -3702) => @ORIENT("R0");
// %t7834 @TEXT("n117", key="name", size=0.75);
// &n117 @WIRE(mode="straight") {#X1472:3 %t7834:p};
// %t7835 = $IO_PORT @ATTACH &n1631 => @PLACE(178, -3698) => @ORIENT("MY");
// %t7835 @TEXT("n1631", key="name", size=0.75);
// &n1631 @WIRE(mode="straight") {#X1472:4 %t7835:p};
// %t7836 = $SUPPLY @ATTACH &vdd => @PLACE(168, -3685);
// &vdd @WIRE(mode="straight") {#X1472:5 %t7836:p};
// %t7837 = $GROUND @ATTACH &vss => @PLACE(168, -3711);
// &vss @WIRE(mode="straight") {#X1472:6 %t7837:p};
// %t7838 = $IO_PORT @ATTACH &n1624 => @PLACE(198, -3694) => @ORIENT("R0");
// %t7838 @TEXT("n1624", key="name", size=0.75);
// &n1624 @WIRE(mode="straight") {#X1473:1 %t7838:p};
// %t7839 = $IO_PORT @ATTACH &n1616 => @PLACE(198, -3698) => @ORIENT("R0");
// %t7839 @TEXT("n1616", key="name", size=0.75);
// &n1616 @WIRE(mode="straight") {#X1473:2 %t7839:p};
// %t7840 = $IO_PORT @ATTACH &n117 => @PLACE(198, -3702) => @ORIENT("R0");
// %t7840 @TEXT("n117", key="name", size=0.75);
// &n117 @WIRE(mode="straight") {#X1473:3 %t7840:p};
// %t7841 = $IO_PORT @ATTACH &n1632 => @PLACE(218, -3698) => @ORIENT("MY");
// %t7841 @TEXT("n1632", key="name", size=0.75);
// &n1632 @WIRE(mode="straight") {#X1473:4 %t7841:p};
// %t7842 = $SUPPLY @ATTACH &vdd => @PLACE(208, -3685);
// &vdd @WIRE(mode="straight") {#X1473:5 %t7842:p};
// %t7843 = $GROUND @ATTACH &vss => @PLACE(208, -3711);
// &vss @WIRE(mode="straight") {#X1473:6 %t7843:p};
// %t7844 = $IO_PORT @ATTACH &vss => @PLACE(238, -3694) => @ORIENT("R0");
// %t7844 @TEXT("vss", key="name", size=0.75);
// &vss @WIRE(mode="straight") {#X1474:1 %t7844:p};
// %t7845 = $IO_PORT @ATTACH &n1625 => @PLACE(238, -3698) => @ORIENT("R0");
// %t7845 @TEXT("n1625", key="name", size=0.75);
// &n1625 @WIRE(mode="straight") {#X1474:2 %t7845:p};
// %t7846 = $IO_PORT @ATTACH &n51 => @PLACE(238, -3702) => @ORIENT("R0");
// %t7846 @TEXT("n51", key="name", size=0.75);
// &n51 @WIRE(mode="straight") {#X1474:3 %t7846:p};
// %t7847 = $IO_PORT @ATTACH &n177 => @PLACE(258, -3698) => @ORIENT("MY");
// %t7847 @TEXT("n177", key="name", size=0.75);
// &n177 @WIRE(mode="straight") {#X1474:4 %t7847:p};
// %t7848 = $SUPPLY @ATTACH &vdd => @PLACE(248, -3685);
// &vdd @WIRE(mode="straight") {#X1474:5 %t7848:p};
// %t7849 = $GROUND @ATTACH &vss => @PLACE(248, -3711);
// &vss @WIRE(mode="straight") {#X1474:6 %t7849:p};
// %t7850 = $IO_PORT @ATTACH &vss => @PLACE(278, -3694) => @ORIENT("R0");
// %t7850 @TEXT("vss", key="name", size=0.75);
// &vss @WIRE(mode="straight") {#X1475:1 %t7850:p};
// %t7851 = $IO_PORT @ATTACH &n1626 => @PLACE(278, -3698) => @ORIENT("R0");
// %t7851 @TEXT("n1626", key="name", size=0.75);
// &n1626 @WIRE(mode="straight") {#X1475:2 %t7851:p};
// %t7852 = $IO_PORT @ATTACH &n51 => @PLACE(278, -3702) => @ORIENT("R0");
// %t7852 @TEXT("n51", key="name", size=0.75);
// &n51 @WIRE(mode="straight") {#X1475:3 %t7852:p};
// %t7853 = $IO_PORT @ATTACH &n176 => @PLACE(298, -3698) => @ORIENT("MY");
// %t7853 @TEXT("n176", key="name", size=0.75);
// &n176 @WIRE(mode="straight") {#X1475:4 %t7853:p};
// %t7854 = $SUPPLY @ATTACH &vdd => @PLACE(288, -3685);
// &vdd @WIRE(mode="straight") {#X1475:5 %t7854:p};
// %t7855 = $GROUND @ATTACH &vss => @PLACE(288, -3711);
// &vss @WIRE(mode="straight") {#X1475:6 %t7855:p};
// %t7856 = $IO_PORT @ATTACH &vss => @PLACE(158, -3729) => @ORIENT("R0");
// %t7856 @TEXT("vss", key="name", size=0.75);
// &vss @WIRE(mode="straight") {#X1476:1 %t7856:p};
// %t7857 = $IO_PORT @ATTACH &n1627 => @PLACE(158, -3733) => @ORIENT("R0");
// %t7857 @TEXT("n1627", key="name", size=0.75);
// &n1627 @WIRE(mode="straight") {#X1476:2 %t7857:p};
// %t7858 = $IO_PORT @ATTACH &n51 => @PLACE(158, -3737) => @ORIENT("R0");
// %t7858 @TEXT("n51", key="name", size=0.75);
// &n51 @WIRE(mode="straight") {#X1476:3 %t7858:p};
// %t7859 = $IO_PORT @ATTACH &n175 => @PLACE(178, -3733) => @ORIENT("MY");
// %t7859 @TEXT("n175", key="name", size=0.75);
// &n175 @WIRE(mode="straight") {#X1476:4 %t7859:p};
// %t7860 = $SUPPLY @ATTACH &vdd => @PLACE(168, -3720);
// &vdd @WIRE(mode="straight") {#X1476:5 %t7860:p};
// %t7861 = $GROUND @ATTACH &vss => @PLACE(168, -3746);
// &vss @WIRE(mode="straight") {#X1476:6 %t7861:p};
// %t7862 = $IO_PORT @ATTACH &vss => @PLACE(198, -3729) => @ORIENT("R0");
// %t7862 @TEXT("vss", key="name", size=0.75);
// &vss @WIRE(mode="straight") {#X1477:1 %t7862:p};
// %t7863 = $IO_PORT @ATTACH &n1628 => @PLACE(198, -3733) => @ORIENT("R0");
// %t7863 @TEXT("n1628", key="name", size=0.75);
// &n1628 @WIRE(mode="straight") {#X1477:2 %t7863:p};
// %t7864 = $IO_PORT @ATTACH &n51 => @PLACE(198, -3737) => @ORIENT("R0");
// %t7864 @TEXT("n51", key="name", size=0.75);
// &n51 @WIRE(mode="straight") {#X1477:3 %t7864:p};
// %t7865 = $IO_PORT @ATTACH &n174 => @PLACE(218, -3733) => @ORIENT("MY");
// %t7865 @TEXT("n174", key="name", size=0.75);
// &n174 @WIRE(mode="straight") {#X1477:4 %t7865:p};
// %t7866 = $SUPPLY @ATTACH &vdd => @PLACE(208, -3720);
// &vdd @WIRE(mode="straight") {#X1477:5 %t7866:p};
// %t7867 = $GROUND @ATTACH &vss => @PLACE(208, -3746);
// &vss @WIRE(mode="straight") {#X1477:6 %t7867:p};
// %t7868 = $IO_PORT @ATTACH &vss => @PLACE(238, -3729) => @ORIENT("R0");
// %t7868 @TEXT("vss", key="name", size=0.75);
// &vss @WIRE(mode="straight") {#X1478:1 %t7868:p};
// %t7869 = $IO_PORT @ATTACH &n1629 => @PLACE(238, -3733) => @ORIENT("R0");
// %t7869 @TEXT("n1629", key="name", size=0.75);
// &n1629 @WIRE(mode="straight") {#X1478:2 %t7869:p};
// %t7870 = $IO_PORT @ATTACH &n51 => @PLACE(238, -3737) => @ORIENT("R0");
// %t7870 @TEXT("n51", key="name", size=0.75);
// &n51 @WIRE(mode="straight") {#X1478:3 %t7870:p};
// %t7871 = $IO_PORT @ATTACH &n173 => @PLACE(258, -3733) => @ORIENT("MY");
// %t7871 @TEXT("n173", key="name", size=0.75);
// &n173 @WIRE(mode="straight") {#X1478:4 %t7871:p};
// %t7872 = $SUPPLY @ATTACH &vdd => @PLACE(248, -3720);
// &vdd @WIRE(mode="straight") {#X1478:5 %t7872:p};
// %t7873 = $GROUND @ATTACH &vss => @PLACE(248, -3746);
// &vss @WIRE(mode="straight") {#X1478:6 %t7873:p};
// %t7874 = $IO_PORT @ATTACH &vss => @PLACE(278, -3729) => @ORIENT("R0");
// %t7874 @TEXT("vss", key="name", size=0.75);
// &vss @WIRE(mode="straight") {#X1479:1 %t7874:p};
// %t7875 = $IO_PORT @ATTACH &n1630 => @PLACE(278, -3733) => @ORIENT("R0");
// %t7875 @TEXT("n1630", key="name", size=0.75);
// &n1630 @WIRE(mode="straight") {#X1479:2 %t7875:p};
// %t7876 = $IO_PORT @ATTACH &n51 => @PLACE(278, -3737) => @ORIENT("R0");
// %t7876 @TEXT("n51", key="name", size=0.75);
// &n51 @WIRE(mode="straight") {#X1479:3 %t7876:p};
// %t7877 = $IO_PORT @ATTACH &n172 => @PLACE(298, -3733) => @ORIENT("MY");
// %t7877 @TEXT("n172", key="name", size=0.75);
// &n172 @WIRE(mode="straight") {#X1479:4 %t7877:p};
// %t7878 = $SUPPLY @ATTACH &vdd => @PLACE(288, -3720);
// &vdd @WIRE(mode="straight") {#X1479:5 %t7878:p};
// %t7879 = $GROUND @ATTACH &vss => @PLACE(288, -3746);
// &vss @WIRE(mode="straight") {#X1479:6 %t7879:p};
// %t7880 = $IO_PORT @ATTACH &vss => @PLACE(158, -3764) => @ORIENT("R0");
// %t7880 @TEXT("vss", key="name", size=0.75);
// &vss @WIRE(mode="straight") {#X1480:1 %t7880:p};
// %t7881 = $IO_PORT @ATTACH &n1631 => @PLACE(158, -3768) => @ORIENT("R0");
// %t7881 @TEXT("n1631", key="name", size=0.75);
// &n1631 @WIRE(mode="straight") {#X1480:2 %t7881:p};
// %t7882 = $IO_PORT @ATTACH &n51 => @PLACE(158, -3772) => @ORIENT("R0");
// %t7882 @TEXT("n51", key="name", size=0.75);
// &n51 @WIRE(mode="straight") {#X1480:3 %t7882:p};
// %t7883 = $IO_PORT @ATTACH &n170 => @PLACE(178, -3768) => @ORIENT("MY");
// %t7883 @TEXT("n170", key="name", size=0.75);
// &n170 @WIRE(mode="straight") {#X1480:4 %t7883:p};
// %t7884 = $SUPPLY @ATTACH &vdd => @PLACE(168, -3755);
// &vdd @WIRE(mode="straight") {#X1480:5 %t7884:p};
// %t7885 = $GROUND @ATTACH &vss => @PLACE(168, -3781);
// &vss @WIRE(mode="straight") {#X1480:6 %t7885:p};
// %t7886 = $IO_PORT @ATTACH &n978 => @PLACE(198, -3764) => @ORIENT("R0");
// %t7886 @TEXT("n978", key="name", size=0.75);
// &n978 @WIRE(mode="straight") {#X1481:1 %t7886:p};
// %t7887 = $IO_PORT @ATTACH &n1632 => @PLACE(198, -3768) => @ORIENT("R0");
// %t7887 @TEXT("n1632", key="name", size=0.75);
// &n1632 @WIRE(mode="straight") {#X1481:2 %t7887:p};
// %t7888 = $IO_PORT @ATTACH &n51 => @PLACE(198, -3772) => @ORIENT("R0");
// %t7888 @TEXT("n51", key="name", size=0.75);
// &n51 @WIRE(mode="straight") {#X1481:3 %t7888:p};
// %t7889 = $IO_PORT @ATTACH &n180 => @PLACE(218, -3768) => @ORIENT("MY");
// %t7889 @TEXT("n180", key="name", size=0.75);
// &n180 @WIRE(mode="straight") {#X1481:4 %t7889:p};
// %t7890 = $SUPPLY @ATTACH &vdd => @PLACE(208, -3755);
// &vdd @WIRE(mode="straight") {#X1481:5 %t7890:p};
// %t7891 = $GROUND @ATTACH &vss => @PLACE(208, -3781);
// &vss @WIRE(mode="straight") {#X1481:6 %t7891:p};
// %t7892 = $IO_PORT @ATTACH &n1484 => @PLACE(238, -3766) => @ORIENT("R0");
// %t7892 @TEXT("n1484", key="name", size=0.75);
// &n1484 @WIRE(mode="straight") {#X1482:1 %t7892:p};
// %t7893 = $IO_PORT @ATTACH &n1055 => @PLACE(238, -3770) => @ORIENT("R0");
// %t7893 @TEXT("n1055", key="name", size=0.75);
// &n1055 @WIRE(mode="straight") {#X1482:2 %t7893:p};
// %t7894 = $IO_PORT @ATTACH &n1180 => @PLACE(258, -3768) => @ORIENT("MY");
// %t7894 @TEXT("n1180", key="name", size=0.75);
// &n1180 @WIRE(mode="straight") {#X1482:3 %t7894:p};
// %t7895 = $SUPPLY @ATTACH &vdd => @PLACE(248, -3757);
// &vdd @WIRE(mode="straight") {#X1482:4 %t7895:p};
// %t7896 = $GROUND @ATTACH &vss => @PLACE(248, -3779);
// &vss @WIRE(mode="straight") {#X1482:5 %t7896:p};
// %t7897 = $IO_PORT @ATTACH &n1476 => @PLACE(278, -3766) => @ORIENT("R0");
// %t7897 @TEXT("n1476", key="name", size=0.75);
// &n1476 @WIRE(mode="straight") {#X1483:1 %t7897:p};
// %t7898 = $IO_PORT @ATTACH &n1238 => @PLACE(278, -3770) => @ORIENT("R0");
// %t7898 @TEXT("n1238", key="name", size=0.75);
// &n1238 @WIRE(mode="straight") {#X1483:2 %t7898:p};
// %t7899 = $IO_PORT @ATTACH &n1181 => @PLACE(298, -3768) => @ORIENT("MY");
// %t7899 @TEXT("n1181", key="name", size=0.75);
// &n1181 @WIRE(mode="straight") {#X1483:3 %t7899:p};
// %t7900 = $SUPPLY @ATTACH &vdd => @PLACE(288, -3757);
// &vdd @WIRE(mode="straight") {#X1483:4 %t7900:p};
// %t7901 = $GROUND @ATTACH &vss => @PLACE(288, -3779);
// &vss @WIRE(mode="straight") {#X1483:5 %t7901:p};
// %t7902 = $IO_PORT @ATTACH &n1468 => @PLACE(158, -3801) => @ORIENT("R0");
// %t7902 @TEXT("n1468", key="name", size=0.75);
// &n1468 @WIRE(mode="straight") {#X1484:1 %t7902:p};
// %t7903 = $IO_PORT @ATTACH &n1053 => @PLACE(158, -3805) => @ORIENT("R0");
// %t7903 @TEXT("n1053", key="name", size=0.75);
// &n1053 @WIRE(mode="straight") {#X1484:2 %t7903:p};
// %t7904 = $IO_PORT @ATTACH &n1183 => @PLACE(178, -3803) => @ORIENT("MY");
// %t7904 @TEXT("n1183", key="name", size=0.75);
// &n1183 @WIRE(mode="straight") {#X1484:3 %t7904:p};
// %t7905 = $SUPPLY @ATTACH &vdd => @PLACE(168, -3792);
// &vdd @WIRE(mode="straight") {#X1484:4 %t7905:p};
// %t7906 = $GROUND @ATTACH &vss => @PLACE(168, -3814);
// &vss @WIRE(mode="straight") {#X1484:5 %t7906:p};
// %t7907 = $IO_PORT @ATTACH &n1460 => @PLACE(198, -3801) => @ORIENT("R0");
// %t7907 @TEXT("n1460", key="name", size=0.75);
// &n1460 @WIRE(mode="straight") {#X1485:1 %t7907:p};
// %t7908 = $IO_PORT @ATTACH &n1175 => @PLACE(198, -3805) => @ORIENT("R0");
// %t7908 @TEXT("n1175", key="name", size=0.75);
// &n1175 @WIRE(mode="straight") {#X1485:2 %t7908:p};
// %t7909 = $IO_PORT @ATTACH &n1184 => @PLACE(218, -3803) => @ORIENT("MY");
// %t7909 @TEXT("n1184", key="name", size=0.75);
// &n1184 @WIRE(mode="straight") {#X1485:3 %t7909:p};
// %t7910 = $SUPPLY @ATTACH &vdd => @PLACE(208, -3792);
// &vdd @WIRE(mode="straight") {#X1485:4 %t7910:p};
// %t7911 = $GROUND @ATTACH &vss => @PLACE(208, -3814);
// &vss @WIRE(mode="straight") {#X1485:5 %t7911:p};
// %t7912 = $IO_PORT @ATTACH &n1485 => @PLACE(238, -3801) => @ORIENT("R0");
// %t7912 @TEXT("n1485", key="name", size=0.75);
// &n1485 @WIRE(mode="straight") {#X1486:1 %t7912:p};
// %t7913 = $IO_PORT @ATTACH &n1055 => @PLACE(238, -3805) => @ORIENT("R0");
// %t7913 @TEXT("n1055", key="name", size=0.75);
// &n1055 @WIRE(mode="straight") {#X1486:2 %t7913:p};
// %t7914 = $IO_PORT @ATTACH &n1187 => @PLACE(258, -3803) => @ORIENT("MY");
// %t7914 @TEXT("n1187", key="name", size=0.75);
// &n1187 @WIRE(mode="straight") {#X1486:3 %t7914:p};
// %t7915 = $SUPPLY @ATTACH &vdd => @PLACE(248, -3792);
// &vdd @WIRE(mode="straight") {#X1486:4 %t7915:p};
// %t7916 = $GROUND @ATTACH &vss => @PLACE(248, -3814);
// &vss @WIRE(mode="straight") {#X1486:5 %t7916:p};
// %t7917 = $IO_PORT @ATTACH &n1477 => @PLACE(278, -3801) => @ORIENT("R0");
// %t7917 @TEXT("n1477", key="name", size=0.75);
// &n1477 @WIRE(mode="straight") {#X1487:1 %t7917:p};
// %t7918 = $IO_PORT @ATTACH &n1238 => @PLACE(278, -3805) => @ORIENT("R0");
// %t7918 @TEXT("n1238", key="name", size=0.75);
// &n1238 @WIRE(mode="straight") {#X1487:2 %t7918:p};
// %t7919 = $IO_PORT @ATTACH &n1188 => @PLACE(298, -3803) => @ORIENT("MY");
// %t7919 @TEXT("n1188", key="name", size=0.75);
// &n1188 @WIRE(mode="straight") {#X1487:3 %t7919:p};
// %t7920 = $SUPPLY @ATTACH &vdd => @PLACE(288, -3792);
// &vdd @WIRE(mode="straight") {#X1487:4 %t7920:p};
// %t7921 = $GROUND @ATTACH &vss => @PLACE(288, -3814);
// &vss @WIRE(mode="straight") {#X1487:5 %t7921:p};
// %t7922 = $IO_PORT @ATTACH &n1469 => @PLACE(326, -3626) => @ORIENT("R0");
// %t7922 @TEXT("n1469", key="name", size=0.75);
// &n1469 @WIRE(mode="straight") {#X1488:1 %t7922:p};
// %t7923 = $IO_PORT @ATTACH &n1053 => @PLACE(326, -3630) => @ORIENT("R0");
// %t7923 @TEXT("n1053", key="name", size=0.75);
// &n1053 @WIRE(mode="straight") {#X1488:2 %t7923:p};
// %t7924 = $IO_PORT @ATTACH &n1190 => @PLACE(346, -3628) => @ORIENT("MY");
// %t7924 @TEXT("n1190", key="name", size=0.75);
// &n1190 @WIRE(mode="straight") {#X1488:3 %t7924:p};
// %t7925 = $SUPPLY @ATTACH &vdd => @PLACE(336, -3617);
// &vdd @WIRE(mode="straight") {#X1488:4 %t7925:p};
// %t7926 = $GROUND @ATTACH &vss => @PLACE(336, -3639);
// &vss @WIRE(mode="straight") {#X1488:5 %t7926:p};
// %t7927 = $IO_PORT @ATTACH &n1461 => @PLACE(366, -3626) => @ORIENT("R0");
// %t7927 @TEXT("n1461", key="name", size=0.75);
// &n1461 @WIRE(mode="straight") {#X1489:1 %t7927:p};
// %t7928 = $IO_PORT @ATTACH &n1175 => @PLACE(366, -3630) => @ORIENT("R0");
// %t7928 @TEXT("n1175", key="name", size=0.75);
// &n1175 @WIRE(mode="straight") {#X1489:2 %t7928:p};
// %t7929 = $IO_PORT @ATTACH &n1191 => @PLACE(386, -3628) => @ORIENT("MY");
// %t7929 @TEXT("n1191", key="name", size=0.75);
// &n1191 @WIRE(mode="straight") {#X1489:3 %t7929:p};
// %t7930 = $SUPPLY @ATTACH &vdd => @PLACE(376, -3617);
// &vdd @WIRE(mode="straight") {#X1489:4 %t7930:p};
// %t7931 = $GROUND @ATTACH &vss => @PLACE(376, -3639);
// &vss @WIRE(mode="straight") {#X1489:5 %t7931:p};
// %t7932 = $IO_PORT @ATTACH &n1486 => @PLACE(406, -3626) => @ORIENT("R0");
// %t7932 @TEXT("n1486", key="name", size=0.75);
// &n1486 @WIRE(mode="straight") {#X1490:1 %t7932:p};
// %t7933 = $IO_PORT @ATTACH &n1055 => @PLACE(406, -3630) => @ORIENT("R0");
// %t7933 @TEXT("n1055", key="name", size=0.75);
// &n1055 @WIRE(mode="straight") {#X1490:2 %t7933:p};
// %t7934 = $IO_PORT @ATTACH &n1194 => @PLACE(426, -3628) => @ORIENT("MY");
// %t7934 @TEXT("n1194", key="name", size=0.75);
// &n1194 @WIRE(mode="straight") {#X1490:3 %t7934:p};
// %t7935 = $SUPPLY @ATTACH &vdd => @PLACE(416, -3617);
// &vdd @WIRE(mode="straight") {#X1490:4 %t7935:p};
// %t7936 = $GROUND @ATTACH &vss => @PLACE(416, -3639);
// &vss @WIRE(mode="straight") {#X1490:5 %t7936:p};
// %t7937 = $IO_PORT @ATTACH &n1478 => @PLACE(446, -3626) => @ORIENT("R0");
// %t7937 @TEXT("n1478", key="name", size=0.75);
// &n1478 @WIRE(mode="straight") {#X1491:1 %t7937:p};
// %t7938 = $IO_PORT @ATTACH &n1238 => @PLACE(446, -3630) => @ORIENT("R0");
// %t7938 @TEXT("n1238", key="name", size=0.75);
// &n1238 @WIRE(mode="straight") {#X1491:2 %t7938:p};
// %t7939 = $IO_PORT @ATTACH &n1195 => @PLACE(466, -3628) => @ORIENT("MY");
// %t7939 @TEXT("n1195", key="name", size=0.75);
// &n1195 @WIRE(mode="straight") {#X1491:3 %t7939:p};
// %t7940 = $SUPPLY @ATTACH &vdd => @PLACE(456, -3617);
// &vdd @WIRE(mode="straight") {#X1491:4 %t7940:p};
// %t7941 = $GROUND @ATTACH &vss => @PLACE(456, -3639);
// &vss @WIRE(mode="straight") {#X1491:5 %t7941:p};
// %t7942 = $IO_PORT @ATTACH &n1470 => @PLACE(326, -3661) => @ORIENT("R0");
// %t7942 @TEXT("n1470", key="name", size=0.75);
// &n1470 @WIRE(mode="straight") {#X1492:1 %t7942:p};
// %t7943 = $IO_PORT @ATTACH &n1053 => @PLACE(326, -3665) => @ORIENT("R0");
// %t7943 @TEXT("n1053", key="name", size=0.75);
// &n1053 @WIRE(mode="straight") {#X1492:2 %t7943:p};
// %t7944 = $IO_PORT @ATTACH &n1197 => @PLACE(346, -3663) => @ORIENT("MY");
// %t7944 @TEXT("n1197", key="name", size=0.75);
// &n1197 @WIRE(mode="straight") {#X1492:3 %t7944:p};
// %t7945 = $SUPPLY @ATTACH &vdd => @PLACE(336, -3652);
// &vdd @WIRE(mode="straight") {#X1492:4 %t7945:p};
// %t7946 = $GROUND @ATTACH &vss => @PLACE(336, -3674);
// &vss @WIRE(mode="straight") {#X1492:5 %t7946:p};
// %t7947 = $IO_PORT @ATTACH &n1462 => @PLACE(366, -3661) => @ORIENT("R0");
// %t7947 @TEXT("n1462", key="name", size=0.75);
// &n1462 @WIRE(mode="straight") {#X1493:1 %t7947:p};
// %t7948 = $IO_PORT @ATTACH &n1175 => @PLACE(366, -3665) => @ORIENT("R0");
// %t7948 @TEXT("n1175", key="name", size=0.75);
// &n1175 @WIRE(mode="straight") {#X1493:2 %t7948:p};
// %t7949 = $IO_PORT @ATTACH &n1198 => @PLACE(386, -3663) => @ORIENT("MY");
// %t7949 @TEXT("n1198", key="name", size=0.75);
// &n1198 @WIRE(mode="straight") {#X1493:3 %t7949:p};
// %t7950 = $SUPPLY @ATTACH &vdd => @PLACE(376, -3652);
// &vdd @WIRE(mode="straight") {#X1493:4 %t7950:p};
// %t7951 = $GROUND @ATTACH &vss => @PLACE(376, -3674);
// &vss @WIRE(mode="straight") {#X1493:5 %t7951:p};
// %t7952 = $IO_PORT @ATTACH &n1487 => @PLACE(406, -3661) => @ORIENT("R0");
// %t7952 @TEXT("n1487", key="name", size=0.75);
// &n1487 @WIRE(mode="straight") {#X1494:1 %t7952:p};
// %t7953 = $IO_PORT @ATTACH &n1055 => @PLACE(406, -3665) => @ORIENT("R0");
// %t7953 @TEXT("n1055", key="name", size=0.75);
// &n1055 @WIRE(mode="straight") {#X1494:2 %t7953:p};
// %t7954 = $IO_PORT @ATTACH &n1201 => @PLACE(426, -3663) => @ORIENT("MY");
// %t7954 @TEXT("n1201", key="name", size=0.75);
// &n1201 @WIRE(mode="straight") {#X1494:3 %t7954:p};
// %t7955 = $SUPPLY @ATTACH &vdd => @PLACE(416, -3652);
// &vdd @WIRE(mode="straight") {#X1494:4 %t7955:p};
// %t7956 = $GROUND @ATTACH &vss => @PLACE(416, -3674);
// &vss @WIRE(mode="straight") {#X1494:5 %t7956:p};
// %t7957 = $IO_PORT @ATTACH &n1479 => @PLACE(446, -3661) => @ORIENT("R0");
// %t7957 @TEXT("n1479", key="name", size=0.75);
// &n1479 @WIRE(mode="straight") {#X1495:1 %t7957:p};
// %t7958 = $IO_PORT @ATTACH &n1238 => @PLACE(446, -3665) => @ORIENT("R0");
// %t7958 @TEXT("n1238", key="name", size=0.75);
// &n1238 @WIRE(mode="straight") {#X1495:2 %t7958:p};
// %t7959 = $IO_PORT @ATTACH &n1202 => @PLACE(466, -3663) => @ORIENT("MY");
// %t7959 @TEXT("n1202", key="name", size=0.75);
// &n1202 @WIRE(mode="straight") {#X1495:3 %t7959:p};
// %t7960 = $SUPPLY @ATTACH &vdd => @PLACE(456, -3652);
// &vdd @WIRE(mode="straight") {#X1495:4 %t7960:p};
// %t7961 = $GROUND @ATTACH &vss => @PLACE(456, -3674);
// &vss @WIRE(mode="straight") {#X1495:5 %t7961:p};
// %t7962 = $IO_PORT @ATTACH &n1471 => @PLACE(326, -3696) => @ORIENT("R0");
// %t7962 @TEXT("n1471", key="name", size=0.75);
// &n1471 @WIRE(mode="straight") {#X1496:1 %t7962:p};
// %t7963 = $IO_PORT @ATTACH &n1053 => @PLACE(326, -3700) => @ORIENT("R0");
// %t7963 @TEXT("n1053", key="name", size=0.75);
// &n1053 @WIRE(mode="straight") {#X1496:2 %t7963:p};
// %t7964 = $IO_PORT @ATTACH &n1204 => @PLACE(346, -3698) => @ORIENT("MY");
// %t7964 @TEXT("n1204", key="name", size=0.75);
// &n1204 @WIRE(mode="straight") {#X1496:3 %t7964:p};
// %t7965 = $SUPPLY @ATTACH &vdd => @PLACE(336, -3687);
// &vdd @WIRE(mode="straight") {#X1496:4 %t7965:p};
// %t7966 = $GROUND @ATTACH &vss => @PLACE(336, -3709);
// &vss @WIRE(mode="straight") {#X1496:5 %t7966:p};
// %t7967 = $IO_PORT @ATTACH &n1463 => @PLACE(366, -3696) => @ORIENT("R0");
// %t7967 @TEXT("n1463", key="name", size=0.75);
// &n1463 @WIRE(mode="straight") {#X1497:1 %t7967:p};
// %t7968 = $IO_PORT @ATTACH &n1175 => @PLACE(366, -3700) => @ORIENT("R0");
// %t7968 @TEXT("n1175", key="name", size=0.75);
// &n1175 @WIRE(mode="straight") {#X1497:2 %t7968:p};
// %t7969 = $IO_PORT @ATTACH &n1205 => @PLACE(386, -3698) => @ORIENT("MY");
// %t7969 @TEXT("n1205", key="name", size=0.75);
// &n1205 @WIRE(mode="straight") {#X1497:3 %t7969:p};
// %t7970 = $SUPPLY @ATTACH &vdd => @PLACE(376, -3687);
// &vdd @WIRE(mode="straight") {#X1497:4 %t7970:p};
// %t7971 = $GROUND @ATTACH &vss => @PLACE(376, -3709);
// &vss @WIRE(mode="straight") {#X1497:5 %t7971:p};
// %t7972 = $IO_PORT @ATTACH &n1488 => @PLACE(406, -3696) => @ORIENT("R0");
// %t7972 @TEXT("n1488", key="name", size=0.75);
// &n1488 @WIRE(mode="straight") {#X1498:1 %t7972:p};
// %t7973 = $IO_PORT @ATTACH &n1055 => @PLACE(406, -3700) => @ORIENT("R0");
// %t7973 @TEXT("n1055", key="name", size=0.75);
// &n1055 @WIRE(mode="straight") {#X1498:2 %t7973:p};
// %t7974 = $IO_PORT @ATTACH &n1208 => @PLACE(426, -3698) => @ORIENT("MY");
// %t7974 @TEXT("n1208", key="name", size=0.75);
// &n1208 @WIRE(mode="straight") {#X1498:3 %t7974:p};
// %t7975 = $SUPPLY @ATTACH &vdd => @PLACE(416, -3687);
// &vdd @WIRE(mode="straight") {#X1498:4 %t7975:p};
// %t7976 = $GROUND @ATTACH &vss => @PLACE(416, -3709);
// &vss @WIRE(mode="straight") {#X1498:5 %t7976:p};
// %t7977 = $IO_PORT @ATTACH &n1480 => @PLACE(446, -3696) => @ORIENT("R0");
// %t7977 @TEXT("n1480", key="name", size=0.75);
// &n1480 @WIRE(mode="straight") {#X1499:1 %t7977:p};
// %t7978 = $IO_PORT @ATTACH &n1238 => @PLACE(446, -3700) => @ORIENT("R0");
// %t7978 @TEXT("n1238", key="name", size=0.75);
// &n1238 @WIRE(mode="straight") {#X1499:2 %t7978:p};
// %t7979 = $IO_PORT @ATTACH &n1209 => @PLACE(466, -3698) => @ORIENT("MY");
// %t7979 @TEXT("n1209", key="name", size=0.75);
// &n1209 @WIRE(mode="straight") {#X1499:3 %t7979:p};
// %t7980 = $SUPPLY @ATTACH &vdd => @PLACE(456, -3687);
// &vdd @WIRE(mode="straight") {#X1499:4 %t7980:p};
// %t7981 = $GROUND @ATTACH &vss => @PLACE(456, -3709);
// &vss @WIRE(mode="straight") {#X1499:5 %t7981:p};
// %t7982 = $IO_PORT @ATTACH &n1472 => @PLACE(326, -3731) => @ORIENT("R0");
// %t7982 @TEXT("n1472", key="name", size=0.75);
// &n1472 @WIRE(mode="straight") {#X1500:1 %t7982:p};
// %t7983 = $IO_PORT @ATTACH &n1053 => @PLACE(326, -3735) => @ORIENT("R0");
// %t7983 @TEXT("n1053", key="name", size=0.75);
// &n1053 @WIRE(mode="straight") {#X1500:2 %t7983:p};
// %t7984 = $IO_PORT @ATTACH &n1211 => @PLACE(346, -3733) => @ORIENT("MY");
// %t7984 @TEXT("n1211", key="name", size=0.75);
// &n1211 @WIRE(mode="straight") {#X1500:3 %t7984:p};
// %t7985 = $SUPPLY @ATTACH &vdd => @PLACE(336, -3722);
// &vdd @WIRE(mode="straight") {#X1500:4 %t7985:p};
// %t7986 = $GROUND @ATTACH &vss => @PLACE(336, -3744);
// &vss @WIRE(mode="straight") {#X1500:5 %t7986:p};
// %t7987 = $IO_PORT @ATTACH &n1464 => @PLACE(366, -3731) => @ORIENT("R0");
// %t7987 @TEXT("n1464", key="name", size=0.75);
// &n1464 @WIRE(mode="straight") {#X1501:1 %t7987:p};
// %t7988 = $IO_PORT @ATTACH &n1175 => @PLACE(366, -3735) => @ORIENT("R0");
// %t7988 @TEXT("n1175", key="name", size=0.75);
// &n1175 @WIRE(mode="straight") {#X1501:2 %t7988:p};
// %t7989 = $IO_PORT @ATTACH &n1212 => @PLACE(386, -3733) => @ORIENT("MY");
// %t7989 @TEXT("n1212", key="name", size=0.75);
// &n1212 @WIRE(mode="straight") {#X1501:3 %t7989:p};
// %t7990 = $SUPPLY @ATTACH &vdd => @PLACE(376, -3722);
// &vdd @WIRE(mode="straight") {#X1501:4 %t7990:p};
// %t7991 = $GROUND @ATTACH &vss => @PLACE(376, -3744);
// &vss @WIRE(mode="straight") {#X1501:5 %t7991:p};
// %t7992 = $IO_PORT @ATTACH &n1489 => @PLACE(406, -3731) => @ORIENT("R0");
// %t7992 @TEXT("n1489", key="name", size=0.75);
// &n1489 @WIRE(mode="straight") {#X1502:1 %t7992:p};
// %t7993 = $IO_PORT @ATTACH &n1055 => @PLACE(406, -3735) => @ORIENT("R0");
// %t7993 @TEXT("n1055", key="name", size=0.75);
// &n1055 @WIRE(mode="straight") {#X1502:2 %t7993:p};
// %t7994 = $IO_PORT @ATTACH &n1215 => @PLACE(426, -3733) => @ORIENT("MY");
// %t7994 @TEXT("n1215", key="name", size=0.75);
// &n1215 @WIRE(mode="straight") {#X1502:3 %t7994:p};
// %t7995 = $SUPPLY @ATTACH &vdd => @PLACE(416, -3722);
// &vdd @WIRE(mode="straight") {#X1502:4 %t7995:p};
// %t7996 = $GROUND @ATTACH &vss => @PLACE(416, -3744);
// &vss @WIRE(mode="straight") {#X1502:5 %t7996:p};
// %t7997 = $IO_PORT @ATTACH &n1481 => @PLACE(446, -3731) => @ORIENT("R0");
// %t7997 @TEXT("n1481", key="name", size=0.75);
// &n1481 @WIRE(mode="straight") {#X1503:1 %t7997:p};
// %t7998 = $IO_PORT @ATTACH &n1238 => @PLACE(446, -3735) => @ORIENT("R0");
// %t7998 @TEXT("n1238", key="name", size=0.75);
// &n1238 @WIRE(mode="straight") {#X1503:2 %t7998:p};
// %t7999 = $IO_PORT @ATTACH &n1216 => @PLACE(466, -3733) => @ORIENT("MY");
// %t7999 @TEXT("n1216", key="name", size=0.75);
// &n1216 @WIRE(mode="straight") {#X1503:3 %t7999:p};
// %t8000 = $SUPPLY @ATTACH &vdd => @PLACE(456, -3722);
// &vdd @WIRE(mode="straight") {#X1503:4 %t8000:p};
// %t8001 = $GROUND @ATTACH &vss => @PLACE(456, -3744);
// &vss @WIRE(mode="straight") {#X1503:5 %t8001:p};
// %t8002 = $IO_PORT @ATTACH &n1473 => @PLACE(326, -3766) => @ORIENT("R0");
// %t8002 @TEXT("n1473", key="name", size=0.75);
// &n1473 @WIRE(mode="straight") {#X1504:1 %t8002:p};
// %t8003 = $IO_PORT @ATTACH &n1053 => @PLACE(326, -3770) => @ORIENT("R0");
// %t8003 @TEXT("n1053", key="name", size=0.75);
// &n1053 @WIRE(mode="straight") {#X1504:2 %t8003:p};
// %t8004 = $IO_PORT @ATTACH &n1218 => @PLACE(346, -3768) => @ORIENT("MY");
// %t8004 @TEXT("n1218", key="name", size=0.75);
// &n1218 @WIRE(mode="straight") {#X1504:3 %t8004:p};
// %t8005 = $SUPPLY @ATTACH &vdd => @PLACE(336, -3757);
// &vdd @WIRE(mode="straight") {#X1504:4 %t8005:p};
// %t8006 = $GROUND @ATTACH &vss => @PLACE(336, -3779);
// &vss @WIRE(mode="straight") {#X1504:5 %t8006:p};
// %t8007 = $IO_PORT @ATTACH &n1465 => @PLACE(366, -3766) => @ORIENT("R0");
// %t8007 @TEXT("n1465", key="name", size=0.75);
// &n1465 @WIRE(mode="straight") {#X1505:1 %t8007:p};
// %t8008 = $IO_PORT @ATTACH &n1175 => @PLACE(366, -3770) => @ORIENT("R0");
// %t8008 @TEXT("n1175", key="name", size=0.75);
// &n1175 @WIRE(mode="straight") {#X1505:2 %t8008:p};
// %t8009 = $IO_PORT @ATTACH &n1219 => @PLACE(386, -3768) => @ORIENT("MY");
// %t8009 @TEXT("n1219", key="name", size=0.75);
// &n1219 @WIRE(mode="straight") {#X1505:3 %t8009:p};
// %t8010 = $SUPPLY @ATTACH &vdd => @PLACE(376, -3757);
// &vdd @WIRE(mode="straight") {#X1505:4 %t8010:p};
// %t8011 = $GROUND @ATTACH &vss => @PLACE(376, -3779);
// &vss @WIRE(mode="straight") {#X1505:5 %t8011:p};
// %t8012 = $IO_PORT @ATTACH &n1490 => @PLACE(406, -3766) => @ORIENT("R0");
// %t8012 @TEXT("n1490", key="name", size=0.75);
// &n1490 @WIRE(mode="straight") {#X1506:1 %t8012:p};
// %t8013 = $IO_PORT @ATTACH &n1055 => @PLACE(406, -3770) => @ORIENT("R0");
// %t8013 @TEXT("n1055", key="name", size=0.75);
// &n1055 @WIRE(mode="straight") {#X1506:2 %t8013:p};
// %t8014 = $IO_PORT @ATTACH &n1222 => @PLACE(426, -3768) => @ORIENT("MY");
// %t8014 @TEXT("n1222", key="name", size=0.75);
// &n1222 @WIRE(mode="straight") {#X1506:3 %t8014:p};
// %t8015 = $SUPPLY @ATTACH &vdd => @PLACE(416, -3757);
// &vdd @WIRE(mode="straight") {#X1506:4 %t8015:p};
// %t8016 = $GROUND @ATTACH &vss => @PLACE(416, -3779);
// &vss @WIRE(mode="straight") {#X1506:5 %t8016:p};
// %t8017 = $IO_PORT @ATTACH &n1482 => @PLACE(446, -3766) => @ORIENT("R0");
// %t8017 @TEXT("n1482", key="name", size=0.75);
// &n1482 @WIRE(mode="straight") {#X1507:1 %t8017:p};
// %t8018 = $IO_PORT @ATTACH &n1238 => @PLACE(446, -3770) => @ORIENT("R0");
// %t8018 @TEXT("n1238", key="name", size=0.75);
// &n1238 @WIRE(mode="straight") {#X1507:2 %t8018:p};
// %t8019 = $IO_PORT @ATTACH &n1223 => @PLACE(466, -3768) => @ORIENT("MY");
// %t8019 @TEXT("n1223", key="name", size=0.75);
// &n1223 @WIRE(mode="straight") {#X1507:3 %t8019:p};
// %t8020 = $SUPPLY @ATTACH &vdd => @PLACE(456, -3757);
// &vdd @WIRE(mode="straight") {#X1507:4 %t8020:p};
// %t8021 = $GROUND @ATTACH &vss => @PLACE(456, -3779);
// &vss @WIRE(mode="straight") {#X1507:5 %t8021:p};
// %t8022 = $IO_PORT @ATTACH &n1474 => @PLACE(326, -3801) => @ORIENT("R0");
// %t8022 @TEXT("n1474", key="name", size=0.75);
// &n1474 @WIRE(mode="straight") {#X1508:1 %t8022:p};
// %t8023 = $IO_PORT @ATTACH &n1053 => @PLACE(326, -3805) => @ORIENT("R0");
// %t8023 @TEXT("n1053", key="name", size=0.75);
// &n1053 @WIRE(mode="straight") {#X1508:2 %t8023:p};
// %t8024 = $IO_PORT @ATTACH &n1225 => @PLACE(346, -3803) => @ORIENT("MY");
// %t8024 @TEXT("n1225", key="name", size=0.75);
// &n1225 @WIRE(mode="straight") {#X1508:3 %t8024:p};
// %t8025 = $SUPPLY @ATTACH &vdd => @PLACE(336, -3792);
// &vdd @WIRE(mode="straight") {#X1508:4 %t8025:p};
// %t8026 = $GROUND @ATTACH &vss => @PLACE(336, -3814);
// &vss @WIRE(mode="straight") {#X1508:5 %t8026:p};
// %t8027 = $IO_PORT @ATTACH &n1466 => @PLACE(366, -3801) => @ORIENT("R0");
// %t8027 @TEXT("n1466", key="name", size=0.75);
// &n1466 @WIRE(mode="straight") {#X1509:1 %t8027:p};
// %t8028 = $IO_PORT @ATTACH &n1175 => @PLACE(366, -3805) => @ORIENT("R0");
// %t8028 @TEXT("n1175", key="name", size=0.75);
// &n1175 @WIRE(mode="straight") {#X1509:2 %t8028:p};
// %t8029 = $IO_PORT @ATTACH &n1226 => @PLACE(386, -3803) => @ORIENT("MY");
// %t8029 @TEXT("n1226", key="name", size=0.75);
// &n1226 @WIRE(mode="straight") {#X1509:3 %t8029:p};
// %t8030 = $SUPPLY @ATTACH &vdd => @PLACE(376, -3792);
// &vdd @WIRE(mode="straight") {#X1509:4 %t8030:p};
// %t8031 = $GROUND @ATTACH &vss => @PLACE(376, -3814);
// &vss @WIRE(mode="straight") {#X1509:5 %t8031:p};
// %t8032 = $IO_PORT @ATTACH &n1491 => @PLACE(406, -3801) => @ORIENT("R0");
// %t8032 @TEXT("n1491", key="name", size=0.75);
// &n1491 @WIRE(mode="straight") {#X1510:1 %t8032:p};
// %t8033 = $IO_PORT @ATTACH &n1055 => @PLACE(406, -3805) => @ORIENT("R0");
// %t8033 @TEXT("n1055", key="name", size=0.75);
// &n1055 @WIRE(mode="straight") {#X1510:2 %t8033:p};
// %t8034 = $IO_PORT @ATTACH &n1229 => @PLACE(426, -3803) => @ORIENT("MY");
// %t8034 @TEXT("n1229", key="name", size=0.75);
// &n1229 @WIRE(mode="straight") {#X1510:3 %t8034:p};
// %t8035 = $SUPPLY @ATTACH &vdd => @PLACE(416, -3792);
// &vdd @WIRE(mode="straight") {#X1510:4 %t8035:p};
// %t8036 = $GROUND @ATTACH &vss => @PLACE(416, -3814);
// &vss @WIRE(mode="straight") {#X1510:5 %t8036:p};
// %t8037 = $IO_PORT @ATTACH &n1483 => @PLACE(446, -3801) => @ORIENT("R0");
// %t8037 @TEXT("n1483", key="name", size=0.75);
// &n1483 @WIRE(mode="straight") {#X1511:1 %t8037:p};
// %t8038 = $IO_PORT @ATTACH &n1238 => @PLACE(446, -3805) => @ORIENT("R0");
// %t8038 @TEXT("n1238", key="name", size=0.75);
// &n1238 @WIRE(mode="straight") {#X1511:2 %t8038:p};
// %t8039 = $IO_PORT @ATTACH &n1230 => @PLACE(466, -3803) => @ORIENT("MY");
// %t8039 @TEXT("n1230", key="name", size=0.75);
// &n1230 @WIRE(mode="straight") {#X1511:3 %t8039:p};
// %t8040 = $SUPPLY @ATTACH &vdd => @PLACE(456, -3792);
// &vdd @WIRE(mode="straight") {#X1511:4 %t8040:p};
// %t8041 = $GROUND @ATTACH &vss => @PLACE(456, -3814);
// &vss @WIRE(mode="straight") {#X1511:5 %t8041:p};
// %t8042 = $IO_PORT @ATTACH &n1475 => @PLACE(494, -3626) => @ORIENT("R0");
// %t8042 @TEXT("n1475", key="name", size=0.75);
// &n1475 @WIRE(mode="straight") {#X1512:1 %t8042:p};
// %t8043 = $IO_PORT @ATTACH &n1053 => @PLACE(494, -3630) => @ORIENT("R0");
// %t8043 @TEXT("n1053", key="name", size=0.75);
// &n1053 @WIRE(mode="straight") {#X1512:2 %t8043:p};
// %t8044 = $IO_PORT @ATTACH &n1232 => @PLACE(514, -3628) => @ORIENT("MY");
// %t8044 @TEXT("n1232", key="name", size=0.75);
// &n1232 @WIRE(mode="straight") {#X1512:3 %t8044:p};
// %t8045 = $SUPPLY @ATTACH &vdd => @PLACE(504, -3617);
// &vdd @WIRE(mode="straight") {#X1512:4 %t8045:p};
// %t8046 = $GROUND @ATTACH &vss => @PLACE(504, -3639);
// &vss @WIRE(mode="straight") {#X1512:5 %t8046:p};
// %t8047 = $IO_PORT @ATTACH &n1467 => @PLACE(534, -3626) => @ORIENT("R0");
// %t8047 @TEXT("n1467", key="name", size=0.75);
// &n1467 @WIRE(mode="straight") {#X1513:1 %t8047:p};
// %t8048 = $IO_PORT @ATTACH &n1175 => @PLACE(534, -3630) => @ORIENT("R0");
// %t8048 @TEXT("n1175", key="name", size=0.75);
// &n1175 @WIRE(mode="straight") {#X1513:2 %t8048:p};
// %t8049 = $IO_PORT @ATTACH &n1233 => @PLACE(554, -3628) => @ORIENT("MY");
// %t8049 @TEXT("n1233", key="name", size=0.75);
// &n1233 @WIRE(mode="straight") {#X1513:3 %t8049:p};
// %t8050 = $SUPPLY @ATTACH &vdd => @PLACE(544, -3617);
// &vdd @WIRE(mode="straight") {#X1513:4 %t8050:p};
// %t8051 = $GROUND @ATTACH &vss => @PLACE(544, -3639);
// &vss @WIRE(mode="straight") {#X1513:5 %t8051:p};
// %t8052 = $IO_PORT @ATTACH &n1505 => @PLACE(574, -3626) => @ORIENT("R0");
// %t8052 @TEXT("n1505", key="name", size=0.75);
// &n1505 @WIRE(mode="straight") {#X1514:1 %t8052:p};
// %t8053 = $IO_PORT @ATTACH &n184 => @PLACE(574, -3630) => @ORIENT("R0");
// %t8053 @TEXT("n184", key="name", size=0.75);
// &n184 @WIRE(mode="straight") {#X1514:2 %t8053:p};
// %t8054 = $IO_PORT @ATTACH &n1241 => @PLACE(594, -3628) => @ORIENT("MY");
// %t8054 @TEXT("n1241", key="name", size=0.75);
// &n1241 @WIRE(mode="straight") {#X1514:3 %t8054:p};
// %t8055 = $SUPPLY @ATTACH &vdd => @PLACE(584, -3617);
// &vdd @WIRE(mode="straight") {#X1514:4 %t8055:p};
// %t8056 = $GROUND @ATTACH &vss => @PLACE(584, -3639);
// &vss @WIRE(mode="straight") {#X1514:5 %t8056:p};
// %t8057 = $IO_PORT @ATTACH &n1511 => @PLACE(614, -3626) => @ORIENT("R0");
// %t8057 @TEXT("n1511", key="name", size=0.75);
// &n1511 @WIRE(mode="straight") {#X1515:1 %t8057:p};
// %t8058 = $IO_PORT @ATTACH &n1055 => @PLACE(614, -3630) => @ORIENT("R0");
// %t8058 @TEXT("n1055", key="name", size=0.75);
// &n1055 @WIRE(mode="straight") {#X1515:2 %t8058:p};
// %t8059 = $IO_PORT @ATTACH &n1245 => @PLACE(635, -3628) => @ORIENT("MY");
// %t8059 @TEXT("n1245", key="name", size=0.75);
// &n1245 @WIRE(mode="straight") {#X1515:3 %t8059:p};
// %t8060 = $SUPPLY @ATTACH &vdd => @PLACE(624, -3617);
// &vdd @WIRE(mode="straight") {#X1515:4 %t8060:p};
// %t8061 = $GROUND @ATTACH &vss => @PLACE(624, -3639);
// &vss @WIRE(mode="straight") {#X1515:5 %t8061:p};
// %t8062 = $IO_PORT @ATTACH &n1493 => @PLACE(494, -3661) => @ORIENT("R0");
// %t8062 @TEXT("n1493", key="name", size=0.75);
// &n1493 @WIRE(mode="straight") {#X1516:1 %t8062:p};
// %t8063 = $IO_PORT @ATTACH &n1175 => @PLACE(494, -3665) => @ORIENT("R0");
// %t8063 @TEXT("n1175", key="name", size=0.75);
// &n1175 @WIRE(mode="straight") {#X1516:2 %t8063:p};
// %t8064 = $IO_PORT @ATTACH &n1253 => @PLACE(514, -3663) => @ORIENT("MY");
// %t8064 @TEXT("n1253", key="name", size=0.75);
// &n1253 @WIRE(mode="straight") {#X1516:3 %t8064:p};
// %t8065 = $SUPPLY @ATTACH &vdd => @PLACE(504, -3652);
// &vdd @WIRE(mode="straight") {#X1516:4 %t8065:p};
// %t8066 = $GROUND @ATTACH &vss => @PLACE(504, -3674);
// &vss @WIRE(mode="straight") {#X1516:5 %t8066:p};
// %t8067 = $IO_PORT @ATTACH &n1507 => @PLACE(534, -3661) => @ORIENT("R0");
// %t8067 @TEXT("n1507", key="name", size=0.75);
// &n1507 @WIRE(mode="straight") {#X1517:1 %t8067:p};
// %t8068 = $IO_PORT @ATTACH &n1053 => @PLACE(534, -3665) => @ORIENT("R0");
// %t8068 @TEXT("n1053", key="name", size=0.75);
// &n1053 @WIRE(mode="straight") {#X1517:2 %t8068:p};
// %t8069 = $IO_PORT @ATTACH &n1242 => @PLACE(554, -3663) => @ORIENT("MY");
// %t8069 @TEXT("n1242", key="name", size=0.75);
// &n1242 @WIRE(mode="straight") {#X1517:3 %t8069:p};
// %t8070 = $SUPPLY @ATTACH &vdd => @PLACE(544, -3652);
// &vdd @WIRE(mode="straight") {#X1517:4 %t8070:p};
// %t8071 = $GROUND @ATTACH &vss => @PLACE(544, -3674);
// &vss @WIRE(mode="straight") {#X1517:5 %t8071:p};
// %t8072 = $IO_PORT @ATTACH &n1510 => @PLACE(574, -3661) => @ORIENT("R0");
// %t8072 @TEXT("n1510", key="name", size=0.75);
// &n1510 @WIRE(mode="straight") {#X1518:1 %t8072:p};
// %t8073 = $IO_PORT @ATTACH &n1238 => @PLACE(574, -3665) => @ORIENT("R0");
// %t8073 @TEXT("n1238", key="name", size=0.75);
// &n1238 @WIRE(mode="straight") {#X1518:2 %t8073:p};
// %t8074 = $IO_PORT @ATTACH &n1250 => @PLACE(594, -3663) => @ORIENT("MY");
// %t8074 @TEXT("n1250", key="name", size=0.75);
// &n1250 @WIRE(mode="straight") {#X1518:3 %t8074:p};
// %t8075 = $SUPPLY @ATTACH &vdd => @PLACE(584, -3652);
// &vdd @WIRE(mode="straight") {#X1518:4 %t8075:p};
// %t8076 = $GROUND @ATTACH &vss => @PLACE(584, -3674);
// &vss @WIRE(mode="straight") {#X1518:5 %t8076:p};
// %t8077 = $IO_PORT @ATTACH &n1492 => @PLACE(614, -3661) => @ORIENT("R0");
// %t8077 @TEXT("n1492", key="name", size=0.75);
// &n1492 @WIRE(mode="straight") {#X1519:1 %t8077:p};
// %t8078 = $IO_PORT @ATTACH &n1175 => @PLACE(614, -3665) => @ORIENT("R0");
// %t8078 @TEXT("n1175", key="name", size=0.75);
// &n1175 @WIRE(mode="straight") {#X1519:2 %t8078:p};
// %t8079 = $IO_PORT @ATTACH &n1247 => @PLACE(635, -3663) => @ORIENT("MY");
// %t8079 @TEXT("n1247", key="name", size=0.75);
// &n1247 @WIRE(mode="straight") {#X1519:3 %t8079:p};
// %t8080 = $SUPPLY @ATTACH &vdd => @PLACE(624, -3652);
// &vdd @WIRE(mode="straight") {#X1519:4 %t8080:p};
// %t8081 = $GROUND @ATTACH &vss => @PLACE(624, -3674);
// &vss @WIRE(mode="straight") {#X1519:5 %t8081:p};
// %t8082 = $IO_PORT @ATTACH &n1506 => @PLACE(494, -3696) => @ORIENT("R0");
// %t8082 @TEXT("n1506", key="name", size=0.75);
// &n1506 @WIRE(mode="straight") {#X1520:1 %t8082:p};
// %t8083 = $IO_PORT @ATTACH &n184 => @PLACE(494, -3700) => @ORIENT("R0");
// %t8083 @TEXT("n184", key="name", size=0.75);
// &n184 @WIRE(mode="straight") {#X1520:2 %t8083:p};
// %t8084 = $IO_PORT @ATTACH &n1256 => @PLACE(514, -3698) => @ORIENT("MY");
// %t8084 @TEXT("n1256", key="name", size=0.75);
// &n1256 @WIRE(mode="straight") {#X1520:3 %t8084:p};
// %t8085 = $SUPPLY @ATTACH &vdd => @PLACE(504, -3687);
// &vdd @WIRE(mode="straight") {#X1520:4 %t8085:p};
// %t8086 = $GROUND @ATTACH &vss => @PLACE(504, -3709);
// &vss @WIRE(mode="straight") {#X1520:5 %t8086:p};
// %t8087 = $IO_PORT @ATTACH &n1508 => @PLACE(534, -3696) => @ORIENT("R0");
// %t8087 @TEXT("n1508", key="name", size=0.75);
// &n1508 @WIRE(mode="straight") {#X1521:1 %t8087:p};
// %t8088 = $IO_PORT @ATTACH &n1053 => @PLACE(534, -3700) => @ORIENT("R0");
// %t8088 @TEXT("n1053", key="name", size=0.75);
// &n1053 @WIRE(mode="straight") {#X1521:2 %t8088:p};
// %t8089 = $IO_PORT @ATTACH &n1257 => @PLACE(554, -3698) => @ORIENT("MY");
// %t8089 @TEXT("n1257", key="name", size=0.75);
// &n1257 @WIRE(mode="straight") {#X1521:3 %t8089:p};
// %t8090 = $SUPPLY @ATTACH &vdd => @PLACE(544, -3687);
// &vdd @WIRE(mode="straight") {#X1521:4 %t8090:p};
// %t8091 = $GROUND @ATTACH &vss => @PLACE(544, -3709);
// &vss @WIRE(mode="straight") {#X1521:5 %t8091:p};
// %t8092 = $IO_PORT @ATTACH &n1509 => @PLACE(574, -3696) => @ORIENT("R0");
// %t8092 @TEXT("n1509", key="name", size=0.75);
// &n1509 @WIRE(mode="straight") {#X1522:1 %t8092:p};
// %t8093 = $IO_PORT @ATTACH &n1238 => @PLACE(574, -3700) => @ORIENT("R0");
// %t8093 @TEXT("n1238", key="name", size=0.75);
// &n1238 @WIRE(mode="straight") {#X1522:2 %t8093:p};
// %t8094 = $IO_PORT @ATTACH &n1244 => @PLACE(594, -3698) => @ORIENT("MY");
// %t8094 @TEXT("n1244", key="name", size=0.75);
// &n1244 @WIRE(mode="straight") {#X1522:3 %t8094:p};
// %t8095 = $SUPPLY @ATTACH &vdd => @PLACE(584, -3687);
// &vdd @WIRE(mode="straight") {#X1522:4 %t8095:p};
// %t8096 = $GROUND @ATTACH &vss => @PLACE(584, -3709);
// &vss @WIRE(mode="straight") {#X1522:5 %t8096:p};
// %t8097 = $IO_PORT @ATTACH &n1512 => @PLACE(614, -3696) => @ORIENT("R0");
// %t8097 @TEXT("n1512", key="name", size=0.75);
// &n1512 @WIRE(mode="straight") {#X1523:1 %t8097:p};
// %t8098 = $IO_PORT @ATTACH &n1055 => @PLACE(614, -3700) => @ORIENT("R0");
// %t8098 @TEXT("n1055", key="name", size=0.75);
// &n1055 @WIRE(mode="straight") {#X1523:2 %t8098:p};
// %t8099 = $IO_PORT @ATTACH &n1251 => @PLACE(635, -3698) => @ORIENT("MY");
// %t8099 @TEXT("n1251", key="name", size=0.75);
// &n1251 @WIRE(mode="straight") {#X1523:3 %t8099:p};
// %t8100 = $SUPPLY @ATTACH &vdd => @PLACE(624, -3687);
// &vdd @WIRE(mode="straight") {#X1523:4 %t8100:p};
// %t8101 = $GROUND @ATTACH &vss => @PLACE(624, -3709);
// &vss @WIRE(mode="straight") {#X1523:5 %t8101:p};
// %t8102 = $IO_PORT @ATTACH &n1520 => @PLACE(494, -3731) => @ORIENT("R0");
// %t8102 @TEXT("n1520", key="name", size=0.75);
// &n1520 @WIRE(mode="straight") {#X1524:1 %t8102:p};
// %t8103 = $IO_PORT @ATTACH &n1175 => @PLACE(494, -3735) => @ORIENT("R0");
// %t8103 @TEXT("n1175", key="name", size=0.75);
// &n1175 @WIRE(mode="straight") {#X1524:2 %t8103:p};
// %t8104 = $IO_PORT @ATTACH &n1262 => @PLACE(514, -3733) => @ORIENT("MY");
// %t8104 @TEXT("n1262", key="name", size=0.75);
// &n1262 @WIRE(mode="straight") {#X1524:3 %t8104:p};
// %t8105 = $SUPPLY @ATTACH &vdd => @PLACE(504, -3722);
// &vdd @WIRE(mode="straight") {#X1524:4 %t8105:p};
// %t8106 = $GROUND @ATTACH &vss => @PLACE(504, -3744);
// &vss @WIRE(mode="straight") {#X1524:5 %t8106:p};
// %t8107 = $IO_PORT @ATTACH &n1531 => @PLACE(534, -3731) => @ORIENT("R0");
// %t8107 @TEXT("n1531", key="name", size=0.75);
// &n1531 @WIRE(mode="straight") {#X1525:1 %t8107:p};
// %t8108 = $IO_PORT @ATTACH &n184 => @PLACE(534, -3735) => @ORIENT("R0");
// %t8108 @TEXT("n184", key="name", size=0.75);
// &n184 @WIRE(mode="straight") {#X1525:2 %t8108:p};
// %t8109 = $IO_PORT @ATTACH &n1263 => @PLACE(554, -3733) => @ORIENT("MY");
// %t8109 @TEXT("n1263", key="name", size=0.75);
// &n1263 @WIRE(mode="straight") {#X1525:3 %t8109:p};
// %t8110 = $SUPPLY @ATTACH &vdd => @PLACE(544, -3722);
// &vdd @WIRE(mode="straight") {#X1525:4 %t8110:p};
// %t8111 = $GROUND @ATTACH &vss => @PLACE(544, -3744);
// &vss @WIRE(mode="straight") {#X1525:5 %t8111:p};
// %t8112 = $IO_PORT @ATTACH &n1069 => @PLACE(574, -3731) => @ORIENT("R0");
// %t8112 @TEXT("n1069", key="name", size=0.75);
// &n1069 @WIRE(mode="straight") {#X1526:1 %t8112:p};
// %t8113 = $IO_PORT @ATTACH &n1055 => @PLACE(574, -3735) => @ORIENT("R0");
// %t8113 @TEXT("n1055", key="name", size=0.75);
// &n1055 @WIRE(mode="straight") {#X1526:2 %t8113:p};
// %t8114 = $IO_PORT @ATTACH &n1265 => @PLACE(594, -3733) => @ORIENT("MY");
// %t8114 @TEXT("n1265", key="name", size=0.75);
// &n1265 @WIRE(mode="straight") {#X1526:3 %t8114:p};
// %t8115 = $SUPPLY @ATTACH &vdd => @PLACE(584, -3722);
// &vdd @WIRE(mode="straight") {#X1526:4 %t8115:p};
// %t8116 = $GROUND @ATTACH &vss => @PLACE(584, -3744);
// &vss @WIRE(mode="straight") {#X1526:5 %t8116:p};
// %t8117 = $IO_PORT @ATTACH &n68 => @PLACE(614, -3733) => @ORIENT("R0");
// %t8117 @TEXT("n68", key="name", size=0.75);
// &n68 @WIRE(mode="straight") {#X1527:1 %t8117:p};
// %t8118 = $IO_PORT @ATTACH &n306 => @PLACE(635, -3733) => @ORIENT("MY");
// %t8118 @TEXT("n306", key="name", size=0.75);
// &n306 @WIRE(mode="straight") {#X1527:2 %t8118:p};
// %t8119 = $SUPPLY @ATTACH &vdd => @PLACE(624, -3724);
// &vdd @WIRE(mode="straight") {#X1527:3 %t8119:p};
// %t8120 = $GROUND @ATTACH &vss => @PLACE(624, -3742);
// &vss @WIRE(mode="straight") {#X1527:4 %t8120:p};
// %t8121 = $IO_PORT @ATTACH &n70 => @PLACE(494, -3768) => @ORIENT("R0");
// %t8121 @TEXT("n70", key="name", size=0.75);
// &n70 @WIRE(mode="straight") {#X1528:1 %t8121:p};
// %t8122 = $IO_PORT @ATTACH &n308 => @PLACE(514, -3768) => @ORIENT("MY");
// %t8122 @TEXT("n308", key="name", size=0.75);
// &n308 @WIRE(mode="straight") {#X1528:2 %t8122:p};
// %t8123 = $SUPPLY @ATTACH &vdd => @PLACE(504, -3759);
// &vdd @WIRE(mode="straight") {#X1528:3 %t8123:p};
// %t8124 = $GROUND @ATTACH &vss => @PLACE(504, -3777);
// &vss @WIRE(mode="straight") {#X1528:4 %t8124:p};
// %t8125 = $IO_PORT @ATTACH &n72 => @PLACE(534, -3768) => @ORIENT("R0");
// %t8125 @TEXT("n72", key="name", size=0.75);
// &n72 @WIRE(mode="straight") {#X1529:1 %t8125:p};
// %t8126 = $IO_PORT @ATTACH &n310 => @PLACE(554, -3768) => @ORIENT("MY");
// %t8126 @TEXT("n310", key="name", size=0.75);
// &n310 @WIRE(mode="straight") {#X1529:2 %t8126:p};
// %t8127 = $SUPPLY @ATTACH &vdd => @PLACE(544, -3759);
// &vdd @WIRE(mode="straight") {#X1529:3 %t8127:p};
// %t8128 = $GROUND @ATTACH &vss => @PLACE(544, -3777);
// &vss @WIRE(mode="straight") {#X1529:4 %t8128:p};
// %t8129 = $IO_PORT @ATTACH &n60 => @PLACE(574, -3768) => @ORIENT("R0");
// %t8129 @TEXT("n60", key="name", size=0.75);
// &n60 @WIRE(mode="straight") {#X1530:1 %t8129:p};
// %t8130 = $IO_PORT @ATTACH &n298 => @PLACE(594, -3768) => @ORIENT("MY");
// %t8130 @TEXT("n298", key="name", size=0.75);
// &n298 @WIRE(mode="straight") {#X1530:2 %t8130:p};
// %t8131 = $SUPPLY @ATTACH &vdd => @PLACE(584, -3759);
// &vdd @WIRE(mode="straight") {#X1530:3 %t8131:p};
// %t8132 = $GROUND @ATTACH &vss => @PLACE(584, -3777);
// &vss @WIRE(mode="straight") {#X1530:4 %t8132:p};
// %t8133 = $IO_PORT @ATTACH &n62 => @PLACE(614, -3768) => @ORIENT("R0");
// %t8133 @TEXT("n62", key="name", size=0.75);
// &n62 @WIRE(mode="straight") {#X1531:1 %t8133:p};
// %t8134 = $IO_PORT @ATTACH &n300 => @PLACE(635, -3768) => @ORIENT("MY");
// %t8134 @TEXT("n300", key="name", size=0.75);
// &n300 @WIRE(mode="straight") {#X1531:2 %t8134:p};
// %t8135 = $SUPPLY @ATTACH &vdd => @PLACE(624, -3759);
// &vdd @WIRE(mode="straight") {#X1531:3 %t8135:p};
// %t8136 = $GROUND @ATTACH &vss => @PLACE(624, -3777);
// &vss @WIRE(mode="straight") {#X1531:4 %t8136:p};
// %t8137 = $IO_PORT @ATTACH &n64 => @PLACE(494, -3803) => @ORIENT("R0");
// %t8137 @TEXT("n64", key="name", size=0.75);
// &n64 @WIRE(mode="straight") {#X1532:1 %t8137:p};
// %t8138 = $IO_PORT @ATTACH &n302 => @PLACE(514, -3803) => @ORIENT("MY");
// %t8138 @TEXT("n302", key="name", size=0.75);
// &n302 @WIRE(mode="straight") {#X1532:2 %t8138:p};
// %t8139 = $SUPPLY @ATTACH &vdd => @PLACE(504, -3794);
// &vdd @WIRE(mode="straight") {#X1532:3 %t8139:p};
// %t8140 = $GROUND @ATTACH &vss => @PLACE(504, -3812);
// &vss @WIRE(mode="straight") {#X1532:4 %t8140:p};
// %t8141 = $IO_PORT @ATTACH &n66 => @PLACE(534, -3803) => @ORIENT("R0");
// %t8141 @TEXT("n66", key="name", size=0.75);
// &n66 @WIRE(mode="straight") {#X1533:1 %t8141:p};
// %t8142 = $IO_PORT @ATTACH &n304 => @PLACE(554, -3803) => @ORIENT("MY");
// %t8142 @TEXT("n304", key="name", size=0.75);
// &n304 @WIRE(mode="straight") {#X1533:2 %t8142:p};
// %t8143 = $SUPPLY @ATTACH &vdd => @PLACE(544, -3794);
// &vdd @WIRE(mode="straight") {#X1533:3 %t8143:p};
// %t8144 = $GROUND @ATTACH &vss => @PLACE(544, -3812);
// &vss @WIRE(mode="straight") {#X1533:4 %t8144:p};
// %t8145 = $IO_PORT @ATTACH &n351 => @PLACE(574, -3803) => @ORIENT("R0");
// %t8145 @TEXT("n351", key="name", size=0.75);
// &n351 @WIRE(mode="straight") {#X1534:1 %t8145:p};
// %t8146 = $IO_PORT @ATTACH &n1031 => @PLACE(594, -3803) => @ORIENT("MY");
// %t8146 @TEXT("n1031", key="name", size=0.75);
// &n1031 @WIRE(mode="straight") {#X1534:2 %t8146:p};
// %t8147 = $SUPPLY @ATTACH &vdd => @PLACE(584, -3794);
// &vdd @WIRE(mode="straight") {#X1534:3 %t8147:p};
// %t8148 = $GROUND @ATTACH &vss => @PLACE(584, -3812);
// &vss @WIRE(mode="straight") {#X1534:4 %t8148:p};
// %t8149 = $IO_PORT @ATTACH &n346 => @PLACE(614, -3803) => @ORIENT("R0");
// %t8149 @TEXT("n346", key="name", size=0.75);
// &n346 @WIRE(mode="straight") {#X1535:1 %t8149:p};
// %t8150 = $IO_PORT @ATTACH &n1126 => @PLACE(635, -3803) => @ORIENT("MY");
// %t8150 @TEXT("n1126", key="name", size=0.75);
// &n1126 @WIRE(mode="straight") {#X1535:2 %t8150:p};
// %t8151 = $SUPPLY @ATTACH &vdd => @PLACE(624, -3794);
// &vdd @WIRE(mode="straight") {#X1535:3 %t8151:p};
// %t8152 = $GROUND @ATTACH &vss => @PLACE(624, -3812);
// &vss @WIRE(mode="straight") {#X1535:4 %t8152:p};
// %t8153 = $IO_PORT @ATTACH &n348 => @PLACE(-11, -3848) => @ORIENT("R0");
// %t8153 @TEXT("n348", key="name", size=0.75);
// &n348 @WIRE(mode="straight") {#X1536:1 %t8153:p};
// %t8154 = $IO_PORT @ATTACH &n1131 => @PLACE(10, -3848) => @ORIENT("MY");
// %t8154 @TEXT("n1131", key="name", size=0.75);
// &n1131 @WIRE(mode="straight") {#X1536:2 %t8154:p};
// %t8155 = $SUPPLY @ATTACH &vdd => @PLACE(0, -3839);
// &vdd @WIRE(mode="straight") {#X1536:3 %t8155:p};
// %t8156 = $GROUND @ATTACH &vss => @PLACE(0, -3857);
// &vss @WIRE(mode="straight") {#X1536:4 %t8156:p};
// %t8157 = $IO_PORT @ATTACH &n824 => @PLACE(30, -3848) => @ORIENT("R0");
// %t8157 @TEXT("n824", key="name", size=0.75);
// &n824 @WIRE(mode="straight") {#X1537:1 %t8157:p};
// %t8158 = $IO_PORT @ATTACH &n349 => @PLACE(50, -3848) => @ORIENT("MY");
// %t8158 @TEXT("n349", key="name", size=0.75);
// &n349 @WIRE(mode="straight") {#X1537:2 %t8158:p};
// %t8159 = $SUPPLY @ATTACH &vdd => @PLACE(40, -3839);
// &vdd @WIRE(mode="straight") {#X1537:3 %t8159:p};
// %t8160 = $GROUND @ATTACH &vss => @PLACE(40, -3857);
// &vss @WIRE(mode="straight") {#X1537:4 %t8160:p};
// %t8161 = $IO_PORT @ATTACH &n908 => @PLACE(70, -3848) => @ORIENT("R0");
// %t8161 @TEXT("n908", key="name", size=0.75);
// &n908 @WIRE(mode="straight") {#X1538:1 %t8161:p};
// %t8162 = $IO_PORT @ATTACH &n1141 => @PLACE(90, -3848) => @ORIENT("MY");
// %t8162 @TEXT("n1141", key="name", size=0.75);
// &n1141 @WIRE(mode="straight") {#X1538:2 %t8162:p};
// %t8163 = $SUPPLY @ATTACH &vdd => @PLACE(80, -3839);
// &vdd @WIRE(mode="straight") {#X1538:3 %t8163:p};
// %t8164 = $GROUND @ATTACH &vss => @PLACE(80, -3857);
// &vss @WIRE(mode="straight") {#X1538:4 %t8164:p};
// %t8165 = $IO_PORT @ATTACH &n354 => @PLACE(110, -3848) => @ORIENT("R0");
// %t8165 @TEXT("n354", key="name", size=0.75);
// &n354 @WIRE(mode="straight") {#X1539:1 %t8165:p};
// %t8166 = $IO_PORT @ATTACH &n1144 => @PLACE(130, -3848) => @ORIENT("MY");
// %t8166 @TEXT("n1144", key="name", size=0.75);
// &n1144 @WIRE(mode="straight") {#X1539:2 %t8166:p};
// %t8167 = $SUPPLY @ATTACH &vdd => @PLACE(120, -3839);
// &vdd @WIRE(mode="straight") {#X1539:3 %t8167:p};
// %t8168 = $GROUND @ATTACH &vss => @PLACE(120, -3857);
// &vss @WIRE(mode="straight") {#X1539:4 %t8168:p};
// %t8169 = $IO_PORT @ATTACH &n943 => @PLACE(-11, -3879) => @ORIENT("R0");
// %t8169 @TEXT("n943", key="name", size=0.75);
// &n943 @WIRE(mode="straight") {#X1540:1 %t8169:p};
// %t8170 = $IO_PORT @ATTACH &n352 => @PLACE(10, -3879) => @ORIENT("MY");
// %t8170 @TEXT("n352", key="name", size=0.75);
// &n352 @WIRE(mode="straight") {#X1540:2 %t8170:p};
// %t8171 = $SUPPLY @ATTACH &vdd => @PLACE(0, -3870);
// &vdd @WIRE(mode="straight") {#X1540:3 %t8171:p};
// %t8172 = $GROUND @ATTACH &vss => @PLACE(0, -3888);
// &vss @WIRE(mode="straight") {#X1540:4 %t8172:p};
// %t8173 = $IO_PORT @ATTACH &n127 => @PLACE(30, -3879) => @ORIENT("R0");
// %t8173 @TEXT("n127", key="name", size=0.75);
// &n127 @WIRE(mode="straight") {#X1541:1 %t8173:p};
// %t8174 = $IO_PORT @ATTACH &n923 => @PLACE(50, -3879) => @ORIENT("MY");
// %t8174 @TEXT("n923", key="name", size=0.75);
// &n923 @WIRE(mode="straight") {#X1541:2 %t8174:p};
// %t8175 = $SUPPLY @ATTACH &vdd => @PLACE(40, -3870);
// &vdd @WIRE(mode="straight") {#X1541:3 %t8175:p};
// %t8176 = $GROUND @ATTACH &vss => @PLACE(40, -3888);
// &vss @WIRE(mode="straight") {#X1541:4 %t8176:p};
// %t8177 = $IO_PORT @ATTACH &n129 => @PLACE(70, -3879) => @ORIENT("R0");
// %t8177 @TEXT("n129", key="name", size=0.75);
// &n129 @WIRE(mode="straight") {#X1542:1 %t8177:p};
// %t8178 = $IO_PORT @ATTACH &n925 => @PLACE(90, -3879) => @ORIENT("MY");
// %t8178 @TEXT("n925", key="name", size=0.75);
// &n925 @WIRE(mode="straight") {#X1542:2 %t8178:p};
// %t8179 = $SUPPLY @ATTACH &vdd => @PLACE(80, -3870);
// &vdd @WIRE(mode="straight") {#X1542:3 %t8179:p};
// %t8180 = $GROUND @ATTACH &vss => @PLACE(80, -3888);
// &vss @WIRE(mode="straight") {#X1542:4 %t8180:p};
// %t8181 = $IO_PORT @ATTACH &n131 => @PLACE(110, -3879) => @ORIENT("R0");
// %t8181 @TEXT("n131", key="name", size=0.75);
// &n131 @WIRE(mode="straight") {#X1543:1 %t8181:p};
// %t8182 = $IO_PORT @ATTACH &n927 => @PLACE(130, -3879) => @ORIENT("MY");
// %t8182 @TEXT("n927", key="name", size=0.75);
// &n927 @WIRE(mode="straight") {#X1543:2 %t8182:p};
// %t8183 = $SUPPLY @ATTACH &vdd => @PLACE(120, -3870);
// &vdd @WIRE(mode="straight") {#X1543:3 %t8183:p};
// %t8184 = $GROUND @ATTACH &vss => @PLACE(120, -3888);
// &vss @WIRE(mode="straight") {#X1543:4 %t8184:p};
// %t8185 = $IO_PORT @ATTACH &n135 => @PLACE(-11, -3910) => @ORIENT("R0");
// %t8185 @TEXT("n135", key="name", size=0.75);
// &n135 @WIRE(mode="straight") {#X1544:1 %t8185:p};
// %t8186 = $IO_PORT @ATTACH &n931 => @PLACE(10, -3910) => @ORIENT("MY");
// %t8186 @TEXT("n931", key="name", size=0.75);
// &n931 @WIRE(mode="straight") {#X1544:2 %t8186:p};
// %t8187 = $SUPPLY @ATTACH &vdd => @PLACE(0, -3901);
// &vdd @WIRE(mode="straight") {#X1544:3 %t8187:p};
// %t8188 = $GROUND @ATTACH &vss => @PLACE(0, -3919);
// &vss @WIRE(mode="straight") {#X1544:4 %t8188:p};
// %t8189 = $IO_PORT @ATTACH &n137 => @PLACE(30, -3910) => @ORIENT("R0");
// %t8189 @TEXT("n137", key="name", size=0.75);
// &n137 @WIRE(mode="straight") {#X1545:1 %t8189:p};
// %t8190 = $IO_PORT @ATTACH &n933 => @PLACE(50, -3910) => @ORIENT("MY");
// %t8190 @TEXT("n933", key="name", size=0.75);
// &n933 @WIRE(mode="straight") {#X1545:2 %t8190:p};
// %t8191 = $SUPPLY @ATTACH &vdd => @PLACE(40, -3901);
// &vdd @WIRE(mode="straight") {#X1545:3 %t8191:p};
// %t8192 = $GROUND @ATTACH &vss => @PLACE(40, -3919);
// &vss @WIRE(mode="straight") {#X1545:4 %t8192:p};
// %t8193 = $IO_PORT @ATTACH &dac1 => @PLACE(70, -3910) => @ORIENT("R0");
// %t8193 @TEXT("dac1", key="name", size=0.75);
// &dac1 @WIRE(mode="straight") {#X1546:1 %t8193:p};
// %t8194 = $IO_PORT @ATTACH &n500 => @PLACE(90, -3910) => @ORIENT("MY");
// %t8194 @TEXT("n500", key="name", size=0.75);
// &n500 @WIRE(mode="straight") {#X1546:2 %t8194:p};
// %t8195 = $SUPPLY @ATTACH &vdd => @PLACE(80, -3901);
// &vdd @WIRE(mode="straight") {#X1546:3 %t8195:p};
// %t8196 = $GROUND @ATTACH &vss => @PLACE(80, -3919);
// &vss @WIRE(mode="straight") {#X1546:4 %t8196:p};
// %t8197 = $IO_PORT @ATTACH &dac5 => @PLACE(110, -3910) => @ORIENT("R0");
// %t8197 @TEXT("dac5", key="name", size=0.75);
// &dac5 @WIRE(mode="straight") {#X1547:1 %t8197:p};
// %t8198 = $IO_PORT @ATTACH &n578 => @PLACE(130, -3910) => @ORIENT("MY");
// %t8198 @TEXT("n578", key="name", size=0.75);
// &n578 @WIRE(mode="straight") {#X1547:2 %t8198:p};
// %t8199 = $SUPPLY @ATTACH &vdd => @PLACE(120, -3901);
// &vdd @WIRE(mode="straight") {#X1547:3 %t8199:p};
// %t8200 = $GROUND @ATTACH &vss => @PLACE(120, -3919);
// &vss @WIRE(mode="straight") {#X1547:4 %t8200:p};
// %t8201 = $IO_PORT @ATTACH &measured0 => @PLACE(-11, -3945) => @ORIENT("R0");
// %t8201 @TEXT("measured0", key="name", size=0.75);
// &measured0 @WIRE(mode="straight") {#X1548:1 %t8201:p};
// %t8202 = $IO_PORT @ATTACH &n403 => @PLACE(10, -3945) => @ORIENT("MY");
// %t8202 @TEXT("n403", key="name", size=0.75);
// &n403 @WIRE(mode="straight") {#X1548:2 %t8202:p};
// %t8203 = $SUPPLY @ATTACH &vdd => @PLACE(0, -3936);
// &vdd @WIRE(mode="straight") {#X1548:3 %t8203:p};
// %t8204 = $GROUND @ATTACH &vss => @PLACE(0, -3954);
// &vss @WIRE(mode="straight") {#X1548:4 %t8204:p};
// %t8205 = $IO_PORT @ATTACH &measured1 => @PLACE(30, -3945) => @ORIENT("R0");
// %t8205 @TEXT("measured1", key="name", size=0.75);
// &measured1 @WIRE(mode="straight") {#X1549:1 %t8205:p};
// %t8206 = $IO_PORT @ATTACH &n402 => @PLACE(50, -3945) => @ORIENT("MY");
// %t8206 @TEXT("n402", key="name", size=0.75);
// &n402 @WIRE(mode="straight") {#X1549:2 %t8206:p};
// %t8207 = $SUPPLY @ATTACH &vdd => @PLACE(40, -3936);
// &vdd @WIRE(mode="straight") {#X1549:3 %t8207:p};
// %t8208 = $GROUND @ATTACH &vss => @PLACE(40, -3954);
// &vss @WIRE(mode="straight") {#X1549:4 %t8208:p};
// %t8209 = $IO_PORT @ATTACH &measured4 => @PLACE(70, -3945) => @ORIENT("R0");
// %t8209 @TEXT("measured4", key="name", size=0.75);
// &measured4 @WIRE(mode="straight") {#X1550:1 %t8209:p};
// %t8210 = $IO_PORT @ATTACH &n641 => @PLACE(90, -3945) => @ORIENT("MY");
// %t8210 @TEXT("n641", key="name", size=0.75);
// &n641 @WIRE(mode="straight") {#X1550:2 %t8210:p};
// %t8211 = $SUPPLY @ATTACH &vdd => @PLACE(80, -3936);
// &vdd @WIRE(mode="straight") {#X1550:3 %t8211:p};
// %t8212 = $GROUND @ATTACH &vss => @PLACE(80, -3954);
// &vss @WIRE(mode="straight") {#X1550:4 %t8212:p};
// %t8213 = $IO_PORT @ATTACH &measured5 => @PLACE(110, -3945) => @ORIENT("R0");
// %t8213 @TEXT("measured5", key="name", size=0.75);
// &measured5 @WIRE(mode="straight") {#X1551:1 %t8213:p};
// %t8214 = $IO_PORT @ATTACH &n644 => @PLACE(130, -3945) => @ORIENT("MY");
// %t8214 @TEXT("n644", key="name", size=0.75);
// &n644 @WIRE(mode="straight") {#X1551:2 %t8214:p};
// %t8215 = $SUPPLY @ATTACH &vdd => @PLACE(120, -3936);
// &vdd @WIRE(mode="straight") {#X1551:3 %t8215:p};
// %t8216 = $GROUND @ATTACH &vss => @PLACE(120, -3954);
// &vss @WIRE(mode="straight") {#X1551:4 %t8216:p};
// %t8217 = $IO_PORT @ATTACH &measured6 => @PLACE(-11, -3980) => @ORIENT("R0");
// %t8217 @TEXT("measured6", key="name", size=0.75);
// &measured6 @WIRE(mode="straight") {#X1552:1 %t8217:p};
// %t8218 = $IO_PORT @ATTACH &n647 => @PLACE(10, -3980) => @ORIENT("MY");
// %t8218 @TEXT("n647", key="name", size=0.75);
// &n647 @WIRE(mode="straight") {#X1552:2 %t8218:p};
// %t8219 = $SUPPLY @ATTACH &vdd => @PLACE(0, -3971);
// &vdd @WIRE(mode="straight") {#X1552:3 %t8219:p};
// %t8220 = $GROUND @ATTACH &vss => @PLACE(0, -3989);
// &vss @WIRE(mode="straight") {#X1552:4 %t8220:p};
// %t8221 = $IO_PORT @ATTACH &measured7 => @PLACE(30, -3980) => @ORIENT("R0");
// %t8221 @TEXT("measured7", key="name", size=0.75);
// &measured7 @WIRE(mode="straight") {#X1553:1 %t8221:p};
// %t8222 = $IO_PORT @ATTACH &n650 => @PLACE(50, -3980) => @ORIENT("MY");
// %t8222 @TEXT("n650", key="name", size=0.75);
// &n650 @WIRE(mode="straight") {#X1553:2 %t8222:p};
// %t8223 = $SUPPLY @ATTACH &vdd => @PLACE(40, -3971);
// &vdd @WIRE(mode="straight") {#X1553:3 %t8223:p};
// %t8224 = $GROUND @ATTACH &vss => @PLACE(40, -3989);
// &vss @WIRE(mode="straight") {#X1553:4 %t8224:p};
// %t8225 = $IO_PORT @ATTACH &measured8 => @PLACE(70, -3980) => @ORIENT("R0");
// %t8225 @TEXT("measured8", key="name", size=0.75);
// &measured8 @WIRE(mode="straight") {#X1554:1 %t8225:p};
// %t8226 = $IO_PORT @ATTACH &n653 => @PLACE(90, -3980) => @ORIENT("MY");
// %t8226 @TEXT("n653", key="name", size=0.75);
// &n653 @WIRE(mode="straight") {#X1554:2 %t8226:p};
// %t8227 = $SUPPLY @ATTACH &vdd => @PLACE(80, -3971);
// &vdd @WIRE(mode="straight") {#X1554:3 %t8227:p};
// %t8228 = $GROUND @ATTACH &vss => @PLACE(80, -3989);
// &vss @WIRE(mode="straight") {#X1554:4 %t8228:p};
// %t8229 = $IO_PORT @ATTACH &measured9 => @PLACE(110, -3980) => @ORIENT("R0");
// %t8229 @TEXT("measured9", key="name", size=0.75);
// &measured9 @WIRE(mode="straight") {#X1555:1 %t8229:p};
// %t8230 = $IO_PORT @ATTACH &n656 => @PLACE(130, -3980) => @ORIENT("MY");
// %t8230 @TEXT("n656", key="name", size=0.75);
// &n656 @WIRE(mode="straight") {#X1555:2 %t8230:p};
// %t8231 = $SUPPLY @ATTACH &vdd => @PLACE(120, -3971);
// &vdd @WIRE(mode="straight") {#X1555:3 %t8231:p};
// %t8232 = $GROUND @ATTACH &vss => @PLACE(120, -3989);
// &vss @WIRE(mode="straight") {#X1555:4 %t8232:p};
// %t8233 = $IO_PORT @ATTACH &measured10 => @PLACE(-11, -4015) => @ORIENT("R0");
// %t8233 @TEXT("measured10", key="name", size=0.75);
// &measured10 @WIRE(mode="straight") {#X1556:1 %t8233:p};
// %t8234 = $IO_PORT @ATTACH &n659 => @PLACE(10, -4015) => @ORIENT("MY");
// %t8234 @TEXT("n659", key="name", size=0.75);
// &n659 @WIRE(mode="straight") {#X1556:2 %t8234:p};
// %t8235 = $SUPPLY @ATTACH &vdd => @PLACE(0, -4006);
// &vdd @WIRE(mode="straight") {#X1556:3 %t8235:p};
// %t8236 = $GROUND @ATTACH &vss => @PLACE(0, -4024);
// &vss @WIRE(mode="straight") {#X1556:4 %t8236:p};
// %t8237 = $IO_PORT @ATTACH &measured11 => @PLACE(30, -4015) => @ORIENT("R0");
// %t8237 @TEXT("measured11", key="name", size=0.75);
// &measured11 @WIRE(mode="straight") {#X1557:1 %t8237:p};
// %t8238 = $IO_PORT @ATTACH &n662 => @PLACE(50, -4015) => @ORIENT("MY");
// %t8238 @TEXT("n662", key="name", size=0.75);
// &n662 @WIRE(mode="straight") {#X1557:2 %t8238:p};
// %t8239 = $SUPPLY @ATTACH &vdd => @PLACE(40, -4006);
// &vdd @WIRE(mode="straight") {#X1557:3 %t8239:p};
// %t8240 = $GROUND @ATTACH &vss => @PLACE(40, -4024);
// &vss @WIRE(mode="straight") {#X1557:4 %t8240:p};
// %t8241 = $IO_PORT @ATTACH &measured12 => @PLACE(70, -4015) => @ORIENT("R0");
// %t8241 @TEXT("measured12", key="name", size=0.75);
// &measured12 @WIRE(mode="straight") {#X1558:1 %t8241:p};
// %t8242 = $IO_PORT @ATTACH &n665 => @PLACE(90, -4015) => @ORIENT("MY");
// %t8242 @TEXT("n665", key="name", size=0.75);
// &n665 @WIRE(mode="straight") {#X1558:2 %t8242:p};
// %t8243 = $SUPPLY @ATTACH &vdd => @PLACE(80, -4006);
// &vdd @WIRE(mode="straight") {#X1558:3 %t8243:p};
// %t8244 = $GROUND @ATTACH &vss => @PLACE(80, -4024);
// &vss @WIRE(mode="straight") {#X1558:4 %t8244:p};
// %t8245 = $IO_PORT @ATTACH &measured13 => @PLACE(110, -4015) => @ORIENT("R0");
// %t8245 @TEXT("measured13", key="name", size=0.75);
// &measured13 @WIRE(mode="straight") {#X1559:1 %t8245:p};
// %t8246 = $IO_PORT @ATTACH &n668 => @PLACE(130, -4015) => @ORIENT("MY");
// %t8246 @TEXT("n668", key="name", size=0.75);
// &n668 @WIRE(mode="straight") {#X1559:2 %t8246:p};
// %t8247 = $SUPPLY @ATTACH &vdd => @PLACE(120, -4006);
// &vdd @WIRE(mode="straight") {#X1559:3 %t8247:p};
// %t8248 = $GROUND @ATTACH &vss => @PLACE(120, -4024);
// &vss @WIRE(mode="straight") {#X1559:4 %t8248:p};
// %t8249 = $IO_PORT @ATTACH &n646 => @PLACE(158, -3848) => @ORIENT("R0");
// %t8249 @TEXT("n646", key="name", size=0.75);
// &n646 @WIRE(mode="straight") {#X1560:1 %t8249:p};
// %t8250 = $IO_PORT @ATTACH &n885 => @PLACE(178, -3848) => @ORIENT("MY");
// %t8250 @TEXT("n885", key="name", size=0.75);
// &n885 @WIRE(mode="straight") {#X1560:2 %t8250:p};
// %t8251 = $SUPPLY @ATTACH &vdd => @PLACE(168, -3839);
// &vdd @WIRE(mode="straight") {#X1560:3 %t8251:p};
// %t8252 = $GROUND @ATTACH &vss => @PLACE(168, -3857);
// &vss @WIRE(mode="straight") {#X1560:4 %t8252:p};
// %t8253 = $IO_PORT @ATTACH &n649 => @PLACE(198, -3848) => @ORIENT("R0");
// %t8253 @TEXT("n649", key="name", size=0.75);
// &n649 @WIRE(mode="straight") {#X1561:1 %t8253:p};
// %t8254 = $IO_PORT @ATTACH &n699 => @PLACE(218, -3848) => @ORIENT("MY");
// %t8254 @TEXT("n699", key="name", size=0.75);
// &n699 @WIRE(mode="straight") {#X1561:2 %t8254:p};
// %t8255 = $SUPPLY @ATTACH &vdd => @PLACE(208, -3839);
// &vdd @WIRE(mode="straight") {#X1561:3 %t8255:p};
// %t8256 = $GROUND @ATTACH &vss => @PLACE(208, -3857);
// &vss @WIRE(mode="straight") {#X1561:4 %t8256:p};
// %t8257 = $IO_PORT @ATTACH &n652 => @PLACE(238, -3848) => @ORIENT("R0");
// %t8257 @TEXT("n652", key="name", size=0.75);
// &n652 @WIRE(mode="straight") {#X1562:1 %t8257:p};
// %t8258 = $IO_PORT @ATTACH &n816 => @PLACE(258, -3848) => @ORIENT("MY");
// %t8258 @TEXT("n816", key="name", size=0.75);
// &n816 @WIRE(mode="straight") {#X1562:2 %t8258:p};
// %t8259 = $SUPPLY @ATTACH &vdd => @PLACE(248, -3839);
// &vdd @WIRE(mode="straight") {#X1562:3 %t8259:p};
// %t8260 = $GROUND @ATTACH &vss => @PLACE(248, -3857);
// &vss @WIRE(mode="straight") {#X1562:4 %t8260:p};
// %t8261 = $IO_PORT @ATTACH &n655 => @PLACE(278, -3848) => @ORIENT("R0");
// %t8261 @TEXT("n655", key="name", size=0.75);
// &n655 @WIRE(mode="straight") {#X1563:1 %t8261:p};
// %t8262 = $IO_PORT @ATTACH &n817 => @PLACE(298, -3848) => @ORIENT("MY");
// %t8262 @TEXT("n817", key="name", size=0.75);
// &n817 @WIRE(mode="straight") {#X1563:2 %t8262:p};
// %t8263 = $SUPPLY @ATTACH &vdd => @PLACE(288, -3839);
// &vdd @WIRE(mode="straight") {#X1563:3 %t8263:p};
// %t8264 = $GROUND @ATTACH &vss => @PLACE(288, -3857);
// &vss @WIRE(mode="straight") {#X1563:4 %t8264:p};
// %t8265 = $IO_PORT @ATTACH &n658 => @PLACE(158, -3879) => @ORIENT("R0");
// %t8265 @TEXT("n658", key="name", size=0.75);
// &n658 @WIRE(mode="straight") {#X1564:1 %t8265:p};
// %t8266 = $IO_PORT @ATTACH &n818 => @PLACE(178, -3879) => @ORIENT("MY");
// %t8266 @TEXT("n818", key="name", size=0.75);
// &n818 @WIRE(mode="straight") {#X1564:2 %t8266:p};
// %t8267 = $SUPPLY @ATTACH &vdd => @PLACE(168, -3870);
// &vdd @WIRE(mode="straight") {#X1564:3 %t8267:p};
// %t8268 = $GROUND @ATTACH &vss => @PLACE(168, -3888);
// &vss @WIRE(mode="straight") {#X1564:4 %t8268:p};
// %t8269 = $IO_PORT @ATTACH &n664 => @PLACE(198, -3879) => @ORIENT("R0");
// %t8269 @TEXT("n664", key="name", size=0.75);
// &n664 @WIRE(mode="straight") {#X1565:1 %t8269:p};
// %t8270 = $IO_PORT @ATTACH &n700 => @PLACE(218, -3879) => @ORIENT("MY");
// %t8270 @TEXT("n700", key="name", size=0.75);
// &n700 @WIRE(mode="straight") {#X1565:2 %t8270:p};
// %t8271 = $SUPPLY @ATTACH &vdd => @PLACE(208, -3870);
// &vdd @WIRE(mode="straight") {#X1565:3 %t8271:p};
// %t8272 = $GROUND @ATTACH &vss => @PLACE(208, -3888);
// &vss @WIRE(mode="straight") {#X1565:4 %t8272:p};
// %t8273 = $IO_PORT @ATTACH &target_k3 => @PLACE(238, -3879) => @ORIENT("R0");
// %t8273 @TEXT("target_k3", key="name", size=0.75);
// &target_k3 @WIRE(mode="straight") {#X1566:1 %t8273:p};
// %t8274 = $IO_PORT @ATTACH &n754 => @PLACE(258, -3879) => @ORIENT("MY");
// %t8274 @TEXT("n754", key="name", size=0.75);
// &n754 @WIRE(mode="straight") {#X1566:2 %t8274:p};
// %t8275 = $SUPPLY @ATTACH &vdd => @PLACE(248, -3870);
// &vdd @WIRE(mode="straight") {#X1566:3 %t8275:p};
// %t8276 = $GROUND @ATTACH &vss => @PLACE(248, -3888);
// &vss @WIRE(mode="straight") {#X1566:4 %t8276:p};
// %t8277 = $IO_PORT @ATTACH &target_k4 => @PLACE(278, -3879) => @ORIENT("R0");
// %t8277 @TEXT("target_k4", key="name", size=0.75);
// &target_k4 @WIRE(mode="straight") {#X1567:1 %t8277:p};
// %t8278 = $IO_PORT @ATTACH &n1123 => @PLACE(298, -3879) => @ORIENT("MY");
// %t8278 @TEXT("n1123", key="name", size=0.75);
// &n1123 @WIRE(mode="straight") {#X1567:2 %t8278:p};
// %t8279 = $SUPPLY @ATTACH &vdd => @PLACE(288, -3870);
// &vdd @WIRE(mode="straight") {#X1567:3 %t8279:p};
// %t8280 = $GROUND @ATTACH &vss => @PLACE(288, -3888);
// &vss @WIRE(mode="straight") {#X1567:4 %t8280:p};
// %t8281 = $IO_PORT @ATTACH &target_k5 => @PLACE(158, -3910) => @ORIENT("R0");
// %t8281 @TEXT("target_k5", key="name", size=0.75);
// &target_k5 @WIRE(mode="straight") {#X1568:1 %t8281:p};
// %t8282 = $IO_PORT @ATTACH &n747 => @PLACE(178, -3910) => @ORIENT("MY");
// %t8282 @TEXT("n747", key="name", size=0.75);
// &n747 @WIRE(mode="straight") {#X1568:2 %t8282:p};
// %t8283 = $SUPPLY @ATTACH &vdd => @PLACE(168, -3901);
// &vdd @WIRE(mode="straight") {#X1568:3 %t8283:p};
// %t8284 = $GROUND @ATTACH &vss => @PLACE(168, -3919);
// &vss @WIRE(mode="straight") {#X1568:4 %t8284:p};
// %t8285 = $IO_PORT @ATTACH &target_k1 => @PLACE(198, -3910) => @ORIENT("R0");
// %t8285 @TEXT("target_k1", key="name", size=0.75);
// &target_k1 @WIRE(mode="straight") {#X1569:1 %t8285:p};
// %t8286 = $IO_PORT @ATTACH &n1118 => @PLACE(218, -3910) => @ORIENT("MY");
// %t8286 @TEXT("n1118", key="name", size=0.75);
// &n1118 @WIRE(mode="straight") {#X1569:2 %t8286:p};
// %t8287 = $SUPPLY @ATTACH &vdd => @PLACE(208, -3901);
// &vdd @WIRE(mode="straight") {#X1569:3 %t8287:p};
// %t8288 = $GROUND @ATTACH &vss => @PLACE(208, -3919);
// &vss @WIRE(mode="straight") {#X1569:4 %t8288:p};
// %t8289 = $IO_PORT @ATTACH &n643 => @PLACE(238, -3910) => @ORIENT("R0");
// %t8289 @TEXT("n643", key="name", size=0.75);
// &n643 @WIRE(mode="straight") {#X1570:1 %t8289:p};
// %t8290 = $IO_PORT @ATTACH &n698 => @PLACE(258, -3910) => @ORIENT("MY");
// %t8290 @TEXT("n698", key="name", size=0.75);
// &n698 @WIRE(mode="straight") {#X1570:2 %t8290:p};
// %t8291 = $SUPPLY @ATTACH &vdd => @PLACE(248, -3901);
// &vdd @WIRE(mode="straight") {#X1570:3 %t8291:p};
// %t8292 = $GROUND @ATTACH &vss => @PLACE(248, -3919);
// &vss @WIRE(mode="straight") {#X1570:4 %t8292:p};
// %t8293 = $IO_PORT @ATTACH &n322 => @PLACE(278, -3910) => @ORIENT("R0");
// %t8293 @TEXT("n322", key="name", size=0.75);
// &n322 @WIRE(mode="straight") {#X1571:1 %t8293:p};
// %t8294 = $IO_PORT @ATTACH &n1128 => @PLACE(298, -3910) => @ORIENT("MY");
// %t8294 @TEXT("n1128", key="name", size=0.75);
// &n1128 @WIRE(mode="straight") {#X1571:2 %t8294:p};
// %t8295 = $SUPPLY @ATTACH &vdd => @PLACE(288, -3901);
// &vdd @WIRE(mode="straight") {#X1571:3 %t8295:p};
// %t8296 = $GROUND @ATTACH &vss => @PLACE(288, -3919);
// &vss @WIRE(mode="straight") {#X1571:4 %t8296:p};
// %t8297 = $IO_PORT @ATTACH &coarse1 => @PLACE(158, -3945) => @ORIENT("R0");
// %t8297 @TEXT("coarse1", key="name", size=0.75);
// &coarse1 @WIRE(mode="straight") {#X1572:1 %t8297:p};
// %t8298 = $IO_PORT @ATTACH &n538 => @PLACE(178, -3945) => @ORIENT("MY");
// %t8298 @TEXT("n538", key="name", size=0.75);
// &n538 @WIRE(mode="straight") {#X1572:2 %t8298:p};
// %t8299 = $SUPPLY @ATTACH &vdd => @PLACE(168, -3936);
// &vdd @WIRE(mode="straight") {#X1572:3 %t8299:p};
// %t8300 = $GROUND @ATTACH &vss => @PLACE(168, -3954);
// &vss @WIRE(mode="straight") {#X1572:4 %t8300:p};
// %t8301 = $IO_PORT @ATTACH &coarse2 => @PLACE(198, -3945) => @ORIENT("R0");
// %t8301 @TEXT("coarse2", key="name", size=0.75);
// &coarse2 @WIRE(mode="straight") {#X1573:1 %t8301:p};
// %t8302 = $IO_PORT @ATTACH &n540 => @PLACE(218, -3945) => @ORIENT("MY");
// %t8302 @TEXT("n540", key="name", size=0.75);
// &n540 @WIRE(mode="straight") {#X1573:2 %t8302:p};
// %t8303 = $SUPPLY @ATTACH &vdd => @PLACE(208, -3936);
// &vdd @WIRE(mode="straight") {#X1573:3 %t8303:p};
// %t8304 = $GROUND @ATTACH &vss => @PLACE(208, -3954);
// &vss @WIRE(mode="straight") {#X1573:4 %t8304:p};
// %t8305 = $IO_PORT @ATTACH &coarse3 => @PLACE(238, -3945) => @ORIENT("R0");
// %t8305 @TEXT("coarse3", key="name", size=0.75);
// &coarse3 @WIRE(mode="straight") {#X1574:1 %t8305:p};
// %t8306 = $IO_PORT @ATTACH &n543 => @PLACE(258, -3945) => @ORIENT("MY");
// %t8306 @TEXT("n543", key="name", size=0.75);
// &n543 @WIRE(mode="straight") {#X1574:2 %t8306:p};
// %t8307 = $SUPPLY @ATTACH &vdd => @PLACE(248, -3936);
// &vdd @WIRE(mode="straight") {#X1574:3 %t8307:p};
// %t8308 = $GROUND @ATTACH &vss => @PLACE(248, -3954);
// &vss @WIRE(mode="straight") {#X1574:4 %t8308:p};
// %t8309 = $IO_PORT @ATTACH &coarse4 => @PLACE(278, -3945) => @ORIENT("R0");
// %t8309 @TEXT("coarse4", key="name", size=0.75);
// &coarse4 @WIRE(mode="straight") {#X1575:1 %t8309:p};
// %t8310 = $IO_PORT @ATTACH &n546 => @PLACE(298, -3945) => @ORIENT("MY");
// %t8310 @TEXT("n546", key="name", size=0.75);
// &n546 @WIRE(mode="straight") {#X1575:2 %t8310:p};
// %t8311 = $SUPPLY @ATTACH &vdd => @PLACE(288, -3936);
// &vdd @WIRE(mode="straight") {#X1575:3 %t8311:p};
// %t8312 = $GROUND @ATTACH &vss => @PLACE(288, -3954);
// &vss @WIRE(mode="straight") {#X1575:4 %t8312:p};
// %t8313 = $IO_PORT @ATTACH &coarse5 => @PLACE(158, -3980) => @ORIENT("R0");
// %t8313 @TEXT("coarse5", key="name", size=0.75);
// &coarse5 @WIRE(mode="straight") {#X1576:1 %t8313:p};
// %t8314 = $IO_PORT @ATTACH &n549 => @PLACE(178, -3980) => @ORIENT("MY");
// %t8314 @TEXT("n549", key="name", size=0.75);
// &n549 @WIRE(mode="straight") {#X1576:2 %t8314:p};
// %t8315 = $SUPPLY @ATTACH &vdd => @PLACE(168, -3971);
// &vdd @WIRE(mode="straight") {#X1576:3 %t8315:p};
// %t8316 = $GROUND @ATTACH &vss => @PLACE(168, -3989);
// &vss @WIRE(mode="straight") {#X1576:4 %t8316:p};
// %t8317 = $IO_PORT @ATTACH &coarse6 => @PLACE(198, -3980) => @ORIENT("R0");
// %t8317 @TEXT("coarse6", key="name", size=0.75);
// &coarse6 @WIRE(mode="straight") {#X1577:1 %t8317:p};
// %t8318 = $IO_PORT @ATTACH &n552 => @PLACE(218, -3980) => @ORIENT("MY");
// %t8318 @TEXT("n552", key="name", size=0.75);
// &n552 @WIRE(mode="straight") {#X1577:2 %t8318:p};
// %t8319 = $SUPPLY @ATTACH &vdd => @PLACE(208, -3971);
// &vdd @WIRE(mode="straight") {#X1577:3 %t8319:p};
// %t8320 = $GROUND @ATTACH &vss => @PLACE(208, -3989);
// &vss @WIRE(mode="straight") {#X1577:4 %t8320:p};
// %t8321 = $IO_PORT @ATTACH &n93 => @PLACE(238, -3980) => @ORIENT("R0");
// %t8321 @TEXT("n93", key="name", size=0.75);
// &n93 @WIRE(mode="straight") {#X1578:1 %t8321:p};
// %t8322 = $IO_PORT @ATTACH &n1089 => @PLACE(258, -3980) => @ORIENT("MY");
// %t8322 @TEXT("n1089", key="name", size=0.75);
// &n1089 @WIRE(mode="straight") {#X1578:2 %t8322:p};
// %t8323 = $SUPPLY @ATTACH &vdd => @PLACE(248, -3971);
// &vdd @WIRE(mode="straight") {#X1578:3 %t8323:p};
// %t8324 = $GROUND @ATTACH &vss => @PLACE(248, -3989);
// &vss @WIRE(mode="straight") {#X1578:4 %t8324:p};
// %t8325 = $IO_PORT @ATTACH &n95 => @PLACE(278, -3980) => @ORIENT("R0");
// %t8325 @TEXT("n95", key="name", size=0.75);
// &n95 @WIRE(mode="straight") {#X1579:1 %t8325:p};
// %t8326 = $IO_PORT @ATTACH &n1090 => @PLACE(298, -3980) => @ORIENT("MY");
// %t8326 @TEXT("n1090", key="name", size=0.75);
// &n1090 @WIRE(mode="straight") {#X1579:2 %t8326:p};
// %t8327 = $SUPPLY @ATTACH &vdd => @PLACE(288, -3971);
// &vdd @WIRE(mode="straight") {#X1579:3 %t8327:p};
// %t8328 = $GROUND @ATTACH &vss => @PLACE(288, -3989);
// &vss @WIRE(mode="straight") {#X1579:4 %t8328:p};
// %t8329 = $IO_PORT @ATTACH &n640 => @PLACE(158, -4015) => @ORIENT("R0");
// %t8329 @TEXT("n640", key="name", size=0.75);
// &n640 @WIRE(mode="straight") {#X1580:1 %t8329:p};
// %t8330 = $IO_PORT @ATTACH &n696 => @PLACE(178, -4015) => @ORIENT("MY");
// %t8330 @TEXT("n696", key="name", size=0.75);
// &n696 @WIRE(mode="straight") {#X1580:2 %t8330:p};
// %t8331 = $SUPPLY @ATTACH &vdd => @PLACE(168, -4006);
// &vdd @WIRE(mode="straight") {#X1580:3 %t8331:p};
// %t8332 = $GROUND @ATTACH &vss => @PLACE(168, -4024);
// &vss @WIRE(mode="straight") {#X1580:4 %t8332:p};
// %t8333 = $IO_PORT @ATTACH &n661 => @PLACE(198, -4015) => @ORIENT("R0");
// %t8333 @TEXT("n661", key="name", size=0.75);
// &n661 @WIRE(mode="straight") {#X1581:1 %t8333:p};
// %t8334 = $IO_PORT @ATTACH &n702 => @PLACE(218, -4015) => @ORIENT("MY");
// %t8334 @TEXT("n702", key="name", size=0.75);
// &n702 @WIRE(mode="straight") {#X1581:2 %t8334:p};
// %t8335 = $SUPPLY @ATTACH &vdd => @PLACE(208, -4006);
// &vdd @WIRE(mode="straight") {#X1581:3 %t8335:p};
// %t8336 = $GROUND @ATTACH &vss => @PLACE(208, -4024);
// &vss @WIRE(mode="straight") {#X1581:4 %t8336:p};
// %t8337 = $IO_PORT @ATTACH &n667 => @PLACE(238, -4015) => @ORIENT("R0");
// %t8337 @TEXT("n667", key="name", size=0.75);
// &n667 @WIRE(mode="straight") {#X1582:1 %t8337:p};
// %t8338 = $IO_PORT @ATTACH &n886 => @PLACE(258, -4015) => @ORIENT("MY");
// %t8338 @TEXT("n886", key="name", size=0.75);
// &n886 @WIRE(mode="straight") {#X1582:2 %t8338:p};
// %t8339 = $SUPPLY @ATTACH &vdd => @PLACE(248, -4006);
// &vdd @WIRE(mode="straight") {#X1582:3 %t8339:p};
// %t8340 = $GROUND @ATTACH &vss => @PLACE(248, -4024);
// &vss @WIRE(mode="straight") {#X1582:4 %t8340:p};
// %t8341 = $IO_PORT @ATTACH &n75 => @PLACE(278, -4015) => @ORIENT("R0");
// %t8341 @TEXT("n75", key="name", size=0.75);
// &n75 @WIRE(mode="straight") {#X1583:1 %t8341:p};
// %t8342 = $IO_PORT @ATTACH &n888 => @PLACE(298, -4015) => @ORIENT("MY");
// %t8342 @TEXT("n888", key="name", size=0.75);
// &n888 @WIRE(mode="straight") {#X1583:2 %t8342:p};
// %t8343 = $SUPPLY @ATTACH &vdd => @PLACE(288, -4006);
// &vdd @WIRE(mode="straight") {#X1583:3 %t8343:p};
// %t8344 = $GROUND @ATTACH &vss => @PLACE(288, -4024);
// &vss @WIRE(mode="straight") {#X1583:4 %t8344:p};
// %t8345 = $IO_PORT @ATTACH &n77 => @PLACE(326, -3848) => @ORIENT("R0");
// %t8345 @TEXT("n77", key="name", size=0.75);
// &n77 @WIRE(mode="straight") {#X1584:1 %t8345:p};
// %t8346 = $IO_PORT @ATTACH &n890 => @PLACE(346, -3848) => @ORIENT("MY");
// %t8346 @TEXT("n890", key="name", size=0.75);
// &n890 @WIRE(mode="straight") {#X1584:2 %t8346:p};
// %t8347 = $SUPPLY @ATTACH &vdd => @PLACE(336, -3839);
// &vdd @WIRE(mode="straight") {#X1584:3 %t8347:p};
// %t8348 = $GROUND @ATTACH &vss => @PLACE(336, -3857);
// &vss @WIRE(mode="straight") {#X1584:4 %t8348:p};
// %t8349 = $IO_PORT @ATTACH &n79 => @PLACE(366, -3848) => @ORIENT("R0");
// %t8349 @TEXT("n79", key="name", size=0.75);
// &n79 @WIRE(mode="straight") {#X1585:1 %t8349:p};
// %t8350 = $IO_PORT @ATTACH &n892 => @PLACE(386, -3848) => @ORIENT("MY");
// %t8350 @TEXT("n892", key="name", size=0.75);
// &n892 @WIRE(mode="straight") {#X1585:2 %t8350:p};
// %t8351 = $SUPPLY @ATTACH &vdd => @PLACE(376, -3839);
// &vdd @WIRE(mode="straight") {#X1585:3 %t8351:p};
// %t8352 = $GROUND @ATTACH &vss => @PLACE(376, -3857);
// &vss @WIRE(mode="straight") {#X1585:4 %t8352:p};
// %t8353 = $IO_PORT @ATTACH &n81 => @PLACE(406, -3848) => @ORIENT("R0");
// %t8353 @TEXT("n81", key="name", size=0.75);
// &n81 @WIRE(mode="straight") {#X1586:1 %t8353:p};
// %t8354 = $IO_PORT @ATTACH &n894 => @PLACE(426, -3848) => @ORIENT("MY");
// %t8354 @TEXT("n894", key="name", size=0.75);
// &n894 @WIRE(mode="straight") {#X1586:2 %t8354:p};
// %t8355 = $SUPPLY @ATTACH &vdd => @PLACE(416, -3839);
// &vdd @WIRE(mode="straight") {#X1586:3 %t8355:p};
// %t8356 = $GROUND @ATTACH &vss => @PLACE(416, -3857);
// &vss @WIRE(mode="straight") {#X1586:4 %t8356:p};
// %t8357 = $IO_PORT @ATTACH &n83 => @PLACE(446, -3848) => @ORIENT("R0");
// %t8357 @TEXT("n83", key="name", size=0.75);
// &n83 @WIRE(mode="straight") {#X1587:1 %t8357:p};
// %t8358 = $IO_PORT @ATTACH &n896 => @PLACE(466, -3848) => @ORIENT("MY");
// %t8358 @TEXT("n896", key="name", size=0.75);
// &n896 @WIRE(mode="straight") {#X1587:2 %t8358:p};
// %t8359 = $SUPPLY @ATTACH &vdd => @PLACE(456, -3839);
// &vdd @WIRE(mode="straight") {#X1587:3 %t8359:p};
// %t8360 = $GROUND @ATTACH &vss => @PLACE(456, -3857);
// &vss @WIRE(mode="straight") {#X1587:4 %t8360:p};
// %t8361 = $IO_PORT @ATTACH &n85 => @PLACE(326, -3879) => @ORIENT("R0");
// %t8361 @TEXT("n85", key="name", size=0.75);
// &n85 @WIRE(mode="straight") {#X1588:1 %t8361:p};
// %t8362 = $IO_PORT @ATTACH &n898 => @PLACE(346, -3879) => @ORIENT("MY");
// %t8362 @TEXT("n898", key="name", size=0.75);
// &n898 @WIRE(mode="straight") {#X1588:2 %t8362:p};
// %t8363 = $SUPPLY @ATTACH &vdd => @PLACE(336, -3870);
// &vdd @WIRE(mode="straight") {#X1588:3 %t8363:p};
// %t8364 = $GROUND @ATTACH &vss => @PLACE(336, -3888);
// &vss @WIRE(mode="straight") {#X1588:4 %t8364:p};
// %t8365 = $IO_PORT @ATTACH &n133 => @PLACE(366, -3879) => @ORIENT("R0");
// %t8365 @TEXT("n133", key="name", size=0.75);
// &n133 @WIRE(mode="straight") {#X1589:1 %t8365:p};
// %t8366 = $IO_PORT @ATTACH &n929 => @PLACE(386, -3879) => @ORIENT("MY");
// %t8366 @TEXT("n929", key="name", size=0.75);
// &n929 @WIRE(mode="straight") {#X1589:2 %t8366:p};
// %t8367 = $SUPPLY @ATTACH &vdd => @PLACE(376, -3870);
// &vdd @WIRE(mode="straight") {#X1589:3 %t8367:p};
// %t8368 = $GROUND @ATTACH &vss => @PLACE(376, -3888);
// &vss @WIRE(mode="straight") {#X1589:4 %t8368:p};
// %t8369 = $IO_PORT @ATTACH &dac2 => @PLACE(406, -3879) => @ORIENT("R0");
// %t8369 @TEXT("dac2", key="name", size=0.75);
// &dac2 @WIRE(mode="straight") {#X1590:1 %t8369:p};
// %t8370 = $IO_PORT @ATTACH &n572 => @PLACE(426, -3879) => @ORIENT("MY");
// %t8370 @TEXT("n572", key="name", size=0.75);
// &n572 @WIRE(mode="straight") {#X1590:2 %t8370:p};
// %t8371 = $SUPPLY @ATTACH &vdd => @PLACE(416, -3870);
// &vdd @WIRE(mode="straight") {#X1590:3 %t8371:p};
// %t8372 = $GROUND @ATTACH &vss => @PLACE(416, -3888);
// &vss @WIRE(mode="straight") {#X1590:4 %t8372:p};
// %t8373 = $IO_PORT @ATTACH &dac4 => @PLACE(446, -3879) => @ORIENT("R0");
// %t8373 @TEXT("dac4", key="name", size=0.75);
// &dac4 @WIRE(mode="straight") {#X1591:1 %t8373:p};
// %t8374 = $IO_PORT @ATTACH &n575 => @PLACE(466, -3879) => @ORIENT("MY");
// %t8374 @TEXT("n575", key="name", size=0.75);
// &n575 @WIRE(mode="straight") {#X1591:2 %t8374:p};
// %t8375 = $SUPPLY @ATTACH &vdd => @PLACE(456, -3870);
// &vdd @WIRE(mode="straight") {#X1591:3 %t8375:p};
// %t8376 = $GROUND @ATTACH &vss => @PLACE(456, -3888);
// &vss @WIRE(mode="straight") {#X1591:4 %t8376:p};
// %t8377 = $IO_PORT @ATTACH &n101 => @PLACE(326, -3910) => @ORIENT("R0");
// %t8377 @TEXT("n101", key="name", size=0.75);
// &n101 @WIRE(mode="straight") {#X1592:1 %t8377:p};
// %t8378 = $IO_PORT @ATTACH &n1075 => @PLACE(346, -3910) => @ORIENT("MY");
// %t8378 @TEXT("n1075", key="name", size=0.75);
// &n1075 @WIRE(mode="straight") {#X1592:2 %t8378:p};
// %t8379 = $SUPPLY @ATTACH &vdd => @PLACE(336, -3901);
// &vdd @WIRE(mode="straight") {#X1592:3 %t8379:p};
// %t8380 = $GROUND @ATTACH &vss => @PLACE(336, -3919);
// &vss @WIRE(mode="straight") {#X1592:4 %t8380:p};
// %t8381 = $IO_PORT @ATTACH &n103 => @PLACE(366, -3910) => @ORIENT("R0");
// %t8381 @TEXT("n103", key="name", size=0.75);
// &n103 @WIRE(mode="straight") {#X1593:1 %t8381:p};
// %t8382 = $IO_PORT @ATTACH &n1062 => @PLACE(386, -3910) => @ORIENT("MY");
// %t8382 @TEXT("n1062", key="name", size=0.75);
// &n1062 @WIRE(mode="straight") {#X1593:2 %t8382:p};
// %t8383 = $SUPPLY @ATTACH &vdd => @PLACE(376, -3901);
// &vdd @WIRE(mode="straight") {#X1593:3 %t8383:p};
// %t8384 = $GROUND @ATTACH &vss => @PLACE(376, -3919);
// &vss @WIRE(mode="straight") {#X1593:4 %t8384:p};
// %t8385 = $IO_PORT @ATTACH &n105 => @PLACE(406, -3910) => @ORIENT("R0");
// %t8385 @TEXT("n105", key="name", size=0.75);
// &n105 @WIRE(mode="straight") {#X1594:1 %t8385:p};
// %t8386 = $IO_PORT @ATTACH &n1098 => @PLACE(426, -3910) => @ORIENT("MY");
// %t8386 @TEXT("n1098", key="name", size=0.75);
// &n1098 @WIRE(mode="straight") {#X1594:2 %t8386:p};
// %t8387 = $SUPPLY @ATTACH &vdd => @PLACE(416, -3901);
// &vdd @WIRE(mode="straight") {#X1594:3 %t8387:p};
// %t8388 = $GROUND @ATTACH &vss => @PLACE(416, -3919);
// &vss @WIRE(mode="straight") {#X1594:4 %t8388:p};
// %t8389 = $IO_PORT @ATTACH &vss => @PLACE(446, -3906) => @ORIENT("R0");
// %t8389 @TEXT("vss", key="name", size=0.75);
// &vss @WIRE(mode="straight") {#X1595:1 %t8389:p};
// %t8390 = $IO_PORT @ATTACH &n1186 => @PLACE(446, -3910) => @ORIENT("R0");
// %t8390 @TEXT("n1186", key="name", size=0.75);
// &n1186 @WIRE(mode="straight") {#X1595:2 %t8390:p};
// %t8391 = $IO_PORT @ATTACH &n1179 => @PLACE(446, -3914) => @ORIENT("R0");
// %t8391 @TEXT("n1179", key="name", size=0.75);
// &n1179 @WIRE(mode="straight") {#X1595:3 %t8391:p};
// %t8392 = $IO_PORT @ATTACH &n209 => @PLACE(466, -3910) => @ORIENT("MY");
// %t8392 @TEXT("n209", key="name", size=0.75);
// &n209 @WIRE(mode="straight") {#X1595:4 %t8392:p};
// %t8393 = $SUPPLY @ATTACH &vdd => @PLACE(456, -3897);
// &vdd @WIRE(mode="straight") {#X1595:5 %t8393:p};
// %t8394 = $GROUND @ATTACH &vss => @PLACE(456, -3923);
// &vss @WIRE(mode="straight") {#X1595:6 %t8394:p};
// %t8395 = $IO_PORT @ATTACH &vss => @PLACE(326, -3941) => @ORIENT("R0");
// %t8395 @TEXT("vss", key="name", size=0.75);
// &vss @WIRE(mode="straight") {#X1596:1 %t8395:p};
// %t8396 = $IO_PORT @ATTACH &n1193 => @PLACE(326, -3945) => @ORIENT("R0");
// %t8396 @TEXT("n1193", key="name", size=0.75);
// &n1193 @WIRE(mode="straight") {#X1596:2 %t8396:p};
// %t8397 = $IO_PORT @ATTACH &n1179 => @PLACE(326, -3949) => @ORIENT("R0");
// %t8397 @TEXT("n1179", key="name", size=0.75);
// &n1179 @WIRE(mode="straight") {#X1596:3 %t8397:p};
// %t8398 = $IO_PORT @ATTACH &n208 => @PLACE(346, -3945) => @ORIENT("MY");
// %t8398 @TEXT("n208", key="name", size=0.75);
// &n208 @WIRE(mode="straight") {#X1596:4 %t8398:p};
// %t8399 = $SUPPLY @ATTACH &vdd => @PLACE(336, -3932);
// &vdd @WIRE(mode="straight") {#X1596:5 %t8399:p};
// %t8400 = $GROUND @ATTACH &vss => @PLACE(336, -3958);
// &vss @WIRE(mode="straight") {#X1596:6 %t8400:p};
// %t8401 = $IO_PORT @ATTACH &vss => @PLACE(366, -3941) => @ORIENT("R0");
// %t8401 @TEXT("vss", key="name", size=0.75);
// &vss @WIRE(mode="straight") {#X1597:1 %t8401:p};
// %t8402 = $IO_PORT @ATTACH &n1200 => @PLACE(366, -3945) => @ORIENT("R0");
// %t8402 @TEXT("n1200", key="name", size=0.75);
// &n1200 @WIRE(mode="straight") {#X1597:2 %t8402:p};
// %t8403 = $IO_PORT @ATTACH &n1179 => @PLACE(366, -3949) => @ORIENT("R0");
// %t8403 @TEXT("n1179", key="name", size=0.75);
// &n1179 @WIRE(mode="straight") {#X1597:3 %t8403:p};
// %t8404 = $IO_PORT @ATTACH &n207 => @PLACE(386, -3945) => @ORIENT("MY");
// %t8404 @TEXT("n207", key="name", size=0.75);
// &n207 @WIRE(mode="straight") {#X1597:4 %t8404:p};
// %t8405 = $SUPPLY @ATTACH &vdd => @PLACE(376, -3932);
// &vdd @WIRE(mode="straight") {#X1597:5 %t8405:p};
// %t8406 = $GROUND @ATTACH &vss => @PLACE(376, -3958);
// &vss @WIRE(mode="straight") {#X1597:6 %t8406:p};
// %t8407 = $IO_PORT @ATTACH &vss => @PLACE(406, -3941) => @ORIENT("R0");
// %t8407 @TEXT("vss", key="name", size=0.75);
// &vss @WIRE(mode="straight") {#X1598:1 %t8407:p};
// %t8408 = $IO_PORT @ATTACH &n1207 => @PLACE(406, -3945) => @ORIENT("R0");
// %t8408 @TEXT("n1207", key="name", size=0.75);
// &n1207 @WIRE(mode="straight") {#X1598:2 %t8408:p};
// %t8409 = $IO_PORT @ATTACH &n1179 => @PLACE(406, -3949) => @ORIENT("R0");
// %t8409 @TEXT("n1179", key="name", size=0.75);
// &n1179 @WIRE(mode="straight") {#X1598:3 %t8409:p};
// %t8410 = $IO_PORT @ATTACH &n206 => @PLACE(426, -3945) => @ORIENT("MY");
// %t8410 @TEXT("n206", key="name", size=0.75);
// &n206 @WIRE(mode="straight") {#X1598:4 %t8410:p};
// %t8411 = $SUPPLY @ATTACH &vdd => @PLACE(416, -3932);
// &vdd @WIRE(mode="straight") {#X1598:5 %t8411:p};
// %t8412 = $GROUND @ATTACH &vss => @PLACE(416, -3958);
// &vss @WIRE(mode="straight") {#X1598:6 %t8412:p};
// %t8413 = $IO_PORT @ATTACH &vss => @PLACE(446, -3941) => @ORIENT("R0");
// %t8413 @TEXT("vss", key="name", size=0.75);
// &vss @WIRE(mode="straight") {#X1599:1 %t8413:p};
// %t8414 = $IO_PORT @ATTACH &n1214 => @PLACE(446, -3945) => @ORIENT("R0");
// %t8414 @TEXT("n1214", key="name", size=0.75);
// &n1214 @WIRE(mode="straight") {#X1599:2 %t8414:p};
// %t8415 = $IO_PORT @ATTACH &n1179 => @PLACE(446, -3949) => @ORIENT("R0");
// %t8415 @TEXT("n1179", key="name", size=0.75);
// &n1179 @WIRE(mode="straight") {#X1599:3 %t8415:p};
// %t8416 = $IO_PORT @ATTACH &n205 => @PLACE(466, -3945) => @ORIENT("MY");
// %t8416 @TEXT("n205", key="name", size=0.75);
// &n205 @WIRE(mode="straight") {#X1599:4 %t8416:p};
// %t8417 = $SUPPLY @ATTACH &vdd => @PLACE(456, -3932);
// &vdd @WIRE(mode="straight") {#X1599:5 %t8417:p};
// %t8418 = $GROUND @ATTACH &vss => @PLACE(456, -3958);
// &vss @WIRE(mode="straight") {#X1599:6 %t8418:p};
// %t8419 = $IO_PORT @ATTACH &vss => @PLACE(326, -3976) => @ORIENT("R0");
// %t8419 @TEXT("vss", key="name", size=0.75);
// &vss @WIRE(mode="straight") {#X1600:1 %t8419:p};
// %t8420 = $IO_PORT @ATTACH &n1221 => @PLACE(326, -3980) => @ORIENT("R0");
// %t8420 @TEXT("n1221", key="name", size=0.75);
// &n1221 @WIRE(mode="straight") {#X1600:2 %t8420:p};
// %t8421 = $IO_PORT @ATTACH &n1179 => @PLACE(326, -3984) => @ORIENT("R0");
// %t8421 @TEXT("n1179", key="name", size=0.75);
// &n1179 @WIRE(mode="straight") {#X1600:3 %t8421:p};
// %t8422 = $IO_PORT @ATTACH &n204 => @PLACE(346, -3980) => @ORIENT("MY");
// %t8422 @TEXT("n204", key="name", size=0.75);
// &n204 @WIRE(mode="straight") {#X1600:4 %t8422:p};
// %t8423 = $SUPPLY @ATTACH &vdd => @PLACE(336, -3967);
// &vdd @WIRE(mode="straight") {#X1600:5 %t8423:p};
// %t8424 = $GROUND @ATTACH &vss => @PLACE(336, -3993);
// &vss @WIRE(mode="straight") {#X1600:6 %t8424:p};
// %t8425 = $IO_PORT @ATTACH &vss => @PLACE(366, -3976) => @ORIENT("R0");
// %t8425 @TEXT("vss", key="name", size=0.75);
// &vss @WIRE(mode="straight") {#X1601:1 %t8425:p};
// %t8426 = $IO_PORT @ATTACH &n1228 => @PLACE(366, -3980) => @ORIENT("R0");
// %t8426 @TEXT("n1228", key="name", size=0.75);
// &n1228 @WIRE(mode="straight") {#X1601:2 %t8426:p};
// %t8427 = $IO_PORT @ATTACH &n1179 => @PLACE(366, -3984) => @ORIENT("R0");
// %t8427 @TEXT("n1179", key="name", size=0.75);
// &n1179 @WIRE(mode="straight") {#X1601:3 %t8427:p};
// %t8428 = $IO_PORT @ATTACH &n202 => @PLACE(386, -3980) => @ORIENT("MY");
// %t8428 @TEXT("n202", key="name", size=0.75);
// &n202 @WIRE(mode="straight") {#X1601:4 %t8428:p};
// %t8429 = $SUPPLY @ATTACH &vdd => @PLACE(376, -3967);
// &vdd @WIRE(mode="straight") {#X1601:5 %t8429:p};
// %t8430 = $GROUND @ATTACH &vss => @PLACE(376, -3993);
// &vss @WIRE(mode="straight") {#X1601:6 %t8430:p};
// %t8431 = $IO_PORT @ATTACH &vss => @PLACE(406, -3976) => @ORIENT("R0");
// %t8431 @TEXT("vss", key="name", size=0.75);
// &vss @WIRE(mode="straight") {#X1602:1 %t8431:p};
// %t8432 = $IO_PORT @ATTACH &n1235 => @PLACE(406, -3980) => @ORIENT("R0");
// %t8432 @TEXT("n1235", key="name", size=0.75);
// &n1235 @WIRE(mode="straight") {#X1602:2 %t8432:p};
// %t8433 = $IO_PORT @ATTACH &n1179 => @PLACE(406, -3984) => @ORIENT("R0");
// %t8433 @TEXT("n1179", key="name", size=0.75);
// &n1179 @WIRE(mode="straight") {#X1602:3 %t8433:p};
// %t8434 = $IO_PORT @ATTACH &n210 => @PLACE(426, -3980) => @ORIENT("MY");
// %t8434 @TEXT("n210", key="name", size=0.75);
// &n210 @WIRE(mode="straight") {#X1602:4 %t8434:p};
// %t8435 = $SUPPLY @ATTACH &vdd => @PLACE(416, -3967);
// &vdd @WIRE(mode="straight") {#X1602:5 %t8435:p};
// %t8436 = $GROUND @ATTACH &vss => @PLACE(416, -3993);
// &vss @WIRE(mode="straight") {#X1602:6 %t8436:p};
// %t8437 = $IO_PORT @ATTACH &vss => @PLACE(446, -3976) => @ORIENT("R0");
// %t8437 @TEXT("vss", key="name", size=0.75);
// &vss @WIRE(mode="straight") {#X1603:1 %t8437:p};
// %t8438 = $IO_PORT @ATTACH &n1249 => @PLACE(446, -3980) => @ORIENT("R0");
// %t8438 @TEXT("n1249", key="name", size=0.75);
// &n1249 @WIRE(mode="straight") {#X1603:2 %t8438:p};
// %t8439 = $IO_PORT @ATTACH &n1240 => @PLACE(446, -3984) => @ORIENT("R0");
// %t8439 @TEXT("n1240", key="name", size=0.75);
// &n1240 @WIRE(mode="straight") {#X1603:3 %t8439:p};
// %t8440 = $IO_PORT @ATTACH &n143 => @PLACE(466, -3980) => @ORIENT("MY");
// %t8440 @TEXT("n143", key="name", size=0.75);
// &n143 @WIRE(mode="straight") {#X1603:4 %t8440:p};
// %t8441 = $SUPPLY @ATTACH &vdd => @PLACE(456, -3967);
// &vdd @WIRE(mode="straight") {#X1603:5 %t8441:p};
// %t8442 = $GROUND @ATTACH &vss => @PLACE(456, -3993);
// &vss @WIRE(mode="straight") {#X1603:6 %t8442:p};
// %t8443 = $IO_PORT @ATTACH &vss => @PLACE(326, -4011) => @ORIENT("R0");
// %t8443 @TEXT("vss", key="name", size=0.75);
// &vss @WIRE(mode="straight") {#X1604:1 %t8443:p};
// %t8444 = $IO_PORT @ATTACH &n1255 => @PLACE(326, -4015) => @ORIENT("R0");
// %t8444 @TEXT("n1255", key="name", size=0.75);
// &n1255 @WIRE(mode="straight") {#X1604:2 %t8444:p};
// %t8445 = $IO_PORT @ATTACH &n1240 => @PLACE(326, -4019) => @ORIENT("R0");
// %t8445 @TEXT("n1240", key="name", size=0.75);
// &n1240 @WIRE(mode="straight") {#X1604:3 %t8445:p};
// %t8446 = $IO_PORT @ATTACH &n141 => @PLACE(346, -4015) => @ORIENT("MY");
// %t8446 @TEXT("n141", key="name", size=0.75);
// &n141 @WIRE(mode="straight") {#X1604:4 %t8446:p};
// %t8447 = $SUPPLY @ATTACH &vdd => @PLACE(336, -4002);
// &vdd @WIRE(mode="straight") {#X1604:5 %t8447:p};
// %t8448 = $GROUND @ATTACH &vss => @PLACE(336, -4028);
// &vss @WIRE(mode="straight") {#X1604:6 %t8448:p};
// %t8449 = $IO_PORT @ATTACH &vss => @PLACE(366, -4011) => @ORIENT("R0");
// %t8449 @TEXT("vss", key="name", size=0.75);
// &vss @WIRE(mode="straight") {#X1605:1 %t8449:p};
// %t8450 = $IO_PORT @ATTACH &n1261 => @PLACE(366, -4015) => @ORIENT("R0");
// %t8450 @TEXT("n1261", key="name", size=0.75);
// &n1261 @WIRE(mode="straight") {#X1605:2 %t8450:p};
// %t8451 = $IO_PORT @ATTACH &n1240 => @PLACE(366, -4019) => @ORIENT("R0");
// %t8451 @TEXT("n1240", key="name", size=0.75);
// &n1240 @WIRE(mode="straight") {#X1605:3 %t8451:p};
// %t8452 = $IO_PORT @ATTACH &n198 => @PLACE(386, -4015) => @ORIENT("MY");
// %t8452 @TEXT("n198", key="name", size=0.75);
// &n198 @WIRE(mode="straight") {#X1605:4 %t8452:p};
// %t8453 = $SUPPLY @ATTACH &vdd => @PLACE(376, -4002);
// &vdd @WIRE(mode="straight") {#X1605:5 %t8453:p};
// %t8454 = $GROUND @ATTACH &vss => @PLACE(376, -4028);
// &vss @WIRE(mode="straight") {#X1605:6 %t8454:p};
// %t8455 = $IO_PORT @ATTACH &vss => @PLACE(406, -4011) => @ORIENT("R0");
// %t8455 @TEXT("vss", key="name", size=0.75);
// &vss @WIRE(mode="straight") {#X1606:1 %t8455:p};
// %t8456 = $IO_PORT @ATTACH &n1264 => @PLACE(406, -4015) => @ORIENT("R0");
// %t8456 @TEXT("n1264", key="name", size=0.75);
// &n1264 @WIRE(mode="straight") {#X1606:2 %t8456:p};
// %t8457 = $IO_PORT @ATTACH &n981 => @PLACE(406, -4019) => @ORIENT("R0");
// %t8457 @TEXT("n981", key="name", size=0.75);
// &n981 @WIRE(mode="straight") {#X1606:3 %t8457:p};
// %t8458 = $IO_PORT @ATTACH &n191 => @PLACE(426, -4015) => @ORIENT("MY");
// %t8458 @TEXT("n191", key="name", size=0.75);
// &n191 @WIRE(mode="straight") {#X1606:4 %t8458:p};
// %t8459 = $SUPPLY @ATTACH &vdd => @PLACE(416, -4002);
// &vdd @WIRE(mode="straight") {#X1606:5 %t8459:p};
// %t8460 = $GROUND @ATTACH &vss => @PLACE(416, -4028);
// &vss @WIRE(mode="straight") {#X1606:6 %t8460:p};
// %t8461 = $IO_PORT @ATTACH &vss => @PLACE(446, -4011) => @ORIENT("R0");
// %t8461 @TEXT("vss", key="name", size=0.75);
// &vss @WIRE(mode="straight") {#X1607:1 %t8461:p};
// %t8462 = $IO_PORT @ATTACH &n1266 => @PLACE(446, -4015) => @ORIENT("R0");
// %t8462 @TEXT("n1266", key="name", size=0.75);
// &n1266 @WIRE(mode="straight") {#X1607:2 %t8462:p};
// %t8463 = $IO_PORT @ATTACH &n189 => @PLACE(446, -4019) => @ORIENT("R0");
// %t8463 @TEXT("n189", key="name", size=0.75);
// &n189 @WIRE(mode="straight") {#X1607:3 %t8463:p};
// %t8464 = $IO_PORT @ATTACH &n188 => @PLACE(466, -4015) => @ORIENT("MY");
// %t8464 @TEXT("n188", key="name", size=0.75);
// &n188 @WIRE(mode="straight") {#X1607:4 %t8464:p};
// %t8465 = $SUPPLY @ATTACH &vdd => @PLACE(456, -4002);
// &vdd @WIRE(mode="straight") {#X1607:5 %t8465:p};
// %t8466 = $GROUND @ATTACH &vss => @PLACE(456, -4028);
// &vss @WIRE(mode="straight") {#X1607:6 %t8466:p};
// %t8467 = $IO_PORT @ATTACH &vss => @PLACE(494, -3844) => @ORIENT("R0");
// %t8467 @TEXT("vss", key="name", size=0.75);
// &vss @WIRE(mode="straight") {#X1608:1 %t8467:p};
// %t8468 = $IO_PORT @ATTACH &n1238 => @PLACE(494, -3848) => @ORIENT("R0");
// %t8468 @TEXT("n1238", key="name", size=0.75);
// &n1238 @WIRE(mode="straight") {#X1608:2 %t8468:p};
// %t8469 = $IO_PORT @ATTACH &n186 => @PLACE(494, -3852) => @ORIENT("R0");
// %t8469 @TEXT("n186", key="name", size=0.75);
// &n186 @WIRE(mode="straight") {#X1608:3 %t8469:p};
// %t8470 = $IO_PORT @ATTACH &n185 => @PLACE(514, -3848) => @ORIENT("MY");
// %t8470 @TEXT("n185", key="name", size=0.75);
// &n185 @WIRE(mode="straight") {#X1608:4 %t8470:p};
// %t8471 = $SUPPLY @ATTACH &vdd => @PLACE(504, -3835);
// &vdd @WIRE(mode="straight") {#X1608:5 %t8471:p};
// %t8472 = $GROUND @ATTACH &vss => @PLACE(504, -3861);
// &vss @WIRE(mode="straight") {#X1608:6 %t8472:p};
// (-16, -486) @TEXT("69  FLL / recenter | 1609 instances", size=1.2, halign="start");
// (-16, -490) @TEXT("Same-name tags connect locally. Open blocks for transistor details.", size=0.8, halign="start");
// }
ends tx_fll_recenter109_v14_pdk110_69
