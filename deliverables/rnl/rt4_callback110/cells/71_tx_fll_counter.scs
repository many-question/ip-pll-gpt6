// RF counter | frozen callback110 / recenter109 | RNL 0.3
// @RNL(type="header") { @VERSION("0.3"); @USE-PACKAGE(name="rnl-std-fill") {} }
simulator lang=spectre
subckt tx_fll_counter_pdk110_71 (clk gate reset q0 q1 q2 q3 q4 q5 q6 q7 q8 q9 q10 q11 q12 q13 vdd vss)
XCI (clk clkb vdd vss) pll_inv_pdk110_59
XGE (gate clkb clk safe_gate vdd vss) pll_latch_pdk110_72
XG (clk safe_gate gclk vdd vss) tx_and_pdk110_47
XF0 (gclk reset q0 qb0 vdd vss) tx_tff_pdk110_73
XF1 (qb0 reset q1 qb1 vdd vss) tx_tff_pdk110_73
XF2 (qb1 reset q2 qb2 vdd vss) tx_tff_pdk110_73
XF3 (qb2 reset q3 qb3 vdd vss) tx_tff_pdk110_73
XF4 (qb3 reset q4 qb4 vdd vss) tx_tff_pdk110_73
XF5 (qb4 reset q5 qb5 vdd vss) tx_tff_pdk110_73
XF6 (qb5 reset q6 qb6 vdd vss) tx_tff_pdk110_73
XF7 (qb6 reset q7 qb7 vdd vss) tx_tff_pdk110_73
XF8 (qb7 reset q8 qb8 vdd vss) tx_tff_pdk110_73
XF9 (qb8 reset q9 qb9 vdd vss) tx_tff_pdk110_73
XF10 (qb9 reset q10 qb10 vdd vss) tx_tff_pdk110_73
XF11 (qb10 reset q11 qb11 vdd vss) tx_tff_pdk110_73
XF12 (qb11 reset q12 qb12 vdd vss) tx_tff_pdk110_73
XF13 (qb12 reset q13 qb13 vdd vss) tx_tff_pdk110_73
// @RNL(author="manual-schematic126") {
// $CELL = @DEFINE-SYMBOL {
// @LINE {(-12, 30) (12, 30) (12, -30) (-12, -30) (-12, 30)};
// (-14, 4) @PIN(terminal="clk", direction="left");
// @LINE {(-14, 4) (-12, 4)};
// (-11.4, 4) @TEXT("clk", size=0.7, halign="start");
// (-14, 0) @PIN(terminal="gate", direction="left");
// @LINE {(-14, 0) (-12, 0)};
// (-11.4, 0) @TEXT("gate", size=0.7, halign="start");
// (-14, -4) @PIN(terminal="reset", direction="left");
// @LINE {(-14, -4) (-12, -4)};
// (-11.4, -4) @TEXT("reset", size=0.7, halign="start");
// (14, 26) @PIN(terminal="q0", direction="right");
// @LINE {(14, 26) (12, 26)};
// (11.4, 26) @TEXT("q0", size=0.7, halign="end");
// (14, 22) @PIN(terminal="q1", direction="right");
// @LINE {(14, 22) (12, 22)};
// (11.4, 22) @TEXT("q1", size=0.7, halign="end");
// (14, 18) @PIN(terminal="q2", direction="right");
// @LINE {(14, 18) (12, 18)};
// (11.4, 18) @TEXT("q2", size=0.7, halign="end");
// (14, 14) @PIN(terminal="q3", direction="right");
// @LINE {(14, 14) (12, 14)};
// (11.4, 14) @TEXT("q3", size=0.7, halign="end");
// (14, 10) @PIN(terminal="q4", direction="right");
// @LINE {(14, 10) (12, 10)};
// (11.4, 10) @TEXT("q4", size=0.7, halign="end");
// (14, 6) @PIN(terminal="q5", direction="right");
// @LINE {(14, 6) (12, 6)};
// (11.4, 6) @TEXT("q5", size=0.7, halign="end");
// (14, 2) @PIN(terminal="q6", direction="right");
// @LINE {(14, 2) (12, 2)};
// (11.4, 2) @TEXT("q6", size=0.7, halign="end");
// (14, -2) @PIN(terminal="q7", direction="right");
// @LINE {(14, -2) (12, -2)};
// (11.4, -2) @TEXT("q7", size=0.7, halign="end");
// (14, -6) @PIN(terminal="q8", direction="right");
// @LINE {(14, -6) (12, -6)};
// (11.4, -6) @TEXT("q8", size=0.7, halign="end");
// (14, -10) @PIN(terminal="q9", direction="right");
// @LINE {(14, -10) (12, -10)};
// (11.4, -10) @TEXT("q9", size=0.7, halign="end");
// (14, -14) @PIN(terminal="q10", direction="right");
// @LINE {(14, -14) (12, -14)};
// (11.4, -14) @TEXT("q10", size=0.7, halign="end");
// (14, -18) @PIN(terminal="q11", direction="right");
// @LINE {(14, -18) (12, -18)};
// (11.4, -18) @TEXT("q11", size=0.7, halign="end");
// (14, -22) @PIN(terminal="q12", direction="right");
// @LINE {(14, -22) (12, -22)};
// (11.4, -22) @TEXT("q12", size=0.7, halign="end");
// (14, -26) @PIN(terminal="q13", direction="right");
// @LINE {(14, -26) (12, -26)};
// (11.4, -26) @TEXT("q13", size=0.7, halign="end");
// (0, 32) @PIN(terminal="vdd", direction="up");
// @LINE {(0, 32) (0, 30)};
// (0, -32) @PIN(terminal="vss", direction="down");
// @LINE {(0, -32) (0, -30)};
// ? @TEXT("${name}", key="name", size=1, halign="middle") => @PLACE(14, 33.5);
// (0, 29.1) @TEXT("RF counter", size=0.85, halign="middle");
// };
// # @SET-SYMBOL $CELL;
// #XCI @PLACE(0, 40) => @ORIENT("R0");
// #XGE @PLACE(40, 40) => @ORIENT("R0");
// #XG @PLACE(80, 40) => @ORIENT("R0");
// #XF0 @PLACE(0, 0) => @ORIENT("R0");
// #XF1 @PLACE(45, 0) => @ORIENT("R0");
// #XF2 @PLACE(90, 0) => @ORIENT("R0");
// #XF3 @PLACE(135, 0) => @ORIENT("R0");
// #XF4 @PLACE(180, 0) => @ORIENT("R0");
// #XF5 @PLACE(225, 0) => @ORIENT("R0");
// #XF6 @PLACE(270, 0) => @ORIENT("R0");
// #XF7 @PLACE(0, -55) => @ORIENT("R0");
// #XF8 @PLACE(45, -55) => @ORIENT("R0");
// #XF9 @PLACE(90, -55) => @ORIENT("R0");
// #XF10 @PLACE(135, -55) => @ORIENT("R0");
// #XF11 @PLACE(180, -55) => @ORIENT("R0");
// #XF12 @PLACE(225, -55) => @ORIENT("R0");
// #XF13 @PLACE(270, -55) => @ORIENT("R0");
// &qb0 @WIRE(mode="straight") {#XF0:4 (25, -2) (25, 2) #XF1:1};
// &qb1 @WIRE(mode="straight") {#XF1:4 (70, -2) (70, 2) #XF2:1};
// &qb2 @WIRE(mode="straight") {#XF2:4 (115, -2) (115, 2) #XF3:1};
// &qb3 @WIRE(mode="straight") {#XF3:4 (160, -2) (160, 2) #XF4:1};
// &qb4 @WIRE(mode="straight") {#XF4:4 (205, -2) (205, 2) #XF5:1};
// &qb5 @WIRE(mode="straight") {#XF5:4 (250, -2) (250, 2) #XF6:1};
// &qb7 @WIRE(mode="straight") {#XF7:4 (25, -57) (25, -53) #XF8:1};
// &qb8 @WIRE(mode="straight") {#XF8:4 (70, -57) (70, -53) #XF9:1};
// &qb9 @WIRE(mode="straight") {#XF9:4 (115, -57) (115, -53) #XF10:1};
// &qb10 @WIRE(mode="straight") {#XF10:4 (160, -57) (160, -53) #XF11:1};
// &qb11 @WIRE(mode="straight") {#XF11:4 (205, -57) (205, -53) #XF12:1};
// &qb12 @WIRE(mode="straight") {#XF12:4 (250, -57) (250, -53) #XF13:1};
// %t1 = $IO_PORT @ATTACH &clk => @PLACE(-11, 40) => @ORIENT("R0");
// %t1 @TEXT("clk", key="name", size=0.75);
// &clk @WIRE(mode="straight") {#XCI:1 %t1:p};
// %t2 = $IO_PORT @ATTACH &clkb => @PLACE(11, 40) => @ORIENT("MY");
// %t2 @TEXT("clkb", key="name", size=0.75);
// &clkb @WIRE(mode="straight") {#XCI:2 %t2:p};
// %t3 = $SUPPLY @ATTACH &vdd => @PLACE(0, 49);
// &vdd @WIRE(mode="straight") {#XCI:3 %t3:p};
// %t4 = $GROUND @ATTACH &vss => @PLACE(0, 31);
// &vss @WIRE(mode="straight") {#XCI:4 %t4:p};
// %t5 = $IO_PORT @ATTACH &gate => @PLACE(29, 44) => @ORIENT("R0");
// %t5 @TEXT("gate", key="name", size=0.75);
// &gate @WIRE(mode="straight") {#XGE:1 %t5:p};
// %t6 = $IO_PORT @ATTACH &clkb => @PLACE(29, 40) => @ORIENT("R0");
// %t6 @TEXT("clkb", key="name", size=0.75);
// &clkb @WIRE(mode="straight") {#XGE:2 %t6:p};
// %t7 = $IO_PORT @ATTACH &clk => @PLACE(29, 36) => @ORIENT("R0");
// %t7 @TEXT("clk", key="name", size=0.75);
// &clk @WIRE(mode="straight") {#XGE:3 %t7:p};
// %t8 = $IO_PORT @ATTACH &safe_gate => @PLACE(51, 40) => @ORIENT("MY");
// %t8 @TEXT("safe_gate", key="name", size=0.75);
// &safe_gate @WIRE(mode="straight") {#XGE:4 %t8:p};
// %t9 = $SUPPLY @ATTACH &vdd => @PLACE(40, 53);
// &vdd @WIRE(mode="straight") {#XGE:5 %t9:p};
// %t10 = $GROUND @ATTACH &vss => @PLACE(40, 27);
// &vss @WIRE(mode="straight") {#XGE:6 %t10:p};
// %t11 = $IO_PORT @ATTACH &clk => @PLACE(69, 42) => @ORIENT("R0");
// %t11 @TEXT("clk", key="name", size=0.75);
// &clk @WIRE(mode="straight") {#XG:1 %t11:p};
// %t12 = $IO_PORT @ATTACH &safe_gate => @PLACE(69, 38) => @ORIENT("R0");
// %t12 @TEXT("safe_gate", key="name", size=0.75);
// &safe_gate @WIRE(mode="straight") {#XG:2 %t12:p};
// %t13 = $IO_PORT @ATTACH &gclk => @PLACE(91, 40) => @ORIENT("MY");
// %t13 @TEXT("gclk", key="name", size=0.75);
// &gclk @WIRE(mode="straight") {#XG:3 %t13:p};
// %t14 = $SUPPLY @ATTACH &vdd => @PLACE(80, 51);
// &vdd @WIRE(mode="straight") {#XG:4 %t14:p};
// %t15 = $GROUND @ATTACH &vss => @PLACE(80, 29);
// &vss @WIRE(mode="straight") {#XG:5 %t15:p};
// %t16 = $IO_PORT @ATTACH &gclk => @PLACE(-11, 2) => @ORIENT("R0");
// %t16 @TEXT("gclk", key="name", size=0.75);
// &gclk @WIRE(mode="straight") {#XF0:1 %t16:p};
// %t17 = $IO_PORT @ATTACH &reset => @PLACE(-11, -2) => @ORIENT("R0");
// %t17 @TEXT("reset", key="name", size=0.75);
// &reset @WIRE(mode="straight") {#XF0:2 %t17:p};
// %t18 = $IO_PORT @ATTACH &q0 => @PLACE(11, 2) => @ORIENT("MY");
// %t18 @TEXT("q0", key="name", size=0.75);
// &q0 @WIRE(mode="straight") {#XF0:3 %t18:p};
// %t19 = $SUPPLY @ATTACH &vdd => @PLACE(0, 11);
// &vdd @WIRE(mode="straight") {#XF0:5 %t19:p};
// %t20 = $GROUND @ATTACH &vss => @PLACE(0, -11);
// &vss @WIRE(mode="straight") {#XF0:6 %t20:p};
// %t21 = $IO_PORT @ATTACH &reset => @PLACE(34, -2) => @ORIENT("R0");
// %t21 @TEXT("reset", key="name", size=0.75);
// &reset @WIRE(mode="straight") {#XF1:2 %t21:p};
// %t22 = $IO_PORT @ATTACH &q1 => @PLACE(56, 2) => @ORIENT("MY");
// %t22 @TEXT("q1", key="name", size=0.75);
// &q1 @WIRE(mode="straight") {#XF1:3 %t22:p};
// %t23 = $SUPPLY @ATTACH &vdd => @PLACE(45, 11);
// &vdd @WIRE(mode="straight") {#XF1:5 %t23:p};
// %t24 = $GROUND @ATTACH &vss => @PLACE(45, -11);
// &vss @WIRE(mode="straight") {#XF1:6 %t24:p};
// %t25 = $IO_PORT @ATTACH &reset => @PLACE(79, -2) => @ORIENT("R0");
// %t25 @TEXT("reset", key="name", size=0.75);
// &reset @WIRE(mode="straight") {#XF2:2 %t25:p};
// %t26 = $IO_PORT @ATTACH &q2 => @PLACE(101, 2) => @ORIENT("MY");
// %t26 @TEXT("q2", key="name", size=0.75);
// &q2 @WIRE(mode="straight") {#XF2:3 %t26:p};
// %t27 = $SUPPLY @ATTACH &vdd => @PLACE(90, 11);
// &vdd @WIRE(mode="straight") {#XF2:5 %t27:p};
// %t28 = $GROUND @ATTACH &vss => @PLACE(90, -11);
// &vss @WIRE(mode="straight") {#XF2:6 %t28:p};
// %t29 = $IO_PORT @ATTACH &reset => @PLACE(124, -2) => @ORIENT("R0");
// %t29 @TEXT("reset", key="name", size=0.75);
// &reset @WIRE(mode="straight") {#XF3:2 %t29:p};
// %t30 = $IO_PORT @ATTACH &q3 => @PLACE(146, 2) => @ORIENT("MY");
// %t30 @TEXT("q3", key="name", size=0.75);
// &q3 @WIRE(mode="straight") {#XF3:3 %t30:p};
// %t31 = $SUPPLY @ATTACH &vdd => @PLACE(135, 11);
// &vdd @WIRE(mode="straight") {#XF3:5 %t31:p};
// %t32 = $GROUND @ATTACH &vss => @PLACE(135, -11);
// &vss @WIRE(mode="straight") {#XF3:6 %t32:p};
// %t33 = $IO_PORT @ATTACH &reset => @PLACE(169, -2) => @ORIENT("R0");
// %t33 @TEXT("reset", key="name", size=0.75);
// &reset @WIRE(mode="straight") {#XF4:2 %t33:p};
// %t34 = $IO_PORT @ATTACH &q4 => @PLACE(191, 2) => @ORIENT("MY");
// %t34 @TEXT("q4", key="name", size=0.75);
// &q4 @WIRE(mode="straight") {#XF4:3 %t34:p};
// %t35 = $SUPPLY @ATTACH &vdd => @PLACE(180, 11);
// &vdd @WIRE(mode="straight") {#XF4:5 %t35:p};
// %t36 = $GROUND @ATTACH &vss => @PLACE(180, -11);
// &vss @WIRE(mode="straight") {#XF4:6 %t36:p};
// %t37 = $IO_PORT @ATTACH &reset => @PLACE(214, -2) => @ORIENT("R0");
// %t37 @TEXT("reset", key="name", size=0.75);
// &reset @WIRE(mode="straight") {#XF5:2 %t37:p};
// %t38 = $IO_PORT @ATTACH &q5 => @PLACE(236, 2) => @ORIENT("MY");
// %t38 @TEXT("q5", key="name", size=0.75);
// &q5 @WIRE(mode="straight") {#XF5:3 %t38:p};
// %t39 = $SUPPLY @ATTACH &vdd => @PLACE(225, 11);
// &vdd @WIRE(mode="straight") {#XF5:5 %t39:p};
// %t40 = $GROUND @ATTACH &vss => @PLACE(225, -11);
// &vss @WIRE(mode="straight") {#XF5:6 %t40:p};
// %t41 = $IO_PORT @ATTACH &reset => @PLACE(259, -2) => @ORIENT("R0");
// %t41 @TEXT("reset", key="name", size=0.75);
// &reset @WIRE(mode="straight") {#XF6:2 %t41:p};
// %t42 = $IO_PORT @ATTACH &q6 => @PLACE(281, 2) => @ORIENT("MY");
// %t42 @TEXT("q6", key="name", size=0.75);
// &q6 @WIRE(mode="straight") {#XF6:3 %t42:p};
// %t43 = $IO_PORT @ATTACH &qb6 => @PLACE(281, -2) => @ORIENT("MY");
// %t43 @TEXT("qb6", key="name", size=0.75);
// &qb6 @WIRE(mode="straight") {#XF6:4 %t43:p};
// %t44 = $SUPPLY @ATTACH &vdd => @PLACE(270, 11);
// &vdd @WIRE(mode="straight") {#XF6:5 %t44:p};
// %t45 = $GROUND @ATTACH &vss => @PLACE(270, -11);
// &vss @WIRE(mode="straight") {#XF6:6 %t45:p};
// %t46 = $IO_PORT @ATTACH &qb6 => @PLACE(-11, -53) => @ORIENT("R0");
// %t46 @TEXT("qb6", key="name", size=0.75);
// &qb6 @WIRE(mode="straight") {#XF7:1 %t46:p};
// %t47 = $IO_PORT @ATTACH &reset => @PLACE(-11, -57) => @ORIENT("R0");
// %t47 @TEXT("reset", key="name", size=0.75);
// &reset @WIRE(mode="straight") {#XF7:2 %t47:p};
// %t48 = $IO_PORT @ATTACH &q7 => @PLACE(11, -53) => @ORIENT("MY");
// %t48 @TEXT("q7", key="name", size=0.75);
// &q7 @WIRE(mode="straight") {#XF7:3 %t48:p};
// %t49 = $SUPPLY @ATTACH &vdd => @PLACE(0, -44);
// &vdd @WIRE(mode="straight") {#XF7:5 %t49:p};
// %t50 = $GROUND @ATTACH &vss => @PLACE(0, -66);
// &vss @WIRE(mode="straight") {#XF7:6 %t50:p};
// %t51 = $IO_PORT @ATTACH &reset => @PLACE(34, -57) => @ORIENT("R0");
// %t51 @TEXT("reset", key="name", size=0.75);
// &reset @WIRE(mode="straight") {#XF8:2 %t51:p};
// %t52 = $IO_PORT @ATTACH &q8 => @PLACE(56, -53) => @ORIENT("MY");
// %t52 @TEXT("q8", key="name", size=0.75);
// &q8 @WIRE(mode="straight") {#XF8:3 %t52:p};
// %t53 = $SUPPLY @ATTACH &vdd => @PLACE(45, -44);
// &vdd @WIRE(mode="straight") {#XF8:5 %t53:p};
// %t54 = $GROUND @ATTACH &vss => @PLACE(45, -66);
// &vss @WIRE(mode="straight") {#XF8:6 %t54:p};
// %t55 = $IO_PORT @ATTACH &reset => @PLACE(79, -57) => @ORIENT("R0");
// %t55 @TEXT("reset", key="name", size=0.75);
// &reset @WIRE(mode="straight") {#XF9:2 %t55:p};
// %t56 = $IO_PORT @ATTACH &q9 => @PLACE(101, -53) => @ORIENT("MY");
// %t56 @TEXT("q9", key="name", size=0.75);
// &q9 @WIRE(mode="straight") {#XF9:3 %t56:p};
// %t57 = $SUPPLY @ATTACH &vdd => @PLACE(90, -44);
// &vdd @WIRE(mode="straight") {#XF9:5 %t57:p};
// %t58 = $GROUND @ATTACH &vss => @PLACE(90, -66);
// &vss @WIRE(mode="straight") {#XF9:6 %t58:p};
// %t59 = $IO_PORT @ATTACH &reset => @PLACE(124, -57) => @ORIENT("R0");
// %t59 @TEXT("reset", key="name", size=0.75);
// &reset @WIRE(mode="straight") {#XF10:2 %t59:p};
// %t60 = $IO_PORT @ATTACH &q10 => @PLACE(146, -53) => @ORIENT("MY");
// %t60 @TEXT("q10", key="name", size=0.75);
// &q10 @WIRE(mode="straight") {#XF10:3 %t60:p};
// %t61 = $SUPPLY @ATTACH &vdd => @PLACE(135, -44);
// &vdd @WIRE(mode="straight") {#XF10:5 %t61:p};
// %t62 = $GROUND @ATTACH &vss => @PLACE(135, -66);
// &vss @WIRE(mode="straight") {#XF10:6 %t62:p};
// %t63 = $IO_PORT @ATTACH &reset => @PLACE(169, -57) => @ORIENT("R0");
// %t63 @TEXT("reset", key="name", size=0.75);
// &reset @WIRE(mode="straight") {#XF11:2 %t63:p};
// %t64 = $IO_PORT @ATTACH &q11 => @PLACE(191, -53) => @ORIENT("MY");
// %t64 @TEXT("q11", key="name", size=0.75);
// &q11 @WIRE(mode="straight") {#XF11:3 %t64:p};
// %t65 = $SUPPLY @ATTACH &vdd => @PLACE(180, -44);
// &vdd @WIRE(mode="straight") {#XF11:5 %t65:p};
// %t66 = $GROUND @ATTACH &vss => @PLACE(180, -66);
// &vss @WIRE(mode="straight") {#XF11:6 %t66:p};
// %t67 = $IO_PORT @ATTACH &reset => @PLACE(214, -57) => @ORIENT("R0");
// %t67 @TEXT("reset", key="name", size=0.75);
// &reset @WIRE(mode="straight") {#XF12:2 %t67:p};
// %t68 = $IO_PORT @ATTACH &q12 => @PLACE(236, -53) => @ORIENT("MY");
// %t68 @TEXT("q12", key="name", size=0.75);
// &q12 @WIRE(mode="straight") {#XF12:3 %t68:p};
// %t69 = $SUPPLY @ATTACH &vdd => @PLACE(225, -44);
// &vdd @WIRE(mode="straight") {#XF12:5 %t69:p};
// %t70 = $GROUND @ATTACH &vss => @PLACE(225, -66);
// &vss @WIRE(mode="straight") {#XF12:6 %t70:p};
// %t71 = $IO_PORT @ATTACH &reset => @PLACE(259, -57) => @ORIENT("R0");
// %t71 @TEXT("reset", key="name", size=0.75);
// &reset @WIRE(mode="straight") {#XF13:2 %t71:p};
// %t72 = $IO_PORT @ATTACH &q13 => @PLACE(281, -53) => @ORIENT("MY");
// %t72 @TEXT("q13", key="name", size=0.75);
// &q13 @WIRE(mode="straight") {#XF13:3 %t72:p};
// %t73 = $IO_PORT @ATTACH &qb13 => @PLACE(281, -57) => @ORIENT("MY");
// %t73 @TEXT("qb13", key="name", size=0.75);
// &qb13 @WIRE(mode="straight") {#XF13:4 %t73:p};
// %t74 = $SUPPLY @ATTACH &vdd => @PLACE(270, -44);
// &vdd @WIRE(mode="straight") {#XF13:5 %t74:p};
// %t75 = $GROUND @ATTACH &vss => @PLACE(270, -66);
// &vss @WIRE(mode="straight") {#XF13:6 %t75:p};
// (-16, 72) @TEXT("71  RF counter | 17 instances", size=1.2, halign="start");
// }
ends tx_fll_counter_pdk110_71
