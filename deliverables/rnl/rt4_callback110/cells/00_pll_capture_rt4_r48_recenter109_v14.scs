// PLL / RT4 | frozen callback110 / recenter109 | RNL 0.3
// @RNL(type="header") { @VERSION("0.3"); @USE-PACKAGE(name="rnl-std-fill") {} }
simulator lang=spectre
subckt pll_capture_rt4_r48_recenter109_v14_pdk110_0 (ref reset apply k0 k1 k2 k3 k4 k5 out qualified range_error cfg_ready frequency_good phase_good amp_good vdd vss)
VVCO (vco_vdd vdd) vsource dc=0
VRX (rx_vdd vdd) vsource dc=0
VRT (rt_vdd vdd) vsource dc=0
XV (vp vn ctrl b0 b1 b2 b3 b4 b5 b6 b7 vco_vdd vss) lc_vco_physical_v14_pdk110_1
XBM (vdd vss vmid) tx_bias_mid_v5_pdk110_5
CCP (vp sp) capacitor c=1.2e-13
CCN (vn sn) capacitor c=1.2e-13
RBP (sp vmid) resistor r=10000
RBN (sn vmid) resistor r=10000
XREF (ref refb vdd vss) tx_reference_buffer_pdk110_6
CR (refb vss) capacitor c=6.000000000000001e-14
XS (refb sp sn hp hn vdd vss) tx_sampler_pdk110_11
XCP (hp hn pulse en ctrl vdd vss) cp_physical_v14_pdk110_14
XLF (ctrl vc1 en preset vdd vss) tx_loop_filter_v5_pdk110_17
XRX (vp clk rx_vdd vss) rf_light24s12_v14_pdk110_19
XD (clk divider_reset s0 s1 s2 s3 s4 s5 q1 data acqclk vdd vss) bank_pulsetrip_v14_pdk110_21
XR (data clk out rt_vdd vss) rt_noise_scale4_v14_pdk110_49
XDET (vp hp hn amp_good phase_good vdd vss) validity_physical_v14_pdk110_53
XC (refb reset apply k0 k1 k2 k3 k4 k5 out acqclk phase_good frequency_good b0 b1 b2 b3 b4 b5 b6 b7 s0 s1 s2 s3 s4 s5 divider_reset en pulse preset qualified range_error cfg_ready cfg_invalid restart count_gate count_reset vdd vss) pll_control_recenter109_v14_pdk110_56
// @RNL(author="manual-schematic126") {
// $CELL = @DEFINE-SYMBOL {
// @LINE {(-12, 20) (12, 20) (12, -20) (-12, -20) (-12, 20)};
// (-14, 16) @PIN(terminal="ref", direction="left");
// @LINE {(-14, 16) (-12, 16)};
// (-11.4, 16) @TEXT("ref", size=0.7, halign="start");
// (-14, 12) @PIN(terminal="reset", direction="left");
// @LINE {(-14, 12) (-12, 12)};
// (-11.4, 12) @TEXT("reset", size=0.7, halign="start");
// (-14, 8) @PIN(terminal="apply", direction="left");
// @LINE {(-14, 8) (-12, 8)};
// (-11.4, 8) @TEXT("apply", size=0.7, halign="start");
// (-14, 4) @PIN(terminal="k0", direction="left");
// @LINE {(-14, 4) (-12, 4)};
// (-11.4, 4) @TEXT("k0", size=0.7, halign="start");
// (-14, 0) @PIN(terminal="k1", direction="left");
// @LINE {(-14, 0) (-12, 0)};
// (-11.4, 0) @TEXT("k1", size=0.7, halign="start");
// (-14, -4) @PIN(terminal="k2", direction="left");
// @LINE {(-14, -4) (-12, -4)};
// (-11.4, -4) @TEXT("k2", size=0.7, halign="start");
// (-14, -8) @PIN(terminal="k3", direction="left");
// @LINE {(-14, -8) (-12, -8)};
// (-11.4, -8) @TEXT("k3", size=0.7, halign="start");
// (-14, -12) @PIN(terminal="k4", direction="left");
// @LINE {(-14, -12) (-12, -12)};
// (-11.4, -12) @TEXT("k4", size=0.7, halign="start");
// (-14, -16) @PIN(terminal="k5", direction="left");
// @LINE {(-14, -16) (-12, -16)};
// (-11.4, -16) @TEXT("k5", size=0.7, halign="start");
// (14, 12) @PIN(terminal="out", direction="right");
// @LINE {(14, 12) (12, 12)};
// (11.4, 12) @TEXT("out", size=0.7, halign="end");
// (14, 8) @PIN(terminal="qualified", direction="right");
// @LINE {(14, 8) (12, 8)};
// (11.4, 8) @TEXT("qualified", size=0.7, halign="end");
// (14, 4) @PIN(terminal="range_error", direction="right");
// @LINE {(14, 4) (12, 4)};
// (11.4, 4) @TEXT("range_error", size=0.7, halign="end");
// (14, 0) @PIN(terminal="cfg_ready", direction="right");
// @LINE {(14, 0) (12, 0)};
// (11.4, 0) @TEXT("cfg_ready", size=0.7, halign="end");
// (14, -4) @PIN(terminal="frequency_good", direction="right");
// @LINE {(14, -4) (12, -4)};
// (11.4, -4) @TEXT("frequency_good", size=0.7, halign="end");
// (14, -8) @PIN(terminal="phase_good", direction="right");
// @LINE {(14, -8) (12, -8)};
// (11.4, -8) @TEXT("phase_good", size=0.7, halign="end");
// (14, -12) @PIN(terminal="amp_good", direction="right");
// @LINE {(14, -12) (12, -12)};
// (11.4, -12) @TEXT("amp_good", size=0.7, halign="end");
// (0, 22) @PIN(terminal="vdd", direction="up");
// @LINE {(0, 22) (0, 20)};
// (0, -22) @PIN(terminal="vss", direction="down");
// @LINE {(0, -22) (0, -20)};
// ? @TEXT("${name}", key="name", size=1, halign="middle") => @PLACE(14, 23.5);
// (0, 19.1) @TEXT("PLL / RT4", size=0.85, halign="middle");
// };
// # @SET-SYMBOL $CELL;
// #XREF @PLACE(0, 50) => @ORIENT("R0");
// #CR @PLACE(28, 42) => @ORIENT("R0");
// #CR @SET-SYMBOL $CAPACITOR;
// #CR @TEXT("60f", key="value", dx=3, dy=-1, size=0.8, halign="start");
// #CR @TEXT("CR", key="name", dx=3, dy=1, size=0.9, halign="start");
// #XS @PLACE(85, 50) => @ORIENT("R0");
// #XCP @PLACE(150, 50) => @ORIENT("R0");
// #XLF @PLACE(210, 50) => @ORIENT("R0");
// #XV @PLACE(280, 50) => @ORIENT("R0");
// #XRX @PLACE(350, 50) => @ORIENT("R0");
// #XD @PLACE(420, 50) => @ORIENT("R0");
// #XR @PLACE(490, 50) => @ORIENT("R0");
// #XC @PLACE(200, -90) => @ORIENT("R0");
// #XDET @PLACE(305, -75) => @ORIENT("R0");
// #XBM @PLACE(0, -30) => @ORIENT("R0");
// #CCP @PLACE(70, 0) => @ORIENT("R90");
// #CCP @SET-SYMBOL $CAPACITOR;
// #CCP @TEXT("120f", key="value", dx=3, dy=-1, size=0.8, halign="start");
// #CCP @TEXT("CCP", key="name", dx=3, dy=1, size=0.9, halign="start");
// #CCN @PLACE(115, -10) => @ORIENT("R90");
// #CCN @SET-SYMBOL $CAPACITOR;
// #CCN @TEXT("120f", key="value", dx=3, dy=-1, size=0.8, halign="start");
// #CCN @TEXT("CCN", key="name", dx=3, dy=1, size=0.9, halign="start");
// #RBP @PLACE(70, -22) => @ORIENT("R0");
// #RBP @SET-SYMBOL $RESISTOR;
// #RBP @TEXT("10k", key="value", dx=3, dy=-1, size=0.8, halign="start");
// #RBP @TEXT("RBP", key="name", dx=3, dy=1, size=0.9, halign="start");
// #RBN @PLACE(115, -38) => @ORIENT("R0");
// #RBN @SET-SYMBOL $RESISTOR;
// #RBN @TEXT("10k", key="value", dx=3, dy=-1, size=0.8, halign="start");
// #RBN @TEXT("RBN", key="name", dx=3, dy=1, size=0.9, halign="start");
// #VVCO @PLACE(350, -50) => @ORIENT("R0");
// #VVCO @SET-SYMBOL $VOLTAGE_SOURCE;
// #VVCO @TEXT("0", key="value", dx=3, dy=-1, size=0.8, halign="start");
// #VVCO @TEXT("VVCO", key="name", dx=3, dy=1, size=0.9, halign="start");
// #VRX @PLACE(395, -50) => @ORIENT("R0");
// #VRX @SET-SYMBOL $VOLTAGE_SOURCE;
// #VRX @TEXT("0", key="value", dx=3, dy=-1, size=0.8, halign="start");
// #VRX @TEXT("VRX", key="name", dx=3, dy=1, size=0.9, halign="start");
// #VRT @PLACE(440, -50) => @ORIENT("R0");
// #VRT @SET-SYMBOL $VOLTAGE_SOURCE;
// #VRT @TEXT("0", key="value", dx=3, dy=-1, size=0.8, halign="start");
// #VRT @TEXT("VRT", key="name", dx=3, dy=1, size=0.9, halign="start");
// &refb @WIRE(mode="straight") {#XREF:2 (42, 50) (42, 54) #XS:1};
// &refb @WIRE(mode="straight") {#XREF:2 (28, 50) #CR:1};
// &hp @WIRE(mode="straight") {#XS:4 (112, 52) (112, 56) #XCP:1};
// &hn @WIRE(mode="straight") {#XS:5 (118, 48) (118, 52) #XCP:2};
// %ctrl = (235, 90);
// &ctrl @WIRE(mode="straight") {#XCP:5 (175, 50) (175, 90) %ctrl (250, 90) (250, 66) #XV:3};
// &ctrl @WIRE(mode="straight") {%ctrl (235, 52) #XLF:1};
// $JUNCTION @ATTACH %ctrl;
// &vp @WIRE(mode="straight") {#XV:1 (320, 52) (320, 50) #XRX:1};
// &clk @WIRE(mode="straight") {#XRX:2 (380, 50) (380, 64) #XD:1};
// &data @WIRE(mode="straight") {#XD:10 (458, 50) (458, 52) #XR:1};
// &clk @WIRE(mode="straight") {#XRX:2 (370, 50) (370, 100) (470, 100) (470, 48) #XR:2};
// &sp @WIRE(mode="straight") {#CCP:2 (62, 0) (62, 50) #XS:2};
// &sn @WIRE(mode="straight") {#CCN:2 (65, -10) (65, 46) #XS:3};
// &sp @WIRE(mode="straight") {#RBP:1 (70, -8) (62, -8) (62, 0) #CCP:2};
// &sn @WIRE(mode="straight") {#RBN:1 (115, -25) (65, -25) (65, -10) #CCN:2};
// (0, 125) @TEXT("Signal path: reference -> sampler -> CP / filter -> VCO -> divider -> RT4", size=1.1, halign="start");
// (0, 119) @TEXT("b[7:0], s[5:0], enables and status use named local tags below.", size=0.9, halign="start");
// (170, -15) @TEXT("Control / capture / supervision", size=1.1, halign="start");
// (0, 5) @TEXT("AC coupling and midrail bias", size=1, halign="start");
// (345, -20) @TEXT("0 V supply-current sensing sources", size=1, halign="start");
// %t1 = $IO_PORT @ATTACH &ref => @PLACE(-11, 50) => @ORIENT("R0");
// %t1 @TEXT("ref", key="name", size=0.75);
// &ref @WIRE(mode="straight") {#XREF:1 %t1:p};
// %t2 = $SUPPLY @ATTACH &vdd => @PLACE(0, 59);
// &vdd @WIRE(mode="straight") {#XREF:3 %t2:p};
// %t3 = $GROUND @ATTACH &vss => @PLACE(0, 41);
// &vss @WIRE(mode="straight") {#XREF:4 %t3:p};
// %t4 = $GROUND @ATTACH &vss => @PLACE(28, 37);
// &vss @WIRE(mode="straight") {#CR:2 %t4:p};
// %t5 = $SUPPLY @ATTACH &vdd => @PLACE(85, 63);
// &vdd @WIRE(mode="straight") {#XS:6 %t5:p};
// %t6 = $GROUND @ATTACH &vss => @PLACE(85, 37);
// &vss @WIRE(mode="straight") {#XS:7 %t6:p};
// %t7 = $IO_PORT @ATTACH &pulse => @PLACE(139, 48) => @ORIENT("R0");
// %t7 @TEXT("pulse", key="name", size=0.75);
// &pulse @WIRE(mode="straight") {#XCP:3 %t7:p};
// %t8 = $IO_PORT @ATTACH &en => @PLACE(139, 44) => @ORIENT("R0");
// %t8 @TEXT("en", key="name", size=0.75);
// &en @WIRE(mode="straight") {#XCP:4 %t8:p};
// %t9 = $SUPPLY @ATTACH &vdd => @PLACE(150, 65);
// &vdd @WIRE(mode="straight") {#XCP:6 %t9:p};
// %t10 = $GROUND @ATTACH &vss => @PLACE(150, 35);
// &vss @WIRE(mode="straight") {#XCP:7 %t10:p};
// %t11 = $IO_PORT @ATTACH &vc1 => @PLACE(221, 48) => @ORIENT("MY");
// %t11 @TEXT("vc1", key="name", size=0.75);
// &vc1 @WIRE(mode="straight") {#XLF:2 %t11:p};
// %t12 = $IO_PORT @ATTACH &en => @PLACE(199, 52) => @ORIENT("R0");
// %t12 @TEXT("en", key="name", size=0.75);
// &en @WIRE(mode="straight") {#XLF:3 %t12:p};
// %t13 = $IO_PORT @ATTACH &preset => @PLACE(199, 48) => @ORIENT("R0");
// %t13 @TEXT("preset", key="name", size=0.75);
// &preset @WIRE(mode="straight") {#XLF:4 %t13:p};
// %t14 = $SUPPLY @ATTACH &vdd => @PLACE(210, 61);
// &vdd @WIRE(mode="straight") {#XLF:5 %t14:p};
// %t15 = $GROUND @ATTACH &vss => @PLACE(210, 39);
// &vss @WIRE(mode="straight") {#XLF:6 %t15:p};
// %t16 = $IO_PORT @ATTACH &vn => @PLACE(297, 48) => @ORIENT("MY");
// %t16 @TEXT("vn", key="name", size=0.75);
// &vn @WIRE(mode="straight") {#XV:2 %t16:p};
// %t17 = $IO_PORT @ATTACH &b0 => @PLACE(263, 62) => @ORIENT("R0");
// %t17 @TEXT("b0", key="name", size=0.75);
// &b0 @WIRE(mode="straight") {#XV:4 %t17:p};
// %t18 = $IO_PORT @ATTACH &b1 => @PLACE(263, 58) => @ORIENT("R0");
// %t18 @TEXT("b1", key="name", size=0.75);
// &b1 @WIRE(mode="straight") {#XV:5 %t18:p};
// %t19 = $IO_PORT @ATTACH &b2 => @PLACE(263, 54) => @ORIENT("R0");
// %t19 @TEXT("b2", key="name", size=0.75);
// &b2 @WIRE(mode="straight") {#XV:6 %t19:p};
// %t20 = $IO_PORT @ATTACH &b3 => @PLACE(263, 50) => @ORIENT("R0");
// %t20 @TEXT("b3", key="name", size=0.75);
// &b3 @WIRE(mode="straight") {#XV:7 %t20:p};
// %t21 = $IO_PORT @ATTACH &b4 => @PLACE(263, 46) => @ORIENT("R0");
// %t21 @TEXT("b4", key="name", size=0.75);
// &b4 @WIRE(mode="straight") {#XV:8 %t21:p};
// %t22 = $IO_PORT @ATTACH &b5 => @PLACE(263, 42) => @ORIENT("R0");
// %t22 @TEXT("b5", key="name", size=0.75);
// &b5 @WIRE(mode="straight") {#XV:9 %t22:p};
// %t23 = $IO_PORT @ATTACH &b6 => @PLACE(263, 38) => @ORIENT("R0");
// %t23 @TEXT("b6", key="name", size=0.75);
// &b6 @WIRE(mode="straight") {#XV:10 %t23:p};
// %t24 = $IO_PORT @ATTACH &b7 => @PLACE(263, 34) => @ORIENT("R0");
// %t24 @TEXT("b7", key="name", size=0.75);
// &b7 @WIRE(mode="straight") {#XV:11 %t24:p};
// %t25 = $IO_PORT @ATTACH &vco_vdd => @PLACE(276, 75) => @ORIENT("R0");
// %t25 @TEXT("vco_vdd", key="name", size=0.75);
// &vco_vdd @WIRE(mode="straight") {#XV:12 (280, 75) %t25:p};
// %t26 = $GROUND @ATTACH &vss => @PLACE(280, 25);
// &vss @WIRE(mode="straight") {#XV:13 %t26:p};
// %t27 = $IO_PORT @ATTACH &rx_vdd => @PLACE(346, 59) => @ORIENT("R0");
// %t27 @TEXT("rx_vdd", key="name", size=0.75);
// &rx_vdd @WIRE(mode="straight") {#XRX:3 (350, 59) %t27:p};
// %t28 = $GROUND @ATTACH &vss => @PLACE(350, 41);
// &vss @WIRE(mode="straight") {#XRX:4 %t28:p};
// %t29 = $IO_PORT @ATTACH &divider_reset => @PLACE(403, 60) => @ORIENT("R0");
// %t29 @TEXT("divider_reset", key="name", size=0.75);
// &divider_reset @WIRE(mode="straight") {#XD:2 %t29:p};
// %t30 = $IO_PORT @ATTACH &s0 => @PLACE(403, 56) => @ORIENT("R0");
// %t30 @TEXT("s0", key="name", size=0.75);
// &s0 @WIRE(mode="straight") {#XD:3 %t30:p};
// %t31 = $IO_PORT @ATTACH &s1 => @PLACE(403, 52) => @ORIENT("R0");
// %t31 @TEXT("s1", key="name", size=0.75);
// &s1 @WIRE(mode="straight") {#XD:4 %t31:p};
// %t32 = $IO_PORT @ATTACH &s2 => @PLACE(403, 48) => @ORIENT("R0");
// %t32 @TEXT("s2", key="name", size=0.75);
// &s2 @WIRE(mode="straight") {#XD:5 %t32:p};
// %t33 = $IO_PORT @ATTACH &s3 => @PLACE(403, 44) => @ORIENT("R0");
// %t33 @TEXT("s3", key="name", size=0.75);
// &s3 @WIRE(mode="straight") {#XD:6 %t33:p};
// %t34 = $IO_PORT @ATTACH &s4 => @PLACE(403, 40) => @ORIENT("R0");
// %t34 @TEXT("s4", key="name", size=0.75);
// &s4 @WIRE(mode="straight") {#XD:7 %t34:p};
// %t35 = $IO_PORT @ATTACH &s5 => @PLACE(403, 36) => @ORIENT("R0");
// %t35 @TEXT("s5", key="name", size=0.75);
// &s5 @WIRE(mode="straight") {#XD:8 %t35:p};
// %t36 = $IO_PORT @ATTACH &q1 => @PLACE(437, 54) => @ORIENT("MY");
// %t36 @TEXT("q1", key="name", size=0.75);
// &q1 @WIRE(mode="straight") {#XD:9 %t36:p};
// %t37 = $IO_PORT @ATTACH &acqclk => @PLACE(437, 46) => @ORIENT("MY");
// %t37 @TEXT("acqclk", key="name", size=0.75);
// &acqclk @WIRE(mode="straight") {#XD:11 %t37:p};
// %t38 = $SUPPLY @ATTACH &vdd => @PLACE(420, 73);
// &vdd @WIRE(mode="straight") {#XD:12 %t38:p};
// %t39 = $GROUND @ATTACH &vss => @PLACE(420, 27);
// &vss @WIRE(mode="straight") {#XD:13 %t39:p};
// %t40 = $IO_PORT @ATTACH &out => @PLACE(501, 50) => @ORIENT("MY");
// %t40 @TEXT("out", key="name", size=0.75);
// &out @WIRE(mode="straight") {#XR:3 %t40:p};
// %t41 = $IO_PORT @ATTACH &rt_vdd => @PLACE(486, 61) => @ORIENT("R0");
// %t41 @TEXT("rt_vdd", key="name", size=0.75);
// &rt_vdd @WIRE(mode="straight") {#XR:4 (490, 61) %t41:p};
// %t42 = $GROUND @ATTACH &vss => @PLACE(490, 39);
// &vss @WIRE(mode="straight") {#XR:5 %t42:p};
// %t43 = $IO_PORT @ATTACH &refb => @PLACE(177, -68) => @ORIENT("R0");
// %t43 @TEXT("refb", key="name", size=0.75);
// &refb @WIRE(mode="straight") {#XC:1 %t43:p};
// %t44 = $IO_PORT @ATTACH &reset => @PLACE(177, -72) => @ORIENT("R0");
// %t44 @TEXT("reset", key="name", size=0.75);
// &reset @WIRE(mode="straight") {#XC:2 %t44:p};
// %t45 = $IO_PORT @ATTACH &apply => @PLACE(177, -76) => @ORIENT("R0");
// %t45 @TEXT("apply", key="name", size=0.75);
// &apply @WIRE(mode="straight") {#XC:3 %t45:p};
// %t46 = $IO_PORT @ATTACH &k0 => @PLACE(177, -80) => @ORIENT("R0");
// %t46 @TEXT("k0", key="name", size=0.75);
// &k0 @WIRE(mode="straight") {#XC:4 %t46:p};
// %t47 = $IO_PORT @ATTACH &k1 => @PLACE(177, -84) => @ORIENT("R0");
// %t47 @TEXT("k1", key="name", size=0.75);
// &k1 @WIRE(mode="straight") {#XC:5 %t47:p};
// %t48 = $IO_PORT @ATTACH &k2 => @PLACE(177, -88) => @ORIENT("R0");
// %t48 @TEXT("k2", key="name", size=0.75);
// &k2 @WIRE(mode="straight") {#XC:6 %t48:p};
// %t49 = $IO_PORT @ATTACH &k3 => @PLACE(177, -92) => @ORIENT("R0");
// %t49 @TEXT("k3", key="name", size=0.75);
// &k3 @WIRE(mode="straight") {#XC:7 %t49:p};
// %t50 = $IO_PORT @ATTACH &k4 => @PLACE(177, -96) => @ORIENT("R0");
// %t50 @TEXT("k4", key="name", size=0.75);
// &k4 @WIRE(mode="straight") {#XC:8 %t50:p};
// %t51 = $IO_PORT @ATTACH &k5 => @PLACE(177, -100) => @ORIENT("R0");
// %t51 @TEXT("k5", key="name", size=0.75);
// &k5 @WIRE(mode="straight") {#XC:9 %t51:p};
// %t52 = $IO_PORT @ATTACH &out => @PLACE(177, -104) => @ORIENT("R0");
// %t52 @TEXT("out", key="name", size=0.75);
// &out @WIRE(mode="straight") {#XC:10 %t52:p};
// %t53 = $IO_PORT @ATTACH &acqclk => @PLACE(177, -108) => @ORIENT("R0");
// %t53 @TEXT("acqclk", key="name", size=0.75);
// &acqclk @WIRE(mode="straight") {#XC:11 %t53:p};
// %t54 = $IO_PORT @ATTACH &phase_good => @PLACE(177, -112) => @ORIENT("R0");
// %t54 @TEXT("phase_good", key="name", size=0.75);
// &phase_good @WIRE(mode="straight") {#XC:12 %t54:p};
// %t55 = $IO_PORT @ATTACH &frequency_good => @PLACE(223, -40) => @ORIENT("MY");
// %t55 @TEXT("frequency_good", key="name", size=0.75);
// &frequency_good @WIRE(mode="straight") {#XC:13 %t55:p};
// %t56 = $IO_PORT @ATTACH &b0 => @PLACE(223, -44) => @ORIENT("MY");
// %t56 @TEXT("b0", key="name", size=0.75);
// &b0 @WIRE(mode="straight") {#XC:14 %t56:p};
// %t57 = $IO_PORT @ATTACH &b1 => @PLACE(223, -48) => @ORIENT("MY");
// %t57 @TEXT("b1", key="name", size=0.75);
// &b1 @WIRE(mode="straight") {#XC:15 %t57:p};
// %t58 = $IO_PORT @ATTACH &b2 => @PLACE(223, -52) => @ORIENT("MY");
// %t58 @TEXT("b2", key="name", size=0.75);
// &b2 @WIRE(mode="straight") {#XC:16 %t58:p};
// %t59 = $IO_PORT @ATTACH &b3 => @PLACE(223, -56) => @ORIENT("MY");
// %t59 @TEXT("b3", key="name", size=0.75);
// &b3 @WIRE(mode="straight") {#XC:17 %t59:p};
// %t60 = $IO_PORT @ATTACH &b4 => @PLACE(223, -60) => @ORIENT("MY");
// %t60 @TEXT("b4", key="name", size=0.75);
// &b4 @WIRE(mode="straight") {#XC:18 %t60:p};
// %t61 = $IO_PORT @ATTACH &b5 => @PLACE(223, -64) => @ORIENT("MY");
// %t61 @TEXT("b5", key="name", size=0.75);
// &b5 @WIRE(mode="straight") {#XC:19 %t61:p};
// %t62 = $IO_PORT @ATTACH &b6 => @PLACE(223, -68) => @ORIENT("MY");
// %t62 @TEXT("b6", key="name", size=0.75);
// &b6 @WIRE(mode="straight") {#XC:20 %t62:p};
// %t63 = $IO_PORT @ATTACH &b7 => @PLACE(223, -72) => @ORIENT("MY");
// %t63 @TEXT("b7", key="name", size=0.75);
// &b7 @WIRE(mode="straight") {#XC:21 %t63:p};
// %t64 = $IO_PORT @ATTACH &s0 => @PLACE(223, -76) => @ORIENT("MY");
// %t64 @TEXT("s0", key="name", size=0.75);
// &s0 @WIRE(mode="straight") {#XC:22 %t64:p};
// %t65 = $IO_PORT @ATTACH &s1 => @PLACE(223, -80) => @ORIENT("MY");
// %t65 @TEXT("s1", key="name", size=0.75);
// &s1 @WIRE(mode="straight") {#XC:23 %t65:p};
// %t66 = $IO_PORT @ATTACH &s2 => @PLACE(223, -84) => @ORIENT("MY");
// %t66 @TEXT("s2", key="name", size=0.75);
// &s2 @WIRE(mode="straight") {#XC:24 %t66:p};
// %t67 = $IO_PORT @ATTACH &s3 => @PLACE(223, -88) => @ORIENT("MY");
// %t67 @TEXT("s3", key="name", size=0.75);
// &s3 @WIRE(mode="straight") {#XC:25 %t67:p};
// %t68 = $IO_PORT @ATTACH &s4 => @PLACE(223, -92) => @ORIENT("MY");
// %t68 @TEXT("s4", key="name", size=0.75);
// &s4 @WIRE(mode="straight") {#XC:26 %t68:p};
// %t69 = $IO_PORT @ATTACH &s5 => @PLACE(223, -96) => @ORIENT("MY");
// %t69 @TEXT("s5", key="name", size=0.75);
// &s5 @WIRE(mode="straight") {#XC:27 %t69:p};
// %t70 = $IO_PORT @ATTACH &divider_reset => @PLACE(223, -100) => @ORIENT("MY");
// %t70 @TEXT("divider_reset", key="name", size=0.75);
// &divider_reset @WIRE(mode="straight") {#XC:28 %t70:p};
// %t71 = $IO_PORT @ATTACH &en => @PLACE(223, -104) => @ORIENT("MY");
// %t71 @TEXT("en", key="name", size=0.75);
// &en @WIRE(mode="straight") {#XC:29 %t71:p};
// %t72 = $IO_PORT @ATTACH &pulse => @PLACE(223, -108) => @ORIENT("MY");
// %t72 @TEXT("pulse", key="name", size=0.75);
// &pulse @WIRE(mode="straight") {#XC:30 %t72:p};
// %t73 = $IO_PORT @ATTACH &preset => @PLACE(223, -112) => @ORIENT("MY");
// %t73 @TEXT("preset", key="name", size=0.75);
// &preset @WIRE(mode="straight") {#XC:31 %t73:p};
// %t74 = $IO_PORT @ATTACH &qualified => @PLACE(223, -116) => @ORIENT("MY");
// %t74 @TEXT("qualified", key="name", size=0.75);
// &qualified @WIRE(mode="straight") {#XC:32 %t74:p};
// %t75 = $IO_PORT @ATTACH &range_error => @PLACE(223, -120) => @ORIENT("MY");
// %t75 @TEXT("range_error", key="name", size=0.75);
// &range_error @WIRE(mode="straight") {#XC:33 %t75:p};
// %t76 = $IO_PORT @ATTACH &cfg_ready => @PLACE(223, -124) => @ORIENT("MY");
// %t76 @TEXT("cfg_ready", key="name", size=0.75);
// &cfg_ready @WIRE(mode="straight") {#XC:34 %t76:p};
// %t77 = $IO_PORT @ATTACH &cfg_invalid => @PLACE(223, -128) => @ORIENT("MY");
// %t77 @TEXT("cfg_invalid", key="name", size=0.75);
// &cfg_invalid @WIRE(mode="straight") {#XC:35 %t77:p};
// %t78 = $IO_PORT @ATTACH &restart => @PLACE(223, -132) => @ORIENT("MY");
// %t78 @TEXT("restart", key="name", size=0.75);
// &restart @WIRE(mode="straight") {#XC:36 %t78:p};
// %t79 = $IO_PORT @ATTACH &count_gate => @PLACE(223, -136) => @ORIENT("MY");
// %t79 @TEXT("count_gate", key="name", size=0.75);
// &count_gate @WIRE(mode="straight") {#XC:37 %t79:p};
// %t80 = $IO_PORT @ATTACH &count_reset => @PLACE(223, -140) => @ORIENT("MY");
// %t80 @TEXT("count_reset", key="name", size=0.75);
// &count_reset @WIRE(mode="straight") {#XC:38 %t80:p};
// %t81 = $SUPPLY @ATTACH &vdd => @PLACE(200, -31);
// &vdd @WIRE(mode="straight") {#XC:39 %t81:p};
// %t82 = $GROUND @ATTACH &vss => @PLACE(200, -149);
// &vss @WIRE(mode="straight") {#XC:40 %t82:p};
// %t83 = $IO_PORT @ATTACH &vp => @PLACE(294, -71) => @ORIENT("R0");
// %t83 @TEXT("vp", key="name", size=0.75);
// &vp @WIRE(mode="straight") {#XDET:1 %t83:p};
// %t84 = $IO_PORT @ATTACH &hp => @PLACE(294, -75) => @ORIENT("R0");
// %t84 @TEXT("hp", key="name", size=0.75);
// &hp @WIRE(mode="straight") {#XDET:2 %t84:p};
// %t85 = $IO_PORT @ATTACH &hn => @PLACE(294, -79) => @ORIENT("R0");
// %t85 @TEXT("hn", key="name", size=0.75);
// &hn @WIRE(mode="straight") {#XDET:3 %t85:p};
// %t86 = $IO_PORT @ATTACH &amp_good => @PLACE(316, -73) => @ORIENT("MY");
// %t86 @TEXT("amp_good", key="name", size=0.75);
// &amp_good @WIRE(mode="straight") {#XDET:4 %t86:p};
// %t87 = $IO_PORT @ATTACH &phase_good => @PLACE(316, -77) => @ORIENT("MY");
// %t87 @TEXT("phase_good", key="name", size=0.75);
// &phase_good @WIRE(mode="straight") {#XDET:5 %t87:p};
// %t88 = $SUPPLY @ATTACH &vdd => @PLACE(305, -62);
// &vdd @WIRE(mode="straight") {#XDET:6 %t88:p};
// %t89 = $GROUND @ATTACH &vss => @PLACE(305, -88);
// &vss @WIRE(mode="straight") {#XDET:7 %t89:p};
// %t90 = $SUPPLY @ATTACH &vdd => @PLACE(0, -21);
// &vdd @WIRE(mode="straight") {#XBM:1 %t90:p};
// %t91 = $GROUND @ATTACH &vss => @PLACE(0, -39);
// &vss @WIRE(mode="straight") {#XBM:2 %t91:p};
// %t92 = $IO_PORT @ATTACH &vmid => @PLACE(11, -30) => @ORIENT("MY");
// %t92 @TEXT("vmid", key="name", size=0.75);
// &vmid @WIRE(mode="straight") {#XBM:3 %t92:p};
// %t93 = $IO_PORT @ATTACH &vp => @PLACE(65, 0) => @ORIENT("R0");
// %t93 @TEXT("vp", key="name", size=0.75);
// &vp @WIRE(mode="straight") {#CCP:1 %t93:p};
// %t94 = $IO_PORT @ATTACH &vn => @PLACE(110, -10) => @ORIENT("R0");
// %t94 @TEXT("vn", key="name", size=0.75);
// &vn @WIRE(mode="straight") {#CCN:1 %t94:p};
// %t95 = $IO_PORT @ATTACH &vmid => @PLACE(66, -27) => @ORIENT("R0");
// %t95 @TEXT("vmid", key="name", size=0.75);
// &vmid @WIRE(mode="straight") {#RBP:2 (70, -27) %t95:p};
// %t96 = $IO_PORT @ATTACH &vmid => @PLACE(111, -43) => @ORIENT("R0");
// %t96 @TEXT("vmid", key="name", size=0.75);
// &vmid @WIRE(mode="straight") {#RBN:2 (115, -43) %t96:p};
// %t97 = $IO_PORT @ATTACH &vco_vdd => @PLACE(346, -45) => @ORIENT("R0");
// %t97 @TEXT("vco_vdd", key="name", size=0.75);
// &vco_vdd @WIRE(mode="straight") {#VVCO:1 (350, -45) %t97:p};
// %t98 = $IO_PORT @ATTACH &vdd => @PLACE(346, -55) => @ORIENT("R0");
// %t98 @TEXT("vdd", key="name", size=0.75);
// &vdd @WIRE(mode="straight") {#VVCO:2 (350, -55) %t98:p};
// %t99 = $IO_PORT @ATTACH &rx_vdd => @PLACE(391, -45) => @ORIENT("R0");
// %t99 @TEXT("rx_vdd", key="name", size=0.75);
// &rx_vdd @WIRE(mode="straight") {#VRX:1 (395, -45) %t99:p};
// %t100 = $IO_PORT @ATTACH &vdd => @PLACE(391, -55) => @ORIENT("R0");
// %t100 @TEXT("vdd", key="name", size=0.75);
// &vdd @WIRE(mode="straight") {#VRX:2 (395, -55) %t100:p};
// %t101 = $IO_PORT @ATTACH &rt_vdd => @PLACE(436, -45) => @ORIENT("R0");
// %t101 @TEXT("rt_vdd", key="name", size=0.75);
// &rt_vdd @WIRE(mode="straight") {#VRT:1 (440, -45) %t101:p};
// %t102 = $IO_PORT @ATTACH &vdd => @PLACE(436, -55) => @ORIENT("R0");
// %t102 @TEXT("vdd", key="name", size=0.75);
// &vdd @WIRE(mode="straight") {#VRT:2 (440, -55) %t102:p};
// (-16, 94) @TEXT("00  PLL / RT4 | 19 instances", size=1.2, halign="start");
// }
ends pll_capture_rt4_r48_recenter109_v14_pdk110_0
