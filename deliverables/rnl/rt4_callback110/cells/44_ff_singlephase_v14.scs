// 1-phase DFF | frozen callback110 / recenter109 | RNL 0.3
// @RNL(type="header") { @VERSION("0.3"); @USE-PACKAGE(name="rnl-std-fill") {} }
simulator lang=spectre
subckt ff_singlephase_v14_pdk110_44 (d clk clkb q vdd vss)
XF (d clk qb vdd vss) pll_tspc_inv_pdk110_25
XO (qb q vdd vss) pll_inv_pdk110_27
XK (q qb vdd vss) pll_inv_pdk110_45
// @RNL(author="manual-schematic126") {
// $CELL = @DEFINE-SYMBOL {
// @LINE {(-6, 8) (6, 8) (6, -8) (-6, -8) (-6, 8)};
// (-8, 4) @PIN(terminal="d", direction="left");
// @LINE {(-8, 4) (-6, 4)};
// (-5.4, 4) @TEXT("d", size=0.7, halign="start");
// (-8, 0) @PIN(terminal="clk", direction="left");
// @LINE {(-8, 0) (-6, 0)};
// (-5.4, 0) @TEXT("clk", size=0.7, halign="start");
// (-8, -4) @PIN(terminal="clkb", direction="left");
// @LINE {(-8, -4) (-6, -4)};
// (-5.4, -4) @TEXT("clkb", size=0.7, halign="start");
// (8, 0) @PIN(terminal="q", direction="right");
// @LINE {(8, 0) (6, 0)};
// (5.4, 0) @TEXT("q", size=0.7, halign="end");
// (0, 10) @PIN(terminal="vdd", direction="up");
// @LINE {(0, 10) (0, 8)};
// (0, -10) @PIN(terminal="vss", direction="down");
// @LINE {(0, -10) (0, -8)};
// ? @TEXT("${name}", key="name", size=1, halign="middle") => @PLACE(8, 11.5);
// (0, 7.1) @TEXT("1-phase DFF", size=0.85, halign="middle");
// };
// # @SET-SYMBOL $CELL;
// #XF @PLACE(0, 0) => @ORIENT("R0");
// #XO @PLACE(40, 0) => @ORIENT("R0");
// #XK @PLACE(40, -35) => @ORIENT("R0");
// &qb @WIRE(mode="straight") {#XF:3 (20, 0) (20, 0) #XO:1};
// &q @WIRE(mode="straight") {#XO:2 (48, -20) (32, -20) #XK:1};
// &qb @WIRE(mode="straight") {#XK:2 (55, -35) (55, -55) (20, -55) (20, 0) #XO:1};
// %t1 = $IO_PORT @ATTACH &d => @PLACE(-11, 2) => @ORIENT("R0");
// %t1 @TEXT("d", key="name", size=0.75);
// &d @WIRE(mode="straight") {#XF:1 %t1:p};
// %t2 = $IO_PORT @ATTACH &clk => @PLACE(-11, -2) => @ORIENT("R0");
// %t2 @TEXT("clk", key="name", size=0.75);
// &clk @WIRE(mode="straight") {#XF:2 %t2:p};
// %t3 = $SUPPLY @ATTACH &vdd => @PLACE(0, 11);
// &vdd @WIRE(mode="straight") {#XF:4 %t3:p};
// %t4 = $GROUND @ATTACH &vss => @PLACE(0, -11);
// &vss @WIRE(mode="straight") {#XF:5 %t4:p};
// %t5 = $SUPPLY @ATTACH &vdd => @PLACE(40, 9);
// &vdd @WIRE(mode="straight") {#XO:3 %t5:p};
// %t6 = $GROUND @ATTACH &vss => @PLACE(40, -9);
// &vss @WIRE(mode="straight") {#XO:4 %t6:p};
// %t7 = $SUPPLY @ATTACH &vdd => @PLACE(40, -26);
// &vdd @WIRE(mode="straight") {#XK:3 %t7:p};
// %t8 = $GROUND @ATTACH &vss => @PLACE(40, -44);
// &vss @WIRE(mode="straight") {#XK:4 %t8:p};
// %t9 = $IO_PORT @ATTACH &q => @PLACE(51, 0) => @ORIENT("MY");
// %t9 @TEXT("q", key="name", size=0.75);
// &q @WIRE(mode="straight") {#XO:2 %t9:p};
// (-16, 30) @TEXT("44  1-phase DFF | 3 instances", size=1.2, halign="start");
// }
ends ff_singlephase_v14_pdk110_44
