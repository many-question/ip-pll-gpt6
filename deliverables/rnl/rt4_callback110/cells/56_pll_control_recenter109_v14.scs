// PLL control | frozen callback110 / recenter109 | RNL 0.3
// @RNL(type="header") { @VERSION("0.3"); @USE-PACKAGE(name="rnl-std-fill") {} }
simulator lang=spectre
subckt pll_control_recenter109_v14_pdk110_56 (refclk reset apply k0 k1 k2 k3 k4 k5 outclk acqclk phase_good frequency_good b0 b1 b2 b3 b4 b5 b6 b7 s0 s1 s2 s3 s4 s5 divider_reset enable pulse preset qualified range_error config_ready config_invalid restart count_gate count_reset vdd vss)
XC (refclk reset apply k0 k1 k2 k3 k4 k5 ak0 ak1 ak2 ak3 ak4 ak5 s0 s1 s2 s3 s4 s5 config_ready config_invalid cfg_reset vdd vss) tx_pll_config_pdk110_57
XR (cfg_reset restart fll_reset vdd vss) tx_or_pdk110_67
XDRESET (cfg_reset restart divider_reset vdd vss) tx_or_pdk110_67
XF (refclk fll_reset ak0 ak1 ak2 ak3 ak4 ak5 m0 m1 m2 m3 m4 m5 m6 m7 m8 m9 m10 m11 m12 m13 b0 b1 b2 b3 b4 b5 b6 b7 d0 d1 d2 d3 d4 d5 fll_gate fll_count_reset acquired range_error state0 state1 state2 vdd vss) tx_fll_recenter109_v14_pdk110_69
XACQI (acquired acquired_b vdd vss) pll_inv_pdk110_7
XACQ0 (acqclk clock_mux acquired_b acquired vdd vss) pll_tg_pdk110_16
XACQ1 (outclk clock_mux acquired acquired_b vdd vss) pll_tg_pdk110_16
XACB0 (clock_mux clock_b vdd vss) pll_inv_pdk110_36
XACB1 (clock_b count_clock vdd vss) pll_inv_pdk110_27
XCOUNT (count_clock count_gate count_reset q0 q1 q2 q3 q4 q5 q6 q7 q8 q9 q10 q11 q12 q13 vdd vss) tx_fll_counter_pdk110_71
XSN (count_gate q0 q1 q2 q3 q4 q5 q6 q7 q8 q9 q10 q11 q12 q13 m0 m1 m2 m3 m4 m5 m6 m7 m8 m9 m10 m11 m12 m13 vdd vss) tx_fll_snapshot_pdk110_74
XDAC (d0 d1 d2 d3 d4 d5 acquired preset vdd vss) tx_fll_dac_pdk110_75
XPHCLK (refclk ref_fall vdd vss) pll_inv_pdk110_7
XPH (phase_good ref_fall reset phase_held vdd vss) tx_dff_r0_pdk110_58
XS (refclk reset config_ready acquired range_error phase_held frequency_good enable qualified restart fault vdd vss) tx_pll_supervisor_capture_v14_pdk110_77
XP (refclk enable fll_reset pulse vdd vss) tx_cp_timing_pdk110_78
XWG (fll_gate watch_gate acquired count_gate vdd vss) tx_mux_pdk110_64
XWR (fll_count_reset watch_reset acquired count_reset vdd vss) tx_mux_pdk110_64
XW (refclk fll_reset acquired ak0 ak1 ak2 ak3 ak4 ak5 m0 m1 m2 m3 m4 m5 m6 m7 m8 m9 m10 m11 m12 m13 watch_gate watch_reset frequency_good watchdog_valid vdd vss) tx_frequency_watchdog_pdk110_80
// @RNL(author="functional-compact127") {
// $CELL = @DEFINE-SYMBOL {
// @LINE {(-18, -54) (18, -54) (18, 54) (-18, 54) (-18, -54)};
// @LINE {(-4, 7) (4, 7) (4, 11) (-4, 11) (-4, 7)};
// (0, 9) @TEXT("CFG", size=0.9, halign="middle");
// @LINE {(-4, 1) (4, 1) (4, 5) (-4, 5) (-4, 1)};
// (0, 3) @TEXT("FLL", size=0.9, halign="middle");
// @LINE {(-4, -5) (4, -5) (4, -1) (-4, -1) (-4, -5)};
// (0, -3) @TEXT("PLL", size=0.9, halign="middle");
// @LINE {(-4, -11) (4, -11) (4, -7) (-4, -7) (-4, -11)};
// (0, -9) @TEXT("QUAL", size=0.9, halign="middle");
// @LINE {(0, 7) (0, 5)};
// @LINE {(0.575311, 6.0531) (0, 5) (-0.575311, 6.0531)};
// @LINE {(0, 1) (0, -1)};
// @LINE {(0.575311, 0.0530991) (0, -1) (-0.575311, 0.0530991)};
// @LINE {(0, -5) (0, -7)};
// @LINE {(0.575311, -5.9469) (0, -7) (-0.575311, -5.9469)};
// @LINE {(4, -3) (7, -3) (7, 3) (4, 3)};
// (0, -15) @TEXT("RT4", size=1.1, halign="middle");
// (-20, 22) @PIN(terminal="refclk", direction="left");
// @LINE {(-20, 22) (-18, 22)};
// (-17.4, 22) @TEXT("refclk", size=0.7, halign="start");
// (-20, 18) @PIN(terminal="reset", direction="left");
// @LINE {(-20, 18) (-18, 18)};
// (-17.4, 18) @TEXT("reset", size=0.7, halign="start");
// (-20, 14) @PIN(terminal="apply", direction="left");
// @LINE {(-20, 14) (-18, 14)};
// (-17.4, 14) @TEXT("apply", size=0.7, halign="start");
// (-20, 10) @PIN(terminal="k0", direction="left");
// @LINE {(-20, 10) (-18, 10)};
// (-17.4, 10) @TEXT("k0", size=0.7, halign="start");
// (-20, 6) @PIN(terminal="k1", direction="left");
// @LINE {(-20, 6) (-18, 6)};
// (-17.4, 6) @TEXT("k1", size=0.7, halign="start");
// (-20, 2) @PIN(terminal="k2", direction="left");
// @LINE {(-20, 2) (-18, 2)};
// (-17.4, 2) @TEXT("k2", size=0.7, halign="start");
// (-20, -2) @PIN(terminal="k3", direction="left");
// @LINE {(-20, -2) (-18, -2)};
// (-17.4, -2) @TEXT("k3", size=0.7, halign="start");
// (-20, -6) @PIN(terminal="k4", direction="left");
// @LINE {(-20, -6) (-18, -6)};
// (-17.4, -6) @TEXT("k4", size=0.7, halign="start");
// (-20, -10) @PIN(terminal="k5", direction="left");
// @LINE {(-20, -10) (-18, -10)};
// (-17.4, -10) @TEXT("k5", size=0.7, halign="start");
// (-20, -14) @PIN(terminal="outclk", direction="left");
// @LINE {(-20, -14) (-18, -14)};
// (-17.4, -14) @TEXT("outclk", size=0.7, halign="start");
// (-20, -18) @PIN(terminal="acqclk", direction="left");
// @LINE {(-20, -18) (-18, -18)};
// (-17.4, -18) @TEXT("acqclk", size=0.7, halign="start");
// (-20, -22) @PIN(terminal="phase_good", direction="left");
// @LINE {(-20, -22) (-18, -22)};
// (-17.4, -22) @TEXT("phase_good", size=0.7, halign="start");
// (20, 50) @PIN(terminal="frequency_good", direction="right");
// @LINE {(20, 50) (18, 50)};
// (17.4, 50) @TEXT("frequency_good", size=0.7, halign="end");
// (20, 46) @PIN(terminal="b0", direction="right");
// @LINE {(20, 46) (18, 46)};
// (17.4, 46) @TEXT("b0", size=0.7, halign="end");
// (20, 42) @PIN(terminal="b1", direction="right");
// @LINE {(20, 42) (18, 42)};
// (17.4, 42) @TEXT("b1", size=0.7, halign="end");
// (20, 38) @PIN(terminal="b2", direction="right");
// @LINE {(20, 38) (18, 38)};
// (17.4, 38) @TEXT("b2", size=0.7, halign="end");
// (20, 34) @PIN(terminal="b3", direction="right");
// @LINE {(20, 34) (18, 34)};
// (17.4, 34) @TEXT("b3", size=0.7, halign="end");
// (20, 30) @PIN(terminal="b4", direction="right");
// @LINE {(20, 30) (18, 30)};
// (17.4, 30) @TEXT("b4", size=0.7, halign="end");
// (20, 26) @PIN(terminal="b5", direction="right");
// @LINE {(20, 26) (18, 26)};
// (17.4, 26) @TEXT("b5", size=0.7, halign="end");
// (20, 22) @PIN(terminal="b6", direction="right");
// @LINE {(20, 22) (18, 22)};
// (17.4, 22) @TEXT("b6", size=0.7, halign="end");
// (20, 18) @PIN(terminal="b7", direction="right");
// @LINE {(20, 18) (18, 18)};
// (17.4, 18) @TEXT("b7", size=0.7, halign="end");
// (20, 14) @PIN(terminal="s0", direction="right");
// @LINE {(20, 14) (18, 14)};
// (17.4, 14) @TEXT("s0", size=0.7, halign="end");
// (20, 10) @PIN(terminal="s1", direction="right");
// @LINE {(20, 10) (18, 10)};
// (17.4, 10) @TEXT("s1", size=0.7, halign="end");
// (20, 6) @PIN(terminal="s2", direction="right");
// @LINE {(20, 6) (18, 6)};
// (17.4, 6) @TEXT("s2", size=0.7, halign="end");
// (20, 2) @PIN(terminal="s3", direction="right");
// @LINE {(20, 2) (18, 2)};
// (17.4, 2) @TEXT("s3", size=0.7, halign="end");
// (20, -2) @PIN(terminal="s4", direction="right");
// @LINE {(20, -2) (18, -2)};
// (17.4, -2) @TEXT("s4", size=0.7, halign="end");
// (20, -6) @PIN(terminal="s5", direction="right");
// @LINE {(20, -6) (18, -6)};
// (17.4, -6) @TEXT("s5", size=0.7, halign="end");
// (20, -10) @PIN(terminal="divider_reset", direction="right");
// @LINE {(20, -10) (18, -10)};
// (17.4, -10) @TEXT("divider_reset", size=0.7, halign="end");
// (20, -14) @PIN(terminal="enable", direction="right");
// @LINE {(20, -14) (18, -14)};
// (17.4, -14) @TEXT("enable", size=0.7, halign="end");
// (20, -18) @PIN(terminal="pulse", direction="right");
// @LINE {(20, -18) (18, -18)};
// (17.4, -18) @TEXT("pulse", size=0.7, halign="end");
// (20, -22) @PIN(terminal="preset", direction="right");
// @LINE {(20, -22) (18, -22)};
// (17.4, -22) @TEXT("preset", size=0.7, halign="end");
// (20, -26) @PIN(terminal="qualified", direction="right");
// @LINE {(20, -26) (18, -26)};
// (17.4, -26) @TEXT("qualified", size=0.7, halign="end");
// (20, -30) @PIN(terminal="range_error", direction="right");
// @LINE {(20, -30) (18, -30)};
// (17.4, -30) @TEXT("range_error", size=0.7, halign="end");
// (20, -34) @PIN(terminal="config_ready", direction="right");
// @LINE {(20, -34) (18, -34)};
// (17.4, -34) @TEXT("config_ready", size=0.7, halign="end");
// (20, -38) @PIN(terminal="config_invalid", direction="right");
// @LINE {(20, -38) (18, -38)};
// (17.4, -38) @TEXT("config_invalid", size=0.7, halign="end");
// (20, -42) @PIN(terminal="restart", direction="right");
// @LINE {(20, -42) (18, -42)};
// (17.4, -42) @TEXT("restart", size=0.7, halign="end");
// (20, -46) @PIN(terminal="count_gate", direction="right");
// @LINE {(20, -46) (18, -46)};
// (17.4, -46) @TEXT("count_gate", size=0.7, halign="end");
// (20, -50) @PIN(terminal="count_reset", direction="right");
// @LINE {(20, -50) (18, -50)};
// (17.4, -50) @TEXT("count_reset", size=0.7, halign="end");
// (0, 56) @PIN(terminal="vdd", direction="up");
// @LINE {(0, 56) (0, 54)};
// (0, -56) @PIN(terminal="vss", direction="down");
// @LINE {(0, -56) (0, -54)};
// ? @TEXT("${name}", key="name", size=1, halign="middle") => @PLACE(20, 57.5);
// (0, 53.1) @TEXT("PLL control", size=0.85, halign="middle");
// };
// # @SET-SYMBOL $CELL;
// #XC @PLACE(0, 15) => @ORIENT("R0");
// #XR @PLACE(0, -50) => @ORIENT("R0");
// #XDRESET @PLACE(32, -50) => @ORIENT("R0");
// #XF @PLACE(65, 15) => @ORIENT("R0");
// #XCOUNT @PLACE(135, 15) => @ORIENT("R0");
// #XSN @PLACE(186, 15) => @ORIENT("R0");
// #XDAC @PLACE(115, -45) => @ORIENT("R0");
// #XS @PLACE(75, -155) => @ORIENT("R0");
// #XP @PLACE(120, -150) => @ORIENT("R0");
// #XW @PLACE(176, -125) => @ORIENT("R0");
// #XACQI @PLACE(0, -83) => @ORIENT("R0");
// #XACQ0 @PLACE(35, -83) => @ORIENT("R0");
// #XACQ1 @PLACE(35, -117) => @ORIENT("R0");
// #XACB0 @PLACE(70, -83) => @ORIENT("R0");
// #XACB1 @PLACE(100, -83) => @ORIENT("R0");
// #XPHCLK @PLACE(0, -155) => @ORIENT("R0");
// #XPH @PLACE(35, -155) => @ORIENT("R0");
// #XWG @PLACE(135, -200) => @ORIENT("R0");
// #XWR @PLACE(176, -200) => @ORIENT("R0");
// &ak0 @WIRE(mode="straight") {#XC:10 (29, 43) (29, 49) #XF:3};
// &ak1 @WIRE(mode="straight") {#XC:11 (31, 39) (31, 45) #XF:4};
// &ak2 @WIRE(mode="straight") {#XC:12 (33, 35) (33, 41) #XF:5};
// &ak3 @WIRE(mode="straight") {#XC:13 (35, 31) (35, 37) #XF:6};
// &ak4 @WIRE(mode="straight") {#XC:14 (37, 27) (37, 33) #XF:7};
// &ak5 @WIRE(mode="straight") {#XC:15 (39, 23) (39, 29) #XF:8};
// &q0 @WIRE(mode="straight") {#XCOUNT:4 (151, 41) (151, 39) #XSN:2};
// &q1 @WIRE(mode="straight") {#XCOUNT:5 (151, 37) (151, 35) #XSN:3};
// &q2 @WIRE(mode="straight") {#XCOUNT:6 (152, 33) (152, 31) #XSN:4};
// &q3 @WIRE(mode="straight") {#XCOUNT:7 (152, 29) (152, 27) #XSN:5};
// &q4 @WIRE(mode="straight") {#XCOUNT:8 (153, 25) (153, 23) #XSN:6};
// &q5 @WIRE(mode="straight") {#XCOUNT:9 (153, 21) (153, 19) #XSN:7};
// &q6 @WIRE(mode="straight") {#XCOUNT:10 (154, 17) (154, 15) #XSN:8};
// &q7 @WIRE(mode="straight") {#XCOUNT:11 (154, 13) (154, 11) #XSN:9};
// &q8 @WIRE(mode="straight") {#XCOUNT:12 (155, 9) (155, 7) #XSN:10};
// &q9 @WIRE(mode="straight") {#XCOUNT:13 (156, 5) (156, 3) #XSN:11};
// &q10 @WIRE(mode="straight") {#XCOUNT:14 (157, 1) (157, -1) #XSN:12};
// &q11 @WIRE(mode="straight") {#XCOUNT:15 (158, -3) (158, -5) #XSN:13};
// &q12 @WIRE(mode="straight") {#XCOUNT:16 (159, -7) (159, -9) #XSN:14};
// &q13 @WIRE(mode="straight") {#XCOUNT:17 (160, -11) (160, -13) #XSN:15};
// &clock_b @WIRE(mode="straight") {#XACB0:2 (85, -83) (85, -83) #XACB1:1};
// &count_clock @WIRE(mode="straight") {#XACB1:2 (156, -83) (156, -23) (115, -23) (115, 19) #XCOUNT:1};
// &ref_fall @WIRE(mode="straight") {#XPHCLK:2 (20, -155) (20, -155) #XPH:2};
// (-20, 79) @TEXT("Configuration -> FLL; RF/4 count -> snapshot", size=1.1, halign="start");
// (55, -95) @TEXT("Handoff / qualification / watchdog", size=0.9, halign="start");
// %t1 = $IO_PORT @ATTACH &refclk => @PLACE(-23, 31) => @ORIENT("R0");
// %t1 @TEXT("refclk", key="name", size=0.75);
// &refclk @WIRE(mode="straight") {#XC:1 %t1:p};
// %t2 = $IO_PORT @ATTACH &reset => @PLACE(-23, 27) => @ORIENT("R0");
// %t2 @TEXT("reset", key="name", size=0.75);
// &reset @WIRE(mode="straight") {#XC:2 %t2:p};
// %t3 = $IO_PORT @ATTACH &apply => @PLACE(-23, 23) => @ORIENT("R0");
// %t3 @TEXT("apply", key="name", size=0.75);
// &apply @WIRE(mode="straight") {#XC:3 %t3:p};
// %t4 = $IO_PORT @ATTACH &k0 => @PLACE(-23, 19) => @ORIENT("R0");
// %t4 @TEXT("k0", key="name", size=0.75);
// &k0 @WIRE(mode="straight") {#XC:4 %t4:p};
// %t5 = $IO_PORT @ATTACH &k1 => @PLACE(-23, 15) => @ORIENT("R0");
// %t5 @TEXT("k1", key="name", size=0.75);
// &k1 @WIRE(mode="straight") {#XC:5 %t5:p};
// %t6 = $IO_PORT @ATTACH &k2 => @PLACE(-23, 11) => @ORIENT("R0");
// %t6 @TEXT("k2", key="name", size=0.75);
// &k2 @WIRE(mode="straight") {#XC:6 %t6:p};
// %t7 = $IO_PORT @ATTACH &k3 => @PLACE(-23, 7) => @ORIENT("R0");
// %t7 @TEXT("k3", key="name", size=0.75);
// &k3 @WIRE(mode="straight") {#XC:7 %t7:p};
// %t8 = $IO_PORT @ATTACH &k4 => @PLACE(-23, 3) => @ORIENT("R0");
// %t8 @TEXT("k4", key="name", size=0.75);
// &k4 @WIRE(mode="straight") {#XC:8 %t8:p};
// %t9 = $IO_PORT @ATTACH &k5 => @PLACE(-23, -1) => @ORIENT("R0");
// %t9 @TEXT("k5", key="name", size=0.75);
// &k5 @WIRE(mode="straight") {#XC:9 %t9:p};
// %t10 = $IO_PORT @ATTACH &s0 => @PLACE(23, 19) => @ORIENT("MY");
// %t10 @TEXT("s0", key="name", size=0.75);
// &s0 @WIRE(mode="straight") {#XC:16 %t10:p};
// %t11 = $IO_PORT @ATTACH &s1 => @PLACE(23, 15) => @ORIENT("MY");
// %t11 @TEXT("s1", key="name", size=0.75);
// &s1 @WIRE(mode="straight") {#XC:17 %t11:p};
// %t12 = $IO_PORT @ATTACH &s2 => @PLACE(23, 11) => @ORIENT("MY");
// %t12 @TEXT("s2", key="name", size=0.75);
// &s2 @WIRE(mode="straight") {#XC:18 %t12:p};
// %t13 = $IO_PORT @ATTACH &s3 => @PLACE(23, 7) => @ORIENT("MY");
// %t13 @TEXT("s3", key="name", size=0.75);
// &s3 @WIRE(mode="straight") {#XC:19 %t13:p};
// %t14 = $IO_PORT @ATTACH &s4 => @PLACE(23, 3) => @ORIENT("MY");
// %t14 @TEXT("s4", key="name", size=0.75);
// &s4 @WIRE(mode="straight") {#XC:20 %t14:p};
// %t15 = $IO_PORT @ATTACH &s5 => @PLACE(23, -1) => @ORIENT("MY");
// %t15 @TEXT("s5", key="name", size=0.75);
// &s5 @WIRE(mode="straight") {#XC:21 %t15:p};
// %t16 = $IO_PORT @ATTACH &config_ready => @PLACE(23, -5) => @ORIENT("MY");
// %t16 @TEXT("config_ready", key="name", size=0.75);
// &config_ready @WIRE(mode="straight") {#XC:22 %t16:p};
// %t17 = $IO_PORT @ATTACH &config_invalid => @PLACE(23, -9) => @ORIENT("MY");
// %t17 @TEXT("config_invalid", key="name", size=0.75);
// &config_invalid @WIRE(mode="straight") {#XC:23 %t17:p};
// %t18 = $IO_PORT @ATTACH &cfg_reset => @PLACE(23, -13) => @ORIENT("MY");
// %t18 @TEXT("cfg_reset", key="name", size=0.75);
// &cfg_reset @WIRE(mode="straight") {#XC:24 %t18:p};
// %t19 = $SUPPLY @ATTACH &vdd => @PLACE(0, 52);
// &vdd @WIRE(mode="straight") {#XC:25 %t19:p};
// %t20 = $GROUND @ATTACH &vss => @PLACE(0, -22);
// &vss @WIRE(mode="straight") {#XC:26 %t20:p};
// %t21 = $IO_PORT @ATTACH &cfg_reset => @PLACE(-11, -48) => @ORIENT("R0");
// %t21 @TEXT("cfg_reset", key="name", size=0.75);
// &cfg_reset @WIRE(mode="straight") {#XR:1 %t21:p};
// %t22 = $IO_PORT @ATTACH &restart => @PLACE(-11, -52) => @ORIENT("R0");
// %t22 @TEXT("restart", key="name", size=0.75);
// &restart @WIRE(mode="straight") {#XR:2 %t22:p};
// %t23 = $IO_PORT @ATTACH &fll_reset => @PLACE(11, -50) => @ORIENT("MY");
// %t23 @TEXT("fll_reset", key="name", size=0.75);
// &fll_reset @WIRE(mode="straight") {#XR:3 %t23:p};
// %t24 = $SUPPLY @ATTACH &vdd => @PLACE(0, -39);
// &vdd @WIRE(mode="straight") {#XR:4 %t24:p};
// %t25 = $GROUND @ATTACH &vss => @PLACE(0, -61);
// &vss @WIRE(mode="straight") {#XR:5 %t25:p};
// %t26 = $IO_PORT @ATTACH &cfg_reset => @PLACE(21, -48) => @ORIENT("R0");
// %t26 @TEXT("cfg_reset", key="name", size=0.75);
// &cfg_reset @WIRE(mode="straight") {#XDRESET:1 %t26:p};
// %t27 = $IO_PORT @ATTACH &restart => @PLACE(21, -52) => @ORIENT("R0");
// %t27 @TEXT("restart", key="name", size=0.75);
// &restart @WIRE(mode="straight") {#XDRESET:2 %t27:p};
// %t28 = $IO_PORT @ATTACH &divider_reset => @PLACE(43, -50) => @ORIENT("MY");
// %t28 @TEXT("divider_reset", key="name", size=0.75);
// &divider_reset @WIRE(mode="straight") {#XDRESET:3 %t28:p};
// %t29 = $SUPPLY @ATTACH &vdd => @PLACE(32, -39);
// &vdd @WIRE(mode="straight") {#XDRESET:4 %t29:p};
// %t30 = $GROUND @ATTACH &vss => @PLACE(32, -61);
// &vss @WIRE(mode="straight") {#XDRESET:5 %t30:p};
// %t31 = $IO_PORT @ATTACH &refclk => @PLACE(42, 57) => @ORIENT("R0");
// %t31 @TEXT("refclk", key="name", size=0.75);
// &refclk @WIRE(mode="straight") {#XF:1 %t31:p};
// %t32 = $IO_PORT @ATTACH &fll_reset => @PLACE(42, 53) => @ORIENT("R0");
// %t32 @TEXT("fll_reset", key="name", size=0.75);
// &fll_reset @WIRE(mode="straight") {#XF:2 %t32:p};
// %t33 = $IO_PORT @ATTACH &m0 => @PLACE(42, 25) => @ORIENT("R0");
// %t33 @TEXT("m0", key="name", size=0.75);
// &m0 @WIRE(mode="straight") {#XF:9 %t33:p};
// %t34 = $IO_PORT @ATTACH &m1 => @PLACE(42, 21) => @ORIENT("R0");
// %t34 @TEXT("m1", key="name", size=0.75);
// &m1 @WIRE(mode="straight") {#XF:10 %t34:p};
// %t35 = $IO_PORT @ATTACH &m2 => @PLACE(42, 17) => @ORIENT("R0");
// %t35 @TEXT("m2", key="name", size=0.75);
// &m2 @WIRE(mode="straight") {#XF:11 %t35:p};
// %t36 = $IO_PORT @ATTACH &m3 => @PLACE(42, 13) => @ORIENT("R0");
// %t36 @TEXT("m3", key="name", size=0.75);
// &m3 @WIRE(mode="straight") {#XF:12 %t36:p};
// %t37 = $IO_PORT @ATTACH &m4 => @PLACE(42, 9) => @ORIENT("R0");
// %t37 @TEXT("m4", key="name", size=0.75);
// &m4 @WIRE(mode="straight") {#XF:13 %t37:p};
// %t38 = $IO_PORT @ATTACH &m5 => @PLACE(42, 5) => @ORIENT("R0");
// %t38 @TEXT("m5", key="name", size=0.75);
// &m5 @WIRE(mode="straight") {#XF:14 %t38:p};
// %t39 = $IO_PORT @ATTACH &m6 => @PLACE(42, 1) => @ORIENT("R0");
// %t39 @TEXT("m6", key="name", size=0.75);
// &m6 @WIRE(mode="straight") {#XF:15 %t39:p};
// %t40 = $IO_PORT @ATTACH &m7 => @PLACE(42, -3) => @ORIENT("R0");
// %t40 @TEXT("m7", key="name", size=0.75);
// &m7 @WIRE(mode="straight") {#XF:16 %t40:p};
// %t41 = $IO_PORT @ATTACH &m8 => @PLACE(42, -7) => @ORIENT("R0");
// %t41 @TEXT("m8", key="name", size=0.75);
// &m8 @WIRE(mode="straight") {#XF:17 %t41:p};
// %t42 = $IO_PORT @ATTACH &m9 => @PLACE(42, -11) => @ORIENT("R0");
// %t42 @TEXT("m9", key="name", size=0.75);
// &m9 @WIRE(mode="straight") {#XF:18 %t42:p};
// %t43 = $IO_PORT @ATTACH &m10 => @PLACE(42, -15) => @ORIENT("R0");
// %t43 @TEXT("m10", key="name", size=0.75);
// &m10 @WIRE(mode="straight") {#XF:19 %t43:p};
// %t44 = $IO_PORT @ATTACH &m11 => @PLACE(42, -19) => @ORIENT("R0");
// %t44 @TEXT("m11", key="name", size=0.75);
// &m11 @WIRE(mode="straight") {#XF:20 %t44:p};
// %t45 = $IO_PORT @ATTACH &m12 => @PLACE(42, -23) => @ORIENT("R0");
// %t45 @TEXT("m12", key="name", size=0.75);
// &m12 @WIRE(mode="straight") {#XF:21 %t45:p};
// %t46 = $IO_PORT @ATTACH &m13 => @PLACE(42, -27) => @ORIENT("R0");
// %t46 @TEXT("m13", key="name", size=0.75);
// &m13 @WIRE(mode="straight") {#XF:22 %t46:p};
// %t47 = $IO_PORT @ATTACH &b0 => @PLACE(88, 55) => @ORIENT("MY");
// %t47 @TEXT("b0", key="name", size=0.75);
// &b0 @WIRE(mode="straight") {#XF:23 %t47:p};
// %t48 = $IO_PORT @ATTACH &b1 => @PLACE(88, 51) => @ORIENT("MY");
// %t48 @TEXT("b1", key="name", size=0.75);
// &b1 @WIRE(mode="straight") {#XF:24 %t48:p};
// %t49 = $IO_PORT @ATTACH &b2 => @PLACE(88, 47) => @ORIENT("MY");
// %t49 @TEXT("b2", key="name", size=0.75);
// &b2 @WIRE(mode="straight") {#XF:25 %t49:p};
// %t50 = $IO_PORT @ATTACH &b3 => @PLACE(88, 43) => @ORIENT("MY");
// %t50 @TEXT("b3", key="name", size=0.75);
// &b3 @WIRE(mode="straight") {#XF:26 %t50:p};
// %t51 = $IO_PORT @ATTACH &b4 => @PLACE(88, 39) => @ORIENT("MY");
// %t51 @TEXT("b4", key="name", size=0.75);
// &b4 @WIRE(mode="straight") {#XF:27 %t51:p};
// %t52 = $IO_PORT @ATTACH &b5 => @PLACE(88, 35) => @ORIENT("MY");
// %t52 @TEXT("b5", key="name", size=0.75);
// &b5 @WIRE(mode="straight") {#XF:28 %t52:p};
// %t53 = $IO_PORT @ATTACH &b6 => @PLACE(88, 31) => @ORIENT("MY");
// %t53 @TEXT("b6", key="name", size=0.75);
// &b6 @WIRE(mode="straight") {#XF:29 %t53:p};
// %t54 = $IO_PORT @ATTACH &b7 => @PLACE(88, 27) => @ORIENT("MY");
// %t54 @TEXT("b7", key="name", size=0.75);
// &b7 @WIRE(mode="straight") {#XF:30 %t54:p};
// %t55 = $IO_PORT @ATTACH &d0 => @PLACE(88, 23) => @ORIENT("MY");
// %t55 @TEXT("d0", key="name", size=0.75);
// &d0 @WIRE(mode="straight") {#XF:31 %t55:p};
// %t56 = $IO_PORT @ATTACH &d1 => @PLACE(88, 19) => @ORIENT("MY");
// %t56 @TEXT("d1", key="name", size=0.75);
// &d1 @WIRE(mode="straight") {#XF:32 %t56:p};
// %t57 = $IO_PORT @ATTACH &d2 => @PLACE(88, 15) => @ORIENT("MY");
// %t57 @TEXT("d2", key="name", size=0.75);
// &d2 @WIRE(mode="straight") {#XF:33 %t57:p};
// %t58 = $IO_PORT @ATTACH &d3 => @PLACE(88, 11) => @ORIENT("MY");
// %t58 @TEXT("d3", key="name", size=0.75);
// &d3 @WIRE(mode="straight") {#XF:34 %t58:p};
// %t59 = $IO_PORT @ATTACH &d4 => @PLACE(88, 7) => @ORIENT("MY");
// %t59 @TEXT("d4", key="name", size=0.75);
// &d4 @WIRE(mode="straight") {#XF:35 %t59:p};
// %t60 = $IO_PORT @ATTACH &d5 => @PLACE(88, 3) => @ORIENT("MY");
// %t60 @TEXT("d5", key="name", size=0.75);
// &d5 @WIRE(mode="straight") {#XF:36 %t60:p};
// %t61 = $IO_PORT @ATTACH &fll_gate => @PLACE(88, -1) => @ORIENT("MY");
// %t61 @TEXT("fll_gate", key="name", size=0.75);
// &fll_gate @WIRE(mode="straight") {#XF:37 %t61:p};
// %t62 = $IO_PORT @ATTACH &fll_count_reset => @PLACE(88, -5) => @ORIENT("MY");
// %t62 @TEXT("fll_count_reset", key="name", size=0.75);
// &fll_count_reset @WIRE(mode="straight") {#XF:38 %t62:p};
// %t63 = $IO_PORT @ATTACH &acquired => @PLACE(88, -9) => @ORIENT("MY");
// %t63 @TEXT("acquired", key="name", size=0.75);
// &acquired @WIRE(mode="straight") {#XF:39 %t63:p};
// %t64 = $IO_PORT @ATTACH &range_error => @PLACE(88, -13) => @ORIENT("MY");
// %t64 @TEXT("range_error", key="name", size=0.75);
// &range_error @WIRE(mode="straight") {#XF:40 %t64:p};
// %t65 = $IO_PORT @ATTACH &state0 => @PLACE(88, -17) => @ORIENT("MY");
// %t65 @TEXT("state0", key="name", size=0.75);
// &state0 @WIRE(mode="straight") {#XF:41 %t65:p};
// %t66 = $IO_PORT @ATTACH &state1 => @PLACE(88, -21) => @ORIENT("MY");
// %t66 @TEXT("state1", key="name", size=0.75);
// &state1 @WIRE(mode="straight") {#XF:42 %t66:p};
// %t67 = $IO_PORT @ATTACH &state2 => @PLACE(88, -25) => @ORIENT("MY");
// %t67 @TEXT("state2", key="name", size=0.75);
// &state2 @WIRE(mode="straight") {#XF:43 %t67:p};
// %t68 = $SUPPLY @ATTACH &vdd => @PLACE(65, 66);
// &vdd @WIRE(mode="straight") {#XF:44 %t68:p};
// %t69 = $GROUND @ATTACH &vss => @PLACE(65, -36);
// &vss @WIRE(mode="straight") {#XF:45 %t69:p};
// %t70 = $IO_PORT @ATTACH &count_gate => @PLACE(118, 15) => @ORIENT("R0");
// %t70 @TEXT("count_gate", key="name", size=0.75);
// &count_gate @WIRE(mode="straight") {#XCOUNT:2 %t70:p};
// %t71 = $IO_PORT @ATTACH &count_reset => @PLACE(118, 11) => @ORIENT("R0");
// %t71 @TEXT("count_reset", key="name", size=0.75);
// &count_reset @WIRE(mode="straight") {#XCOUNT:3 %t71:p};
// %t72 = $SUPPLY @ATTACH &vdd => @PLACE(135, 50);
// &vdd @WIRE(mode="straight") {#XCOUNT:18 %t72:p};
// %t73 = $GROUND @ATTACH &vss => @PLACE(135, -20);
// &vss @WIRE(mode="straight") {#XCOUNT:19 %t73:p};
// %t74 = $IO_PORT @ATTACH &count_gate => @PLACE(163, 43) => @ORIENT("R0");
// %t74 @TEXT("count_gate", key="name", size=0.75);
// &count_gate @WIRE(mode="straight") {#XSN:1 %t74:p};
// %t75 = $IO_PORT @ATTACH &m0 => @PLACE(209, 41) => @ORIENT("MY");
// %t75 @TEXT("m0", key="name", size=0.75);
// &m0 @WIRE(mode="straight") {#XSN:16 %t75:p};
// %t76 = $IO_PORT @ATTACH &m1 => @PLACE(209, 37) => @ORIENT("MY");
// %t76 @TEXT("m1", key="name", size=0.75);
// &m1 @WIRE(mode="straight") {#XSN:17 %t76:p};
// %t77 = $IO_PORT @ATTACH &m2 => @PLACE(209, 33) => @ORIENT("MY");
// %t77 @TEXT("m2", key="name", size=0.75);
// &m2 @WIRE(mode="straight") {#XSN:18 %t77:p};
// %t78 = $IO_PORT @ATTACH &m3 => @PLACE(209, 29) => @ORIENT("MY");
// %t78 @TEXT("m3", key="name", size=0.75);
// &m3 @WIRE(mode="straight") {#XSN:19 %t78:p};
// %t79 = $IO_PORT @ATTACH &m4 => @PLACE(209, 25) => @ORIENT("MY");
// %t79 @TEXT("m4", key="name", size=0.75);
// &m4 @WIRE(mode="straight") {#XSN:20 %t79:p};
// %t80 = $IO_PORT @ATTACH &m5 => @PLACE(209, 21) => @ORIENT("MY");
// %t80 @TEXT("m5", key="name", size=0.75);
// &m5 @WIRE(mode="straight") {#XSN:21 %t80:p};
// %t81 = $IO_PORT @ATTACH &m6 => @PLACE(209, 17) => @ORIENT("MY");
// %t81 @TEXT("m6", key="name", size=0.75);
// &m6 @WIRE(mode="straight") {#XSN:22 %t81:p};
// %t82 = $IO_PORT @ATTACH &m7 => @PLACE(209, 13) => @ORIENT("MY");
// %t82 @TEXT("m7", key="name", size=0.75);
// &m7 @WIRE(mode="straight") {#XSN:23 %t82:p};
// %t83 = $IO_PORT @ATTACH &m8 => @PLACE(209, 9) => @ORIENT("MY");
// %t83 @TEXT("m8", key="name", size=0.75);
// &m8 @WIRE(mode="straight") {#XSN:24 %t83:p};
// %t84 = $IO_PORT @ATTACH &m9 => @PLACE(209, 5) => @ORIENT("MY");
// %t84 @TEXT("m9", key="name", size=0.75);
// &m9 @WIRE(mode="straight") {#XSN:25 %t84:p};
// %t85 = $IO_PORT @ATTACH &m10 => @PLACE(209, 1) => @ORIENT("MY");
// %t85 @TEXT("m10", key="name", size=0.75);
// &m10 @WIRE(mode="straight") {#XSN:26 %t85:p};
// %t86 = $IO_PORT @ATTACH &m11 => @PLACE(209, -3) => @ORIENT("MY");
// %t86 @TEXT("m11", key="name", size=0.75);
// &m11 @WIRE(mode="straight") {#XSN:27 %t86:p};
// %t87 = $IO_PORT @ATTACH &m12 => @PLACE(209, -7) => @ORIENT("MY");
// %t87 @TEXT("m12", key="name", size=0.75);
// &m12 @WIRE(mode="straight") {#XSN:28 %t87:p};
// %t88 = $IO_PORT @ATTACH &m13 => @PLACE(209, -11) => @ORIENT("MY");
// %t88 @TEXT("m13", key="name", size=0.75);
// &m13 @WIRE(mode="straight") {#XSN:29 %t88:p};
// %t89 = $SUPPLY @ATTACH &vdd => @PLACE(186, 52);
// &vdd @WIRE(mode="straight") {#XSN:30 %t89:p};
// %t90 = $GROUND @ATTACH &vss => @PLACE(186, -22);
// &vss @WIRE(mode="straight") {#XSN:31 %t90:p};
// %t91 = $IO_PORT @ATTACH &d0 => @PLACE(98, -33) => @ORIENT("R0");
// %t91 @TEXT("d0", key="name", size=0.75);
// &d0 @WIRE(mode="straight") {#XDAC:1 %t91:p};
// %t92 = $IO_PORT @ATTACH &d1 => @PLACE(98, -37) => @ORIENT("R0");
// %t92 @TEXT("d1", key="name", size=0.75);
// &d1 @WIRE(mode="straight") {#XDAC:2 %t92:p};
// %t93 = $IO_PORT @ATTACH &d2 => @PLACE(98, -41) => @ORIENT("R0");
// %t93 @TEXT("d2", key="name", size=0.75);
// &d2 @WIRE(mode="straight") {#XDAC:3 %t93:p};
// %t94 = $IO_PORT @ATTACH &d3 => @PLACE(98, -45) => @ORIENT("R0");
// %t94 @TEXT("d3", key="name", size=0.75);
// &d3 @WIRE(mode="straight") {#XDAC:4 %t94:p};
// %t95 = $IO_PORT @ATTACH &d4 => @PLACE(98, -49) => @ORIENT("R0");
// %t95 @TEXT("d4", key="name", size=0.75);
// &d4 @WIRE(mode="straight") {#XDAC:5 %t95:p};
// %t96 = $IO_PORT @ATTACH &d5 => @PLACE(98, -53) => @ORIENT("R0");
// %t96 @TEXT("d5", key="name", size=0.75);
// &d5 @WIRE(mode="straight") {#XDAC:6 %t96:p};
// %t97 = $IO_PORT @ATTACH &acquired => @PLACE(98, -57) => @ORIENT("R0");
// %t97 @TEXT("acquired", key="name", size=0.75);
// &acquired @WIRE(mode="straight") {#XDAC:7 %t97:p};
// %t98 = $IO_PORT @ATTACH &preset => @PLACE(132, -45) => @ORIENT("MY");
// %t98 @TEXT("preset", key="name", size=0.75);
// &preset @WIRE(mode="straight") {#XDAC:8 %t98:p};
// %t99 = $SUPPLY @ATTACH &vdd => @PLACE(115, -24);
// &vdd @WIRE(mode="straight") {#XDAC:9 %t99:p};
// %t100 = $GROUND @ATTACH &vss => @PLACE(115, -66);
// &vss @WIRE(mode="straight") {#XDAC:10 %t100:p};
// %t101 = $IO_PORT @ATTACH &refclk => @PLACE(58, -143) => @ORIENT("R0");
// %t101 @TEXT("refclk", key="name", size=0.75);
// &refclk @WIRE(mode="straight") {#XS:1 %t101:p};
// %t102 = $IO_PORT @ATTACH &reset => @PLACE(58, -147) => @ORIENT("R0");
// %t102 @TEXT("reset", key="name", size=0.75);
// &reset @WIRE(mode="straight") {#XS:2 %t102:p};
// %t103 = $IO_PORT @ATTACH &config_ready => @PLACE(58, -151) => @ORIENT("R0");
// %t103 @TEXT("config_ready", key="name", size=0.75);
// &config_ready @WIRE(mode="straight") {#XS:3 %t103:p};
// %t104 = $IO_PORT @ATTACH &acquired => @PLACE(58, -155) => @ORIENT("R0");
// %t104 @TEXT("acquired", key="name", size=0.75);
// &acquired @WIRE(mode="straight") {#XS:4 %t104:p};
// %t105 = $IO_PORT @ATTACH &range_error => @PLACE(58, -159) => @ORIENT("R0");
// %t105 @TEXT("range_error", key="name", size=0.75);
// &range_error @WIRE(mode="straight") {#XS:5 %t105:p};
// %t106 = $IO_PORT @ATTACH &phase_held => @PLACE(58, -163) => @ORIENT("R0");
// %t106 @TEXT("phase_held", key="name", size=0.75);
// &phase_held @WIRE(mode="straight") {#XS:6 %t106:p};
// %t107 = $IO_PORT @ATTACH &frequency_good => @PLACE(58, -167) => @ORIENT("R0");
// %t107 @TEXT("frequency_good", key="name", size=0.75);
// &frequency_good @WIRE(mode="straight") {#XS:7 %t107:p};
// %t108 = $IO_PORT @ATTACH &enable => @PLACE(92, -149) => @ORIENT("MY");
// %t108 @TEXT("enable", key="name", size=0.75);
// &enable @WIRE(mode="straight") {#XS:8 %t108:p};
// %t109 = $IO_PORT @ATTACH &qualified => @PLACE(92, -153) => @ORIENT("MY");
// %t109 @TEXT("qualified", key="name", size=0.75);
// &qualified @WIRE(mode="straight") {#XS:9 %t109:p};
// %t110 = $IO_PORT @ATTACH &restart => @PLACE(92, -157) => @ORIENT("MY");
// %t110 @TEXT("restart", key="name", size=0.75);
// &restart @WIRE(mode="straight") {#XS:10 %t110:p};
// %t111 = $IO_PORT @ATTACH &fault => @PLACE(92, -161) => @ORIENT("MY");
// %t111 @TEXT("fault", key="name", size=0.75);
// &fault @WIRE(mode="straight") {#XS:11 %t111:p};
// %t112 = $SUPPLY @ATTACH &vdd => @PLACE(75, -134);
// &vdd @WIRE(mode="straight") {#XS:12 %t112:p};
// %t113 = $GROUND @ATTACH &vss => @PLACE(75, -176);
// &vss @WIRE(mode="straight") {#XS:13 %t113:p};
// %t114 = $IO_PORT @ATTACH &refclk => @PLACE(109, -146) => @ORIENT("R0");
// %t114 @TEXT("refclk", key="name", size=0.75);
// &refclk @WIRE(mode="straight") {#XP:1 %t114:p};
// %t115 = $IO_PORT @ATTACH &enable => @PLACE(109, -150) => @ORIENT("R0");
// %t115 @TEXT("enable", key="name", size=0.75);
// &enable @WIRE(mode="straight") {#XP:2 %t115:p};
// %t116 = $IO_PORT @ATTACH &fll_reset => @PLACE(109, -154) => @ORIENT("R0");
// %t116 @TEXT("fll_reset", key="name", size=0.75);
// &fll_reset @WIRE(mode="straight") {#XP:3 %t116:p};
// %t117 = $IO_PORT @ATTACH &pulse => @PLACE(131, -150) => @ORIENT("MY");
// %t117 @TEXT("pulse", key="name", size=0.75);
// &pulse @WIRE(mode="straight") {#XP:4 %t117:p};
// %t118 = $SUPPLY @ATTACH &vdd => @PLACE(120, -137);
// &vdd @WIRE(mode="straight") {#XP:5 %t118:p};
// %t119 = $GROUND @ATTACH &vss => @PLACE(120, -163);
// &vss @WIRE(mode="straight") {#XP:6 %t119:p};
// %t120 = $IO_PORT @ATTACH &refclk => @PLACE(154, -81) => @ORIENT("R0");
// %t120 @TEXT("refclk", key="name", size=0.75);
// &refclk @WIRE(mode="straight") {#XW:1 %t120:p};
// %t121 = $IO_PORT @ATTACH &fll_reset => @PLACE(154, -85) => @ORIENT("R0");
// %t121 @TEXT("fll_reset", key="name", size=0.75);
// &fll_reset @WIRE(mode="straight") {#XW:2 %t121:p};
// %t122 = $IO_PORT @ATTACH &acquired => @PLACE(154, -89) => @ORIENT("R0");
// %t122 @TEXT("acquired", key="name", size=0.75);
// &acquired @WIRE(mode="straight") {#XW:3 %t122:p};
// %t123 = $IO_PORT @ATTACH &ak0 => @PLACE(154, -93) => @ORIENT("R0");
// %t123 @TEXT("ak0", key="name", size=0.75);
// &ak0 @WIRE(mode="straight") {#XW:4 %t123:p};
// %t124 = $IO_PORT @ATTACH &ak1 => @PLACE(154, -97) => @ORIENT("R0");
// %t124 @TEXT("ak1", key="name", size=0.75);
// &ak1 @WIRE(mode="straight") {#XW:5 %t124:p};
// %t125 = $IO_PORT @ATTACH &ak2 => @PLACE(154, -101) => @ORIENT("R0");
// %t125 @TEXT("ak2", key="name", size=0.75);
// &ak2 @WIRE(mode="straight") {#XW:6 %t125:p};
// %t126 = $IO_PORT @ATTACH &ak3 => @PLACE(154, -105) => @ORIENT("R0");
// %t126 @TEXT("ak3", key="name", size=0.75);
// &ak3 @WIRE(mode="straight") {#XW:7 %t126:p};
// %t127 = $IO_PORT @ATTACH &ak4 => @PLACE(154, -109) => @ORIENT("R0");
// %t127 @TEXT("ak4", key="name", size=0.75);
// &ak4 @WIRE(mode="straight") {#XW:8 %t127:p};
// %t128 = $IO_PORT @ATTACH &ak5 => @PLACE(154, -113) => @ORIENT("R0");
// %t128 @TEXT("ak5", key="name", size=0.75);
// &ak5 @WIRE(mode="straight") {#XW:9 %t128:p};
// %t129 = $IO_PORT @ATTACH &m0 => @PLACE(154, -117) => @ORIENT("R0");
// %t129 @TEXT("m0", key="name", size=0.75);
// &m0 @WIRE(mode="straight") {#XW:10 %t129:p};
// %t130 = $IO_PORT @ATTACH &m1 => @PLACE(154, -121) => @ORIENT("R0");
// %t130 @TEXT("m1", key="name", size=0.75);
// &m1 @WIRE(mode="straight") {#XW:11 %t130:p};
// %t131 = $IO_PORT @ATTACH &m2 => @PLACE(154, -125) => @ORIENT("R0");
// %t131 @TEXT("m2", key="name", size=0.75);
// &m2 @WIRE(mode="straight") {#XW:12 %t131:p};
// %t132 = $IO_PORT @ATTACH &m3 => @PLACE(154, -129) => @ORIENT("R0");
// %t132 @TEXT("m3", key="name", size=0.75);
// &m3 @WIRE(mode="straight") {#XW:13 %t132:p};
// %t133 = $IO_PORT @ATTACH &m4 => @PLACE(154, -133) => @ORIENT("R0");
// %t133 @TEXT("m4", key="name", size=0.75);
// &m4 @WIRE(mode="straight") {#XW:14 %t133:p};
// %t134 = $IO_PORT @ATTACH &m5 => @PLACE(154, -137) => @ORIENT("R0");
// %t134 @TEXT("m5", key="name", size=0.75);
// &m5 @WIRE(mode="straight") {#XW:15 %t134:p};
// %t135 = $IO_PORT @ATTACH &m6 => @PLACE(154, -141) => @ORIENT("R0");
// %t135 @TEXT("m6", key="name", size=0.75);
// &m6 @WIRE(mode="straight") {#XW:16 %t135:p};
// %t136 = $IO_PORT @ATTACH &m7 => @PLACE(154, -145) => @ORIENT("R0");
// %t136 @TEXT("m7", key="name", size=0.75);
// &m7 @WIRE(mode="straight") {#XW:17 %t136:p};
// %t137 = $IO_PORT @ATTACH &m8 => @PLACE(154, -149) => @ORIENT("R0");
// %t137 @TEXT("m8", key="name", size=0.75);
// &m8 @WIRE(mode="straight") {#XW:18 %t137:p};
// %t138 = $IO_PORT @ATTACH &m9 => @PLACE(154, -153) => @ORIENT("R0");
// %t138 @TEXT("m9", key="name", size=0.75);
// &m9 @WIRE(mode="straight") {#XW:19 %t138:p};
// %t139 = $IO_PORT @ATTACH &m10 => @PLACE(154, -157) => @ORIENT("R0");
// %t139 @TEXT("m10", key="name", size=0.75);
// &m10 @WIRE(mode="straight") {#XW:20 %t139:p};
// %t140 = $IO_PORT @ATTACH &m11 => @PLACE(154, -161) => @ORIENT("R0");
// %t140 @TEXT("m11", key="name", size=0.75);
// &m11 @WIRE(mode="straight") {#XW:21 %t140:p};
// %t141 = $IO_PORT @ATTACH &m12 => @PLACE(154, -165) => @ORIENT("R0");
// %t141 @TEXT("m12", key="name", size=0.75);
// &m12 @WIRE(mode="straight") {#XW:22 %t141:p};
// %t142 = $IO_PORT @ATTACH &m13 => @PLACE(154, -169) => @ORIENT("R0");
// %t142 @TEXT("m13", key="name", size=0.75);
// &m13 @WIRE(mode="straight") {#XW:23 %t142:p};
// %t143 = $IO_PORT @ATTACH &watch_gate => @PLACE(199, -119) => @ORIENT("MY");
// %t143 @TEXT("watch_gate", key="name", size=0.75);
// &watch_gate @WIRE(mode="straight") {#XW:24 %t143:p};
// %t144 = $IO_PORT @ATTACH &watch_reset => @PLACE(199, -123) => @ORIENT("MY");
// %t144 @TEXT("watch_reset", key="name", size=0.75);
// &watch_reset @WIRE(mode="straight") {#XW:25 %t144:p};
// %t145 = $IO_PORT @ATTACH &frequency_good => @PLACE(199, -127) => @ORIENT("MY");
// %t145 @TEXT("frequency_good", key="name", size=0.75);
// &frequency_good @WIRE(mode="straight") {#XW:26 %t145:p};
// %t146 = $IO_PORT @ATTACH &watchdog_valid => @PLACE(199, -131) => @ORIENT("MY");
// %t146 @TEXT("watchdog_valid", key="name", size=0.75);
// &watchdog_valid @WIRE(mode="straight") {#XW:27 %t146:p};
// %t147 = $SUPPLY @ATTACH &vdd => @PLACE(176, -72);
// &vdd @WIRE(mode="straight") {#XW:28 %t147:p};
// %t148 = $GROUND @ATTACH &vss => @PLACE(176, -178);
// &vss @WIRE(mode="straight") {#XW:29 %t148:p};
// %t149 = $IO_PORT @ATTACH &acquired => @PLACE(-11, -83) => @ORIENT("R0");
// %t149 @TEXT("acquired", key="name", size=0.75);
// &acquired @WIRE(mode="straight") {#XACQI:1 %t149:p};
// %t150 = $IO_PORT @ATTACH &acquired_b => @PLACE(11, -83) => @ORIENT("MY");
// %t150 @TEXT("acquired_b", key="name", size=0.75);
// &acquired_b @WIRE(mode="straight") {#XACQI:2 %t150:p};
// %t151 = $SUPPLY @ATTACH &vdd => @PLACE(0, -74);
// &vdd @WIRE(mode="straight") {#XACQI:3 %t151:p};
// %t152 = $GROUND @ATTACH &vss => @PLACE(0, -92);
// &vss @WIRE(mode="straight") {#XACQI:4 %t152:p};
// %t153 = $IO_PORT @ATTACH &acqclk => @PLACE(24, -79) => @ORIENT("R0");
// %t153 @TEXT("acqclk", key="name", size=0.75);
// &acqclk @WIRE(mode="straight") {#XACQ0:1 %t153:p};
// %t154 = $IO_PORT @ATTACH &clock_mux => @PLACE(46, -83) => @ORIENT("MY");
// %t154 @TEXT("clock_mux", key="name", size=0.75);
// &clock_mux @WIRE(mode="straight") {#XACQ0:2 %t154:p};
// %t155 = $IO_PORT @ATTACH &acquired_b => @PLACE(24, -83) => @ORIENT("R0");
// %t155 @TEXT("acquired_b", key="name", size=0.75);
// &acquired_b @WIRE(mode="straight") {#XACQ0:3 %t155:p};
// %t156 = $IO_PORT @ATTACH &acquired => @PLACE(24, -87) => @ORIENT("R0");
// %t156 @TEXT("acquired", key="name", size=0.75);
// &acquired @WIRE(mode="straight") {#XACQ0:4 %t156:p};
// %t157 = $SUPPLY @ATTACH &vdd => @PLACE(35, -70);
// &vdd @WIRE(mode="straight") {#XACQ0:5 %t157:p};
// %t158 = $GROUND @ATTACH &vss => @PLACE(35, -96);
// &vss @WIRE(mode="straight") {#XACQ0:6 %t158:p};
// %t159 = $IO_PORT @ATTACH &outclk => @PLACE(24, -113) => @ORIENT("R0");
// %t159 @TEXT("outclk", key="name", size=0.75);
// &outclk @WIRE(mode="straight") {#XACQ1:1 %t159:p};
// %t160 = $IO_PORT @ATTACH &clock_mux => @PLACE(46, -117) => @ORIENT("MY");
// %t160 @TEXT("clock_mux", key="name", size=0.75);
// &clock_mux @WIRE(mode="straight") {#XACQ1:2 %t160:p};
// %t161 = $IO_PORT @ATTACH &acquired => @PLACE(24, -117) => @ORIENT("R0");
// %t161 @TEXT("acquired", key="name", size=0.75);
// &acquired @WIRE(mode="straight") {#XACQ1:3 %t161:p};
// %t162 = $IO_PORT @ATTACH &acquired_b => @PLACE(24, -121) => @ORIENT("R0");
// %t162 @TEXT("acquired_b", key="name", size=0.75);
// &acquired_b @WIRE(mode="straight") {#XACQ1:4 %t162:p};
// %t163 = $SUPPLY @ATTACH &vdd => @PLACE(35, -104);
// &vdd @WIRE(mode="straight") {#XACQ1:5 %t163:p};
// %t164 = $GROUND @ATTACH &vss => @PLACE(35, -130);
// &vss @WIRE(mode="straight") {#XACQ1:6 %t164:p};
// %t165 = $IO_PORT @ATTACH &clock_mux => @PLACE(59, -83) => @ORIENT("R0");
// %t165 @TEXT("clock_mux", key="name", size=0.75);
// &clock_mux @WIRE(mode="straight") {#XACB0:1 %t165:p};
// %t166 = $SUPPLY @ATTACH &vdd => @PLACE(70, -74);
// &vdd @WIRE(mode="straight") {#XACB0:3 %t166:p};
// %t167 = $GROUND @ATTACH &vss => @PLACE(70, -92);
// &vss @WIRE(mode="straight") {#XACB0:4 %t167:p};
// %t168 = $SUPPLY @ATTACH &vdd => @PLACE(100, -74);
// &vdd @WIRE(mode="straight") {#XACB1:3 %t168:p};
// %t169 = $GROUND @ATTACH &vss => @PLACE(100, -92);
// &vss @WIRE(mode="straight") {#XACB1:4 %t169:p};
// %t170 = $IO_PORT @ATTACH &refclk => @PLACE(-11, -155) => @ORIENT("R0");
// %t170 @TEXT("refclk", key="name", size=0.75);
// &refclk @WIRE(mode="straight") {#XPHCLK:1 %t170:p};
// %t171 = $SUPPLY @ATTACH &vdd => @PLACE(0, -146);
// &vdd @WIRE(mode="straight") {#XPHCLK:3 %t171:p};
// %t172 = $GROUND @ATTACH &vss => @PLACE(0, -164);
// &vss @WIRE(mode="straight") {#XPHCLK:4 %t172:p};
// %t173 = $IO_PORT @ATTACH &phase_good => @PLACE(24, -151) => @ORIENT("R0");
// %t173 @TEXT("phase_good", key="name", size=0.75);
// &phase_good @WIRE(mode="straight") {#XPH:1 %t173:p};
// %t174 = $IO_PORT @ATTACH &reset => @PLACE(24, -159) => @ORIENT("R0");
// %t174 @TEXT("reset", key="name", size=0.75);
// &reset @WIRE(mode="straight") {#XPH:3 %t174:p};
// %t175 = $IO_PORT @ATTACH &phase_held => @PLACE(46, -155) => @ORIENT("MY");
// %t175 @TEXT("phase_held", key="name", size=0.75);
// &phase_held @WIRE(mode="straight") {#XPH:4 %t175:p};
// %t176 = $SUPPLY @ATTACH &vdd => @PLACE(35, -142);
// &vdd @WIRE(mode="straight") {#XPH:5 %t176:p};
// %t177 = $GROUND @ATTACH &vss => @PLACE(35, -168);
// &vss @WIRE(mode="straight") {#XPH:6 %t177:p};
// %t178 = $IO_PORT @ATTACH &fll_gate => @PLACE(124, -196) => @ORIENT("R0");
// %t178 @TEXT("fll_gate", key="name", size=0.75);
// &fll_gate @WIRE(mode="straight") {#XWG:1 %t178:p};
// %t179 = $IO_PORT @ATTACH &watch_gate => @PLACE(124, -200) => @ORIENT("R0");
// %t179 @TEXT("watch_gate", key="name", size=0.75);
// &watch_gate @WIRE(mode="straight") {#XWG:2 %t179:p};
// %t180 = $IO_PORT @ATTACH &acquired => @PLACE(124, -204) => @ORIENT("R0");
// %t180 @TEXT("acquired", key="name", size=0.75);
// &acquired @WIRE(mode="straight") {#XWG:3 %t180:p};
// %t181 = $IO_PORT @ATTACH &count_gate => @PLACE(146, -200) => @ORIENT("MY");
// %t181 @TEXT("count_gate", key="name", size=0.75);
// &count_gate @WIRE(mode="straight") {#XWG:4 %t181:p};
// %t182 = $SUPPLY @ATTACH &vdd => @PLACE(135, -187);
// &vdd @WIRE(mode="straight") {#XWG:5 %t182:p};
// %t183 = $GROUND @ATTACH &vss => @PLACE(135, -213);
// &vss @WIRE(mode="straight") {#XWG:6 %t183:p};
// %t184 = $IO_PORT @ATTACH &fll_count_reset => @PLACE(165, -196) => @ORIENT("R0");
// %t184 @TEXT("fll_count_reset", key="name", size=0.75);
// &fll_count_reset @WIRE(mode="straight") {#XWR:1 %t184:p};
// %t185 = $IO_PORT @ATTACH &watch_reset => @PLACE(165, -200) => @ORIENT("R0");
// %t185 @TEXT("watch_reset", key="name", size=0.75);
// &watch_reset @WIRE(mode="straight") {#XWR:2 %t185:p};
// %t186 = $IO_PORT @ATTACH &acquired => @PLACE(165, -204) => @ORIENT("R0");
// %t186 @TEXT("acquired", key="name", size=0.75);
// &acquired @WIRE(mode="straight") {#XWR:3 %t186:p};
// %t187 = $IO_PORT @ATTACH &count_reset => @PLACE(187, -200) => @ORIENT("MY");
// %t187 @TEXT("count_reset", key="name", size=0.75);
// &count_reset @WIRE(mode="straight") {#XWR:4 %t187:p};
// %t188 = $SUPPLY @ATTACH &vdd => @PLACE(176, -187);
// &vdd @WIRE(mode="straight") {#XWR:5 %t188:p};
// %t189 = $GROUND @ATTACH &vss => @PLACE(176, -213);
// &vss @WIRE(mode="straight") {#XWR:6 %t189:p};
// (-28, 85) @TEXT("56  PLL control | 19 instances", size=1.2, halign="start");
// }
ends pll_control_recenter109_v14_pdk110_56
