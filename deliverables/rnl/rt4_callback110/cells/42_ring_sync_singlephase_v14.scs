// Ring stage | frozen callback110 / recenter109 | RNL 0.3
// @RNL(type="header") { @VERSION("0.3"); @USE-PACKAGE(name="rnl-std-fill") {} }
simulator lang=spectre
subckt ring_sync_singlephase_v14_pdk110_42 (d clk clkb load loadb init q vdd vss)
XDATA (d din loadb load vdd vss) pll_tg_pdk110_43
XINIT (init din load loadb vdd vss) pll_tg_pdk110_43
XF (din clk clkb q vdd vss) ff_singlephase_v14_pdk110_44
// @RNL(author="functional-compact127") {
// $CELL = @DEFINE-SYMBOL {
// @LINE {(-12, -14) (12, -14) (12, 14) (-12, 14) (-12, -14)};
// (-2, 1) @TEXT("D", size=1.15, halign="middle");
// (2, 1) @TEXT("Q", size=1.15, halign="middle");
// @LINE {(-2, -1) (2, -1)};
// @LINE {(0.946901, -0.424689) (2, -1) (0.946901, -1.57531)};
// (0, -3) @TEXT("FF", size=0.8, halign="middle");
// @LINE {(-12, 7) (-10.5, 6) (-12, 5)};
// (-14, 10) @PIN(terminal="d", direction="left");
// @LINE {(-14, 10) (-12, 10)};
// (-11.4, 10) @TEXT("d", size=0.7, halign="start");
// (-14, 6) @PIN(terminal="clk", direction="left");
// @LINE {(-14, 6) (-12, 6)};
// (-11.4, 6) @TEXT("clk", size=0.7, halign="start");
// (-14, 2) @PIN(terminal="clkb", direction="left");
// @LINE {(-14, 2) (-12, 2)};
// (-11.4, 2) @TEXT("clkb", size=0.7, halign="start");
// (-14, -2) @PIN(terminal="load", direction="left");
// @LINE {(-14, -2) (-12, -2)};
// (-11.4, -2) @TEXT("load", size=0.7, halign="start");
// (-14, -6) @PIN(terminal="loadb", direction="left");
// @LINE {(-14, -6) (-12, -6)};
// (-11.4, -6) @TEXT("loadb", size=0.7, halign="start");
// (-14, -10) @PIN(terminal="init", direction="left");
// @LINE {(-14, -10) (-12, -10)};
// (-11.4, -10) @TEXT("init", size=0.7, halign="start");
// (14, 0) @PIN(terminal="q", direction="right");
// @LINE {(14, 0) (12, 0)};
// (11.4, 0) @TEXT("q", size=0.7, halign="end");
// (0, 16) @PIN(terminal="vdd", direction="up");
// @LINE {(0, 16) (0, 14)};
// (0, -16) @PIN(terminal="vss", direction="down");
// @LINE {(0, -16) (0, -14)};
// ? @TEXT("${name}", key="name", size=1, halign="middle") => @PLACE(14, 17.5);
// (0, 13.1) @TEXT("Ring stage", size=0.85, halign="middle");
// };
// # @SET-SYMBOL $CELL;
// #XDATA @PLACE(0, 15) => @ORIENT("R0");
// #XINIT @PLACE(0, -20) => @ORIENT("R0");
// #XF @PLACE(32, 0) => @ORIENT("R0");
// &din @WIRE(mode="straight") {#XDATA:2 (18, 15) (18, 4) #XF:1};
// &din @WIRE(mode="straight") {#XINIT:2 (18, -20) (18, 4) #XF:1};
// %t1 = $IO_PORT @ATTACH &d => @PLACE(-11, 19) => @ORIENT("R0");
// %t1 @TEXT("d", key="name", size=0.75);
// &d @WIRE(mode="straight") {#XDATA:1 %t1:p};
// %t2 = $IO_PORT @ATTACH &loadb => @PLACE(-11, 15) => @ORIENT("R0");
// %t2 @TEXT("loadb", key="name", size=0.75);
// &loadb @WIRE(mode="straight") {#XDATA:3 %t2:p};
// %t3 = $IO_PORT @ATTACH &load => @PLACE(-11, 11) => @ORIENT("R0");
// %t3 @TEXT("load", key="name", size=0.75);
// &load @WIRE(mode="straight") {#XDATA:4 %t3:p};
// %t4 = $SUPPLY @ATTACH &vdd => @PLACE(0, 28);
// &vdd @WIRE(mode="straight") {#XDATA:5 %t4:p};
// %t5 = $GROUND @ATTACH &vss => @PLACE(0, 2);
// &vss @WIRE(mode="straight") {#XDATA:6 %t5:p};
// %t6 = $IO_PORT @ATTACH &init => @PLACE(-11, -16) => @ORIENT("R0");
// %t6 @TEXT("init", key="name", size=0.75);
// &init @WIRE(mode="straight") {#XINIT:1 %t6:p};
// %t7 = $IO_PORT @ATTACH &load => @PLACE(-11, -20) => @ORIENT("R0");
// %t7 @TEXT("load", key="name", size=0.75);
// &load @WIRE(mode="straight") {#XINIT:3 %t7:p};
// %t8 = $IO_PORT @ATTACH &loadb => @PLACE(-11, -24) => @ORIENT("R0");
// %t8 @TEXT("loadb", key="name", size=0.75);
// &loadb @WIRE(mode="straight") {#XINIT:4 %t8:p};
// %t9 = $SUPPLY @ATTACH &vdd => @PLACE(0, -7);
// &vdd @WIRE(mode="straight") {#XINIT:5 %t9:p};
// %t10 = $GROUND @ATTACH &vss => @PLACE(0, -33);
// &vss @WIRE(mode="straight") {#XINIT:6 %t10:p};
// %t11 = $IO_PORT @ATTACH &clk => @PLACE(22, 0) => @ORIENT("R0");
// %t11 @TEXT("clk", key="name", size=0.75);
// &clk @WIRE(mode="straight") {#XF:2 %t11:p};
// %t12 = $IO_PORT @ATTACH &clkb => @PLACE(22, -4) => @ORIENT("R0");
// %t12 @TEXT("clkb", key="name", size=0.75);
// &clkb @WIRE(mode="straight") {#XF:3 %t12:p};
// %t13 = $IO_PORT @ATTACH &q => @PLACE(43, 0) => @ORIENT("MY");
// %t13 @TEXT("q", key="name", size=0.75);
// &q @WIRE(mode="straight") {#XF:4 %t13:p};
// %t14 = $SUPPLY @ATTACH &vdd => @PLACE(32, 13);
// &vdd @WIRE(mode="straight") {#XF:5 %t14:p};
// %t15 = $GROUND @ATTACH &vss => @PLACE(32, -13);
// &vss @WIRE(mode="straight") {#XF:6 %t15:p};
// (-16, 47) @TEXT("42  Ring stage | 3 instances", size=1.2, halign="start");
// }
ends ring_sync_singlephase_v14_pdk110_42
