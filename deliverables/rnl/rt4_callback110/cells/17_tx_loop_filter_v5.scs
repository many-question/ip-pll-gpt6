// Loop filter | frozen callback110 / recenter109 | RNL 0.3
// @RNL(type="header") { @VERSION("0.3"); @USE-PACKAGE(name="rnl-std-fill") {} }
simulator lang=spectre
subckt tx_loop_filter_v5_pdk110_17 (ctrl vc1 enable preset vdd vss)
R (ctrl vc1) resistor r=100000
C1 (vc1 vss) capacitor c=7.1619724391353e-12
C2 (ctrl vss) capacitor c=4.77464829275685e-13
XI (enable enb vdd vss) pll_inv_pdk110_7
XP0 (preset ctrl enb enable vdd vss) pll_tg_pdk110_18
XP1 (preset vc1 enb enable vdd vss) pll_tg_pdk110_18
// @RNL(author="functional-compact127") {
// $CELL = @DEFINE-SYMBOL {
// @LINE {(-6, -6) (6, -6) (6, 6) (-6, 6) (-6, -6)};
// @LINE {(-4, 2) (-2, 2) (-1, 3) (0, 1) (1, 3) (2, 2) (4, 2) (4, 0)};
// @LINE {(4, 0) (4, -1.5)};
// @LINE {(2.5, -1.5) (5.5, -1.5)};
// @LINE {(2.5, -2.5) (5.5, -2.5)};
// @LINE {(4, -2.5) (4, -4)};
// (-2, -2) @TEXT("R-C", size=1, halign="middle");
// (-8, 2) @PIN(terminal="enable", direction="left");
// @LINE {(-8, 2) (-6, 2)};
// (-5.4, 2) @TEXT("enable", size=0.7, halign="start");
// (-8, -2) @PIN(terminal="preset", direction="left");
// @LINE {(-8, -2) (-6, -2)};
// (-5.4, -2) @TEXT("preset", size=0.7, halign="start");
// (8, 2) @PIN(terminal="ctrl", direction="right");
// @LINE {(8, 2) (6, 2)};
// (5.4, 2) @TEXT("ctrl", size=0.7, halign="end");
// (8, -2) @PIN(terminal="vc1", direction="right");
// @LINE {(8, -2) (6, -2)};
// (5.4, -2) @TEXT("vc1", size=0.7, halign="end");
// (0, 8) @PIN(terminal="vdd", direction="up");
// @LINE {(0, 8) (0, 6)};
// (0, -8) @PIN(terminal="vss", direction="down");
// @LINE {(0, -8) (0, -6)};
// ? @TEXT("${name}", key="name", size=1, halign="middle") => @PLACE(8, 9.5);
// (0, 5.1) @TEXT("Loop filter", size=0.85, halign="middle");
// };
// # @SET-SYMBOL $CELL;
// #R @PLACE(-16, 10) => @ORIENT("R90");
// #R @SET-SYMBOL $RESISTOR;
// #R @TEXT("100k", key="value", dx=3, dy=-1, size=0.8, halign="start");
// #R @TEXT("R", key="name", dx=3, dy=1, size=0.9, halign="start");
// #C1 @PLACE(4, -6) => @ORIENT("R0");
// #C1 @SET-SYMBOL $CAPACITOR;
// #C1 @TEXT("7.162p", key="value", dx=3, dy=-1, size=0.8, halign="start");
// #C1 @TEXT("C1", key="name", dx=3, dy=1, size=0.9, halign="start");
// #C2 @PLACE(-37, -6) => @ORIENT("R0");
// #C2 @SET-SYMBOL $CAPACITOR;
// #C2 @TEXT("477.46f", key="value", dx=3, dy=-1, size=0.8, halign="start");
// #C2 @TEXT("C2", key="name", dx=3, dy=1, size=0.9, halign="start");
// #XI @PLACE(-65, -25) => @ORIENT("R0");
// #XP0 @PLACE(-37, -40) => @ORIENT("R0");
// #XP1 @PLACE(4, -40) => @ORIENT("R0");
// %t1 = $IO_PORT @ATTACH &ctrl => @PLACE(-21, 10) => @ORIENT("R0");
// %t1 @TEXT("ctrl", key="name", size=0.75);
// &ctrl @WIRE(mode="straight") {#R:1 %t1:p};
// %t2 = $IO_PORT @ATTACH &vc1 => @PLACE(-11, 10) => @ORIENT("MY");
// %t2 @TEXT("vc1", key="name", size=0.75);
// &vc1 @WIRE(mode="straight") {#R:2 %t2:p};
// %t3 = $IO_PORT @ATTACH &vc1 => @PLACE(0, -1) => @ORIENT("R0");
// %t3 @TEXT("vc1", key="name", size=0.75);
// &vc1 @WIRE(mode="straight") {#C1:1 (4, -1) %t3:p};
// %t4 = $GROUND @ATTACH &vss => @PLACE(4, -11);
// &vss @WIRE(mode="straight") {#C1:2 %t4:p};
// %t5 = $IO_PORT @ATTACH &ctrl => @PLACE(-41, -1) => @ORIENT("R0");
// %t5 @TEXT("ctrl", key="name", size=0.75);
// &ctrl @WIRE(mode="straight") {#C2:1 (-37, -1) %t5:p};
// %t6 = $GROUND @ATTACH &vss => @PLACE(-37, -11);
// &vss @WIRE(mode="straight") {#C2:2 %t6:p};
// %t7 = $IO_PORT @ATTACH &enable => @PLACE(-76, -25) => @ORIENT("R0");
// %t7 @TEXT("enable", key="name", size=0.75);
// &enable @WIRE(mode="straight") {#XI:1 %t7:p};
// %t8 = $IO_PORT @ATTACH &enb => @PLACE(-55, -25) => @ORIENT("MY");
// %t8 @TEXT("enb", key="name", size=0.75);
// &enb @WIRE(mode="straight") {#XI:2 %t8:p};
// %t9 = $SUPPLY @ATTACH &vdd => @PLACE(-65, -16);
// &vdd @WIRE(mode="straight") {#XI:3 %t9:p};
// %t10 = $GROUND @ATTACH &vss => @PLACE(-65, -34);
// &vss @WIRE(mode="straight") {#XI:4 %t10:p};
// %t11 = $IO_PORT @ATTACH &preset => @PLACE(-47, -36) => @ORIENT("R0");
// %t11 @TEXT("preset", key="name", size=0.75);
// &preset @WIRE(mode="straight") {#XP0:1 %t11:p};
// %t12 = $IO_PORT @ATTACH &ctrl => @PLACE(-26, -40) => @ORIENT("MY");
// %t12 @TEXT("ctrl", key="name", size=0.75);
// &ctrl @WIRE(mode="straight") {#XP0:2 %t12:p};
// %t13 = $IO_PORT @ATTACH &enb => @PLACE(-47, -40) => @ORIENT("R0");
// %t13 @TEXT("enb", key="name", size=0.75);
// &enb @WIRE(mode="straight") {#XP0:3 %t13:p};
// %t14 = $IO_PORT @ATTACH &enable => @PLACE(-47, -44) => @ORIENT("R0");
// %t14 @TEXT("enable", key="name", size=0.75);
// &enable @WIRE(mode="straight") {#XP0:4 %t14:p};
// %t15 = $SUPPLY @ATTACH &vdd => @PLACE(-37, -27);
// &vdd @WIRE(mode="straight") {#XP0:5 %t15:p};
// %t16 = $GROUND @ATTACH &vss => @PLACE(-37, -53);
// &vss @WIRE(mode="straight") {#XP0:6 %t16:p};
// %t17 = $IO_PORT @ATTACH &preset => @PLACE(-6, -36) => @ORIENT("R0");
// %t17 @TEXT("preset", key="name", size=0.75);
// &preset @WIRE(mode="straight") {#XP1:1 %t17:p};
// %t18 = $IO_PORT @ATTACH &vc1 => @PLACE(15, -40) => @ORIENT("MY");
// %t18 @TEXT("vc1", key="name", size=0.75);
// &vc1 @WIRE(mode="straight") {#XP1:2 %t18:p};
// %t19 = $IO_PORT @ATTACH &enb => @PLACE(-6, -40) => @ORIENT("R0");
// %t19 @TEXT("enb", key="name", size=0.75);
// &enb @WIRE(mode="straight") {#XP1:3 %t19:p};
// %t20 = $IO_PORT @ATTACH &enable => @PLACE(-6, -44) => @ORIENT("R0");
// %t20 @TEXT("enable", key="name", size=0.75);
// &enable @WIRE(mode="straight") {#XP1:4 %t20:p};
// %t21 = $SUPPLY @ATTACH &vdd => @PLACE(4, -27);
// &vdd @WIRE(mode="straight") {#XP1:5 %t21:p};
// %t22 = $GROUND @ATTACH &vss => @PLACE(4, -53);
// &vss @WIRE(mode="straight") {#XP1:6 %t22:p};
// (-81, 32) @TEXT("17  Loop filter | 6 instances", size=1.2, halign="start");
// }
ends tx_loop_filter_v5_pdk110_17
