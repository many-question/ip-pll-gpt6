// Divider bank | frozen callback110 / recenter109 | RNL 0.3
// @RNL(type="header") { @VERSION("0.3"); @USE-PACKAGE(name="rnl-std-fill") {} }
simulator lang=spectre
subckt bank_pulsetrip_v14_pdk110_21 (clk reset s0 s1 s2 s3 s4 s5 q1 out fllclk vdd vss)
XPRE (q0 clk q0 vdd vss) ff_fbdelay50_v14_pdk110_22
XPB0 (q0 qb0 vdd vss) pll_inv_pdk110_23
XPB1 (qb0 q1 vdd vss) pll_inv_pdk110_24
XD4 (d4b q1 d4b vdd vss) pll_tspc_inv_pdk110_25
XB40 (d4b b40 vdd vss) pll_inv_pdk110_26
XB41 (b40 b41 vdd vss) pll_inv_pdk110_27
XB42 (b41 d4 vdd vss) pll_inv_pdk110_28
XFAC0 (d4 fab vdd vss) pll_inv_pdk110_29
XFAC1 (fab fllclk vdd vss) pll_inv_pdk110_27
XD8 (d8b d4 d8b vdd vss) pll_tspc_inv_pdk110_25
XB8 (d8b d8 vdd vss) pll_inv_pdk110_27
XD12 (d4 d12 vdd vss) div3_fast_v14_pdk110_30
XCT0 (q1 ct0 vdd vss) pll_inv_pdk110_36
XCT1 (ct0 ct1 vdd vss) pll_inv_pdk110_37
XCT2 (ct1 cb vdd vss) pll_inv_pdk110_38
XCT3 (cb ck vdd vss) pll_inv_pdk110_39
XD6 (ck d6 vdd vss) div3_fast_v14_pdk110_30
XRL (reset ck loadb vdd vss) pll_tspc_inv_pdk110_25
XRLI (loadb load vdd vss) pll_inv_pdk110_40
XRK (load loadb vdd vss) pll_inv_pdk110_41
XF0 (fb ck ck load loadb vdd r0 vdd vss) ring_sync_singlephase_v14_pdk110_42
XF1 (r0 ck ck load loadb vdd r1 vdd vss) ring_sync_singlephase_v14_pdk110_42
XF2 (r1 ck ck load loadb vdd r2 vdd vss) ring_sync_singlephase_v14_pdk110_42
XF3 (r2 ck ck load loadb s5 r3 vdd vss) ring_sync_singlephase_v14_pdk110_42
XF4 (r3 ck ck load loadb vss r4 vdd vss) ring_sync_singlephase_v14_pdk110_42
XF5 (r4 ck ck load loadb vss s5 r5 vdd vss) ring_tail_singlephase_v14_pdk110_46
XF6 (r5 ck ck load loadb vss s5 r6 vdd vss) ring_tail_singlephase_v14_pdk110_46
XSI3 (s3 sb3 vdd vss) pll_inv_pdk110_7
XSI5 (s5 sb5 vdd vss) pll_inv_pdk110_7
XT5 (r4 fb s3 sb3 vdd vss) pll_tg_pdk110_43
XT7 (r6 fb s5 sb5 vdd vss) pll_tg_pdk110_43
RFB (fb vss) resistor r=10000000
XRI (reset resetb vdd vss) pll_inv_pdk110_7
XSEB0 (s0 resetb eb0 vdd vss) pll_nand2_pdk110_15
XSE0 (eb0 es0 vdd vss) pll_inv_pdk110_7
XMX0 (d4 mux es0 eb0 vdd vss) pll_tg_pdk110_16
XSEB1 (s1 resetb eb1 vdd vss) pll_nand2_pdk110_15
XSE1 (eb1 es1 vdd vss) pll_inv_pdk110_7
XMX1 (d6 mux es1 eb1 vdd vss) pll_tg_pdk110_16
XSEB2 (s2 resetb eb2 vdd vss) pll_nand2_pdk110_15
XSE2 (eb2 es2 vdd vss) pll_inv_pdk110_7
XMX2 (d8 mux es2 eb2 vdd vss) pll_tg_pdk110_16
XSEB3 (s3 resetb eb3 vdd vss) pll_nand2_pdk110_15
XSE3 (eb3 es3 vdd vss) pll_inv_pdk110_7
XMX3 (r0 mux es3 eb3 vdd vss) pll_tg_pdk110_16
XSEB4 (s4 resetb eb4 vdd vss) pll_nand2_pdk110_15
XSE4 (eb4 es4 vdd vss) pll_inv_pdk110_7
XMX4 (d12 mux es4 eb4 vdd vss) pll_tg_pdk110_16
XSEB5 (s5 resetb eb5 vdd vss) pll_nand2_pdk110_15
XSE5 (eb5 es5 vdd vss) pll_inv_pdk110_7
XMX5 (r0 mux es5 eb5 vdd vss) pll_tg_pdk110_16
MMUTE (mux reset vss vss) nch w=2e-06 l=1.8e-07 ad=9.599999999999999e-13 as=9.599999999999999e-13 pd=4.96e-06 ps=4.96e-06 nrd=0.135 nrs=0.135 sa=4.8e-07 sb=4.8e-07 sd=5.4e-07 sca=0 scb=0 scc=0
RKEEP (mux vss) resistor r=10000000
XO0 (mux ob vdd vss) pll_inv_pdk110_36
XO1 (ob out vdd vss) pll_inv_pdk110_27
// @RNL(author="manual-schematic126") {
// $CELL = @DEFINE-SYMBOL {
// @LINE {(-12, 18) (12, 18) (12, -18) (-12, -18) (-12, 18)};
// (-14, 14) @PIN(terminal="clk", direction="left");
// @LINE {(-14, 14) (-12, 14)};
// (-11.4, 14) @TEXT("clk", size=0.7, halign="start");
// (-14, 10) @PIN(terminal="reset", direction="left");
// @LINE {(-14, 10) (-12, 10)};
// (-11.4, 10) @TEXT("reset", size=0.7, halign="start");
// (-14, 6) @PIN(terminal="s0", direction="left");
// @LINE {(-14, 6) (-12, 6)};
// (-11.4, 6) @TEXT("s0", size=0.7, halign="start");
// (-14, 2) @PIN(terminal="s1", direction="left");
// @LINE {(-14, 2) (-12, 2)};
// (-11.4, 2) @TEXT("s1", size=0.7, halign="start");
// (-14, -2) @PIN(terminal="s2", direction="left");
// @LINE {(-14, -2) (-12, -2)};
// (-11.4, -2) @TEXT("s2", size=0.7, halign="start");
// (-14, -6) @PIN(terminal="s3", direction="left");
// @LINE {(-14, -6) (-12, -6)};
// (-11.4, -6) @TEXT("s3", size=0.7, halign="start");
// (-14, -10) @PIN(terminal="s4", direction="left");
// @LINE {(-14, -10) (-12, -10)};
// (-11.4, -10) @TEXT("s4", size=0.7, halign="start");
// (-14, -14) @PIN(terminal="s5", direction="left");
// @LINE {(-14, -14) (-12, -14)};
// (-11.4, -14) @TEXT("s5", size=0.7, halign="start");
// (14, 4) @PIN(terminal="q1", direction="right");
// @LINE {(14, 4) (12, 4)};
// (11.4, 4) @TEXT("q1", size=0.7, halign="end");
// (14, 0) @PIN(terminal="out", direction="right");
// @LINE {(14, 0) (12, 0)};
// (11.4, 0) @TEXT("out", size=0.7, halign="end");
// (14, -4) @PIN(terminal="fllclk", direction="right");
// @LINE {(14, -4) (12, -4)};
// (11.4, -4) @TEXT("fllclk", size=0.7, halign="end");
// (0, 20) @PIN(terminal="vdd", direction="up");
// @LINE {(0, 20) (0, 18)};
// (0, -20) @PIN(terminal="vss", direction="down");
// @LINE {(0, -20) (0, -18)};
// ? @TEXT("${name}", key="name", size=1, halign="middle") => @PLACE(14, 21.5);
// (0, 17.1) @TEXT("Divider bank", size=0.85, halign="middle");
// };
// # @SET-SYMBOL $CELL;
// #XPRE @PLACE(0, 60) => @ORIENT("R0");
// #XPB0 @PLACE(40, 60) => @ORIENT("R0");
// #XPB1 @PLACE(80, 60) => @ORIENT("R0");
// #XD4 @PLACE(120, 60) => @ORIENT("R0");
// #XB40 @PLACE(160, 60) => @ORIENT("R0");
// #XB41 @PLACE(200, 60) => @ORIENT("R0");
// #XB42 @PLACE(240, 60) => @ORIENT("R0");
// #XFAC0 @PLACE(280, 60) => @ORIENT("R0");
// #XFAC1 @PLACE(320, 60) => @ORIENT("R0");
// #XD8 @PLACE(120, 5) => @ORIENT("R0");
// #XB8 @PLACE(160, 5) => @ORIENT("R0");
// #XD12 @PLACE(240, 5) => @ORIENT("R0");
// #XCT0 @PLACE(0, -50) => @ORIENT("R0");
// #XCT1 @PLACE(40, -50) => @ORIENT("R0");
// #XCT2 @PLACE(80, -50) => @ORIENT("R0");
// #XCT3 @PLACE(120, -50) => @ORIENT("R0");
// #XD6 @PLACE(160, -50) => @ORIENT("R0");
// #XRL @PLACE(0, -110) => @ORIENT("R0");
// #XRLI @PLACE(40, -110) => @ORIENT("R0");
// #XRK @PLACE(80, -110) => @ORIENT("R0");
// #XF0 @PLACE(0, -180) => @ORIENT("R0");
// #XF1 @PLACE(40, -180) => @ORIENT("R0");
// #XF2 @PLACE(80, -180) => @ORIENT("R0");
// #XF3 @PLACE(120, -180) => @ORIENT("R0");
// #XF4 @PLACE(160, -180) => @ORIENT("R0");
// #XF5 @PLACE(200, -180) => @ORIENT("R0");
// #XF6 @PLACE(240, -180) => @ORIENT("R0");
// #XSI3 @PLACE(0, -250) => @ORIENT("R0");
// #XSI5 @PLACE(40, -250) => @ORIENT("R0");
// #XT5 @PLACE(100, -250) => @ORIENT("R0");
// #XT7 @PLACE(150, -250) => @ORIENT("R0");
// #RFB @PLACE(200, -250) => @ORIENT("R0");
// #RFB @SET-SYMBOL $RESISTOR;
// #RFB @TEXT("10M", key="value", dx=3, dy=-1, size=0.8, halign="start");
// #RFB @TEXT("RFB", key="name", dx=3, dy=1, size=0.9, halign="start");
// #XRI @PLACE(0, -315) => @ORIENT("R0");
// #XSEB0 @PLACE(0, -365) => @ORIENT("R0");
// #XSEB1 @PLACE(65, -365) => @ORIENT("R0");
// #XSEB2 @PLACE(130, -365) => @ORIENT("R0");
// #XSEB3 @PLACE(195, -365) => @ORIENT("R0");
// #XSEB4 @PLACE(260, -365) => @ORIENT("R0");
// #XSEB5 @PLACE(325, -365) => @ORIENT("R0");
// #XSE0 @PLACE(0, -405) => @ORIENT("R0");
// #XSE1 @PLACE(65, -405) => @ORIENT("R0");
// #XSE2 @PLACE(130, -405) => @ORIENT("R0");
// #XSE3 @PLACE(195, -405) => @ORIENT("R0");
// #XSE4 @PLACE(260, -405) => @ORIENT("R0");
// #XSE5 @PLACE(325, -405) => @ORIENT("R0");
// #XMX0 @PLACE(0, -450) => @ORIENT("R0");
// #XMX1 @PLACE(65, -450) => @ORIENT("R0");
// #XMX2 @PLACE(130, -450) => @ORIENT("R0");
// #XMX3 @PLACE(195, -450) => @ORIENT("R0");
// #XMX4 @PLACE(260, -450) => @ORIENT("R0");
// #XMX5 @PLACE(325, -450) => @ORIENT("R0");
// #MMUTE @PLACE(0, -540) => @ORIENT("R0");
// #MMUTE @SET-SYMBOL $NMOS_4TERM;
// #MMUTE @TEXT("MMUTE", key="name", dx=5, dy=1.5, size=0.9, halign="start");
// #MMUTE @TEXT("2u / 180n", key="model", dx=5, dy=-1.5, size=0.75, halign="start");
// #RKEEP @PLACE(52, -540) => @ORIENT("R0");
// #RKEEP @SET-SYMBOL $RESISTOR;
// #RKEEP @TEXT("10M", key="value", dx=3, dy=-1, size=0.8, halign="start");
// #RKEEP @TEXT("RKEEP", key="name", dx=3, dy=1, size=0.9, halign="start");
// #XO0 @PLACE(104, -540) => @ORIENT("R0");
// #XO1 @PLACE(156, -540) => @ORIENT("R0");
// %t1 = $IO_PORT @ATTACH &q0 => @PLACE(-11, 62) => @ORIENT("R0");
// %t1 @TEXT("q0", key="name", size=0.75);
// &q0 @WIRE(mode="straight") {#XPRE:1 %t1:p};
// %t2 = $IO_PORT @ATTACH &clk => @PLACE(-11, 58) => @ORIENT("R0");
// %t2 @TEXT("clk", key="name", size=0.75);
// &clk @WIRE(mode="straight") {#XPRE:2 %t2:p};
// %t3 = $IO_PORT @ATTACH &q0 => @PLACE(11, 60) => @ORIENT("MY");
// %t3 @TEXT("q0", key="name", size=0.75);
// &q0 @WIRE(mode="straight") {#XPRE:3 %t3:p};
// %t4 = $SUPPLY @ATTACH &vdd => @PLACE(0, 71);
// &vdd @WIRE(mode="straight") {#XPRE:4 %t4:p};
// %t5 = $GROUND @ATTACH &vss => @PLACE(0, 49);
// &vss @WIRE(mode="straight") {#XPRE:5 %t5:p};
// %t6 = $IO_PORT @ATTACH &q0 => @PLACE(29, 60) => @ORIENT("R0");
// %t6 @TEXT("q0", key="name", size=0.75);
// &q0 @WIRE(mode="straight") {#XPB0:1 %t6:p};
// %t7 = $IO_PORT @ATTACH &qb0 => @PLACE(51, 60) => @ORIENT("MY");
// %t7 @TEXT("qb0", key="name", size=0.75);
// &qb0 @WIRE(mode="straight") {#XPB0:2 %t7:p};
// %t8 = $SUPPLY @ATTACH &vdd => @PLACE(40, 69);
// &vdd @WIRE(mode="straight") {#XPB0:3 %t8:p};
// %t9 = $GROUND @ATTACH &vss => @PLACE(40, 51);
// &vss @WIRE(mode="straight") {#XPB0:4 %t9:p};
// %t10 = $IO_PORT @ATTACH &qb0 => @PLACE(69, 60) => @ORIENT("R0");
// %t10 @TEXT("qb0", key="name", size=0.75);
// &qb0 @WIRE(mode="straight") {#XPB1:1 %t10:p};
// %t11 = $IO_PORT @ATTACH &q1 => @PLACE(91, 60) => @ORIENT("MY");
// %t11 @TEXT("q1", key="name", size=0.75);
// &q1 @WIRE(mode="straight") {#XPB1:2 %t11:p};
// %t12 = $SUPPLY @ATTACH &vdd => @PLACE(80, 69);
// &vdd @WIRE(mode="straight") {#XPB1:3 %t12:p};
// %t13 = $GROUND @ATTACH &vss => @PLACE(80, 51);
// &vss @WIRE(mode="straight") {#XPB1:4 %t13:p};
// %t14 = $IO_PORT @ATTACH &d4b => @PLACE(109, 62) => @ORIENT("R0");
// %t14 @TEXT("d4b", key="name", size=0.75);
// &d4b @WIRE(mode="straight") {#XD4:1 %t14:p};
// %t15 = $IO_PORT @ATTACH &q1 => @PLACE(109, 58) => @ORIENT("R0");
// %t15 @TEXT("q1", key="name", size=0.75);
// &q1 @WIRE(mode="straight") {#XD4:2 %t15:p};
// %t16 = $IO_PORT @ATTACH &d4b => @PLACE(131, 60) => @ORIENT("MY");
// %t16 @TEXT("d4b", key="name", size=0.75);
// &d4b @WIRE(mode="straight") {#XD4:3 %t16:p};
// %t17 = $SUPPLY @ATTACH &vdd => @PLACE(120, 71);
// &vdd @WIRE(mode="straight") {#XD4:4 %t17:p};
// %t18 = $GROUND @ATTACH &vss => @PLACE(120, 49);
// &vss @WIRE(mode="straight") {#XD4:5 %t18:p};
// %t19 = $IO_PORT @ATTACH &d4b => @PLACE(149, 60) => @ORIENT("R0");
// %t19 @TEXT("d4b", key="name", size=0.75);
// &d4b @WIRE(mode="straight") {#XB40:1 %t19:p};
// %t20 = $IO_PORT @ATTACH &b40 => @PLACE(171, 60) => @ORIENT("MY");
// %t20 @TEXT("b40", key="name", size=0.75);
// &b40 @WIRE(mode="straight") {#XB40:2 %t20:p};
// %t21 = $SUPPLY @ATTACH &vdd => @PLACE(160, 69);
// &vdd @WIRE(mode="straight") {#XB40:3 %t21:p};
// %t22 = $GROUND @ATTACH &vss => @PLACE(160, 51);
// &vss @WIRE(mode="straight") {#XB40:4 %t22:p};
// %t23 = $IO_PORT @ATTACH &b40 => @PLACE(189, 60) => @ORIENT("R0");
// %t23 @TEXT("b40", key="name", size=0.75);
// &b40 @WIRE(mode="straight") {#XB41:1 %t23:p};
// %t24 = $IO_PORT @ATTACH &b41 => @PLACE(211, 60) => @ORIENT("MY");
// %t24 @TEXT("b41", key="name", size=0.75);
// &b41 @WIRE(mode="straight") {#XB41:2 %t24:p};
// %t25 = $SUPPLY @ATTACH &vdd => @PLACE(200, 69);
// &vdd @WIRE(mode="straight") {#XB41:3 %t25:p};
// %t26 = $GROUND @ATTACH &vss => @PLACE(200, 51);
// &vss @WIRE(mode="straight") {#XB41:4 %t26:p};
// %t27 = $IO_PORT @ATTACH &b41 => @PLACE(229, 60) => @ORIENT("R0");
// %t27 @TEXT("b41", key="name", size=0.75);
// &b41 @WIRE(mode="straight") {#XB42:1 %t27:p};
// %t28 = $IO_PORT @ATTACH &d4 => @PLACE(251, 60) => @ORIENT("MY");
// %t28 @TEXT("d4", key="name", size=0.75);
// &d4 @WIRE(mode="straight") {#XB42:2 %t28:p};
// %t29 = $SUPPLY @ATTACH &vdd => @PLACE(240, 69);
// &vdd @WIRE(mode="straight") {#XB42:3 %t29:p};
// %t30 = $GROUND @ATTACH &vss => @PLACE(240, 51);
// &vss @WIRE(mode="straight") {#XB42:4 %t30:p};
// %t31 = $IO_PORT @ATTACH &d4 => @PLACE(269, 60) => @ORIENT("R0");
// %t31 @TEXT("d4", key="name", size=0.75);
// &d4 @WIRE(mode="straight") {#XFAC0:1 %t31:p};
// %t32 = $IO_PORT @ATTACH &fab => @PLACE(291, 60) => @ORIENT("MY");
// %t32 @TEXT("fab", key="name", size=0.75);
// &fab @WIRE(mode="straight") {#XFAC0:2 %t32:p};
// %t33 = $SUPPLY @ATTACH &vdd => @PLACE(280, 69);
// &vdd @WIRE(mode="straight") {#XFAC0:3 %t33:p};
// %t34 = $GROUND @ATTACH &vss => @PLACE(280, 51);
// &vss @WIRE(mode="straight") {#XFAC0:4 %t34:p};
// %t35 = $IO_PORT @ATTACH &fab => @PLACE(309, 60) => @ORIENT("R0");
// %t35 @TEXT("fab", key="name", size=0.75);
// &fab @WIRE(mode="straight") {#XFAC1:1 %t35:p};
// %t36 = $IO_PORT @ATTACH &fllclk => @PLACE(331, 60) => @ORIENT("MY");
// %t36 @TEXT("fllclk", key="name", size=0.75);
// &fllclk @WIRE(mode="straight") {#XFAC1:2 %t36:p};
// %t37 = $SUPPLY @ATTACH &vdd => @PLACE(320, 69);
// &vdd @WIRE(mode="straight") {#XFAC1:3 %t37:p};
// %t38 = $GROUND @ATTACH &vss => @PLACE(320, 51);
// &vss @WIRE(mode="straight") {#XFAC1:4 %t38:p};
// %t39 = $IO_PORT @ATTACH &d8b => @PLACE(109, 7) => @ORIENT("R0");
// %t39 @TEXT("d8b", key="name", size=0.75);
// &d8b @WIRE(mode="straight") {#XD8:1 %t39:p};
// %t40 = $IO_PORT @ATTACH &d4 => @PLACE(109, 3) => @ORIENT("R0");
// %t40 @TEXT("d4", key="name", size=0.75);
// &d4 @WIRE(mode="straight") {#XD8:2 %t40:p};
// %t41 = $IO_PORT @ATTACH &d8b => @PLACE(131, 5) => @ORIENT("MY");
// %t41 @TEXT("d8b", key="name", size=0.75);
// &d8b @WIRE(mode="straight") {#XD8:3 %t41:p};
// %t42 = $SUPPLY @ATTACH &vdd => @PLACE(120, 16);
// &vdd @WIRE(mode="straight") {#XD8:4 %t42:p};
// %t43 = $GROUND @ATTACH &vss => @PLACE(120, -6);
// &vss @WIRE(mode="straight") {#XD8:5 %t43:p};
// %t44 = $IO_PORT @ATTACH &d8b => @PLACE(149, 5) => @ORIENT("R0");
// %t44 @TEXT("d8b", key="name", size=0.75);
// &d8b @WIRE(mode="straight") {#XB8:1 %t44:p};
// %t45 = $IO_PORT @ATTACH &d8 => @PLACE(171, 5) => @ORIENT("MY");
// %t45 @TEXT("d8", key="name", size=0.75);
// &d8 @WIRE(mode="straight") {#XB8:2 %t45:p};
// %t46 = $SUPPLY @ATTACH &vdd => @PLACE(160, 14);
// &vdd @WIRE(mode="straight") {#XB8:3 %t46:p};
// %t47 = $GROUND @ATTACH &vss => @PLACE(160, -4);
// &vss @WIRE(mode="straight") {#XB8:4 %t47:p};
// %t48 = $IO_PORT @ATTACH &d4 => @PLACE(229, 5) => @ORIENT("R0");
// %t48 @TEXT("d4", key="name", size=0.75);
// &d4 @WIRE(mode="straight") {#XD12:1 %t48:p};
// %t49 = $IO_PORT @ATTACH &d12 => @PLACE(251, 5) => @ORIENT("MY");
// %t49 @TEXT("d12", key="name", size=0.75);
// &d12 @WIRE(mode="straight") {#XD12:2 %t49:p};
// %t50 = $SUPPLY @ATTACH &vdd => @PLACE(240, 14);
// &vdd @WIRE(mode="straight") {#XD12:3 %t50:p};
// %t51 = $GROUND @ATTACH &vss => @PLACE(240, -4);
// &vss @WIRE(mode="straight") {#XD12:4 %t51:p};
// %t52 = $IO_PORT @ATTACH &q1 => @PLACE(-11, -50) => @ORIENT("R0");
// %t52 @TEXT("q1", key="name", size=0.75);
// &q1 @WIRE(mode="straight") {#XCT0:1 %t52:p};
// %t53 = $IO_PORT @ATTACH &ct0 => @PLACE(11, -50) => @ORIENT("MY");
// %t53 @TEXT("ct0", key="name", size=0.75);
// &ct0 @WIRE(mode="straight") {#XCT0:2 %t53:p};
// %t54 = $SUPPLY @ATTACH &vdd => @PLACE(0, -41);
// &vdd @WIRE(mode="straight") {#XCT0:3 %t54:p};
// %t55 = $GROUND @ATTACH &vss => @PLACE(0, -59);
// &vss @WIRE(mode="straight") {#XCT0:4 %t55:p};
// %t56 = $IO_PORT @ATTACH &ct0 => @PLACE(29, -50) => @ORIENT("R0");
// %t56 @TEXT("ct0", key="name", size=0.75);
// &ct0 @WIRE(mode="straight") {#XCT1:1 %t56:p};
// %t57 = $IO_PORT @ATTACH &ct1 => @PLACE(51, -50) => @ORIENT("MY");
// %t57 @TEXT("ct1", key="name", size=0.75);
// &ct1 @WIRE(mode="straight") {#XCT1:2 %t57:p};
// %t58 = $SUPPLY @ATTACH &vdd => @PLACE(40, -41);
// &vdd @WIRE(mode="straight") {#XCT1:3 %t58:p};
// %t59 = $GROUND @ATTACH &vss => @PLACE(40, -59);
// &vss @WIRE(mode="straight") {#XCT1:4 %t59:p};
// %t60 = $IO_PORT @ATTACH &ct1 => @PLACE(69, -50) => @ORIENT("R0");
// %t60 @TEXT("ct1", key="name", size=0.75);
// &ct1 @WIRE(mode="straight") {#XCT2:1 %t60:p};
// %t61 = $IO_PORT @ATTACH &cb => @PLACE(91, -50) => @ORIENT("MY");
// %t61 @TEXT("cb", key="name", size=0.75);
// &cb @WIRE(mode="straight") {#XCT2:2 %t61:p};
// %t62 = $SUPPLY @ATTACH &vdd => @PLACE(80, -41);
// &vdd @WIRE(mode="straight") {#XCT2:3 %t62:p};
// %t63 = $GROUND @ATTACH &vss => @PLACE(80, -59);
// &vss @WIRE(mode="straight") {#XCT2:4 %t63:p};
// %t64 = $IO_PORT @ATTACH &cb => @PLACE(109, -50) => @ORIENT("R0");
// %t64 @TEXT("cb", key="name", size=0.75);
// &cb @WIRE(mode="straight") {#XCT3:1 %t64:p};
// %t65 = $IO_PORT @ATTACH &ck => @PLACE(131, -50) => @ORIENT("MY");
// %t65 @TEXT("ck", key="name", size=0.75);
// &ck @WIRE(mode="straight") {#XCT3:2 %t65:p};
// %t66 = $SUPPLY @ATTACH &vdd => @PLACE(120, -41);
// &vdd @WIRE(mode="straight") {#XCT3:3 %t66:p};
// %t67 = $GROUND @ATTACH &vss => @PLACE(120, -59);
// &vss @WIRE(mode="straight") {#XCT3:4 %t67:p};
// %t68 = $IO_PORT @ATTACH &ck => @PLACE(149, -50) => @ORIENT("R0");
// %t68 @TEXT("ck", key="name", size=0.75);
// &ck @WIRE(mode="straight") {#XD6:1 %t68:p};
// %t69 = $IO_PORT @ATTACH &d6 => @PLACE(171, -50) => @ORIENT("MY");
// %t69 @TEXT("d6", key="name", size=0.75);
// &d6 @WIRE(mode="straight") {#XD6:2 %t69:p};
// %t70 = $SUPPLY @ATTACH &vdd => @PLACE(160, -41);
// &vdd @WIRE(mode="straight") {#XD6:3 %t70:p};
// %t71 = $GROUND @ATTACH &vss => @PLACE(160, -59);
// &vss @WIRE(mode="straight") {#XD6:4 %t71:p};
// %t72 = $IO_PORT @ATTACH &reset => @PLACE(-11, -108) => @ORIENT("R0");
// %t72 @TEXT("reset", key="name", size=0.75);
// &reset @WIRE(mode="straight") {#XRL:1 %t72:p};
// %t73 = $IO_PORT @ATTACH &ck => @PLACE(-11, -112) => @ORIENT("R0");
// %t73 @TEXT("ck", key="name", size=0.75);
// &ck @WIRE(mode="straight") {#XRL:2 %t73:p};
// %t74 = $IO_PORT @ATTACH &loadb => @PLACE(11, -110) => @ORIENT("MY");
// %t74 @TEXT("loadb", key="name", size=0.75);
// &loadb @WIRE(mode="straight") {#XRL:3 %t74:p};
// %t75 = $SUPPLY @ATTACH &vdd => @PLACE(0, -99);
// &vdd @WIRE(mode="straight") {#XRL:4 %t75:p};
// %t76 = $GROUND @ATTACH &vss => @PLACE(0, -121);
// &vss @WIRE(mode="straight") {#XRL:5 %t76:p};
// %t77 = $IO_PORT @ATTACH &loadb => @PLACE(29, -110) => @ORIENT("R0");
// %t77 @TEXT("loadb", key="name", size=0.75);
// &loadb @WIRE(mode="straight") {#XRLI:1 %t77:p};
// %t78 = $IO_PORT @ATTACH &load => @PLACE(51, -110) => @ORIENT("MY");
// %t78 @TEXT("load", key="name", size=0.75);
// &load @WIRE(mode="straight") {#XRLI:2 %t78:p};
// %t79 = $SUPPLY @ATTACH &vdd => @PLACE(40, -101);
// &vdd @WIRE(mode="straight") {#XRLI:3 %t79:p};
// %t80 = $GROUND @ATTACH &vss => @PLACE(40, -119);
// &vss @WIRE(mode="straight") {#XRLI:4 %t80:p};
// %t81 = $IO_PORT @ATTACH &load => @PLACE(69, -110) => @ORIENT("R0");
// %t81 @TEXT("load", key="name", size=0.75);
// &load @WIRE(mode="straight") {#XRK:1 %t81:p};
// %t82 = $IO_PORT @ATTACH &loadb => @PLACE(91, -110) => @ORIENT("MY");
// %t82 @TEXT("loadb", key="name", size=0.75);
// &loadb @WIRE(mode="straight") {#XRK:2 %t82:p};
// %t83 = $SUPPLY @ATTACH &vdd => @PLACE(80, -101);
// &vdd @WIRE(mode="straight") {#XRK:3 %t83:p};
// %t84 = $GROUND @ATTACH &vss => @PLACE(80, -119);
// &vss @WIRE(mode="straight") {#XRK:4 %t84:p};
// %t85 = $IO_PORT @ATTACH &fb => @PLACE(-17, -170) => @ORIENT("R0");
// %t85 @TEXT("fb", key="name", size=0.75);
// &fb @WIRE(mode="straight") {#XF0:1 %t85:p};
// %t86 = $IO_PORT @ATTACH &ck => @PLACE(-17, -174) => @ORIENT("R0");
// %t86 @TEXT("ck", key="name", size=0.75);
// &ck @WIRE(mode="straight") {#XF0:2 %t86:p};
// %t87 = $IO_PORT @ATTACH &ck => @PLACE(-17, -178) => @ORIENT("R0");
// %t87 @TEXT("ck", key="name", size=0.75);
// &ck @WIRE(mode="straight") {#XF0:3 %t87:p};
// %t88 = $IO_PORT @ATTACH &load => @PLACE(-17, -182) => @ORIENT("R0");
// %t88 @TEXT("load", key="name", size=0.75);
// &load @WIRE(mode="straight") {#XF0:4 %t88:p};
// %t89 = $IO_PORT @ATTACH &loadb => @PLACE(-17, -186) => @ORIENT("R0");
// %t89 @TEXT("loadb", key="name", size=0.75);
// &loadb @WIRE(mode="straight") {#XF0:5 %t89:p};
// %t90 = $IO_PORT @ATTACH &vdd => @PLACE(-17, -190) => @ORIENT("R0");
// %t90 @TEXT("vdd", key="name", size=0.75);
// &vdd @WIRE(mode="straight") {#XF0:6 %t90:p};
// %t91 = $IO_PORT @ATTACH &r0 => @PLACE(17, -180) => @ORIENT("MY");
// %t91 @TEXT("r0", key="name", size=0.75);
// &r0 @WIRE(mode="straight") {#XF0:7 %t91:p};
// %t92 = $SUPPLY @ATTACH &vdd => @PLACE(0, -161);
// &vdd @WIRE(mode="straight") {#XF0:8 %t92:p};
// %t93 = $GROUND @ATTACH &vss => @PLACE(0, -199);
// &vss @WIRE(mode="straight") {#XF0:9 %t93:p};
// %t94 = $IO_PORT @ATTACH &r0 => @PLACE(23, -170) => @ORIENT("R0");
// %t94 @TEXT("r0", key="name", size=0.75);
// &r0 @WIRE(mode="straight") {#XF1:1 %t94:p};
// %t95 = $IO_PORT @ATTACH &ck => @PLACE(23, -174) => @ORIENT("R0");
// %t95 @TEXT("ck", key="name", size=0.75);
// &ck @WIRE(mode="straight") {#XF1:2 %t95:p};
// %t96 = $IO_PORT @ATTACH &ck => @PLACE(23, -178) => @ORIENT("R0");
// %t96 @TEXT("ck", key="name", size=0.75);
// &ck @WIRE(mode="straight") {#XF1:3 %t96:p};
// %t97 = $IO_PORT @ATTACH &load => @PLACE(23, -182) => @ORIENT("R0");
// %t97 @TEXT("load", key="name", size=0.75);
// &load @WIRE(mode="straight") {#XF1:4 %t97:p};
// %t98 = $IO_PORT @ATTACH &loadb => @PLACE(23, -186) => @ORIENT("R0");
// %t98 @TEXT("loadb", key="name", size=0.75);
// &loadb @WIRE(mode="straight") {#XF1:5 %t98:p};
// %t99 = $IO_PORT @ATTACH &vdd => @PLACE(23, -190) => @ORIENT("R0");
// %t99 @TEXT("vdd", key="name", size=0.75);
// &vdd @WIRE(mode="straight") {#XF1:6 %t99:p};
// %t100 = $IO_PORT @ATTACH &r1 => @PLACE(57, -180) => @ORIENT("MY");
// %t100 @TEXT("r1", key="name", size=0.75);
// &r1 @WIRE(mode="straight") {#XF1:7 %t100:p};
// %t101 = $SUPPLY @ATTACH &vdd => @PLACE(40, -161);
// &vdd @WIRE(mode="straight") {#XF1:8 %t101:p};
// %t102 = $GROUND @ATTACH &vss => @PLACE(40, -199);
// &vss @WIRE(mode="straight") {#XF1:9 %t102:p};
// %t103 = $IO_PORT @ATTACH &r1 => @PLACE(63, -170) => @ORIENT("R0");
// %t103 @TEXT("r1", key="name", size=0.75);
// &r1 @WIRE(mode="straight") {#XF2:1 %t103:p};
// %t104 = $IO_PORT @ATTACH &ck => @PLACE(63, -174) => @ORIENT("R0");
// %t104 @TEXT("ck", key="name", size=0.75);
// &ck @WIRE(mode="straight") {#XF2:2 %t104:p};
// %t105 = $IO_PORT @ATTACH &ck => @PLACE(63, -178) => @ORIENT("R0");
// %t105 @TEXT("ck", key="name", size=0.75);
// &ck @WIRE(mode="straight") {#XF2:3 %t105:p};
// %t106 = $IO_PORT @ATTACH &load => @PLACE(63, -182) => @ORIENT("R0");
// %t106 @TEXT("load", key="name", size=0.75);
// &load @WIRE(mode="straight") {#XF2:4 %t106:p};
// %t107 = $IO_PORT @ATTACH &loadb => @PLACE(63, -186) => @ORIENT("R0");
// %t107 @TEXT("loadb", key="name", size=0.75);
// &loadb @WIRE(mode="straight") {#XF2:5 %t107:p};
// %t108 = $IO_PORT @ATTACH &vdd => @PLACE(63, -190) => @ORIENT("R0");
// %t108 @TEXT("vdd", key="name", size=0.75);
// &vdd @WIRE(mode="straight") {#XF2:6 %t108:p};
// %t109 = $IO_PORT @ATTACH &r2 => @PLACE(97, -180) => @ORIENT("MY");
// %t109 @TEXT("r2", key="name", size=0.75);
// &r2 @WIRE(mode="straight") {#XF2:7 %t109:p};
// %t110 = $SUPPLY @ATTACH &vdd => @PLACE(80, -161);
// &vdd @WIRE(mode="straight") {#XF2:8 %t110:p};
// %t111 = $GROUND @ATTACH &vss => @PLACE(80, -199);
// &vss @WIRE(mode="straight") {#XF2:9 %t111:p};
// %t112 = $IO_PORT @ATTACH &r2 => @PLACE(103, -170) => @ORIENT("R0");
// %t112 @TEXT("r2", key="name", size=0.75);
// &r2 @WIRE(mode="straight") {#XF3:1 %t112:p};
// %t113 = $IO_PORT @ATTACH &ck => @PLACE(103, -174) => @ORIENT("R0");
// %t113 @TEXT("ck", key="name", size=0.75);
// &ck @WIRE(mode="straight") {#XF3:2 %t113:p};
// %t114 = $IO_PORT @ATTACH &ck => @PLACE(103, -178) => @ORIENT("R0");
// %t114 @TEXT("ck", key="name", size=0.75);
// &ck @WIRE(mode="straight") {#XF3:3 %t114:p};
// %t115 = $IO_PORT @ATTACH &load => @PLACE(103, -182) => @ORIENT("R0");
// %t115 @TEXT("load", key="name", size=0.75);
// &load @WIRE(mode="straight") {#XF3:4 %t115:p};
// %t116 = $IO_PORT @ATTACH &loadb => @PLACE(103, -186) => @ORIENT("R0");
// %t116 @TEXT("loadb", key="name", size=0.75);
// &loadb @WIRE(mode="straight") {#XF3:5 %t116:p};
// %t117 = $IO_PORT @ATTACH &s5 => @PLACE(103, -190) => @ORIENT("R0");
// %t117 @TEXT("s5", key="name", size=0.75);
// &s5 @WIRE(mode="straight") {#XF3:6 %t117:p};
// %t118 = $IO_PORT @ATTACH &r3 => @PLACE(137, -180) => @ORIENT("MY");
// %t118 @TEXT("r3", key="name", size=0.75);
// &r3 @WIRE(mode="straight") {#XF3:7 %t118:p};
// %t119 = $SUPPLY @ATTACH &vdd => @PLACE(120, -161);
// &vdd @WIRE(mode="straight") {#XF3:8 %t119:p};
// %t120 = $GROUND @ATTACH &vss => @PLACE(120, -199);
// &vss @WIRE(mode="straight") {#XF3:9 %t120:p};
// %t121 = $IO_PORT @ATTACH &r3 => @PLACE(143, -170) => @ORIENT("R0");
// %t121 @TEXT("r3", key="name", size=0.75);
// &r3 @WIRE(mode="straight") {#XF4:1 %t121:p};
// %t122 = $IO_PORT @ATTACH &ck => @PLACE(143, -174) => @ORIENT("R0");
// %t122 @TEXT("ck", key="name", size=0.75);
// &ck @WIRE(mode="straight") {#XF4:2 %t122:p};
// %t123 = $IO_PORT @ATTACH &ck => @PLACE(143, -178) => @ORIENT("R0");
// %t123 @TEXT("ck", key="name", size=0.75);
// &ck @WIRE(mode="straight") {#XF4:3 %t123:p};
// %t124 = $IO_PORT @ATTACH &load => @PLACE(143, -182) => @ORIENT("R0");
// %t124 @TEXT("load", key="name", size=0.75);
// &load @WIRE(mode="straight") {#XF4:4 %t124:p};
// %t125 = $IO_PORT @ATTACH &loadb => @PLACE(143, -186) => @ORIENT("R0");
// %t125 @TEXT("loadb", key="name", size=0.75);
// &loadb @WIRE(mode="straight") {#XF4:5 %t125:p};
// %t126 = $IO_PORT @ATTACH &vss => @PLACE(143, -190) => @ORIENT("R0");
// %t126 @TEXT("vss", key="name", size=0.75);
// &vss @WIRE(mode="straight") {#XF4:6 %t126:p};
// %t127 = $IO_PORT @ATTACH &r4 => @PLACE(177, -180) => @ORIENT("MY");
// %t127 @TEXT("r4", key="name", size=0.75);
// &r4 @WIRE(mode="straight") {#XF4:7 %t127:p};
// %t128 = $SUPPLY @ATTACH &vdd => @PLACE(160, -161);
// &vdd @WIRE(mode="straight") {#XF4:8 %t128:p};
// %t129 = $GROUND @ATTACH &vss => @PLACE(160, -199);
// &vss @WIRE(mode="straight") {#XF4:9 %t129:p};
// %t130 = $IO_PORT @ATTACH &r4 => @PLACE(183, -168) => @ORIENT("R0");
// %t130 @TEXT("r4", key="name", size=0.75);
// &r4 @WIRE(mode="straight") {#XF5:1 %t130:p};
// %t131 = $IO_PORT @ATTACH &ck => @PLACE(183, -172) => @ORIENT("R0");
// %t131 @TEXT("ck", key="name", size=0.75);
// &ck @WIRE(mode="straight") {#XF5:2 %t131:p};
// %t132 = $IO_PORT @ATTACH &ck => @PLACE(183, -176) => @ORIENT("R0");
// %t132 @TEXT("ck", key="name", size=0.75);
// &ck @WIRE(mode="straight") {#XF5:3 %t132:p};
// %t133 = $IO_PORT @ATTACH &load => @PLACE(183, -180) => @ORIENT("R0");
// %t133 @TEXT("load", key="name", size=0.75);
// &load @WIRE(mode="straight") {#XF5:4 %t133:p};
// %t134 = $IO_PORT @ATTACH &loadb => @PLACE(183, -184) => @ORIENT("R0");
// %t134 @TEXT("loadb", key="name", size=0.75);
// &loadb @WIRE(mode="straight") {#XF5:5 %t134:p};
// %t135 = $IO_PORT @ATTACH &vss => @PLACE(183, -188) => @ORIENT("R0");
// %t135 @TEXT("vss", key="name", size=0.75);
// &vss @WIRE(mode="straight") {#XF5:6 %t135:p};
// %t136 = $IO_PORT @ATTACH &s5 => @PLACE(183, -192) => @ORIENT("R0");
// %t136 @TEXT("s5", key="name", size=0.75);
// &s5 @WIRE(mode="straight") {#XF5:7 %t136:p};
// %t137 = $IO_PORT @ATTACH &r5 => @PLACE(217, -180) => @ORIENT("MY");
// %t137 @TEXT("r5", key="name", size=0.75);
// &r5 @WIRE(mode="straight") {#XF5:8 %t137:p};
// %t138 = $SUPPLY @ATTACH &vdd => @PLACE(200, -159);
// &vdd @WIRE(mode="straight") {#XF5:9 %t138:p};
// %t139 = $GROUND @ATTACH &vss => @PLACE(200, -201);
// &vss @WIRE(mode="straight") {#XF5:10 %t139:p};
// %t140 = $IO_PORT @ATTACH &r5 => @PLACE(223, -168) => @ORIENT("R0");
// %t140 @TEXT("r5", key="name", size=0.75);
// &r5 @WIRE(mode="straight") {#XF6:1 %t140:p};
// %t141 = $IO_PORT @ATTACH &ck => @PLACE(223, -172) => @ORIENT("R0");
// %t141 @TEXT("ck", key="name", size=0.75);
// &ck @WIRE(mode="straight") {#XF6:2 %t141:p};
// %t142 = $IO_PORT @ATTACH &ck => @PLACE(223, -176) => @ORIENT("R0");
// %t142 @TEXT("ck", key="name", size=0.75);
// &ck @WIRE(mode="straight") {#XF6:3 %t142:p};
// %t143 = $IO_PORT @ATTACH &load => @PLACE(223, -180) => @ORIENT("R0");
// %t143 @TEXT("load", key="name", size=0.75);
// &load @WIRE(mode="straight") {#XF6:4 %t143:p};
// %t144 = $IO_PORT @ATTACH &loadb => @PLACE(223, -184) => @ORIENT("R0");
// %t144 @TEXT("loadb", key="name", size=0.75);
// &loadb @WIRE(mode="straight") {#XF6:5 %t144:p};
// %t145 = $IO_PORT @ATTACH &vss => @PLACE(223, -188) => @ORIENT("R0");
// %t145 @TEXT("vss", key="name", size=0.75);
// &vss @WIRE(mode="straight") {#XF6:6 %t145:p};
// %t146 = $IO_PORT @ATTACH &s5 => @PLACE(223, -192) => @ORIENT("R0");
// %t146 @TEXT("s5", key="name", size=0.75);
// &s5 @WIRE(mode="straight") {#XF6:7 %t146:p};
// %t147 = $IO_PORT @ATTACH &r6 => @PLACE(257, -180) => @ORIENT("MY");
// %t147 @TEXT("r6", key="name", size=0.75);
// &r6 @WIRE(mode="straight") {#XF6:8 %t147:p};
// %t148 = $SUPPLY @ATTACH &vdd => @PLACE(240, -159);
// &vdd @WIRE(mode="straight") {#XF6:9 %t148:p};
// %t149 = $GROUND @ATTACH &vss => @PLACE(240, -201);
// &vss @WIRE(mode="straight") {#XF6:10 %t149:p};
// %t150 = $IO_PORT @ATTACH &s3 => @PLACE(-11, -250) => @ORIENT("R0");
// %t150 @TEXT("s3", key="name", size=0.75);
// &s3 @WIRE(mode="straight") {#XSI3:1 %t150:p};
// %t151 = $IO_PORT @ATTACH &sb3 => @PLACE(11, -250) => @ORIENT("MY");
// %t151 @TEXT("sb3", key="name", size=0.75);
// &sb3 @WIRE(mode="straight") {#XSI3:2 %t151:p};
// %t152 = $SUPPLY @ATTACH &vdd => @PLACE(0, -241);
// &vdd @WIRE(mode="straight") {#XSI3:3 %t152:p};
// %t153 = $GROUND @ATTACH &vss => @PLACE(0, -259);
// &vss @WIRE(mode="straight") {#XSI3:4 %t153:p};
// %t154 = $IO_PORT @ATTACH &s5 => @PLACE(29, -250) => @ORIENT("R0");
// %t154 @TEXT("s5", key="name", size=0.75);
// &s5 @WIRE(mode="straight") {#XSI5:1 %t154:p};
// %t155 = $IO_PORT @ATTACH &sb5 => @PLACE(51, -250) => @ORIENT("MY");
// %t155 @TEXT("sb5", key="name", size=0.75);
// &sb5 @WIRE(mode="straight") {#XSI5:2 %t155:p};
// %t156 = $SUPPLY @ATTACH &vdd => @PLACE(40, -241);
// &vdd @WIRE(mode="straight") {#XSI5:3 %t156:p};
// %t157 = $GROUND @ATTACH &vss => @PLACE(40, -259);
// &vss @WIRE(mode="straight") {#XSI5:4 %t157:p};
// %t158 = $IO_PORT @ATTACH &r4 => @PLACE(89, -246) => @ORIENT("R0");
// %t158 @TEXT("r4", key="name", size=0.75);
// &r4 @WIRE(mode="straight") {#XT5:1 %t158:p};
// %t159 = $IO_PORT @ATTACH &fb => @PLACE(111, -250) => @ORIENT("MY");
// %t159 @TEXT("fb", key="name", size=0.75);
// &fb @WIRE(mode="straight") {#XT5:2 %t159:p};
// %t160 = $IO_PORT @ATTACH &s3 => @PLACE(89, -250) => @ORIENT("R0");
// %t160 @TEXT("s3", key="name", size=0.75);
// &s3 @WIRE(mode="straight") {#XT5:3 %t160:p};
// %t161 = $IO_PORT @ATTACH &sb3 => @PLACE(89, -254) => @ORIENT("R0");
// %t161 @TEXT("sb3", key="name", size=0.75);
// &sb3 @WIRE(mode="straight") {#XT5:4 %t161:p};
// %t162 = $SUPPLY @ATTACH &vdd => @PLACE(100, -237);
// &vdd @WIRE(mode="straight") {#XT5:5 %t162:p};
// %t163 = $GROUND @ATTACH &vss => @PLACE(100, -263);
// &vss @WIRE(mode="straight") {#XT5:6 %t163:p};
// %t164 = $IO_PORT @ATTACH &r6 => @PLACE(139, -246) => @ORIENT("R0");
// %t164 @TEXT("r6", key="name", size=0.75);
// &r6 @WIRE(mode="straight") {#XT7:1 %t164:p};
// %t165 = $IO_PORT @ATTACH &fb => @PLACE(161, -250) => @ORIENT("MY");
// %t165 @TEXT("fb", key="name", size=0.75);
// &fb @WIRE(mode="straight") {#XT7:2 %t165:p};
// %t166 = $IO_PORT @ATTACH &s5 => @PLACE(139, -250) => @ORIENT("R0");
// %t166 @TEXT("s5", key="name", size=0.75);
// &s5 @WIRE(mode="straight") {#XT7:3 %t166:p};
// %t167 = $IO_PORT @ATTACH &sb5 => @PLACE(139, -254) => @ORIENT("R0");
// %t167 @TEXT("sb5", key="name", size=0.75);
// &sb5 @WIRE(mode="straight") {#XT7:4 %t167:p};
// %t168 = $SUPPLY @ATTACH &vdd => @PLACE(150, -237);
// &vdd @WIRE(mode="straight") {#XT7:5 %t168:p};
// %t169 = $GROUND @ATTACH &vss => @PLACE(150, -263);
// &vss @WIRE(mode="straight") {#XT7:6 %t169:p};
// %t170 = $IO_PORT @ATTACH &fb => @PLACE(196, -245) => @ORIENT("R0");
// %t170 @TEXT("fb", key="name", size=0.75);
// &fb @WIRE(mode="straight") {#RFB:1 (200, -245) %t170:p};
// %t171 = $GROUND @ATTACH &vss => @PLACE(200, -255);
// &vss @WIRE(mode="straight") {#RFB:2 %t171:p};
// %t172 = $IO_PORT @ATTACH &reset => @PLACE(-11, -315) => @ORIENT("R0");
// %t172 @TEXT("reset", key="name", size=0.75);
// &reset @WIRE(mode="straight") {#XRI:1 %t172:p};
// %t173 = $IO_PORT @ATTACH &resetb => @PLACE(11, -315) => @ORIENT("MY");
// %t173 @TEXT("resetb", key="name", size=0.75);
// &resetb @WIRE(mode="straight") {#XRI:2 %t173:p};
// %t174 = $SUPPLY @ATTACH &vdd => @PLACE(0, -306);
// &vdd @WIRE(mode="straight") {#XRI:3 %t174:p};
// %t175 = $GROUND @ATTACH &vss => @PLACE(0, -324);
// &vss @WIRE(mode="straight") {#XRI:4 %t175:p};
// %t176 = $IO_PORT @ATTACH &s0 => @PLACE(-11, -363) => @ORIENT("R0");
// %t176 @TEXT("s0", key="name", size=0.75);
// &s0 @WIRE(mode="straight") {#XSEB0:1 %t176:p};
// %t177 = $IO_PORT @ATTACH &resetb => @PLACE(-11, -367) => @ORIENT("R0");
// %t177 @TEXT("resetb", key="name", size=0.75);
// &resetb @WIRE(mode="straight") {#XSEB0:2 %t177:p};
// %t178 = $IO_PORT @ATTACH &eb0 => @PLACE(11, -365) => @ORIENT("MY");
// %t178 @TEXT("eb0", key="name", size=0.75);
// &eb0 @WIRE(mode="straight") {#XSEB0:3 %t178:p};
// %t179 = $SUPPLY @ATTACH &vdd => @PLACE(0, -354);
// &vdd @WIRE(mode="straight") {#XSEB0:4 %t179:p};
// %t180 = $GROUND @ATTACH &vss => @PLACE(0, -376);
// &vss @WIRE(mode="straight") {#XSEB0:5 %t180:p};
// %t181 = $IO_PORT @ATTACH &s1 => @PLACE(54, -363) => @ORIENT("R0");
// %t181 @TEXT("s1", key="name", size=0.75);
// &s1 @WIRE(mode="straight") {#XSEB1:1 %t181:p};
// %t182 = $IO_PORT @ATTACH &resetb => @PLACE(54, -367) => @ORIENT("R0");
// %t182 @TEXT("resetb", key="name", size=0.75);
// &resetb @WIRE(mode="straight") {#XSEB1:2 %t182:p};
// %t183 = $IO_PORT @ATTACH &eb1 => @PLACE(76, -365) => @ORIENT("MY");
// %t183 @TEXT("eb1", key="name", size=0.75);
// &eb1 @WIRE(mode="straight") {#XSEB1:3 %t183:p};
// %t184 = $SUPPLY @ATTACH &vdd => @PLACE(65, -354);
// &vdd @WIRE(mode="straight") {#XSEB1:4 %t184:p};
// %t185 = $GROUND @ATTACH &vss => @PLACE(65, -376);
// &vss @WIRE(mode="straight") {#XSEB1:5 %t185:p};
// %t186 = $IO_PORT @ATTACH &s2 => @PLACE(119, -363) => @ORIENT("R0");
// %t186 @TEXT("s2", key="name", size=0.75);
// &s2 @WIRE(mode="straight") {#XSEB2:1 %t186:p};
// %t187 = $IO_PORT @ATTACH &resetb => @PLACE(119, -367) => @ORIENT("R0");
// %t187 @TEXT("resetb", key="name", size=0.75);
// &resetb @WIRE(mode="straight") {#XSEB2:2 %t187:p};
// %t188 = $IO_PORT @ATTACH &eb2 => @PLACE(141, -365) => @ORIENT("MY");
// %t188 @TEXT("eb2", key="name", size=0.75);
// &eb2 @WIRE(mode="straight") {#XSEB2:3 %t188:p};
// %t189 = $SUPPLY @ATTACH &vdd => @PLACE(130, -354);
// &vdd @WIRE(mode="straight") {#XSEB2:4 %t189:p};
// %t190 = $GROUND @ATTACH &vss => @PLACE(130, -376);
// &vss @WIRE(mode="straight") {#XSEB2:5 %t190:p};
// %t191 = $IO_PORT @ATTACH &s3 => @PLACE(184, -363) => @ORIENT("R0");
// %t191 @TEXT("s3", key="name", size=0.75);
// &s3 @WIRE(mode="straight") {#XSEB3:1 %t191:p};
// %t192 = $IO_PORT @ATTACH &resetb => @PLACE(184, -367) => @ORIENT("R0");
// %t192 @TEXT("resetb", key="name", size=0.75);
// &resetb @WIRE(mode="straight") {#XSEB3:2 %t192:p};
// %t193 = $IO_PORT @ATTACH &eb3 => @PLACE(206, -365) => @ORIENT("MY");
// %t193 @TEXT("eb3", key="name", size=0.75);
// &eb3 @WIRE(mode="straight") {#XSEB3:3 %t193:p};
// %t194 = $SUPPLY @ATTACH &vdd => @PLACE(195, -354);
// &vdd @WIRE(mode="straight") {#XSEB3:4 %t194:p};
// %t195 = $GROUND @ATTACH &vss => @PLACE(195, -376);
// &vss @WIRE(mode="straight") {#XSEB3:5 %t195:p};
// %t196 = $IO_PORT @ATTACH &s4 => @PLACE(249, -363) => @ORIENT("R0");
// %t196 @TEXT("s4", key="name", size=0.75);
// &s4 @WIRE(mode="straight") {#XSEB4:1 %t196:p};
// %t197 = $IO_PORT @ATTACH &resetb => @PLACE(249, -367) => @ORIENT("R0");
// %t197 @TEXT("resetb", key="name", size=0.75);
// &resetb @WIRE(mode="straight") {#XSEB4:2 %t197:p};
// %t198 = $IO_PORT @ATTACH &eb4 => @PLACE(271, -365) => @ORIENT("MY");
// %t198 @TEXT("eb4", key="name", size=0.75);
// &eb4 @WIRE(mode="straight") {#XSEB4:3 %t198:p};
// %t199 = $SUPPLY @ATTACH &vdd => @PLACE(260, -354);
// &vdd @WIRE(mode="straight") {#XSEB4:4 %t199:p};
// %t200 = $GROUND @ATTACH &vss => @PLACE(260, -376);
// &vss @WIRE(mode="straight") {#XSEB4:5 %t200:p};
// %t201 = $IO_PORT @ATTACH &s5 => @PLACE(314, -363) => @ORIENT("R0");
// %t201 @TEXT("s5", key="name", size=0.75);
// &s5 @WIRE(mode="straight") {#XSEB5:1 %t201:p};
// %t202 = $IO_PORT @ATTACH &resetb => @PLACE(314, -367) => @ORIENT("R0");
// %t202 @TEXT("resetb", key="name", size=0.75);
// &resetb @WIRE(mode="straight") {#XSEB5:2 %t202:p};
// %t203 = $IO_PORT @ATTACH &eb5 => @PLACE(336, -365) => @ORIENT("MY");
// %t203 @TEXT("eb5", key="name", size=0.75);
// &eb5 @WIRE(mode="straight") {#XSEB5:3 %t203:p};
// %t204 = $SUPPLY @ATTACH &vdd => @PLACE(325, -354);
// &vdd @WIRE(mode="straight") {#XSEB5:4 %t204:p};
// %t205 = $GROUND @ATTACH &vss => @PLACE(325, -376);
// &vss @WIRE(mode="straight") {#XSEB5:5 %t205:p};
// %t206 = $IO_PORT @ATTACH &eb0 => @PLACE(-11, -405) => @ORIENT("R0");
// %t206 @TEXT("eb0", key="name", size=0.75);
// &eb0 @WIRE(mode="straight") {#XSE0:1 %t206:p};
// %t207 = $IO_PORT @ATTACH &es0 => @PLACE(11, -405) => @ORIENT("MY");
// %t207 @TEXT("es0", key="name", size=0.75);
// &es0 @WIRE(mode="straight") {#XSE0:2 %t207:p};
// %t208 = $SUPPLY @ATTACH &vdd => @PLACE(0, -396);
// &vdd @WIRE(mode="straight") {#XSE0:3 %t208:p};
// %t209 = $GROUND @ATTACH &vss => @PLACE(0, -414);
// &vss @WIRE(mode="straight") {#XSE0:4 %t209:p};
// %t210 = $IO_PORT @ATTACH &eb1 => @PLACE(54, -405) => @ORIENT("R0");
// %t210 @TEXT("eb1", key="name", size=0.75);
// &eb1 @WIRE(mode="straight") {#XSE1:1 %t210:p};
// %t211 = $IO_PORT @ATTACH &es1 => @PLACE(76, -405) => @ORIENT("MY");
// %t211 @TEXT("es1", key="name", size=0.75);
// &es1 @WIRE(mode="straight") {#XSE1:2 %t211:p};
// %t212 = $SUPPLY @ATTACH &vdd => @PLACE(65, -396);
// &vdd @WIRE(mode="straight") {#XSE1:3 %t212:p};
// %t213 = $GROUND @ATTACH &vss => @PLACE(65, -414);
// &vss @WIRE(mode="straight") {#XSE1:4 %t213:p};
// %t214 = $IO_PORT @ATTACH &eb2 => @PLACE(119, -405) => @ORIENT("R0");
// %t214 @TEXT("eb2", key="name", size=0.75);
// &eb2 @WIRE(mode="straight") {#XSE2:1 %t214:p};
// %t215 = $IO_PORT @ATTACH &es2 => @PLACE(141, -405) => @ORIENT("MY");
// %t215 @TEXT("es2", key="name", size=0.75);
// &es2 @WIRE(mode="straight") {#XSE2:2 %t215:p};
// %t216 = $SUPPLY @ATTACH &vdd => @PLACE(130, -396);
// &vdd @WIRE(mode="straight") {#XSE2:3 %t216:p};
// %t217 = $GROUND @ATTACH &vss => @PLACE(130, -414);
// &vss @WIRE(mode="straight") {#XSE2:4 %t217:p};
// %t218 = $IO_PORT @ATTACH &eb3 => @PLACE(184, -405) => @ORIENT("R0");
// %t218 @TEXT("eb3", key="name", size=0.75);
// &eb3 @WIRE(mode="straight") {#XSE3:1 %t218:p};
// %t219 = $IO_PORT @ATTACH &es3 => @PLACE(206, -405) => @ORIENT("MY");
// %t219 @TEXT("es3", key="name", size=0.75);
// &es3 @WIRE(mode="straight") {#XSE3:2 %t219:p};
// %t220 = $SUPPLY @ATTACH &vdd => @PLACE(195, -396);
// &vdd @WIRE(mode="straight") {#XSE3:3 %t220:p};
// %t221 = $GROUND @ATTACH &vss => @PLACE(195, -414);
// &vss @WIRE(mode="straight") {#XSE3:4 %t221:p};
// %t222 = $IO_PORT @ATTACH &eb4 => @PLACE(249, -405) => @ORIENT("R0");
// %t222 @TEXT("eb4", key="name", size=0.75);
// &eb4 @WIRE(mode="straight") {#XSE4:1 %t222:p};
// %t223 = $IO_PORT @ATTACH &es4 => @PLACE(271, -405) => @ORIENT("MY");
// %t223 @TEXT("es4", key="name", size=0.75);
// &es4 @WIRE(mode="straight") {#XSE4:2 %t223:p};
// %t224 = $SUPPLY @ATTACH &vdd => @PLACE(260, -396);
// &vdd @WIRE(mode="straight") {#XSE4:3 %t224:p};
// %t225 = $GROUND @ATTACH &vss => @PLACE(260, -414);
// &vss @WIRE(mode="straight") {#XSE4:4 %t225:p};
// %t226 = $IO_PORT @ATTACH &eb5 => @PLACE(314, -405) => @ORIENT("R0");
// %t226 @TEXT("eb5", key="name", size=0.75);
// &eb5 @WIRE(mode="straight") {#XSE5:1 %t226:p};
// %t227 = $IO_PORT @ATTACH &es5 => @PLACE(336, -405) => @ORIENT("MY");
// %t227 @TEXT("es5", key="name", size=0.75);
// &es5 @WIRE(mode="straight") {#XSE5:2 %t227:p};
// %t228 = $SUPPLY @ATTACH &vdd => @PLACE(325, -396);
// &vdd @WIRE(mode="straight") {#XSE5:3 %t228:p};
// %t229 = $GROUND @ATTACH &vss => @PLACE(325, -414);
// &vss @WIRE(mode="straight") {#XSE5:4 %t229:p};
// %t230 = $IO_PORT @ATTACH &d4 => @PLACE(-11, -446) => @ORIENT("R0");
// %t230 @TEXT("d4", key="name", size=0.75);
// &d4 @WIRE(mode="straight") {#XMX0:1 %t230:p};
// %t231 = $IO_PORT @ATTACH &mux => @PLACE(11, -450) => @ORIENT("MY");
// %t231 @TEXT("mux", key="name", size=0.75);
// &mux @WIRE(mode="straight") {#XMX0:2 %t231:p};
// %t232 = $IO_PORT @ATTACH &es0 => @PLACE(-11, -450) => @ORIENT("R0");
// %t232 @TEXT("es0", key="name", size=0.75);
// &es0 @WIRE(mode="straight") {#XMX0:3 %t232:p};
// %t233 = $IO_PORT @ATTACH &eb0 => @PLACE(-11, -454) => @ORIENT("R0");
// %t233 @TEXT("eb0", key="name", size=0.75);
// &eb0 @WIRE(mode="straight") {#XMX0:4 %t233:p};
// %t234 = $SUPPLY @ATTACH &vdd => @PLACE(0, -437);
// &vdd @WIRE(mode="straight") {#XMX0:5 %t234:p};
// %t235 = $GROUND @ATTACH &vss => @PLACE(0, -463);
// &vss @WIRE(mode="straight") {#XMX0:6 %t235:p};
// %t236 = $IO_PORT @ATTACH &d6 => @PLACE(54, -446) => @ORIENT("R0");
// %t236 @TEXT("d6", key="name", size=0.75);
// &d6 @WIRE(mode="straight") {#XMX1:1 %t236:p};
// %t237 = $IO_PORT @ATTACH &mux => @PLACE(76, -450) => @ORIENT("MY");
// %t237 @TEXT("mux", key="name", size=0.75);
// &mux @WIRE(mode="straight") {#XMX1:2 %t237:p};
// %t238 = $IO_PORT @ATTACH &es1 => @PLACE(54, -450) => @ORIENT("R0");
// %t238 @TEXT("es1", key="name", size=0.75);
// &es1 @WIRE(mode="straight") {#XMX1:3 %t238:p};
// %t239 = $IO_PORT @ATTACH &eb1 => @PLACE(54, -454) => @ORIENT("R0");
// %t239 @TEXT("eb1", key="name", size=0.75);
// &eb1 @WIRE(mode="straight") {#XMX1:4 %t239:p};
// %t240 = $SUPPLY @ATTACH &vdd => @PLACE(65, -437);
// &vdd @WIRE(mode="straight") {#XMX1:5 %t240:p};
// %t241 = $GROUND @ATTACH &vss => @PLACE(65, -463);
// &vss @WIRE(mode="straight") {#XMX1:6 %t241:p};
// %t242 = $IO_PORT @ATTACH &d8 => @PLACE(119, -446) => @ORIENT("R0");
// %t242 @TEXT("d8", key="name", size=0.75);
// &d8 @WIRE(mode="straight") {#XMX2:1 %t242:p};
// %t243 = $IO_PORT @ATTACH &mux => @PLACE(141, -450) => @ORIENT("MY");
// %t243 @TEXT("mux", key="name", size=0.75);
// &mux @WIRE(mode="straight") {#XMX2:2 %t243:p};
// %t244 = $IO_PORT @ATTACH &es2 => @PLACE(119, -450) => @ORIENT("R0");
// %t244 @TEXT("es2", key="name", size=0.75);
// &es2 @WIRE(mode="straight") {#XMX2:3 %t244:p};
// %t245 = $IO_PORT @ATTACH &eb2 => @PLACE(119, -454) => @ORIENT("R0");
// %t245 @TEXT("eb2", key="name", size=0.75);
// &eb2 @WIRE(mode="straight") {#XMX2:4 %t245:p};
// %t246 = $SUPPLY @ATTACH &vdd => @PLACE(130, -437);
// &vdd @WIRE(mode="straight") {#XMX2:5 %t246:p};
// %t247 = $GROUND @ATTACH &vss => @PLACE(130, -463);
// &vss @WIRE(mode="straight") {#XMX2:6 %t247:p};
// %t248 = $IO_PORT @ATTACH &r0 => @PLACE(184, -446) => @ORIENT("R0");
// %t248 @TEXT("r0", key="name", size=0.75);
// &r0 @WIRE(mode="straight") {#XMX3:1 %t248:p};
// %t249 = $IO_PORT @ATTACH &mux => @PLACE(206, -450) => @ORIENT("MY");
// %t249 @TEXT("mux", key="name", size=0.75);
// &mux @WIRE(mode="straight") {#XMX3:2 %t249:p};
// %t250 = $IO_PORT @ATTACH &es3 => @PLACE(184, -450) => @ORIENT("R0");
// %t250 @TEXT("es3", key="name", size=0.75);
// &es3 @WIRE(mode="straight") {#XMX3:3 %t250:p};
// %t251 = $IO_PORT @ATTACH &eb3 => @PLACE(184, -454) => @ORIENT("R0");
// %t251 @TEXT("eb3", key="name", size=0.75);
// &eb3 @WIRE(mode="straight") {#XMX3:4 %t251:p};
// %t252 = $SUPPLY @ATTACH &vdd => @PLACE(195, -437);
// &vdd @WIRE(mode="straight") {#XMX3:5 %t252:p};
// %t253 = $GROUND @ATTACH &vss => @PLACE(195, -463);
// &vss @WIRE(mode="straight") {#XMX3:6 %t253:p};
// %t254 = $IO_PORT @ATTACH &d12 => @PLACE(249, -446) => @ORIENT("R0");
// %t254 @TEXT("d12", key="name", size=0.75);
// &d12 @WIRE(mode="straight") {#XMX4:1 %t254:p};
// %t255 = $IO_PORT @ATTACH &mux => @PLACE(271, -450) => @ORIENT("MY");
// %t255 @TEXT("mux", key="name", size=0.75);
// &mux @WIRE(mode="straight") {#XMX4:2 %t255:p};
// %t256 = $IO_PORT @ATTACH &es4 => @PLACE(249, -450) => @ORIENT("R0");
// %t256 @TEXT("es4", key="name", size=0.75);
// &es4 @WIRE(mode="straight") {#XMX4:3 %t256:p};
// %t257 = $IO_PORT @ATTACH &eb4 => @PLACE(249, -454) => @ORIENT("R0");
// %t257 @TEXT("eb4", key="name", size=0.75);
// &eb4 @WIRE(mode="straight") {#XMX4:4 %t257:p};
// %t258 = $SUPPLY @ATTACH &vdd => @PLACE(260, -437);
// &vdd @WIRE(mode="straight") {#XMX4:5 %t258:p};
// %t259 = $GROUND @ATTACH &vss => @PLACE(260, -463);
// &vss @WIRE(mode="straight") {#XMX4:6 %t259:p};
// %t260 = $IO_PORT @ATTACH &r0 => @PLACE(314, -446) => @ORIENT("R0");
// %t260 @TEXT("r0", key="name", size=0.75);
// &r0 @WIRE(mode="straight") {#XMX5:1 %t260:p};
// %t261 = $IO_PORT @ATTACH &mux => @PLACE(336, -450) => @ORIENT("MY");
// %t261 @TEXT("mux", key="name", size=0.75);
// &mux @WIRE(mode="straight") {#XMX5:2 %t261:p};
// %t262 = $IO_PORT @ATTACH &es5 => @PLACE(314, -450) => @ORIENT("R0");
// %t262 @TEXT("es5", key="name", size=0.75);
// &es5 @WIRE(mode="straight") {#XMX5:3 %t262:p};
// %t263 = $IO_PORT @ATTACH &eb5 => @PLACE(314, -454) => @ORIENT("R0");
// %t263 @TEXT("eb5", key="name", size=0.75);
// &eb5 @WIRE(mode="straight") {#XMX5:4 %t263:p};
// %t264 = $SUPPLY @ATTACH &vdd => @PLACE(325, -437);
// &vdd @WIRE(mode="straight") {#XMX5:5 %t264:p};
// %t265 = $GROUND @ATTACH &vss => @PLACE(325, -463);
// &vss @WIRE(mode="straight") {#XMX5:6 %t265:p};
// %t266 = $IO_PORT @ATTACH &mux => @PLACE(-4, -535) => @ORIENT("R0");
// %t266 @TEXT("mux", key="name", size=0.75);
// &mux @WIRE(mode="straight") {#MMUTE:1 (0, -535) %t266:p};
// %t267 = $IO_PORT @ATTACH &reset => @PLACE(-6, -540) => @ORIENT("R0");
// %t267 @TEXT("reset", key="name", size=0.75);
// &reset @WIRE(mode="straight") {#MMUTE:2 %t267:p};
// %t268 = $GROUND @ATTACH &vss => @PLACE(0, -545);
// &vss @WIRE(mode="straight") {#MMUTE:3 %t268:p};
// %t269 = $IO_PORT @ATTACH &vss => @PLACE(4, -540) => @ORIENT("MY");
// %t269 @TEXT("vss", key="name", size=0.75);
// &vss @WIRE(mode="straight") {#MMUTE:4 %t269:p};
// %t270 = $IO_PORT @ATTACH &mux => @PLACE(48, -535) => @ORIENT("R0");
// %t270 @TEXT("mux", key="name", size=0.75);
// &mux @WIRE(mode="straight") {#RKEEP:1 (52, -535) %t270:p};
// %t271 = $GROUND @ATTACH &vss => @PLACE(52, -545);
// &vss @WIRE(mode="straight") {#RKEEP:2 %t271:p};
// %t272 = $IO_PORT @ATTACH &mux => @PLACE(93, -540) => @ORIENT("R0");
// %t272 @TEXT("mux", key="name", size=0.75);
// &mux @WIRE(mode="straight") {#XO0:1 %t272:p};
// %t273 = $IO_PORT @ATTACH &ob => @PLACE(115, -540) => @ORIENT("MY");
// %t273 @TEXT("ob", key="name", size=0.75);
// &ob @WIRE(mode="straight") {#XO0:2 %t273:p};
// %t274 = $SUPPLY @ATTACH &vdd => @PLACE(104, -531);
// &vdd @WIRE(mode="straight") {#XO0:3 %t274:p};
// %t275 = $GROUND @ATTACH &vss => @PLACE(104, -549);
// &vss @WIRE(mode="straight") {#XO0:4 %t275:p};
// %t276 = $IO_PORT @ATTACH &ob => @PLACE(145, -540) => @ORIENT("R0");
// %t276 @TEXT("ob", key="name", size=0.75);
// &ob @WIRE(mode="straight") {#XO1:1 %t276:p};
// %t277 = $IO_PORT @ATTACH &out => @PLACE(167, -540) => @ORIENT("MY");
// %t277 @TEXT("out", key="name", size=0.75);
// &out @WIRE(mode="straight") {#XO1:2 %t277:p};
// %t278 = $SUPPLY @ATTACH &vdd => @PLACE(156, -531);
// &vdd @WIRE(mode="straight") {#XO1:3 %t278:p};
// %t279 = $GROUND @ATTACH &vss => @PLACE(156, -549);
// &vss @WIRE(mode="straight") {#XO1:4 %t279:p};
// (-22, 90) @TEXT("21  Divider bank | 55 instances", size=1.2, halign="start");
// (-22, 86) @TEXT("Same-name tags connect locally. Open blocks for transistor details.", size=0.8, halign="start");
// }
ends bank_pulsetrip_v14_pdk110_21
