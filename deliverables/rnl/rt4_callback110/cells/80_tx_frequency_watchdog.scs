// Watchdog | frozen callback110 / recenter109 | RNL 0.3
// @RNL(type="header") { @VERSION("0.3"); @USE-PACKAGE(name="rnl-std-fill") {} }
simulator lang=spectre
subckt tx_frequency_watchdog_pdk110_80 (refclk reset active target_k0 target_k1 target_k2 target_k3 target_k4 target_k5 measured0 measured1 measured2 measured3 measured4 measured5 measured6 measured7 measured8 measured9 measured10 measured11 measured12 measured13 count_gate count_reset frequency_good valid vdd vss)
X0 (n29 refclk reset count_reset vdd vss) tx_dff_r1_pdk110_70
X1 (n30 refclk reset count_gate vdd vss) tx_dff_r0_pdk110_58
X2 (n31 refclk reset frequency_good vdd vss) tx_dff_r0_pdk110_58
X3 (n32 refclk reset valid vdd vss) tx_dff_r0_pdk110_58
X4 (n33 refclk reset n34 vdd vss) tx_dff_r0_pdk110_58
X5 (n35 refclk reset n36 vdd vss) tx_dff_r0_pdk110_58
X6 (n37 refclk reset n38 vdd vss) tx_dff_r0_pdk110_58
X7 (n39 refclk reset n40 vdd vss) tx_dff_r0_pdk110_58
X8 (n41 refclk reset n42 vdd vss) tx_dff_r0_pdk110_58
X9 (n43 refclk reset n44 vdd vss) tx_dff_r0_pdk110_58
X10 (n45 refclk reset n46 vdd vss) tx_dff_r0_pdk110_58
X11 (n47 refclk reset n48 vdd vss) tx_dff_r0_pdk110_58
X12 (count_reset n49 n50 n29 vdd vss) tx_mux_pdk110_64
X13 (count_gate n51 n52 n30 vdd vss) tx_mux_pdk110_64
X14 (frequency_good n53 n54 n31 vdd vss) tx_mux_pdk110_64
X15 (measured1 n55 vdd vss) pll_inv_pdk110_7
X16 (measured4 n56 vdd vss) pll_inv_pdk110_7
X17 (measured3 n57 vdd vss) pll_inv_pdk110_7
X18 (measured2 n58 vdd vss) pll_inv_pdk110_7
X19 (measured11 n59 vdd vss) pll_inv_pdk110_7
X20 (measured13 n60 vdd vss) pll_inv_pdk110_7
X21 (measured12 n61 vdd vss) pll_inv_pdk110_7
X22 (n62 n63 vdd vss) pll_inv_pdk110_7
X23 (n64 n65 vdd vss) pll_inv_pdk110_7
X24 (n66 n67 vdd vss) pll_inv_pdk110_7
X25 (n68 n69 vdd vss) pll_inv_pdk110_7
X26 (n70 n71 vdd vss) pll_inv_pdk110_7
X27 (n72 n73 vdd vss) pll_inv_pdk110_7
X28 (n74 n75 vdd vss) pll_inv_pdk110_7
X29 (target_k1 n76 vdd vss) pll_inv_pdk110_7
X30 (target_k0 n77 vdd vss) pll_inv_pdk110_7
X31 (active n78 vdd vss) pll_inv_pdk110_7
X32 (n79 n80 vdd vss) pll_inv_pdk110_7
X33 (n81 n82 vdd vss) pll_inv_pdk110_7
X34 (n38 n83 n84 vdd vss) tx_and_pdk110_47
X35 (n42 n85 n86 vdd vss) tx_and_pdk110_47
X36 (n87 n85 n88 vdd vss) tx_and_pdk110_47
X37 (n46 n88 n89 vdd vss) tx_and_pdk110_47
X38 (n90 n83 n85 vdd vss) tx_and_pdk110_47
X39 (n44 n42 n87 vdd vss) tx_and_pdk110_47
X40 (n40 n38 n90 vdd vss) tx_and_pdk110_47
X41 (n36 n34 n83 vdd vss) tx_and_pdk110_47
X42 (n91 n92 n81 vdd vss) tx_or_pdk110_67
X43 (n93 n94 n92 vdd vss) tx_and_pdk110_47
X44 (n95 n96 n94 vdd vss) tx_or_pdk110_67
X45 (n97 n98 n96 vdd vss) tx_and_pdk110_47
X46 (n99 n100 n93 vdd vss) tx_and_pdk110_47
X47 (target_k5 n101 n91 vdd vss) tx_or_pdk110_67
X48 (n99 target_k4 n101 vdd vss) tx_and_pdk110_47
X49 (n102 n94 n103 vdd vss) tx_and_pdk110_47
X50 (n104 n103 n79 vdd vss) tx_or_pdk110_67
X51 (target_k5 target_k4 n104 vdd vss) tx_and_pdk110_47
X52 (target_k3 target_k2 n95 vdd vss) tx_and_pdk110_47
X53 (target_k1 n105 n98 vdd vss) tx_or_pdk110_67
X54 (n76 target_k0 n105 vdd vss) tx_and_pdk110_47
X55 (measured4 n106 n107 vdd vss) tx_and_pdk110_47
X56 (measured2 n108 n109 vdd vss) tx_and_pdk110_47
X57 (measured10 n110 n111 vdd vss) tx_and_pdk110_47
X58 (n112 n113 n110 vdd vss) tx_and_pdk110_47
X59 (n114 n106 n115 vdd vss) tx_and_pdk110_47
X60 (measured6 n115 n116 vdd vss) tx_and_pdk110_47
X61 (n117 n113 n118 vdd vss) tx_and_pdk110_47
X62 (measured12 n118 n119 vdd vss) tx_and_pdk110_47
X63 (n120 n106 n113 vdd vss) tx_and_pdk110_47
X64 (n121 n112 n117 vdd vss) tx_and_pdk110_47
X65 (n122 n114 n120 vdd vss) tx_and_pdk110_47
X66 (n123 n108 n106 vdd vss) tx_and_pdk110_47
X67 (measured11 measured10 n121 vdd vss) tx_and_pdk110_47
X68 (measured9 measured8 n112 vdd vss) tx_and_pdk110_47
X69 (measured7 measured6 n122 vdd vss) tx_and_pdk110_47
X70 (measured5 measured4 n114 vdd vss) tx_and_pdk110_47
X71 (measured3 measured2 n123 vdd vss) tx_and_pdk110_47
X72 (measured8 n113 n124 vdd vss) tx_and_pdk110_47
X73 (measured1 measured0 n108 vdd vss) tx_and_pdk110_47
X74 (n125 n77 n126 vdd vss) tx_and_pdk110_47
X75 (n127 n76 n128 vdd vss) tx_and_pdk110_47
X76 (n129 n130 n131 vdd vss) tx_and_pdk110_47
X77 (n132 n133 n134 vdd vss) tx_and_pdk110_47
X78 (n135 n100 n136 vdd vss) tx_and_pdk110_47
X79 (n137 n99 n138 vdd vss) tx_and_pdk110_47
X80 (n125 n77 n139 vdd vss) tx_xor_pdk110_66
X81 (n127 n76 n140 vdd vss) tx_xor_pdk110_66
X82 (n129 n130 n141 vdd vss) tx_xor_pdk110_66
X83 (n132 n133 n142 vdd vss) tx_xor_pdk110_66
X84 (n135 n100 n143 vdd vss) tx_xor_pdk110_66
X85 (n137 n99 n144 vdd vss) tx_xor_pdk110_66
X86 (n145 n146 n147 vdd vss) tx_or_pdk110_67
X87 (n148 n149 n146 vdd vss) tx_and_pdk110_47
X88 (n150 n151 n149 vdd vss) tx_or_pdk110_67
X89 (n152 n153 n151 vdd vss) tx_and_pdk110_47
X90 (n154 n155 n153 vdd vss) tx_or_pdk110_67
X91 (n156 n157 n155 vdd vss) tx_and_pdk110_47
X92 (n158 n159 n150 vdd vss) tx_or_pdk110_67
X93 (n160 n161 n159 vdd vss) tx_and_pdk110_47
X94 (n162 n163 n154 vdd vss) tx_or_pdk110_67
X95 (n164 n165 n163 vdd vss) tx_and_pdk110_47
X96 (n166 n167 n157 vdd vss) tx_or_pdk110_67
X97 (n72 n168 n145 vdd vss) tx_or_pdk110_67
X98 (n73 n74 n168 vdd vss) tx_and_pdk110_47
X99 (n71 n144 n160 vdd vss) tx_and_pdk110_47
X100 (n70 n169 n158 vdd vss) tx_or_pdk110_67
X101 (n71 n138 n169 vdd vss) tx_and_pdk110_47
X102 (n143 n142 n170 vdd vss) tx_and_pdk110_47
X103 (n136 n171 n161 vdd vss) tx_or_pdk110_67
X104 (n143 n134 n171 vdd vss) tx_and_pdk110_47
X105 (n131 n172 n162 vdd vss) tx_or_pdk110_67
X106 (n141 n128 n172 vdd vss) tx_and_pdk110_47
X107 (n126 n173 n165 vdd vss) tx_or_pdk110_67
X108 (n139 n64 n173 vdd vss) tx_and_pdk110_47
X109 (n67 n69 n167 vdd vss) tx_and_pdk110_47
X110 (n66 n174 n166 vdd vss) tx_or_pdk110_67
X111 (n67 n68 n174 vdd vss) tx_and_pdk110_47
X112 (measured5 n77 n175 vdd vss) tx_and_pdk110_47
X113 (measured6 n76 n176 vdd vss) tx_and_pdk110_47
X114 (measured7 n130 n177 vdd vss) tx_and_pdk110_47
X115 (measured8 n133 n178 vdd vss) tx_and_pdk110_47
X116 (measured9 n100 n179 vdd vss) tx_and_pdk110_47
X117 (measured10 n99 n180 vdd vss) tx_and_pdk110_47
X118 (measured5 n77 n181 vdd vss) tx_xor_pdk110_66
X119 (measured6 n76 n182 vdd vss) tx_xor_pdk110_66
X120 (measured7 n130 n183 vdd vss) tx_xor_pdk110_66
X121 (measured8 n133 n184 vdd vss) tx_xor_pdk110_66
X122 (measured9 n100 n185 vdd vss) tx_xor_pdk110_66
X123 (measured10 n99 n186 vdd vss) tx_xor_pdk110_66
X124 (n187 n188 n189 vdd vss) tx_or_pdk110_67
X125 (n190 n191 n188 vdd vss) tx_and_pdk110_47
X126 (n192 n193 n191 vdd vss) tx_or_pdk110_67
X127 (n194 n195 n193 vdd vss) tx_and_pdk110_47
X128 (n196 n197 n195 vdd vss) tx_or_pdk110_67
X129 (n198 n199 n197 vdd vss) tx_and_pdk110_47
X130 (n200 n201 n192 vdd vss) tx_or_pdk110_67
X131 (n202 n203 n201 vdd vss) tx_and_pdk110_47
X132 (n204 n205 n196 vdd vss) tx_or_pdk110_67
X133 (n206 n207 n205 vdd vss) tx_and_pdk110_47
X134 (n208 n209 n199 vdd vss) tx_or_pdk110_67
X135 (n210 n211 n209 vdd vss) tx_and_pdk110_47
X136 (measured13 n212 n187 vdd vss) tx_or_pdk110_67
X137 (n60 measured12 n212 vdd vss) tx_and_pdk110_47
X138 (measured11 n213 n200 vdd vss) tx_or_pdk110_67
X139 (n59 n180 n213 vdd vss) tx_and_pdk110_47
X140 (n185 n184 n214 vdd vss) tx_and_pdk110_47
X141 (n179 n215 n203 vdd vss) tx_or_pdk110_67
X142 (n185 n178 n215 vdd vss) tx_and_pdk110_47
X143 (n183 n182 n206 vdd vss) tx_and_pdk110_47
X144 (n177 n216 n204 vdd vss) tx_or_pdk110_67
X145 (n183 n176 n216 vdd vss) tx_and_pdk110_47
X146 (n181 n56 n217 vdd vss) tx_and_pdk110_47
X147 (n175 n218 n207 vdd vss) tx_or_pdk110_67
X148 (n181 measured4 n218 vdd vss) tx_and_pdk110_47
X149 (measured3 n219 n208 vdd vss) tx_or_pdk110_67
X150 (n57 measured2 n219 vdd vss) tx_and_pdk110_47
X151 (measured1 n220 n211 vdd vss) tx_or_pdk110_67
X152 (n55 measured0 n220 vdd vss) tx_and_pdk110_47
X153 (n82 n221 n222 vdd vss) tx_or_pdk110_67
X154 (n223 n224 n225 vdd vss) tx_or_pdk110_67
X155 (n36 n34 n226 vdd vss) tx_xor_pdk110_66
X156 (n38 n83 n227 vdd vss) tx_xor_pdk110_66
X157 (n40 n84 n228 vdd vss) tx_xor_pdk110_66
X158 (n42 n85 n229 vdd vss) tx_xor_pdk110_66
X159 (n44 n86 n230 vdd vss) tx_xor_pdk110_66
X160 (n46 n88 n231 vdd vss) tx_xor_pdk110_66
X161 (n48 n89 n232 vdd vss) tx_xor_pdk110_66
X162 (measured1 measured0 n62 vdd vss) tx_xor_pdk110_66
X163 (measured2 n108 n68 vdd vss) tx_xor_pdk110_66
X164 (measured3 n109 n66 vdd vss) tx_xor_pdk110_66
X165 (measured4 n106 n64 vdd vss) tx_xor_pdk110_66
X166 (measured5 n107 n125 vdd vss) tx_xor_pdk110_66
X167 (measured6 n115 n127 vdd vss) tx_xor_pdk110_66
X168 (measured7 n116 n129 vdd vss) tx_xor_pdk110_66
X169 (measured8 n113 n132 vdd vss) tx_xor_pdk110_66
X170 (measured9 n124 n135 vdd vss) tx_xor_pdk110_66
X171 (measured10 n110 n137 vdd vss) tx_xor_pdk110_66
X172 (measured11 n111 n70 vdd vss) tx_xor_pdk110_66
X173 (measured12 n118 n74 vdd vss) tx_xor_pdk110_66
X174 (measured13 n119 n72 vdd vss) tx_xor_pdk110_66
X175 (n78 n233 n234 vdd vss) tx_or_pdk110_67
X176 (n234 n235 n50 vdd vss) tx_or_pdk110_67
X177 (n78 n236 n237 vdd vss) tx_or_pdk110_67
X178 (n237 n238 n52 vdd vss) tx_or_pdk110_67
X179 (n78 n239 n54 vdd vss) tx_or_pdk110_67
X180 (n240 n36 n241 vdd vss) tx_or_pdk110_67
X181 (n241 n242 n243 vdd vss) tx_or_pdk110_67
X182 (n243 n244 n245 vdd vss) tx_or_pdk110_67
X183 (n246 n40 n242 vdd vss) tx_or_pdk110_67
X184 (n247 n242 n248 vdd vss) tx_or_pdk110_67
X185 (n248 n244 n249 vdd vss) tx_or_pdk110_67
X186 (n42 n250 n251 vdd vss) tx_or_pdk110_67
X187 (n251 n252 n244 vdd vss) tx_or_pdk110_67
X188 (n253 n244 n254 vdd vss) tx_or_pdk110_67
X189 (n34 n255 n247 vdd vss) tx_or_pdk110_67
X190 (n38 n40 n256 vdd vss) tx_or_pdk110_67
X191 (n42 n44 n257 vdd vss) tx_or_pdk110_67
X192 (n46 n48 n252 vdd vss) tx_or_pdk110_67
X193 (n247 n256 n253 vdd vss) tx_or_pdk110_67
X194 (n257 n252 n258 vdd vss) tx_or_pdk110_67
X195 (n253 n258 n259 vdd vss) tx_or_pdk110_67
X196 (n260 n93 n221 vdd vss) tx_and_pdk110_47
X197 (n261 n221 n262 vdd vss) tx_or_pdk110_67
X198 (n130 target_k3 n97 vdd vss) tx_and_pdk110_47
X199 (n100 target_k5 n102 vdd vss) tx_and_pdk110_47
X200 (n105 n97 n260 vdd vss) tx_and_pdk110_47
X201 (n260 n102 n263 vdd vss) tx_and_pdk110_47
X202 (n80 n263 n264 vdd vss) tx_or_pdk110_67
X203 (measured0 n63 n265 vdd vss) tx_and_pdk110_47
X204 (n65 n139 n266 vdd vss) tx_and_pdk110_47
X205 (n140 n141 n164 vdd vss) tx_and_pdk110_47
X206 (n75 n73 n148 vdd vss) tx_and_pdk110_47
X207 (n265 n167 n267 vdd vss) tx_and_pdk110_47
X208 (n266 n164 n156 vdd vss) tx_and_pdk110_47
X209 (n170 n160 n152 vdd vss) tx_and_pdk110_47
X210 (n267 n156 n268 vdd vss) tx_and_pdk110_47
X211 (n152 n148 n269 vdd vss) tx_and_pdk110_47
X212 (n268 n269 n224 vdd vss) tx_and_pdk110_47
X213 (n270 n224 n271 vdd vss) tx_or_pdk110_67
X214 (n58 n57 n210 vdd vss) tx_and_pdk110_47
X215 (n186 n59 n202 vdd vss) tx_and_pdk110_47
X216 (n61 n60 n190 vdd vss) tx_and_pdk110_47
X217 (n220 n210 n272 vdd vss) tx_and_pdk110_47
X218 (n217 n206 n198 vdd vss) tx_and_pdk110_47
X219 (n214 n202 n194 vdd vss) tx_and_pdk110_47
X220 (n272 n198 n273 vdd vss) tx_and_pdk110_47
X221 (n194 n190 n274 vdd vss) tx_and_pdk110_47
X222 (n273 n274 n275 vdd vss) tx_and_pdk110_47
X223 (n276 n275 n277 vdd vss) tx_or_pdk110_67
X224 (n233 n235 n278 vdd vss) tx_or_pdk110_67
X225 (n34 n36 n279 vdd vss) tx_or_pdk110_67
X226 (n279 n256 n280 vdd vss) tx_or_pdk110_67
X227 (n280 n258 n281 vdd vss) tx_or_pdk110_67
X228 (n236 n238 n282 vdd vss) tx_or_pdk110_67
X229 (n245 n239 vdd vss) pll_inv_pdk110_7
X230 (n249 n233 vdd vss) pll_inv_pdk110_7
X231 (n281 n235 vdd vss) pll_inv_pdk110_7
X232 (n254 n236 vdd vss) pll_inv_pdk110_7
X233 (n259 n238 vdd vss) pll_inv_pdk110_7
X234 (n262 n264 n283 vdd vss) tx_and_pdk110_47
X235 (n283 n271 n284 vdd vss) tx_and_pdk110_47
X236 (n284 n277 n285 vdd vss) tx_and_pdk110_47
X237 (vss n239 active n32 vdd vss) tx_mux_pdk110_64
X238 (vss n240 active n33 vdd vss) tx_mux_pdk110_64
X239 (vss n226 active n35 vdd vss) tx_mux_pdk110_64
X240 (vss n227 active n37 vdd vss) tx_mux_pdk110_64
X241 (vss n228 active n39 vdd vss) tx_mux_pdk110_64
X242 (vss n229 active n41 vdd vss) tx_mux_pdk110_64
X243 (vss n230 active n43 vdd vss) tx_mux_pdk110_64
X244 (vss n231 active n45 vdd vss) tx_mux_pdk110_64
X245 (vss n232 active n47 vdd vss) tx_mux_pdk110_64
X246 (n285 nx n245 n286 vdd vss) tx_mux_pdk110_64
X247 (vss n286 active n53 vdd vss) tx_mux_pdk110_64
X248 (vdd n287 active n49 vdd vss) tx_mux_pdk110_64
X249 (vss n288 active n51 vdd vss) tx_mux_pdk110_64
X250 (target_k2 n130 vdd vss) pll_inv_pdk110_7
X251 (target_k3 n133 vdd vss) pll_inv_pdk110_7
X252 (target_k4 n100 vdd vss) pll_inv_pdk110_7
X253 (target_k5 n99 vdd vss) pll_inv_pdk110_7
X254 (n222 n261 vdd vss) pll_inv_pdk110_7
X255 (n225 n270 vdd vss) pll_inv_pdk110_7
X256 (n147 n223 vdd vss) pll_inv_pdk110_7
X257 (n189 n276 vdd vss) pll_inv_pdk110_7
X258 (n34 n240 vdd vss) pll_inv_pdk110_7
X259 (n36 n255 vdd vss) pll_inv_pdk110_7
X260 (n38 n246 vdd vss) pll_inv_pdk110_7
X261 (n44 n250 vdd vss) pll_inv_pdk110_7
X262 (nx n233 n278 n287 vdd vss) tx_mux_pdk110_64
X263 (nx n238 n282 n288 vdd vss) tx_mux_pdk110_64
// @RNL(author="functional-compact127") {
// $CELL = @DEFINE-SYMBOL {
// @LINE {(-18, -48) (18, -48) (18, 48) (-18, 48) (-18, -48)};
// (0, 4) @TEXT("f / fref", size=1.05, halign="middle");
// @LINE {(-4, 0) (4, 0)};
// (0, -3) @TEXT("WINDOW", size=0.85, halign="middle");
// (0, -7) @TEXT("good / fault", size=0.7, halign="middle");
// (-20, 44) @PIN(terminal="refclk", direction="left");
// @LINE {(-20, 44) (-18, 44)};
// (-17.4, 44) @TEXT("refclk", size=0.7, halign="start");
// (-20, 40) @PIN(terminal="reset", direction="left");
// @LINE {(-20, 40) (-18, 40)};
// (-17.4, 40) @TEXT("reset", size=0.7, halign="start");
// (-20, 36) @PIN(terminal="active", direction="left");
// @LINE {(-20, 36) (-18, 36)};
// (-17.4, 36) @TEXT("active", size=0.7, halign="start");
// (-20, 32) @PIN(terminal="target_k0", direction="left");
// @LINE {(-20, 32) (-18, 32)};
// (-17.4, 32) @TEXT("target_k0", size=0.7, halign="start");
// (-20, 28) @PIN(terminal="target_k1", direction="left");
// @LINE {(-20, 28) (-18, 28)};
// (-17.4, 28) @TEXT("target_k1", size=0.7, halign="start");
// (-20, 24) @PIN(terminal="target_k2", direction="left");
// @LINE {(-20, 24) (-18, 24)};
// (-17.4, 24) @TEXT("target_k2", size=0.7, halign="start");
// (-20, 20) @PIN(terminal="target_k3", direction="left");
// @LINE {(-20, 20) (-18, 20)};
// (-17.4, 20) @TEXT("target_k3", size=0.7, halign="start");
// (-20, 16) @PIN(terminal="target_k4", direction="left");
// @LINE {(-20, 16) (-18, 16)};
// (-17.4, 16) @TEXT("target_k4", size=0.7, halign="start");
// (-20, 12) @PIN(terminal="target_k5", direction="left");
// @LINE {(-20, 12) (-18, 12)};
// (-17.4, 12) @TEXT("target_k5", size=0.7, halign="start");
// (-20, 8) @PIN(terminal="measured0", direction="left");
// @LINE {(-20, 8) (-18, 8)};
// (-17.4, 8) @TEXT("measured0", size=0.7, halign="start");
// (-20, 4) @PIN(terminal="measured1", direction="left");
// @LINE {(-20, 4) (-18, 4)};
// (-17.4, 4) @TEXT("measured1", size=0.7, halign="start");
// (-20, 0) @PIN(terminal="measured2", direction="left");
// @LINE {(-20, 0) (-18, 0)};
// (-17.4, 0) @TEXT("measured2", size=0.7, halign="start");
// (-20, -4) @PIN(terminal="measured3", direction="left");
// @LINE {(-20, -4) (-18, -4)};
// (-17.4, -4) @TEXT("measured3", size=0.7, halign="start");
// (-20, -8) @PIN(terminal="measured4", direction="left");
// @LINE {(-20, -8) (-18, -8)};
// (-17.4, -8) @TEXT("measured4", size=0.7, halign="start");
// (-20, -12) @PIN(terminal="measured5", direction="left");
// @LINE {(-20, -12) (-18, -12)};
// (-17.4, -12) @TEXT("measured5", size=0.7, halign="start");
// (-20, -16) @PIN(terminal="measured6", direction="left");
// @LINE {(-20, -16) (-18, -16)};
// (-17.4, -16) @TEXT("measured6", size=0.7, halign="start");
// (-20, -20) @PIN(terminal="measured7", direction="left");
// @LINE {(-20, -20) (-18, -20)};
// (-17.4, -20) @TEXT("measured7", size=0.7, halign="start");
// (-20, -24) @PIN(terminal="measured8", direction="left");
// @LINE {(-20, -24) (-18, -24)};
// (-17.4, -24) @TEXT("measured8", size=0.7, halign="start");
// (-20, -28) @PIN(terminal="measured9", direction="left");
// @LINE {(-20, -28) (-18, -28)};
// (-17.4, -28) @TEXT("measured9", size=0.7, halign="start");
// (-20, -32) @PIN(terminal="measured10", direction="left");
// @LINE {(-20, -32) (-18, -32)};
// (-17.4, -32) @TEXT("measured10", size=0.7, halign="start");
// (-20, -36) @PIN(terminal="measured11", direction="left");
// @LINE {(-20, -36) (-18, -36)};
// (-17.4, -36) @TEXT("measured11", size=0.7, halign="start");
// (-20, -40) @PIN(terminal="measured12", direction="left");
// @LINE {(-20, -40) (-18, -40)};
// (-17.4, -40) @TEXT("measured12", size=0.7, halign="start");
// (-20, -44) @PIN(terminal="measured13", direction="left");
// @LINE {(-20, -44) (-18, -44)};
// (-17.4, -44) @TEXT("measured13", size=0.7, halign="start");
// (20, 6) @PIN(terminal="count_gate", direction="right");
// @LINE {(20, 6) (18, 6)};
// (17.4, 6) @TEXT("count_gate", size=0.7, halign="end");
// (20, 2) @PIN(terminal="count_reset", direction="right");
// @LINE {(20, 2) (18, 2)};
// (17.4, 2) @TEXT("count_reset", size=0.7, halign="end");
// (20, -2) @PIN(terminal="frequency_good", direction="right");
// @LINE {(20, -2) (18, -2)};
// (17.4, -2) @TEXT("frequency_good", size=0.7, halign="end");
// (20, -6) @PIN(terminal="valid", direction="right");
// @LINE {(20, -6) (18, -6)};
// (17.4, -6) @TEXT("valid", size=0.7, halign="end");
// (0, 50) @PIN(terminal="vdd", direction="up");
// @LINE {(0, 50) (0, 48)};
// (0, -50) @PIN(terminal="vss", direction="down");
// @LINE {(0, -50) (0, -48)};
// ? @TEXT("${name}", key="name", size=1, halign="middle") => @PLACE(20, 51.5);
// (0, 47.1) @TEXT("Watchdog", size=0.85, halign="middle");
// };
// # @SET-SYMBOL $CELL;
// #X0 @PLACE(0, -77) => @ORIENT("R0");
// (-25, -63) @TEXT("Panel 01 | X0 - X23", size=1.1, halign="start");
// #X1 @PLACE(40, -77) => @ORIENT("R0");
// #X2 @PLACE(80, -77) => @ORIENT("R0");
// #X3 @PLACE(120, -77) => @ORIENT("R0");
// #X4 @PLACE(0, -112) => @ORIENT("R0");
// #X5 @PLACE(40, -112) => @ORIENT("R0");
// #X6 @PLACE(80, -112) => @ORIENT("R0");
// #X7 @PLACE(120, -112) => @ORIENT("R0");
// #X8 @PLACE(0, -147) => @ORIENT("R0");
// #X9 @PLACE(40, -147) => @ORIENT("R0");
// #X10 @PLACE(80, -147) => @ORIENT("R0");
// #X11 @PLACE(120, -147) => @ORIENT("R0");
// #X12 @PLACE(0, -182) => @ORIENT("R0");
// #X13 @PLACE(40, -182) => @ORIENT("R0");
// #X14 @PLACE(80, -182) => @ORIENT("R0");
// #X15 @PLACE(120, -182) => @ORIENT("R0");
// #X16 @PLACE(0, -215) => @ORIENT("R0");
// #X17 @PLACE(40, -215) => @ORIENT("R0");
// #X18 @PLACE(80, -215) => @ORIENT("R0");
// #X19 @PLACE(120, -215) => @ORIENT("R0");
// #X20 @PLACE(0, -246) => @ORIENT("R0");
// #X21 @PLACE(40, -246) => @ORIENT("R0");
// #X22 @PLACE(80, -246) => @ORIENT("R0");
// #X23 @PLACE(120, -246) => @ORIENT("R0");
// #X24 @PLACE(168, -77) => @ORIENT("R0");
// (152, -63) @TEXT("Panel 02 | X24 - X47", size=1.1, halign="start");
// #X25 @PLACE(208, -77) => @ORIENT("R0");
// #X26 @PLACE(248, -77) => @ORIENT("R0");
// #X27 @PLACE(288, -77) => @ORIENT("R0");
// #X28 @PLACE(168, -112) => @ORIENT("R0");
// #X29 @PLACE(208, -112) => @ORIENT("R0");
// #X30 @PLACE(248, -112) => @ORIENT("R0");
// #X31 @PLACE(288, -112) => @ORIENT("R0");
// #X32 @PLACE(168, -147) => @ORIENT("R0");
// #X33 @PLACE(208, -147) => @ORIENT("R0");
// #X34 @PLACE(248, -147) => @ORIENT("R0");
// #X35 @PLACE(288, -147) => @ORIENT("R0");
// #X36 @PLACE(168, -182) => @ORIENT("R0");
// #X37 @PLACE(208, -182) => @ORIENT("R0");
// #X38 @PLACE(248, -182) => @ORIENT("R0");
// #X39 @PLACE(288, -182) => @ORIENT("R0");
// #X40 @PLACE(168, -215) => @ORIENT("R0");
// #X41 @PLACE(208, -215) => @ORIENT("R0");
// #X42 @PLACE(248, -215) => @ORIENT("R0");
// #X43 @PLACE(288, -215) => @ORIENT("R0");
// #X44 @PLACE(168, -246) => @ORIENT("R0");
// #X45 @PLACE(208, -246) => @ORIENT("R0");
// #X46 @PLACE(248, -246) => @ORIENT("R0");
// #X47 @PLACE(288, -246) => @ORIENT("R0");
// #X48 @PLACE(336, -77) => @ORIENT("R0");
// (320, -63) @TEXT("Panel 03 | X48 - X71", size=1.1, halign="start");
// #X49 @PLACE(376, -77) => @ORIENT("R0");
// #X50 @PLACE(416, -77) => @ORIENT("R0");
// #X51 @PLACE(456, -77) => @ORIENT("R0");
// #X52 @PLACE(336, -112) => @ORIENT("R0");
// #X53 @PLACE(376, -112) => @ORIENT("R0");
// #X54 @PLACE(416, -112) => @ORIENT("R0");
// #X55 @PLACE(456, -112) => @ORIENT("R0");
// #X56 @PLACE(336, -147) => @ORIENT("R0");
// #X57 @PLACE(376, -147) => @ORIENT("R0");
// #X58 @PLACE(416, -147) => @ORIENT("R0");
// #X59 @PLACE(456, -147) => @ORIENT("R0");
// #X60 @PLACE(336, -182) => @ORIENT("R0");
// #X61 @PLACE(376, -182) => @ORIENT("R0");
// #X62 @PLACE(416, -182) => @ORIENT("R0");
// #X63 @PLACE(456, -182) => @ORIENT("R0");
// #X64 @PLACE(336, -215) => @ORIENT("R0");
// #X65 @PLACE(376, -215) => @ORIENT("R0");
// #X66 @PLACE(416, -215) => @ORIENT("R0");
// #X67 @PLACE(456, -215) => @ORIENT("R0");
// #X68 @PLACE(336, -246) => @ORIENT("R0");
// #X69 @PLACE(376, -246) => @ORIENT("R0");
// #X70 @PLACE(416, -246) => @ORIENT("R0");
// #X71 @PLACE(456, -246) => @ORIENT("R0");
// #X72 @PLACE(504, -77) => @ORIENT("R0");
// (488, -63) @TEXT("Panel 04 | X72 - X95", size=1.1, halign="start");
// #X73 @PLACE(544, -77) => @ORIENT("R0");
// #X74 @PLACE(584, -77) => @ORIENT("R0");
// #X75 @PLACE(624, -77) => @ORIENT("R0");
// #X76 @PLACE(504, -112) => @ORIENT("R0");
// #X77 @PLACE(544, -112) => @ORIENT("R0");
// #X78 @PLACE(584, -112) => @ORIENT("R0");
// #X79 @PLACE(624, -112) => @ORIENT("R0");
// #X80 @PLACE(504, -147) => @ORIENT("R0");
// #X81 @PLACE(544, -147) => @ORIENT("R0");
// #X82 @PLACE(584, -147) => @ORIENT("R0");
// #X83 @PLACE(624, -147) => @ORIENT("R0");
// #X84 @PLACE(504, -182) => @ORIENT("R0");
// #X85 @PLACE(544, -182) => @ORIENT("R0");
// #X86 @PLACE(584, -182) => @ORIENT("R0");
// #X87 @PLACE(624, -182) => @ORIENT("R0");
// #X88 @PLACE(504, -215) => @ORIENT("R0");
// #X89 @PLACE(544, -215) => @ORIENT("R0");
// #X90 @PLACE(584, -215) => @ORIENT("R0");
// #X91 @PLACE(624, -215) => @ORIENT("R0");
// #X92 @PLACE(504, -246) => @ORIENT("R0");
// #X93 @PLACE(544, -246) => @ORIENT("R0");
// #X94 @PLACE(584, -246) => @ORIENT("R0");
// #X95 @PLACE(624, -246) => @ORIENT("R0");
// #X96 @PLACE(0, -289) => @ORIENT("R0");
// (-25, -275) @TEXT("Panel 05 | X96 - X119", size=1.1, halign="start");
// #X97 @PLACE(40, -289) => @ORIENT("R0");
// #X98 @PLACE(80, -289) => @ORIENT("R0");
// #X99 @PLACE(120, -289) => @ORIENT("R0");
// #X100 @PLACE(0, -320) => @ORIENT("R0");
// #X101 @PLACE(40, -320) => @ORIENT("R0");
// #X102 @PLACE(80, -320) => @ORIENT("R0");
// #X103 @PLACE(120, -320) => @ORIENT("R0");
// #X104 @PLACE(0, -351) => @ORIENT("R0");
// #X105 @PLACE(40, -351) => @ORIENT("R0");
// #X106 @PLACE(80, -351) => @ORIENT("R0");
// #X107 @PLACE(120, -351) => @ORIENT("R0");
// #X108 @PLACE(0, -382) => @ORIENT("R0");
// #X109 @PLACE(40, -382) => @ORIENT("R0");
// #X110 @PLACE(80, -382) => @ORIENT("R0");
// #X111 @PLACE(120, -382) => @ORIENT("R0");
// #X112 @PLACE(0, -413) => @ORIENT("R0");
// #X113 @PLACE(40, -413) => @ORIENT("R0");
// #X114 @PLACE(80, -413) => @ORIENT("R0");
// #X115 @PLACE(120, -413) => @ORIENT("R0");
// #X116 @PLACE(0, -444) => @ORIENT("R0");
// #X117 @PLACE(40, -444) => @ORIENT("R0");
// #X118 @PLACE(80, -444) => @ORIENT("R0");
// #X119 @PLACE(120, -444) => @ORIENT("R0");
// #X120 @PLACE(168, -289) => @ORIENT("R0");
// (152, -275) @TEXT("Panel 06 | X120 - X143", size=1.1, halign="start");
// #X121 @PLACE(208, -289) => @ORIENT("R0");
// #X122 @PLACE(248, -289) => @ORIENT("R0");
// #X123 @PLACE(288, -289) => @ORIENT("R0");
// #X124 @PLACE(168, -320) => @ORIENT("R0");
// #X125 @PLACE(208, -320) => @ORIENT("R0");
// #X126 @PLACE(248, -320) => @ORIENT("R0");
// #X127 @PLACE(288, -320) => @ORIENT("R0");
// #X128 @PLACE(168, -351) => @ORIENT("R0");
// #X129 @PLACE(208, -351) => @ORIENT("R0");
// #X130 @PLACE(248, -351) => @ORIENT("R0");
// #X131 @PLACE(288, -351) => @ORIENT("R0");
// #X132 @PLACE(168, -382) => @ORIENT("R0");
// #X133 @PLACE(208, -382) => @ORIENT("R0");
// #X134 @PLACE(248, -382) => @ORIENT("R0");
// #X135 @PLACE(288, -382) => @ORIENT("R0");
// #X136 @PLACE(168, -413) => @ORIENT("R0");
// #X137 @PLACE(208, -413) => @ORIENT("R0");
// #X138 @PLACE(248, -413) => @ORIENT("R0");
// #X139 @PLACE(288, -413) => @ORIENT("R0");
// #X140 @PLACE(168, -444) => @ORIENT("R0");
// #X141 @PLACE(208, -444) => @ORIENT("R0");
// #X142 @PLACE(248, -444) => @ORIENT("R0");
// #X143 @PLACE(288, -444) => @ORIENT("R0");
// #X144 @PLACE(336, -289) => @ORIENT("R0");
// (320, -275) @TEXT("Panel 07 | X144 - X167", size=1.1, halign="start");
// #X145 @PLACE(376, -289) => @ORIENT("R0");
// #X146 @PLACE(416, -289) => @ORIENT("R0");
// #X147 @PLACE(456, -289) => @ORIENT("R0");
// #X148 @PLACE(336, -320) => @ORIENT("R0");
// #X149 @PLACE(376, -320) => @ORIENT("R0");
// #X150 @PLACE(416, -320) => @ORIENT("R0");
// #X151 @PLACE(456, -320) => @ORIENT("R0");
// #X152 @PLACE(336, -351) => @ORIENT("R0");
// #X153 @PLACE(376, -351) => @ORIENT("R0");
// #X154 @PLACE(416, -351) => @ORIENT("R0");
// #X155 @PLACE(456, -351) => @ORIENT("R0");
// #X156 @PLACE(336, -382) => @ORIENT("R0");
// #X157 @PLACE(376, -382) => @ORIENT("R0");
// #X158 @PLACE(416, -382) => @ORIENT("R0");
// #X159 @PLACE(456, -382) => @ORIENT("R0");
// #X160 @PLACE(336, -413) => @ORIENT("R0");
// #X161 @PLACE(376, -413) => @ORIENT("R0");
// #X162 @PLACE(416, -413) => @ORIENT("R0");
// #X163 @PLACE(456, -413) => @ORIENT("R0");
// #X164 @PLACE(336, -444) => @ORIENT("R0");
// #X165 @PLACE(376, -444) => @ORIENT("R0");
// #X166 @PLACE(416, -444) => @ORIENT("R0");
// #X167 @PLACE(456, -444) => @ORIENT("R0");
// #X168 @PLACE(504, -289) => @ORIENT("R0");
// (488, -275) @TEXT("Panel 08 | X168 - X191", size=1.1, halign="start");
// #X169 @PLACE(544, -289) => @ORIENT("R0");
// #X170 @PLACE(584, -289) => @ORIENT("R0");
// #X171 @PLACE(624, -289) => @ORIENT("R0");
// #X172 @PLACE(504, -320) => @ORIENT("R0");
// #X173 @PLACE(544, -320) => @ORIENT("R0");
// #X174 @PLACE(584, -320) => @ORIENT("R0");
// #X175 @PLACE(624, -320) => @ORIENT("R0");
// #X176 @PLACE(504, -351) => @ORIENT("R0");
// #X177 @PLACE(544, -351) => @ORIENT("R0");
// #X178 @PLACE(584, -351) => @ORIENT("R0");
// #X179 @PLACE(624, -351) => @ORIENT("R0");
// #X180 @PLACE(504, -382) => @ORIENT("R0");
// #X181 @PLACE(544, -382) => @ORIENT("R0");
// #X182 @PLACE(584, -382) => @ORIENT("R0");
// #X183 @PLACE(624, -382) => @ORIENT("R0");
// #X184 @PLACE(504, -413) => @ORIENT("R0");
// #X185 @PLACE(544, -413) => @ORIENT("R0");
// #X186 @PLACE(584, -413) => @ORIENT("R0");
// #X187 @PLACE(624, -413) => @ORIENT("R0");
// #X188 @PLACE(504, -444) => @ORIENT("R0");
// #X189 @PLACE(544, -444) => @ORIENT("R0");
// #X190 @PLACE(584, -444) => @ORIENT("R0");
// #X191 @PLACE(624, -444) => @ORIENT("R0");
// #X192 @PLACE(0, -488) => @ORIENT("R0");
// (-25, -474) @TEXT("Panel 09 | X192 - X215", size=1.1, halign="start");
// #X193 @PLACE(40, -488) => @ORIENT("R0");
// #X194 @PLACE(80, -488) => @ORIENT("R0");
// #X195 @PLACE(120, -488) => @ORIENT("R0");
// #X196 @PLACE(0, -523) => @ORIENT("R0");
// #X197 @PLACE(40, -523) => @ORIENT("R0");
// #X198 @PLACE(80, -523) => @ORIENT("R0");
// #X199 @PLACE(120, -523) => @ORIENT("R0");
// #X200 @PLACE(0, -558) => @ORIENT("R0");
// #X201 @PLACE(40, -558) => @ORIENT("R0");
// #X202 @PLACE(80, -558) => @ORIENT("R0");
// #X203 @PLACE(120, -558) => @ORIENT("R0");
// #X204 @PLACE(0, -591) => @ORIENT("R0");
// #X205 @PLACE(40, -591) => @ORIENT("R0");
// #X206 @PLACE(80, -591) => @ORIENT("R0");
// #X207 @PLACE(120, -591) => @ORIENT("R0");
// #X208 @PLACE(0, -622) => @ORIENT("R0");
// #X209 @PLACE(40, -622) => @ORIENT("R0");
// #X210 @PLACE(80, -622) => @ORIENT("R0");
// #X211 @PLACE(120, -622) => @ORIENT("R0");
// #X212 @PLACE(0, -655) => @ORIENT("R0");
// #X213 @PLACE(40, -655) => @ORIENT("R0");
// #X214 @PLACE(80, -655) => @ORIENT("R0");
// #X215 @PLACE(120, -655) => @ORIENT("R0");
// #X216 @PLACE(168, -488) => @ORIENT("R0");
// (152, -474) @TEXT("Panel 10 | X216 - X239", size=1.1, halign="start");
// #X217 @PLACE(208, -488) => @ORIENT("R0");
// #X218 @PLACE(248, -488) => @ORIENT("R0");
// #X219 @PLACE(288, -488) => @ORIENT("R0");
// #X220 @PLACE(168, -523) => @ORIENT("R0");
// #X221 @PLACE(208, -523) => @ORIENT("R0");
// #X222 @PLACE(248, -523) => @ORIENT("R0");
// #X223 @PLACE(288, -523) => @ORIENT("R0");
// #X224 @PLACE(168, -558) => @ORIENT("R0");
// #X225 @PLACE(208, -558) => @ORIENT("R0");
// #X226 @PLACE(248, -558) => @ORIENT("R0");
// #X227 @PLACE(288, -558) => @ORIENT("R0");
// #X228 @PLACE(168, -591) => @ORIENT("R0");
// #X229 @PLACE(208, -591) => @ORIENT("R0");
// #X230 @PLACE(248, -591) => @ORIENT("R0");
// #X231 @PLACE(288, -591) => @ORIENT("R0");
// #X232 @PLACE(168, -622) => @ORIENT("R0");
// #X233 @PLACE(208, -622) => @ORIENT("R0");
// #X234 @PLACE(248, -622) => @ORIENT("R0");
// #X235 @PLACE(288, -622) => @ORIENT("R0");
// #X236 @PLACE(168, -655) => @ORIENT("R0");
// #X237 @PLACE(208, -655) => @ORIENT("R0");
// #X238 @PLACE(248, -655) => @ORIENT("R0");
// #X239 @PLACE(288, -655) => @ORIENT("R0");
// #X240 @PLACE(336, -488) => @ORIENT("R0");
// (320, -474) @TEXT("Panel 11 | X240 - X263", size=1.1, halign="start");
// #X241 @PLACE(376, -488) => @ORIENT("R0");
// #X242 @PLACE(416, -488) => @ORIENT("R0");
// #X243 @PLACE(456, -488) => @ORIENT("R0");
// #X244 @PLACE(336, -523) => @ORIENT("R0");
// #X245 @PLACE(376, -523) => @ORIENT("R0");
// #X246 @PLACE(416, -523) => @ORIENT("R0");
// #X247 @PLACE(456, -523) => @ORIENT("R0");
// #X248 @PLACE(336, -558) => @ORIENT("R0");
// #X249 @PLACE(376, -558) => @ORIENT("R0");
// #X250 @PLACE(416, -558) => @ORIENT("R0");
// #X251 @PLACE(456, -558) => @ORIENT("R0");
// #X252 @PLACE(336, -591) => @ORIENT("R0");
// #X253 @PLACE(376, -591) => @ORIENT("R0");
// #X254 @PLACE(416, -591) => @ORIENT("R0");
// #X255 @PLACE(456, -591) => @ORIENT("R0");
// #X256 @PLACE(336, -622) => @ORIENT("R0");
// #X257 @PLACE(376, -622) => @ORIENT("R0");
// #X258 @PLACE(416, -622) => @ORIENT("R0");
// #X259 @PLACE(456, -622) => @ORIENT("R0");
// #X260 @PLACE(336, -655) => @ORIENT("R0");
// #X261 @PLACE(376, -655) => @ORIENT("R0");
// #X262 @PLACE(416, -655) => @ORIENT("R0");
// #X263 @PLACE(456, -655) => @ORIENT("R0");
// %t1 = $IO_PORT @ATTACH &n29 => @PLACE(-11, -73) => @ORIENT("R0");
// %t1 @TEXT("n29", key="name", size=0.75);
// &n29 @WIRE(mode="straight") {#X0:1 %t1:p};
// %t2 = $IO_PORT @ATTACH &refclk => @PLACE(-11, -77) => @ORIENT("R0");
// %t2 @TEXT("refclk", key="name", size=0.75);
// &refclk @WIRE(mode="straight") {#X0:2 %t2:p};
// %t3 = $IO_PORT @ATTACH &reset => @PLACE(-11, -81) => @ORIENT("R0");
// %t3 @TEXT("reset", key="name", size=0.75);
// &reset @WIRE(mode="straight") {#X0:3 %t3:p};
// %t4 = $IO_PORT @ATTACH &count_reset => @PLACE(10, -77) => @ORIENT("MY");
// %t4 @TEXT("count_reset", key="name", size=0.75);
// &count_reset @WIRE(mode="straight") {#X0:4 %t4:p};
// %t5 = $SUPPLY @ATTACH &vdd => @PLACE(0, -64);
// &vdd @WIRE(mode="straight") {#X0:5 %t5:p};
// %t6 = $GROUND @ATTACH &vss => @PLACE(0, -90);
// &vss @WIRE(mode="straight") {#X0:6 %t6:p};
// %t7 = $IO_PORT @ATTACH &n30 => @PLACE(30, -73) => @ORIENT("R0");
// %t7 @TEXT("n30", key="name", size=0.75);
// &n30 @WIRE(mode="straight") {#X1:1 %t7:p};
// %t8 = $IO_PORT @ATTACH &refclk => @PLACE(30, -77) => @ORIENT("R0");
// %t8 @TEXT("refclk", key="name", size=0.75);
// &refclk @WIRE(mode="straight") {#X1:2 %t8:p};
// %t9 = $IO_PORT @ATTACH &reset => @PLACE(30, -81) => @ORIENT("R0");
// %t9 @TEXT("reset", key="name", size=0.75);
// &reset @WIRE(mode="straight") {#X1:3 %t9:p};
// %t10 = $IO_PORT @ATTACH &count_gate => @PLACE(50, -77) => @ORIENT("MY");
// %t10 @TEXT("count_gate", key="name", size=0.75);
// &count_gate @WIRE(mode="straight") {#X1:4 %t10:p};
// %t11 = $SUPPLY @ATTACH &vdd => @PLACE(40, -64);
// &vdd @WIRE(mode="straight") {#X1:5 %t11:p};
// %t12 = $GROUND @ATTACH &vss => @PLACE(40, -90);
// &vss @WIRE(mode="straight") {#X1:6 %t12:p};
// %t13 = $IO_PORT @ATTACH &n31 => @PLACE(70, -73) => @ORIENT("R0");
// %t13 @TEXT("n31", key="name", size=0.75);
// &n31 @WIRE(mode="straight") {#X2:1 %t13:p};
// %t14 = $IO_PORT @ATTACH &refclk => @PLACE(70, -77) => @ORIENT("R0");
// %t14 @TEXT("refclk", key="name", size=0.75);
// &refclk @WIRE(mode="straight") {#X2:2 %t14:p};
// %t15 = $IO_PORT @ATTACH &reset => @PLACE(70, -81) => @ORIENT("R0");
// %t15 @TEXT("reset", key="name", size=0.75);
// &reset @WIRE(mode="straight") {#X2:3 %t15:p};
// %t16 = $IO_PORT @ATTACH &frequency_good => @PLACE(90, -77) => @ORIENT("MY");
// %t16 @TEXT("frequency_good", key="name", size=0.75);
// &frequency_good @WIRE(mode="straight") {#X2:4 %t16:p};
// %t17 = $SUPPLY @ATTACH &vdd => @PLACE(80, -64);
// &vdd @WIRE(mode="straight") {#X2:5 %t17:p};
// %t18 = $GROUND @ATTACH &vss => @PLACE(80, -90);
// &vss @WIRE(mode="straight") {#X2:6 %t18:p};
// %t19 = $IO_PORT @ATTACH &n32 => @PLACE(110, -73) => @ORIENT("R0");
// %t19 @TEXT("n32", key="name", size=0.75);
// &n32 @WIRE(mode="straight") {#X3:1 %t19:p};
// %t20 = $IO_PORT @ATTACH &refclk => @PLACE(110, -77) => @ORIENT("R0");
// %t20 @TEXT("refclk", key="name", size=0.75);
// &refclk @WIRE(mode="straight") {#X3:2 %t20:p};
// %t21 = $IO_PORT @ATTACH &reset => @PLACE(110, -81) => @ORIENT("R0");
// %t21 @TEXT("reset", key="name", size=0.75);
// &reset @WIRE(mode="straight") {#X3:3 %t21:p};
// %t22 = $IO_PORT @ATTACH &valid => @PLACE(130, -77) => @ORIENT("MY");
// %t22 @TEXT("valid", key="name", size=0.75);
// &valid @WIRE(mode="straight") {#X3:4 %t22:p};
// %t23 = $SUPPLY @ATTACH &vdd => @PLACE(120, -64);
// &vdd @WIRE(mode="straight") {#X3:5 %t23:p};
// %t24 = $GROUND @ATTACH &vss => @PLACE(120, -90);
// &vss @WIRE(mode="straight") {#X3:6 %t24:p};
// %t25 = $IO_PORT @ATTACH &n33 => @PLACE(-11, -108) => @ORIENT("R0");
// %t25 @TEXT("n33", key="name", size=0.75);
// &n33 @WIRE(mode="straight") {#X4:1 %t25:p};
// %t26 = $IO_PORT @ATTACH &refclk => @PLACE(-11, -112) => @ORIENT("R0");
// %t26 @TEXT("refclk", key="name", size=0.75);
// &refclk @WIRE(mode="straight") {#X4:2 %t26:p};
// %t27 = $IO_PORT @ATTACH &reset => @PLACE(-11, -116) => @ORIENT("R0");
// %t27 @TEXT("reset", key="name", size=0.75);
// &reset @WIRE(mode="straight") {#X4:3 %t27:p};
// %t28 = $IO_PORT @ATTACH &n34 => @PLACE(10, -112) => @ORIENT("MY");
// %t28 @TEXT("n34", key="name", size=0.75);
// &n34 @WIRE(mode="straight") {#X4:4 %t28:p};
// %t29 = $SUPPLY @ATTACH &vdd => @PLACE(0, -99);
// &vdd @WIRE(mode="straight") {#X4:5 %t29:p};
// %t30 = $GROUND @ATTACH &vss => @PLACE(0, -125);
// &vss @WIRE(mode="straight") {#X4:6 %t30:p};
// %t31 = $IO_PORT @ATTACH &n35 => @PLACE(30, -108) => @ORIENT("R0");
// %t31 @TEXT("n35", key="name", size=0.75);
// &n35 @WIRE(mode="straight") {#X5:1 %t31:p};
// %t32 = $IO_PORT @ATTACH &refclk => @PLACE(30, -112) => @ORIENT("R0");
// %t32 @TEXT("refclk", key="name", size=0.75);
// &refclk @WIRE(mode="straight") {#X5:2 %t32:p};
// %t33 = $IO_PORT @ATTACH &reset => @PLACE(30, -116) => @ORIENT("R0");
// %t33 @TEXT("reset", key="name", size=0.75);
// &reset @WIRE(mode="straight") {#X5:3 %t33:p};
// %t34 = $IO_PORT @ATTACH &n36 => @PLACE(50, -112) => @ORIENT("MY");
// %t34 @TEXT("n36", key="name", size=0.75);
// &n36 @WIRE(mode="straight") {#X5:4 %t34:p};
// %t35 = $SUPPLY @ATTACH &vdd => @PLACE(40, -99);
// &vdd @WIRE(mode="straight") {#X5:5 %t35:p};
// %t36 = $GROUND @ATTACH &vss => @PLACE(40, -125);
// &vss @WIRE(mode="straight") {#X5:6 %t36:p};
// %t37 = $IO_PORT @ATTACH &n37 => @PLACE(70, -108) => @ORIENT("R0");
// %t37 @TEXT("n37", key="name", size=0.75);
// &n37 @WIRE(mode="straight") {#X6:1 %t37:p};
// %t38 = $IO_PORT @ATTACH &refclk => @PLACE(70, -112) => @ORIENT("R0");
// %t38 @TEXT("refclk", key="name", size=0.75);
// &refclk @WIRE(mode="straight") {#X6:2 %t38:p};
// %t39 = $IO_PORT @ATTACH &reset => @PLACE(70, -116) => @ORIENT("R0");
// %t39 @TEXT("reset", key="name", size=0.75);
// &reset @WIRE(mode="straight") {#X6:3 %t39:p};
// %t40 = $IO_PORT @ATTACH &n38 => @PLACE(90, -112) => @ORIENT("MY");
// %t40 @TEXT("n38", key="name", size=0.75);
// &n38 @WIRE(mode="straight") {#X6:4 %t40:p};
// %t41 = $SUPPLY @ATTACH &vdd => @PLACE(80, -99);
// &vdd @WIRE(mode="straight") {#X6:5 %t41:p};
// %t42 = $GROUND @ATTACH &vss => @PLACE(80, -125);
// &vss @WIRE(mode="straight") {#X6:6 %t42:p};
// %t43 = $IO_PORT @ATTACH &n39 => @PLACE(110, -108) => @ORIENT("R0");
// %t43 @TEXT("n39", key="name", size=0.75);
// &n39 @WIRE(mode="straight") {#X7:1 %t43:p};
// %t44 = $IO_PORT @ATTACH &refclk => @PLACE(110, -112) => @ORIENT("R0");
// %t44 @TEXT("refclk", key="name", size=0.75);
// &refclk @WIRE(mode="straight") {#X7:2 %t44:p};
// %t45 = $IO_PORT @ATTACH &reset => @PLACE(110, -116) => @ORIENT("R0");
// %t45 @TEXT("reset", key="name", size=0.75);
// &reset @WIRE(mode="straight") {#X7:3 %t45:p};
// %t46 = $IO_PORT @ATTACH &n40 => @PLACE(130, -112) => @ORIENT("MY");
// %t46 @TEXT("n40", key="name", size=0.75);
// &n40 @WIRE(mode="straight") {#X7:4 %t46:p};
// %t47 = $SUPPLY @ATTACH &vdd => @PLACE(120, -99);
// &vdd @WIRE(mode="straight") {#X7:5 %t47:p};
// %t48 = $GROUND @ATTACH &vss => @PLACE(120, -125);
// &vss @WIRE(mode="straight") {#X7:6 %t48:p};
// %t49 = $IO_PORT @ATTACH &n41 => @PLACE(-11, -143) => @ORIENT("R0");
// %t49 @TEXT("n41", key="name", size=0.75);
// &n41 @WIRE(mode="straight") {#X8:1 %t49:p};
// %t50 = $IO_PORT @ATTACH &refclk => @PLACE(-11, -147) => @ORIENT("R0");
// %t50 @TEXT("refclk", key="name", size=0.75);
// &refclk @WIRE(mode="straight") {#X8:2 %t50:p};
// %t51 = $IO_PORT @ATTACH &reset => @PLACE(-11, -151) => @ORIENT("R0");
// %t51 @TEXT("reset", key="name", size=0.75);
// &reset @WIRE(mode="straight") {#X8:3 %t51:p};
// %t52 = $IO_PORT @ATTACH &n42 => @PLACE(10, -147) => @ORIENT("MY");
// %t52 @TEXT("n42", key="name", size=0.75);
// &n42 @WIRE(mode="straight") {#X8:4 %t52:p};
// %t53 = $SUPPLY @ATTACH &vdd => @PLACE(0, -134);
// &vdd @WIRE(mode="straight") {#X8:5 %t53:p};
// %t54 = $GROUND @ATTACH &vss => @PLACE(0, -160);
// &vss @WIRE(mode="straight") {#X8:6 %t54:p};
// %t55 = $IO_PORT @ATTACH &n43 => @PLACE(30, -143) => @ORIENT("R0");
// %t55 @TEXT("n43", key="name", size=0.75);
// &n43 @WIRE(mode="straight") {#X9:1 %t55:p};
// %t56 = $IO_PORT @ATTACH &refclk => @PLACE(30, -147) => @ORIENT("R0");
// %t56 @TEXT("refclk", key="name", size=0.75);
// &refclk @WIRE(mode="straight") {#X9:2 %t56:p};
// %t57 = $IO_PORT @ATTACH &reset => @PLACE(30, -151) => @ORIENT("R0");
// %t57 @TEXT("reset", key="name", size=0.75);
// &reset @WIRE(mode="straight") {#X9:3 %t57:p};
// %t58 = $IO_PORT @ATTACH &n44 => @PLACE(50, -147) => @ORIENT("MY");
// %t58 @TEXT("n44", key="name", size=0.75);
// &n44 @WIRE(mode="straight") {#X9:4 %t58:p};
// %t59 = $SUPPLY @ATTACH &vdd => @PLACE(40, -134);
// &vdd @WIRE(mode="straight") {#X9:5 %t59:p};
// %t60 = $GROUND @ATTACH &vss => @PLACE(40, -160);
// &vss @WIRE(mode="straight") {#X9:6 %t60:p};
// %t61 = $IO_PORT @ATTACH &n45 => @PLACE(70, -143) => @ORIENT("R0");
// %t61 @TEXT("n45", key="name", size=0.75);
// &n45 @WIRE(mode="straight") {#X10:1 %t61:p};
// %t62 = $IO_PORT @ATTACH &refclk => @PLACE(70, -147) => @ORIENT("R0");
// %t62 @TEXT("refclk", key="name", size=0.75);
// &refclk @WIRE(mode="straight") {#X10:2 %t62:p};
// %t63 = $IO_PORT @ATTACH &reset => @PLACE(70, -151) => @ORIENT("R0");
// %t63 @TEXT("reset", key="name", size=0.75);
// &reset @WIRE(mode="straight") {#X10:3 %t63:p};
// %t64 = $IO_PORT @ATTACH &n46 => @PLACE(90, -147) => @ORIENT("MY");
// %t64 @TEXT("n46", key="name", size=0.75);
// &n46 @WIRE(mode="straight") {#X10:4 %t64:p};
// %t65 = $SUPPLY @ATTACH &vdd => @PLACE(80, -134);
// &vdd @WIRE(mode="straight") {#X10:5 %t65:p};
// %t66 = $GROUND @ATTACH &vss => @PLACE(80, -160);
// &vss @WIRE(mode="straight") {#X10:6 %t66:p};
// %t67 = $IO_PORT @ATTACH &n47 => @PLACE(110, -143) => @ORIENT("R0");
// %t67 @TEXT("n47", key="name", size=0.75);
// &n47 @WIRE(mode="straight") {#X11:1 %t67:p};
// %t68 = $IO_PORT @ATTACH &refclk => @PLACE(110, -147) => @ORIENT("R0");
// %t68 @TEXT("refclk", key="name", size=0.75);
// &refclk @WIRE(mode="straight") {#X11:2 %t68:p};
// %t69 = $IO_PORT @ATTACH &reset => @PLACE(110, -151) => @ORIENT("R0");
// %t69 @TEXT("reset", key="name", size=0.75);
// &reset @WIRE(mode="straight") {#X11:3 %t69:p};
// %t70 = $IO_PORT @ATTACH &n48 => @PLACE(130, -147) => @ORIENT("MY");
// %t70 @TEXT("n48", key="name", size=0.75);
// &n48 @WIRE(mode="straight") {#X11:4 %t70:p};
// %t71 = $SUPPLY @ATTACH &vdd => @PLACE(120, -134);
// &vdd @WIRE(mode="straight") {#X11:5 %t71:p};
// %t72 = $GROUND @ATTACH &vss => @PLACE(120, -160);
// &vss @WIRE(mode="straight") {#X11:6 %t72:p};
// %t73 = $IO_PORT @ATTACH &count_reset => @PLACE(-11, -178) => @ORIENT("R0");
// %t73 @TEXT("count_reset", key="name", size=0.75);
// &count_reset @WIRE(mode="straight") {#X12:1 %t73:p};
// %t74 = $IO_PORT @ATTACH &n49 => @PLACE(-11, -182) => @ORIENT("R0");
// %t74 @TEXT("n49", key="name", size=0.75);
// &n49 @WIRE(mode="straight") {#X12:2 %t74:p};
// %t75 = $IO_PORT @ATTACH &n50 => @PLACE(-11, -186) => @ORIENT("R0");
// %t75 @TEXT("n50", key="name", size=0.75);
// &n50 @WIRE(mode="straight") {#X12:3 %t75:p};
// %t76 = $IO_PORT @ATTACH &n29 => @PLACE(10, -182) => @ORIENT("MY");
// %t76 @TEXT("n29", key="name", size=0.75);
// &n29 @WIRE(mode="straight") {#X12:4 %t76:p};
// %t77 = $SUPPLY @ATTACH &vdd => @PLACE(0, -169);
// &vdd @WIRE(mode="straight") {#X12:5 %t77:p};
// %t78 = $GROUND @ATTACH &vss => @PLACE(0, -195);
// &vss @WIRE(mode="straight") {#X12:6 %t78:p};
// %t79 = $IO_PORT @ATTACH &count_gate => @PLACE(30, -178) => @ORIENT("R0");
// %t79 @TEXT("count_gate", key="name", size=0.75);
// &count_gate @WIRE(mode="straight") {#X13:1 %t79:p};
// %t80 = $IO_PORT @ATTACH &n51 => @PLACE(30, -182) => @ORIENT("R0");
// %t80 @TEXT("n51", key="name", size=0.75);
// &n51 @WIRE(mode="straight") {#X13:2 %t80:p};
// %t81 = $IO_PORT @ATTACH &n52 => @PLACE(30, -186) => @ORIENT("R0");
// %t81 @TEXT("n52", key="name", size=0.75);
// &n52 @WIRE(mode="straight") {#X13:3 %t81:p};
// %t82 = $IO_PORT @ATTACH &n30 => @PLACE(50, -182) => @ORIENT("MY");
// %t82 @TEXT("n30", key="name", size=0.75);
// &n30 @WIRE(mode="straight") {#X13:4 %t82:p};
// %t83 = $SUPPLY @ATTACH &vdd => @PLACE(40, -169);
// &vdd @WIRE(mode="straight") {#X13:5 %t83:p};
// %t84 = $GROUND @ATTACH &vss => @PLACE(40, -195);
// &vss @WIRE(mode="straight") {#X13:6 %t84:p};
// %t85 = $IO_PORT @ATTACH &frequency_good => @PLACE(70, -178) => @ORIENT("R0");
// %t85 @TEXT("frequency_good", key="name", size=0.75);
// &frequency_good @WIRE(mode="straight") {#X14:1 %t85:p};
// %t86 = $IO_PORT @ATTACH &n53 => @PLACE(70, -182) => @ORIENT("R0");
// %t86 @TEXT("n53", key="name", size=0.75);
// &n53 @WIRE(mode="straight") {#X14:2 %t86:p};
// %t87 = $IO_PORT @ATTACH &n54 => @PLACE(70, -186) => @ORIENT("R0");
// %t87 @TEXT("n54", key="name", size=0.75);
// &n54 @WIRE(mode="straight") {#X14:3 %t87:p};
// %t88 = $IO_PORT @ATTACH &n31 => @PLACE(90, -182) => @ORIENT("MY");
// %t88 @TEXT("n31", key="name", size=0.75);
// &n31 @WIRE(mode="straight") {#X14:4 %t88:p};
// %t89 = $SUPPLY @ATTACH &vdd => @PLACE(80, -169);
// &vdd @WIRE(mode="straight") {#X14:5 %t89:p};
// %t90 = $GROUND @ATTACH &vss => @PLACE(80, -195);
// &vss @WIRE(mode="straight") {#X14:6 %t90:p};
// %t91 = $IO_PORT @ATTACH &measured1 => @PLACE(110, -182) => @ORIENT("R0");
// %t91 @TEXT("measured1", key="name", size=0.75);
// &measured1 @WIRE(mode="straight") {#X15:1 %t91:p};
// %t92 = $IO_PORT @ATTACH &n55 => @PLACE(130, -182) => @ORIENT("MY");
// %t92 @TEXT("n55", key="name", size=0.75);
// &n55 @WIRE(mode="straight") {#X15:2 %t92:p};
// %t93 = $SUPPLY @ATTACH &vdd => @PLACE(120, -173);
// &vdd @WIRE(mode="straight") {#X15:3 %t93:p};
// %t94 = $GROUND @ATTACH &vss => @PLACE(120, -191);
// &vss @WIRE(mode="straight") {#X15:4 %t94:p};
// %t95 = $IO_PORT @ATTACH &measured4 => @PLACE(-11, -215) => @ORIENT("R0");
// %t95 @TEXT("measured4", key="name", size=0.75);
// &measured4 @WIRE(mode="straight") {#X16:1 %t95:p};
// %t96 = $IO_PORT @ATTACH &n56 => @PLACE(10, -215) => @ORIENT("MY");
// %t96 @TEXT("n56", key="name", size=0.75);
// &n56 @WIRE(mode="straight") {#X16:2 %t96:p};
// %t97 = $SUPPLY @ATTACH &vdd => @PLACE(0, -206);
// &vdd @WIRE(mode="straight") {#X16:3 %t97:p};
// %t98 = $GROUND @ATTACH &vss => @PLACE(0, -224);
// &vss @WIRE(mode="straight") {#X16:4 %t98:p};
// %t99 = $IO_PORT @ATTACH &measured3 => @PLACE(30, -215) => @ORIENT("R0");
// %t99 @TEXT("measured3", key="name", size=0.75);
// &measured3 @WIRE(mode="straight") {#X17:1 %t99:p};
// %t100 = $IO_PORT @ATTACH &n57 => @PLACE(50, -215) => @ORIENT("MY");
// %t100 @TEXT("n57", key="name", size=0.75);
// &n57 @WIRE(mode="straight") {#X17:2 %t100:p};
// %t101 = $SUPPLY @ATTACH &vdd => @PLACE(40, -206);
// &vdd @WIRE(mode="straight") {#X17:3 %t101:p};
// %t102 = $GROUND @ATTACH &vss => @PLACE(40, -224);
// &vss @WIRE(mode="straight") {#X17:4 %t102:p};
// %t103 = $IO_PORT @ATTACH &measured2 => @PLACE(70, -215) => @ORIENT("R0");
// %t103 @TEXT("measured2", key="name", size=0.75);
// &measured2 @WIRE(mode="straight") {#X18:1 %t103:p};
// %t104 = $IO_PORT @ATTACH &n58 => @PLACE(90, -215) => @ORIENT("MY");
// %t104 @TEXT("n58", key="name", size=0.75);
// &n58 @WIRE(mode="straight") {#X18:2 %t104:p};
// %t105 = $SUPPLY @ATTACH &vdd => @PLACE(80, -206);
// &vdd @WIRE(mode="straight") {#X18:3 %t105:p};
// %t106 = $GROUND @ATTACH &vss => @PLACE(80, -224);
// &vss @WIRE(mode="straight") {#X18:4 %t106:p};
// %t107 = $IO_PORT @ATTACH &measured11 => @PLACE(110, -215) => @ORIENT("R0");
// %t107 @TEXT("measured11", key="name", size=0.75);
// &measured11 @WIRE(mode="straight") {#X19:1 %t107:p};
// %t108 = $IO_PORT @ATTACH &n59 => @PLACE(130, -215) => @ORIENT("MY");
// %t108 @TEXT("n59", key="name", size=0.75);
// &n59 @WIRE(mode="straight") {#X19:2 %t108:p};
// %t109 = $SUPPLY @ATTACH &vdd => @PLACE(120, -206);
// &vdd @WIRE(mode="straight") {#X19:3 %t109:p};
// %t110 = $GROUND @ATTACH &vss => @PLACE(120, -224);
// &vss @WIRE(mode="straight") {#X19:4 %t110:p};
// %t111 = $IO_PORT @ATTACH &measured13 => @PLACE(-11, -246) => @ORIENT("R0");
// %t111 @TEXT("measured13", key="name", size=0.75);
// &measured13 @WIRE(mode="straight") {#X20:1 %t111:p};
// %t112 = $IO_PORT @ATTACH &n60 => @PLACE(10, -246) => @ORIENT("MY");
// %t112 @TEXT("n60", key="name", size=0.75);
// &n60 @WIRE(mode="straight") {#X20:2 %t112:p};
// %t113 = $SUPPLY @ATTACH &vdd => @PLACE(0, -237);
// &vdd @WIRE(mode="straight") {#X20:3 %t113:p};
// %t114 = $GROUND @ATTACH &vss => @PLACE(0, -255);
// &vss @WIRE(mode="straight") {#X20:4 %t114:p};
// %t115 = $IO_PORT @ATTACH &measured12 => @PLACE(30, -246) => @ORIENT("R0");
// %t115 @TEXT("measured12", key="name", size=0.75);
// &measured12 @WIRE(mode="straight") {#X21:1 %t115:p};
// %t116 = $IO_PORT @ATTACH &n61 => @PLACE(50, -246) => @ORIENT("MY");
// %t116 @TEXT("n61", key="name", size=0.75);
// &n61 @WIRE(mode="straight") {#X21:2 %t116:p};
// %t117 = $SUPPLY @ATTACH &vdd => @PLACE(40, -237);
// &vdd @WIRE(mode="straight") {#X21:3 %t117:p};
// %t118 = $GROUND @ATTACH &vss => @PLACE(40, -255);
// &vss @WIRE(mode="straight") {#X21:4 %t118:p};
// %t119 = $IO_PORT @ATTACH &n62 => @PLACE(70, -246) => @ORIENT("R0");
// %t119 @TEXT("n62", key="name", size=0.75);
// &n62 @WIRE(mode="straight") {#X22:1 %t119:p};
// %t120 = $IO_PORT @ATTACH &n63 => @PLACE(90, -246) => @ORIENT("MY");
// %t120 @TEXT("n63", key="name", size=0.75);
// &n63 @WIRE(mode="straight") {#X22:2 %t120:p};
// %t121 = $SUPPLY @ATTACH &vdd => @PLACE(80, -237);
// &vdd @WIRE(mode="straight") {#X22:3 %t121:p};
// %t122 = $GROUND @ATTACH &vss => @PLACE(80, -255);
// &vss @WIRE(mode="straight") {#X22:4 %t122:p};
// %t123 = $IO_PORT @ATTACH &n64 => @PLACE(110, -246) => @ORIENT("R0");
// %t123 @TEXT("n64", key="name", size=0.75);
// &n64 @WIRE(mode="straight") {#X23:1 %t123:p};
// %t124 = $IO_PORT @ATTACH &n65 => @PLACE(130, -246) => @ORIENT("MY");
// %t124 @TEXT("n65", key="name", size=0.75);
// &n65 @WIRE(mode="straight") {#X23:2 %t124:p};
// %t125 = $SUPPLY @ATTACH &vdd => @PLACE(120, -237);
// &vdd @WIRE(mode="straight") {#X23:3 %t125:p};
// %t126 = $GROUND @ATTACH &vss => @PLACE(120, -255);
// &vss @WIRE(mode="straight") {#X23:4 %t126:p};
// %t127 = $IO_PORT @ATTACH &n66 => @PLACE(158, -77) => @ORIENT("R0");
// %t127 @TEXT("n66", key="name", size=0.75);
// &n66 @WIRE(mode="straight") {#X24:1 %t127:p};
// %t128 = $IO_PORT @ATTACH &n67 => @PLACE(178, -77) => @ORIENT("MY");
// %t128 @TEXT("n67", key="name", size=0.75);
// &n67 @WIRE(mode="straight") {#X24:2 %t128:p};
// %t129 = $SUPPLY @ATTACH &vdd => @PLACE(168, -68);
// &vdd @WIRE(mode="straight") {#X24:3 %t129:p};
// %t130 = $GROUND @ATTACH &vss => @PLACE(168, -86);
// &vss @WIRE(mode="straight") {#X24:4 %t130:p};
// %t131 = $IO_PORT @ATTACH &n68 => @PLACE(198, -77) => @ORIENT("R0");
// %t131 @TEXT("n68", key="name", size=0.75);
// &n68 @WIRE(mode="straight") {#X25:1 %t131:p};
// %t132 = $IO_PORT @ATTACH &n69 => @PLACE(218, -77) => @ORIENT("MY");
// %t132 @TEXT("n69", key="name", size=0.75);
// &n69 @WIRE(mode="straight") {#X25:2 %t132:p};
// %t133 = $SUPPLY @ATTACH &vdd => @PLACE(208, -68);
// &vdd @WIRE(mode="straight") {#X25:3 %t133:p};
// %t134 = $GROUND @ATTACH &vss => @PLACE(208, -86);
// &vss @WIRE(mode="straight") {#X25:4 %t134:p};
// %t135 = $IO_PORT @ATTACH &n70 => @PLACE(238, -77) => @ORIENT("R0");
// %t135 @TEXT("n70", key="name", size=0.75);
// &n70 @WIRE(mode="straight") {#X26:1 %t135:p};
// %t136 = $IO_PORT @ATTACH &n71 => @PLACE(258, -77) => @ORIENT("MY");
// %t136 @TEXT("n71", key="name", size=0.75);
// &n71 @WIRE(mode="straight") {#X26:2 %t136:p};
// %t137 = $SUPPLY @ATTACH &vdd => @PLACE(248, -68);
// &vdd @WIRE(mode="straight") {#X26:3 %t137:p};
// %t138 = $GROUND @ATTACH &vss => @PLACE(248, -86);
// &vss @WIRE(mode="straight") {#X26:4 %t138:p};
// %t139 = $IO_PORT @ATTACH &n72 => @PLACE(278, -77) => @ORIENT("R0");
// %t139 @TEXT("n72", key="name", size=0.75);
// &n72 @WIRE(mode="straight") {#X27:1 %t139:p};
// %t140 = $IO_PORT @ATTACH &n73 => @PLACE(298, -77) => @ORIENT("MY");
// %t140 @TEXT("n73", key="name", size=0.75);
// &n73 @WIRE(mode="straight") {#X27:2 %t140:p};
// %t141 = $SUPPLY @ATTACH &vdd => @PLACE(288, -68);
// &vdd @WIRE(mode="straight") {#X27:3 %t141:p};
// %t142 = $GROUND @ATTACH &vss => @PLACE(288, -86);
// &vss @WIRE(mode="straight") {#X27:4 %t142:p};
// %t143 = $IO_PORT @ATTACH &n74 => @PLACE(158, -112) => @ORIENT("R0");
// %t143 @TEXT("n74", key="name", size=0.75);
// &n74 @WIRE(mode="straight") {#X28:1 %t143:p};
// %t144 = $IO_PORT @ATTACH &n75 => @PLACE(178, -112) => @ORIENT("MY");
// %t144 @TEXT("n75", key="name", size=0.75);
// &n75 @WIRE(mode="straight") {#X28:2 %t144:p};
// %t145 = $SUPPLY @ATTACH &vdd => @PLACE(168, -103);
// &vdd @WIRE(mode="straight") {#X28:3 %t145:p};
// %t146 = $GROUND @ATTACH &vss => @PLACE(168, -121);
// &vss @WIRE(mode="straight") {#X28:4 %t146:p};
// %t147 = $IO_PORT @ATTACH &target_k1 => @PLACE(198, -112) => @ORIENT("R0");
// %t147 @TEXT("target_k1", key="name", size=0.75);
// &target_k1 @WIRE(mode="straight") {#X29:1 %t147:p};
// %t148 = $IO_PORT @ATTACH &n76 => @PLACE(218, -112) => @ORIENT("MY");
// %t148 @TEXT("n76", key="name", size=0.75);
// &n76 @WIRE(mode="straight") {#X29:2 %t148:p};
// %t149 = $SUPPLY @ATTACH &vdd => @PLACE(208, -103);
// &vdd @WIRE(mode="straight") {#X29:3 %t149:p};
// %t150 = $GROUND @ATTACH &vss => @PLACE(208, -121);
// &vss @WIRE(mode="straight") {#X29:4 %t150:p};
// %t151 = $IO_PORT @ATTACH &target_k0 => @PLACE(238, -112) => @ORIENT("R0");
// %t151 @TEXT("target_k0", key="name", size=0.75);
// &target_k0 @WIRE(mode="straight") {#X30:1 %t151:p};
// %t152 = $IO_PORT @ATTACH &n77 => @PLACE(258, -112) => @ORIENT("MY");
// %t152 @TEXT("n77", key="name", size=0.75);
// &n77 @WIRE(mode="straight") {#X30:2 %t152:p};
// %t153 = $SUPPLY @ATTACH &vdd => @PLACE(248, -103);
// &vdd @WIRE(mode="straight") {#X30:3 %t153:p};
// %t154 = $GROUND @ATTACH &vss => @PLACE(248, -121);
// &vss @WIRE(mode="straight") {#X30:4 %t154:p};
// %t155 = $IO_PORT @ATTACH &active => @PLACE(278, -112) => @ORIENT("R0");
// %t155 @TEXT("active", key="name", size=0.75);
// &active @WIRE(mode="straight") {#X31:1 %t155:p};
// %t156 = $IO_PORT @ATTACH &n78 => @PLACE(298, -112) => @ORIENT("MY");
// %t156 @TEXT("n78", key="name", size=0.75);
// &n78 @WIRE(mode="straight") {#X31:2 %t156:p};
// %t157 = $SUPPLY @ATTACH &vdd => @PLACE(288, -103);
// &vdd @WIRE(mode="straight") {#X31:3 %t157:p};
// %t158 = $GROUND @ATTACH &vss => @PLACE(288, -121);
// &vss @WIRE(mode="straight") {#X31:4 %t158:p};
// %t159 = $IO_PORT @ATTACH &n79 => @PLACE(158, -147) => @ORIENT("R0");
// %t159 @TEXT("n79", key="name", size=0.75);
// &n79 @WIRE(mode="straight") {#X32:1 %t159:p};
// %t160 = $IO_PORT @ATTACH &n80 => @PLACE(178, -147) => @ORIENT("MY");
// %t160 @TEXT("n80", key="name", size=0.75);
// &n80 @WIRE(mode="straight") {#X32:2 %t160:p};
// %t161 = $SUPPLY @ATTACH &vdd => @PLACE(168, -138);
// &vdd @WIRE(mode="straight") {#X32:3 %t161:p};
// %t162 = $GROUND @ATTACH &vss => @PLACE(168, -156);
// &vss @WIRE(mode="straight") {#X32:4 %t162:p};
// %t163 = $IO_PORT @ATTACH &n81 => @PLACE(198, -147) => @ORIENT("R0");
// %t163 @TEXT("n81", key="name", size=0.75);
// &n81 @WIRE(mode="straight") {#X33:1 %t163:p};
// %t164 = $IO_PORT @ATTACH &n82 => @PLACE(218, -147) => @ORIENT("MY");
// %t164 @TEXT("n82", key="name", size=0.75);
// &n82 @WIRE(mode="straight") {#X33:2 %t164:p};
// %t165 = $SUPPLY @ATTACH &vdd => @PLACE(208, -138);
// &vdd @WIRE(mode="straight") {#X33:3 %t165:p};
// %t166 = $GROUND @ATTACH &vss => @PLACE(208, -156);
// &vss @WIRE(mode="straight") {#X33:4 %t166:p};
// %t167 = $IO_PORT @ATTACH &n38 => @PLACE(238, -145) => @ORIENT("R0");
// %t167 @TEXT("n38", key="name", size=0.75);
// &n38 @WIRE(mode="straight") {#X34:1 %t167:p};
// %t168 = $IO_PORT @ATTACH &n83 => @PLACE(238, -149) => @ORIENT("R0");
// %t168 @TEXT("n83", key="name", size=0.75);
// &n83 @WIRE(mode="straight") {#X34:2 %t168:p};
// %t169 = $IO_PORT @ATTACH &n84 => @PLACE(258, -147) => @ORIENT("MY");
// %t169 @TEXT("n84", key="name", size=0.75);
// &n84 @WIRE(mode="straight") {#X34:3 %t169:p};
// %t170 = $SUPPLY @ATTACH &vdd => @PLACE(248, -136);
// &vdd @WIRE(mode="straight") {#X34:4 %t170:p};
// %t171 = $GROUND @ATTACH &vss => @PLACE(248, -158);
// &vss @WIRE(mode="straight") {#X34:5 %t171:p};
// %t172 = $IO_PORT @ATTACH &n42 => @PLACE(278, -145) => @ORIENT("R0");
// %t172 @TEXT("n42", key="name", size=0.75);
// &n42 @WIRE(mode="straight") {#X35:1 %t172:p};
// %t173 = $IO_PORT @ATTACH &n85 => @PLACE(278, -149) => @ORIENT("R0");
// %t173 @TEXT("n85", key="name", size=0.75);
// &n85 @WIRE(mode="straight") {#X35:2 %t173:p};
// %t174 = $IO_PORT @ATTACH &n86 => @PLACE(298, -147) => @ORIENT("MY");
// %t174 @TEXT("n86", key="name", size=0.75);
// &n86 @WIRE(mode="straight") {#X35:3 %t174:p};
// %t175 = $SUPPLY @ATTACH &vdd => @PLACE(288, -136);
// &vdd @WIRE(mode="straight") {#X35:4 %t175:p};
// %t176 = $GROUND @ATTACH &vss => @PLACE(288, -158);
// &vss @WIRE(mode="straight") {#X35:5 %t176:p};
// %t177 = $IO_PORT @ATTACH &n87 => @PLACE(158, -180) => @ORIENT("R0");
// %t177 @TEXT("n87", key="name", size=0.75);
// &n87 @WIRE(mode="straight") {#X36:1 %t177:p};
// %t178 = $IO_PORT @ATTACH &n85 => @PLACE(158, -184) => @ORIENT("R0");
// %t178 @TEXT("n85", key="name", size=0.75);
// &n85 @WIRE(mode="straight") {#X36:2 %t178:p};
// %t179 = $IO_PORT @ATTACH &n88 => @PLACE(178, -182) => @ORIENT("MY");
// %t179 @TEXT("n88", key="name", size=0.75);
// &n88 @WIRE(mode="straight") {#X36:3 %t179:p};
// %t180 = $SUPPLY @ATTACH &vdd => @PLACE(168, -171);
// &vdd @WIRE(mode="straight") {#X36:4 %t180:p};
// %t181 = $GROUND @ATTACH &vss => @PLACE(168, -193);
// &vss @WIRE(mode="straight") {#X36:5 %t181:p};
// %t182 = $IO_PORT @ATTACH &n46 => @PLACE(198, -180) => @ORIENT("R0");
// %t182 @TEXT("n46", key="name", size=0.75);
// &n46 @WIRE(mode="straight") {#X37:1 %t182:p};
// %t183 = $IO_PORT @ATTACH &n88 => @PLACE(198, -184) => @ORIENT("R0");
// %t183 @TEXT("n88", key="name", size=0.75);
// &n88 @WIRE(mode="straight") {#X37:2 %t183:p};
// %t184 = $IO_PORT @ATTACH &n89 => @PLACE(218, -182) => @ORIENT("MY");
// %t184 @TEXT("n89", key="name", size=0.75);
// &n89 @WIRE(mode="straight") {#X37:3 %t184:p};
// %t185 = $SUPPLY @ATTACH &vdd => @PLACE(208, -171);
// &vdd @WIRE(mode="straight") {#X37:4 %t185:p};
// %t186 = $GROUND @ATTACH &vss => @PLACE(208, -193);
// &vss @WIRE(mode="straight") {#X37:5 %t186:p};
// %t187 = $IO_PORT @ATTACH &n90 => @PLACE(238, -180) => @ORIENT("R0");
// %t187 @TEXT("n90", key="name", size=0.75);
// &n90 @WIRE(mode="straight") {#X38:1 %t187:p};
// %t188 = $IO_PORT @ATTACH &n83 => @PLACE(238, -184) => @ORIENT("R0");
// %t188 @TEXT("n83", key="name", size=0.75);
// &n83 @WIRE(mode="straight") {#X38:2 %t188:p};
// %t189 = $IO_PORT @ATTACH &n85 => @PLACE(258, -182) => @ORIENT("MY");
// %t189 @TEXT("n85", key="name", size=0.75);
// &n85 @WIRE(mode="straight") {#X38:3 %t189:p};
// %t190 = $SUPPLY @ATTACH &vdd => @PLACE(248, -171);
// &vdd @WIRE(mode="straight") {#X38:4 %t190:p};
// %t191 = $GROUND @ATTACH &vss => @PLACE(248, -193);
// &vss @WIRE(mode="straight") {#X38:5 %t191:p};
// %t192 = $IO_PORT @ATTACH &n44 => @PLACE(278, -180) => @ORIENT("R0");
// %t192 @TEXT("n44", key="name", size=0.75);
// &n44 @WIRE(mode="straight") {#X39:1 %t192:p};
// %t193 = $IO_PORT @ATTACH &n42 => @PLACE(278, -184) => @ORIENT("R0");
// %t193 @TEXT("n42", key="name", size=0.75);
// &n42 @WIRE(mode="straight") {#X39:2 %t193:p};
// %t194 = $IO_PORT @ATTACH &n87 => @PLACE(298, -182) => @ORIENT("MY");
// %t194 @TEXT("n87", key="name", size=0.75);
// &n87 @WIRE(mode="straight") {#X39:3 %t194:p};
// %t195 = $SUPPLY @ATTACH &vdd => @PLACE(288, -171);
// &vdd @WIRE(mode="straight") {#X39:4 %t195:p};
// %t196 = $GROUND @ATTACH &vss => @PLACE(288, -193);
// &vss @WIRE(mode="straight") {#X39:5 %t196:p};
// %t197 = $IO_PORT @ATTACH &n40 => @PLACE(158, -213) => @ORIENT("R0");
// %t197 @TEXT("n40", key="name", size=0.75);
// &n40 @WIRE(mode="straight") {#X40:1 %t197:p};
// %t198 = $IO_PORT @ATTACH &n38 => @PLACE(158, -217) => @ORIENT("R0");
// %t198 @TEXT("n38", key="name", size=0.75);
// &n38 @WIRE(mode="straight") {#X40:2 %t198:p};
// %t199 = $IO_PORT @ATTACH &n90 => @PLACE(178, -215) => @ORIENT("MY");
// %t199 @TEXT("n90", key="name", size=0.75);
// &n90 @WIRE(mode="straight") {#X40:3 %t199:p};
// %t200 = $SUPPLY @ATTACH &vdd => @PLACE(168, -204);
// &vdd @WIRE(mode="straight") {#X40:4 %t200:p};
// %t201 = $GROUND @ATTACH &vss => @PLACE(168, -226);
// &vss @WIRE(mode="straight") {#X40:5 %t201:p};
// %t202 = $IO_PORT @ATTACH &n36 => @PLACE(198, -213) => @ORIENT("R0");
// %t202 @TEXT("n36", key="name", size=0.75);
// &n36 @WIRE(mode="straight") {#X41:1 %t202:p};
// %t203 = $IO_PORT @ATTACH &n34 => @PLACE(198, -217) => @ORIENT("R0");
// %t203 @TEXT("n34", key="name", size=0.75);
// &n34 @WIRE(mode="straight") {#X41:2 %t203:p};
// %t204 = $IO_PORT @ATTACH &n83 => @PLACE(218, -215) => @ORIENT("MY");
// %t204 @TEXT("n83", key="name", size=0.75);
// &n83 @WIRE(mode="straight") {#X41:3 %t204:p};
// %t205 = $SUPPLY @ATTACH &vdd => @PLACE(208, -204);
// &vdd @WIRE(mode="straight") {#X41:4 %t205:p};
// %t206 = $GROUND @ATTACH &vss => @PLACE(208, -226);
// &vss @WIRE(mode="straight") {#X41:5 %t206:p};
// %t207 = $IO_PORT @ATTACH &n91 => @PLACE(238, -213) => @ORIENT("R0");
// %t207 @TEXT("n91", key="name", size=0.75);
// &n91 @WIRE(mode="straight") {#X42:1 %t207:p};
// %t208 = $IO_PORT @ATTACH &n92 => @PLACE(238, -217) => @ORIENT("R0");
// %t208 @TEXT("n92", key="name", size=0.75);
// &n92 @WIRE(mode="straight") {#X42:2 %t208:p};
// %t209 = $IO_PORT @ATTACH &n81 => @PLACE(258, -215) => @ORIENT("MY");
// %t209 @TEXT("n81", key="name", size=0.75);
// &n81 @WIRE(mode="straight") {#X42:3 %t209:p};
// %t210 = $SUPPLY @ATTACH &vdd => @PLACE(248, -204);
// &vdd @WIRE(mode="straight") {#X42:4 %t210:p};
// %t211 = $GROUND @ATTACH &vss => @PLACE(248, -226);
// &vss @WIRE(mode="straight") {#X42:5 %t211:p};
// %t212 = $IO_PORT @ATTACH &n93 => @PLACE(278, -213) => @ORIENT("R0");
// %t212 @TEXT("n93", key="name", size=0.75);
// &n93 @WIRE(mode="straight") {#X43:1 %t212:p};
// %t213 = $IO_PORT @ATTACH &n94 => @PLACE(278, -217) => @ORIENT("R0");
// %t213 @TEXT("n94", key="name", size=0.75);
// &n94 @WIRE(mode="straight") {#X43:2 %t213:p};
// %t214 = $IO_PORT @ATTACH &n92 => @PLACE(298, -215) => @ORIENT("MY");
// %t214 @TEXT("n92", key="name", size=0.75);
// &n92 @WIRE(mode="straight") {#X43:3 %t214:p};
// %t215 = $SUPPLY @ATTACH &vdd => @PLACE(288, -204);
// &vdd @WIRE(mode="straight") {#X43:4 %t215:p};
// %t216 = $GROUND @ATTACH &vss => @PLACE(288, -226);
// &vss @WIRE(mode="straight") {#X43:5 %t216:p};
// %t217 = $IO_PORT @ATTACH &n95 => @PLACE(158, -244) => @ORIENT("R0");
// %t217 @TEXT("n95", key="name", size=0.75);
// &n95 @WIRE(mode="straight") {#X44:1 %t217:p};
// %t218 = $IO_PORT @ATTACH &n96 => @PLACE(158, -248) => @ORIENT("R0");
// %t218 @TEXT("n96", key="name", size=0.75);
// &n96 @WIRE(mode="straight") {#X44:2 %t218:p};
// %t219 = $IO_PORT @ATTACH &n94 => @PLACE(178, -246) => @ORIENT("MY");
// %t219 @TEXT("n94", key="name", size=0.75);
// &n94 @WIRE(mode="straight") {#X44:3 %t219:p};
// %t220 = $SUPPLY @ATTACH &vdd => @PLACE(168, -235);
// &vdd @WIRE(mode="straight") {#X44:4 %t220:p};
// %t221 = $GROUND @ATTACH &vss => @PLACE(168, -257);
// &vss @WIRE(mode="straight") {#X44:5 %t221:p};
// %t222 = $IO_PORT @ATTACH &n97 => @PLACE(198, -244) => @ORIENT("R0");
// %t222 @TEXT("n97", key="name", size=0.75);
// &n97 @WIRE(mode="straight") {#X45:1 %t222:p};
// %t223 = $IO_PORT @ATTACH &n98 => @PLACE(198, -248) => @ORIENT("R0");
// %t223 @TEXT("n98", key="name", size=0.75);
// &n98 @WIRE(mode="straight") {#X45:2 %t223:p};
// %t224 = $IO_PORT @ATTACH &n96 => @PLACE(218, -246) => @ORIENT("MY");
// %t224 @TEXT("n96", key="name", size=0.75);
// &n96 @WIRE(mode="straight") {#X45:3 %t224:p};
// %t225 = $SUPPLY @ATTACH &vdd => @PLACE(208, -235);
// &vdd @WIRE(mode="straight") {#X45:4 %t225:p};
// %t226 = $GROUND @ATTACH &vss => @PLACE(208, -257);
// &vss @WIRE(mode="straight") {#X45:5 %t226:p};
// %t227 = $IO_PORT @ATTACH &n99 => @PLACE(238, -244) => @ORIENT("R0");
// %t227 @TEXT("n99", key="name", size=0.75);
// &n99 @WIRE(mode="straight") {#X46:1 %t227:p};
// %t228 = $IO_PORT @ATTACH &n100 => @PLACE(238, -248) => @ORIENT("R0");
// %t228 @TEXT("n100", key="name", size=0.75);
// &n100 @WIRE(mode="straight") {#X46:2 %t228:p};
// %t229 = $IO_PORT @ATTACH &n93 => @PLACE(258, -246) => @ORIENT("MY");
// %t229 @TEXT("n93", key="name", size=0.75);
// &n93 @WIRE(mode="straight") {#X46:3 %t229:p};
// %t230 = $SUPPLY @ATTACH &vdd => @PLACE(248, -235);
// &vdd @WIRE(mode="straight") {#X46:4 %t230:p};
// %t231 = $GROUND @ATTACH &vss => @PLACE(248, -257);
// &vss @WIRE(mode="straight") {#X46:5 %t231:p};
// %t232 = $IO_PORT @ATTACH &target_k5 => @PLACE(278, -244) => @ORIENT("R0");
// %t232 @TEXT("target_k5", key="name", size=0.75);
// &target_k5 @WIRE(mode="straight") {#X47:1 %t232:p};
// %t233 = $IO_PORT @ATTACH &n101 => @PLACE(278, -248) => @ORIENT("R0");
// %t233 @TEXT("n101", key="name", size=0.75);
// &n101 @WIRE(mode="straight") {#X47:2 %t233:p};
// %t234 = $IO_PORT @ATTACH &n91 => @PLACE(298, -246) => @ORIENT("MY");
// %t234 @TEXT("n91", key="name", size=0.75);
// &n91 @WIRE(mode="straight") {#X47:3 %t234:p};
// %t235 = $SUPPLY @ATTACH &vdd => @PLACE(288, -235);
// &vdd @WIRE(mode="straight") {#X47:4 %t235:p};
// %t236 = $GROUND @ATTACH &vss => @PLACE(288, -257);
// &vss @WIRE(mode="straight") {#X47:5 %t236:p};
// %t237 = $IO_PORT @ATTACH &n99 => @PLACE(326, -75) => @ORIENT("R0");
// %t237 @TEXT("n99", key="name", size=0.75);
// &n99 @WIRE(mode="straight") {#X48:1 %t237:p};
// %t238 = $IO_PORT @ATTACH &target_k4 => @PLACE(326, -79) => @ORIENT("R0");
// %t238 @TEXT("target_k4", key="name", size=0.75);
// &target_k4 @WIRE(mode="straight") {#X48:2 %t238:p};
// %t239 = $IO_PORT @ATTACH &n101 => @PLACE(346, -77) => @ORIENT("MY");
// %t239 @TEXT("n101", key="name", size=0.75);
// &n101 @WIRE(mode="straight") {#X48:3 %t239:p};
// %t240 = $SUPPLY @ATTACH &vdd => @PLACE(336, -66);
// &vdd @WIRE(mode="straight") {#X48:4 %t240:p};
// %t241 = $GROUND @ATTACH &vss => @PLACE(336, -88);
// &vss @WIRE(mode="straight") {#X48:5 %t241:p};
// %t242 = $IO_PORT @ATTACH &n102 => @PLACE(366, -75) => @ORIENT("R0");
// %t242 @TEXT("n102", key="name", size=0.75);
// &n102 @WIRE(mode="straight") {#X49:1 %t242:p};
// %t243 = $IO_PORT @ATTACH &n94 => @PLACE(366, -79) => @ORIENT("R0");
// %t243 @TEXT("n94", key="name", size=0.75);
// &n94 @WIRE(mode="straight") {#X49:2 %t243:p};
// %t244 = $IO_PORT @ATTACH &n103 => @PLACE(386, -77) => @ORIENT("MY");
// %t244 @TEXT("n103", key="name", size=0.75);
// &n103 @WIRE(mode="straight") {#X49:3 %t244:p};
// %t245 = $SUPPLY @ATTACH &vdd => @PLACE(376, -66);
// &vdd @WIRE(mode="straight") {#X49:4 %t245:p};
// %t246 = $GROUND @ATTACH &vss => @PLACE(376, -88);
// &vss @WIRE(mode="straight") {#X49:5 %t246:p};
// %t247 = $IO_PORT @ATTACH &n104 => @PLACE(406, -75) => @ORIENT("R0");
// %t247 @TEXT("n104", key="name", size=0.75);
// &n104 @WIRE(mode="straight") {#X50:1 %t247:p};
// %t248 = $IO_PORT @ATTACH &n103 => @PLACE(406, -79) => @ORIENT("R0");
// %t248 @TEXT("n103", key="name", size=0.75);
// &n103 @WIRE(mode="straight") {#X50:2 %t248:p};
// %t249 = $IO_PORT @ATTACH &n79 => @PLACE(426, -77) => @ORIENT("MY");
// %t249 @TEXT("n79", key="name", size=0.75);
// &n79 @WIRE(mode="straight") {#X50:3 %t249:p};
// %t250 = $SUPPLY @ATTACH &vdd => @PLACE(416, -66);
// &vdd @WIRE(mode="straight") {#X50:4 %t250:p};
// %t251 = $GROUND @ATTACH &vss => @PLACE(416, -88);
// &vss @WIRE(mode="straight") {#X50:5 %t251:p};
// %t252 = $IO_PORT @ATTACH &target_k5 => @PLACE(446, -75) => @ORIENT("R0");
// %t252 @TEXT("target_k5", key="name", size=0.75);
// &target_k5 @WIRE(mode="straight") {#X51:1 %t252:p};
// %t253 = $IO_PORT @ATTACH &target_k4 => @PLACE(446, -79) => @ORIENT("R0");
// %t253 @TEXT("target_k4", key="name", size=0.75);
// &target_k4 @WIRE(mode="straight") {#X51:2 %t253:p};
// %t254 = $IO_PORT @ATTACH &n104 => @PLACE(466, -77) => @ORIENT("MY");
// %t254 @TEXT("n104", key="name", size=0.75);
// &n104 @WIRE(mode="straight") {#X51:3 %t254:p};
// %t255 = $SUPPLY @ATTACH &vdd => @PLACE(456, -66);
// &vdd @WIRE(mode="straight") {#X51:4 %t255:p};
// %t256 = $GROUND @ATTACH &vss => @PLACE(456, -88);
// &vss @WIRE(mode="straight") {#X51:5 %t256:p};
// %t257 = $IO_PORT @ATTACH &target_k3 => @PLACE(326, -110) => @ORIENT("R0");
// %t257 @TEXT("target_k3", key="name", size=0.75);
// &target_k3 @WIRE(mode="straight") {#X52:1 %t257:p};
// %t258 = $IO_PORT @ATTACH &target_k2 => @PLACE(326, -114) => @ORIENT("R0");
// %t258 @TEXT("target_k2", key="name", size=0.75);
// &target_k2 @WIRE(mode="straight") {#X52:2 %t258:p};
// %t259 = $IO_PORT @ATTACH &n95 => @PLACE(346, -112) => @ORIENT("MY");
// %t259 @TEXT("n95", key="name", size=0.75);
// &n95 @WIRE(mode="straight") {#X52:3 %t259:p};
// %t260 = $SUPPLY @ATTACH &vdd => @PLACE(336, -101);
// &vdd @WIRE(mode="straight") {#X52:4 %t260:p};
// %t261 = $GROUND @ATTACH &vss => @PLACE(336, -123);
// &vss @WIRE(mode="straight") {#X52:5 %t261:p};
// %t262 = $IO_PORT @ATTACH &target_k1 => @PLACE(366, -110) => @ORIENT("R0");
// %t262 @TEXT("target_k1", key="name", size=0.75);
// &target_k1 @WIRE(mode="straight") {#X53:1 %t262:p};
// %t263 = $IO_PORT @ATTACH &n105 => @PLACE(366, -114) => @ORIENT("R0");
// %t263 @TEXT("n105", key="name", size=0.75);
// &n105 @WIRE(mode="straight") {#X53:2 %t263:p};
// %t264 = $IO_PORT @ATTACH &n98 => @PLACE(386, -112) => @ORIENT("MY");
// %t264 @TEXT("n98", key="name", size=0.75);
// &n98 @WIRE(mode="straight") {#X53:3 %t264:p};
// %t265 = $SUPPLY @ATTACH &vdd => @PLACE(376, -101);
// &vdd @WIRE(mode="straight") {#X53:4 %t265:p};
// %t266 = $GROUND @ATTACH &vss => @PLACE(376, -123);
// &vss @WIRE(mode="straight") {#X53:5 %t266:p};
// %t267 = $IO_PORT @ATTACH &n76 => @PLACE(406, -110) => @ORIENT("R0");
// %t267 @TEXT("n76", key="name", size=0.75);
// &n76 @WIRE(mode="straight") {#X54:1 %t267:p};
// %t268 = $IO_PORT @ATTACH &target_k0 => @PLACE(406, -114) => @ORIENT("R0");
// %t268 @TEXT("target_k0", key="name", size=0.75);
// &target_k0 @WIRE(mode="straight") {#X54:2 %t268:p};
// %t269 = $IO_PORT @ATTACH &n105 => @PLACE(426, -112) => @ORIENT("MY");
// %t269 @TEXT("n105", key="name", size=0.75);
// &n105 @WIRE(mode="straight") {#X54:3 %t269:p};
// %t270 = $SUPPLY @ATTACH &vdd => @PLACE(416, -101);
// &vdd @WIRE(mode="straight") {#X54:4 %t270:p};
// %t271 = $GROUND @ATTACH &vss => @PLACE(416, -123);
// &vss @WIRE(mode="straight") {#X54:5 %t271:p};
// %t272 = $IO_PORT @ATTACH &measured4 => @PLACE(446, -110) => @ORIENT("R0");
// %t272 @TEXT("measured4", key="name", size=0.75);
// &measured4 @WIRE(mode="straight") {#X55:1 %t272:p};
// %t273 = $IO_PORT @ATTACH &n106 => @PLACE(446, -114) => @ORIENT("R0");
// %t273 @TEXT("n106", key="name", size=0.75);
// &n106 @WIRE(mode="straight") {#X55:2 %t273:p};
// %t274 = $IO_PORT @ATTACH &n107 => @PLACE(466, -112) => @ORIENT("MY");
// %t274 @TEXT("n107", key="name", size=0.75);
// &n107 @WIRE(mode="straight") {#X55:3 %t274:p};
// %t275 = $SUPPLY @ATTACH &vdd => @PLACE(456, -101);
// &vdd @WIRE(mode="straight") {#X55:4 %t275:p};
// %t276 = $GROUND @ATTACH &vss => @PLACE(456, -123);
// &vss @WIRE(mode="straight") {#X55:5 %t276:p};
// %t277 = $IO_PORT @ATTACH &measured2 => @PLACE(326, -145) => @ORIENT("R0");
// %t277 @TEXT("measured2", key="name", size=0.75);
// &measured2 @WIRE(mode="straight") {#X56:1 %t277:p};
// %t278 = $IO_PORT @ATTACH &n108 => @PLACE(326, -149) => @ORIENT("R0");
// %t278 @TEXT("n108", key="name", size=0.75);
// &n108 @WIRE(mode="straight") {#X56:2 %t278:p};
// %t279 = $IO_PORT @ATTACH &n109 => @PLACE(346, -147) => @ORIENT("MY");
// %t279 @TEXT("n109", key="name", size=0.75);
// &n109 @WIRE(mode="straight") {#X56:3 %t279:p};
// %t280 = $SUPPLY @ATTACH &vdd => @PLACE(336, -136);
// &vdd @WIRE(mode="straight") {#X56:4 %t280:p};
// %t281 = $GROUND @ATTACH &vss => @PLACE(336, -158);
// &vss @WIRE(mode="straight") {#X56:5 %t281:p};
// %t282 = $IO_PORT @ATTACH &measured10 => @PLACE(366, -145) => @ORIENT("R0");
// %t282 @TEXT("measured10", key="name", size=0.75);
// &measured10 @WIRE(mode="straight") {#X57:1 %t282:p};
// %t283 = $IO_PORT @ATTACH &n110 => @PLACE(366, -149) => @ORIENT("R0");
// %t283 @TEXT("n110", key="name", size=0.75);
// &n110 @WIRE(mode="straight") {#X57:2 %t283:p};
// %t284 = $IO_PORT @ATTACH &n111 => @PLACE(386, -147) => @ORIENT("MY");
// %t284 @TEXT("n111", key="name", size=0.75);
// &n111 @WIRE(mode="straight") {#X57:3 %t284:p};
// %t285 = $SUPPLY @ATTACH &vdd => @PLACE(376, -136);
// &vdd @WIRE(mode="straight") {#X57:4 %t285:p};
// %t286 = $GROUND @ATTACH &vss => @PLACE(376, -158);
// &vss @WIRE(mode="straight") {#X57:5 %t286:p};
// %t287 = $IO_PORT @ATTACH &n112 => @PLACE(406, -145) => @ORIENT("R0");
// %t287 @TEXT("n112", key="name", size=0.75);
// &n112 @WIRE(mode="straight") {#X58:1 %t287:p};
// %t288 = $IO_PORT @ATTACH &n113 => @PLACE(406, -149) => @ORIENT("R0");
// %t288 @TEXT("n113", key="name", size=0.75);
// &n113 @WIRE(mode="straight") {#X58:2 %t288:p};
// %t289 = $IO_PORT @ATTACH &n110 => @PLACE(426, -147) => @ORIENT("MY");
// %t289 @TEXT("n110", key="name", size=0.75);
// &n110 @WIRE(mode="straight") {#X58:3 %t289:p};
// %t290 = $SUPPLY @ATTACH &vdd => @PLACE(416, -136);
// &vdd @WIRE(mode="straight") {#X58:4 %t290:p};
// %t291 = $GROUND @ATTACH &vss => @PLACE(416, -158);
// &vss @WIRE(mode="straight") {#X58:5 %t291:p};
// %t292 = $IO_PORT @ATTACH &n114 => @PLACE(446, -145) => @ORIENT("R0");
// %t292 @TEXT("n114", key="name", size=0.75);
// &n114 @WIRE(mode="straight") {#X59:1 %t292:p};
// %t293 = $IO_PORT @ATTACH &n106 => @PLACE(446, -149) => @ORIENT("R0");
// %t293 @TEXT("n106", key="name", size=0.75);
// &n106 @WIRE(mode="straight") {#X59:2 %t293:p};
// %t294 = $IO_PORT @ATTACH &n115 => @PLACE(466, -147) => @ORIENT("MY");
// %t294 @TEXT("n115", key="name", size=0.75);
// &n115 @WIRE(mode="straight") {#X59:3 %t294:p};
// %t295 = $SUPPLY @ATTACH &vdd => @PLACE(456, -136);
// &vdd @WIRE(mode="straight") {#X59:4 %t295:p};
// %t296 = $GROUND @ATTACH &vss => @PLACE(456, -158);
// &vss @WIRE(mode="straight") {#X59:5 %t296:p};
// %t297 = $IO_PORT @ATTACH &measured6 => @PLACE(326, -180) => @ORIENT("R0");
// %t297 @TEXT("measured6", key="name", size=0.75);
// &measured6 @WIRE(mode="straight") {#X60:1 %t297:p};
// %t298 = $IO_PORT @ATTACH &n115 => @PLACE(326, -184) => @ORIENT("R0");
// %t298 @TEXT("n115", key="name", size=0.75);
// &n115 @WIRE(mode="straight") {#X60:2 %t298:p};
// %t299 = $IO_PORT @ATTACH &n116 => @PLACE(346, -182) => @ORIENT("MY");
// %t299 @TEXT("n116", key="name", size=0.75);
// &n116 @WIRE(mode="straight") {#X60:3 %t299:p};
// %t300 = $SUPPLY @ATTACH &vdd => @PLACE(336, -171);
// &vdd @WIRE(mode="straight") {#X60:4 %t300:p};
// %t301 = $GROUND @ATTACH &vss => @PLACE(336, -193);
// &vss @WIRE(mode="straight") {#X60:5 %t301:p};
// %t302 = $IO_PORT @ATTACH &n117 => @PLACE(366, -180) => @ORIENT("R0");
// %t302 @TEXT("n117", key="name", size=0.75);
// &n117 @WIRE(mode="straight") {#X61:1 %t302:p};
// %t303 = $IO_PORT @ATTACH &n113 => @PLACE(366, -184) => @ORIENT("R0");
// %t303 @TEXT("n113", key="name", size=0.75);
// &n113 @WIRE(mode="straight") {#X61:2 %t303:p};
// %t304 = $IO_PORT @ATTACH &n118 => @PLACE(386, -182) => @ORIENT("MY");
// %t304 @TEXT("n118", key="name", size=0.75);
// &n118 @WIRE(mode="straight") {#X61:3 %t304:p};
// %t305 = $SUPPLY @ATTACH &vdd => @PLACE(376, -171);
// &vdd @WIRE(mode="straight") {#X61:4 %t305:p};
// %t306 = $GROUND @ATTACH &vss => @PLACE(376, -193);
// &vss @WIRE(mode="straight") {#X61:5 %t306:p};
// %t307 = $IO_PORT @ATTACH &measured12 => @PLACE(406, -180) => @ORIENT("R0");
// %t307 @TEXT("measured12", key="name", size=0.75);
// &measured12 @WIRE(mode="straight") {#X62:1 %t307:p};
// %t308 = $IO_PORT @ATTACH &n118 => @PLACE(406, -184) => @ORIENT("R0");
// %t308 @TEXT("n118", key="name", size=0.75);
// &n118 @WIRE(mode="straight") {#X62:2 %t308:p};
// %t309 = $IO_PORT @ATTACH &n119 => @PLACE(426, -182) => @ORIENT("MY");
// %t309 @TEXT("n119", key="name", size=0.75);
// &n119 @WIRE(mode="straight") {#X62:3 %t309:p};
// %t310 = $SUPPLY @ATTACH &vdd => @PLACE(416, -171);
// &vdd @WIRE(mode="straight") {#X62:4 %t310:p};
// %t311 = $GROUND @ATTACH &vss => @PLACE(416, -193);
// &vss @WIRE(mode="straight") {#X62:5 %t311:p};
// %t312 = $IO_PORT @ATTACH &n120 => @PLACE(446, -180) => @ORIENT("R0");
// %t312 @TEXT("n120", key="name", size=0.75);
// &n120 @WIRE(mode="straight") {#X63:1 %t312:p};
// %t313 = $IO_PORT @ATTACH &n106 => @PLACE(446, -184) => @ORIENT("R0");
// %t313 @TEXT("n106", key="name", size=0.75);
// &n106 @WIRE(mode="straight") {#X63:2 %t313:p};
// %t314 = $IO_PORT @ATTACH &n113 => @PLACE(466, -182) => @ORIENT("MY");
// %t314 @TEXT("n113", key="name", size=0.75);
// &n113 @WIRE(mode="straight") {#X63:3 %t314:p};
// %t315 = $SUPPLY @ATTACH &vdd => @PLACE(456, -171);
// &vdd @WIRE(mode="straight") {#X63:4 %t315:p};
// %t316 = $GROUND @ATTACH &vss => @PLACE(456, -193);
// &vss @WIRE(mode="straight") {#X63:5 %t316:p};
// %t317 = $IO_PORT @ATTACH &n121 => @PLACE(326, -213) => @ORIENT("R0");
// %t317 @TEXT("n121", key="name", size=0.75);
// &n121 @WIRE(mode="straight") {#X64:1 %t317:p};
// %t318 = $IO_PORT @ATTACH &n112 => @PLACE(326, -217) => @ORIENT("R0");
// %t318 @TEXT("n112", key="name", size=0.75);
// &n112 @WIRE(mode="straight") {#X64:2 %t318:p};
// %t319 = $IO_PORT @ATTACH &n117 => @PLACE(346, -215) => @ORIENT("MY");
// %t319 @TEXT("n117", key="name", size=0.75);
// &n117 @WIRE(mode="straight") {#X64:3 %t319:p};
// %t320 = $SUPPLY @ATTACH &vdd => @PLACE(336, -204);
// &vdd @WIRE(mode="straight") {#X64:4 %t320:p};
// %t321 = $GROUND @ATTACH &vss => @PLACE(336, -226);
// &vss @WIRE(mode="straight") {#X64:5 %t321:p};
// %t322 = $IO_PORT @ATTACH &n122 => @PLACE(366, -213) => @ORIENT("R0");
// %t322 @TEXT("n122", key="name", size=0.75);
// &n122 @WIRE(mode="straight") {#X65:1 %t322:p};
// %t323 = $IO_PORT @ATTACH &n114 => @PLACE(366, -217) => @ORIENT("R0");
// %t323 @TEXT("n114", key="name", size=0.75);
// &n114 @WIRE(mode="straight") {#X65:2 %t323:p};
// %t324 = $IO_PORT @ATTACH &n120 => @PLACE(386, -215) => @ORIENT("MY");
// %t324 @TEXT("n120", key="name", size=0.75);
// &n120 @WIRE(mode="straight") {#X65:3 %t324:p};
// %t325 = $SUPPLY @ATTACH &vdd => @PLACE(376, -204);
// &vdd @WIRE(mode="straight") {#X65:4 %t325:p};
// %t326 = $GROUND @ATTACH &vss => @PLACE(376, -226);
// &vss @WIRE(mode="straight") {#X65:5 %t326:p};
// %t327 = $IO_PORT @ATTACH &n123 => @PLACE(406, -213) => @ORIENT("R0");
// %t327 @TEXT("n123", key="name", size=0.75);
// &n123 @WIRE(mode="straight") {#X66:1 %t327:p};
// %t328 = $IO_PORT @ATTACH &n108 => @PLACE(406, -217) => @ORIENT("R0");
// %t328 @TEXT("n108", key="name", size=0.75);
// &n108 @WIRE(mode="straight") {#X66:2 %t328:p};
// %t329 = $IO_PORT @ATTACH &n106 => @PLACE(426, -215) => @ORIENT("MY");
// %t329 @TEXT("n106", key="name", size=0.75);
// &n106 @WIRE(mode="straight") {#X66:3 %t329:p};
// %t330 = $SUPPLY @ATTACH &vdd => @PLACE(416, -204);
// &vdd @WIRE(mode="straight") {#X66:4 %t330:p};
// %t331 = $GROUND @ATTACH &vss => @PLACE(416, -226);
// &vss @WIRE(mode="straight") {#X66:5 %t331:p};
// %t332 = $IO_PORT @ATTACH &measured11 => @PLACE(446, -213) => @ORIENT("R0");
// %t332 @TEXT("measured11", key="name", size=0.75);
// &measured11 @WIRE(mode="straight") {#X67:1 %t332:p};
// %t333 = $IO_PORT @ATTACH &measured10 => @PLACE(446, -217) => @ORIENT("R0");
// %t333 @TEXT("measured10", key="name", size=0.75);
// &measured10 @WIRE(mode="straight") {#X67:2 %t333:p};
// %t334 = $IO_PORT @ATTACH &n121 => @PLACE(466, -215) => @ORIENT("MY");
// %t334 @TEXT("n121", key="name", size=0.75);
// &n121 @WIRE(mode="straight") {#X67:3 %t334:p};
// %t335 = $SUPPLY @ATTACH &vdd => @PLACE(456, -204);
// &vdd @WIRE(mode="straight") {#X67:4 %t335:p};
// %t336 = $GROUND @ATTACH &vss => @PLACE(456, -226);
// &vss @WIRE(mode="straight") {#X67:5 %t336:p};
// %t337 = $IO_PORT @ATTACH &measured9 => @PLACE(326, -244) => @ORIENT("R0");
// %t337 @TEXT("measured9", key="name", size=0.75);
// &measured9 @WIRE(mode="straight") {#X68:1 %t337:p};
// %t338 = $IO_PORT @ATTACH &measured8 => @PLACE(326, -248) => @ORIENT("R0");
// %t338 @TEXT("measured8", key="name", size=0.75);
// &measured8 @WIRE(mode="straight") {#X68:2 %t338:p};
// %t339 = $IO_PORT @ATTACH &n112 => @PLACE(346, -246) => @ORIENT("MY");
// %t339 @TEXT("n112", key="name", size=0.75);
// &n112 @WIRE(mode="straight") {#X68:3 %t339:p};
// %t340 = $SUPPLY @ATTACH &vdd => @PLACE(336, -235);
// &vdd @WIRE(mode="straight") {#X68:4 %t340:p};
// %t341 = $GROUND @ATTACH &vss => @PLACE(336, -257);
// &vss @WIRE(mode="straight") {#X68:5 %t341:p};
// %t342 = $IO_PORT @ATTACH &measured7 => @PLACE(366, -244) => @ORIENT("R0");
// %t342 @TEXT("measured7", key="name", size=0.75);
// &measured7 @WIRE(mode="straight") {#X69:1 %t342:p};
// %t343 = $IO_PORT @ATTACH &measured6 => @PLACE(366, -248) => @ORIENT("R0");
// %t343 @TEXT("measured6", key="name", size=0.75);
// &measured6 @WIRE(mode="straight") {#X69:2 %t343:p};
// %t344 = $IO_PORT @ATTACH &n122 => @PLACE(386, -246) => @ORIENT("MY");
// %t344 @TEXT("n122", key="name", size=0.75);
// &n122 @WIRE(mode="straight") {#X69:3 %t344:p};
// %t345 = $SUPPLY @ATTACH &vdd => @PLACE(376, -235);
// &vdd @WIRE(mode="straight") {#X69:4 %t345:p};
// %t346 = $GROUND @ATTACH &vss => @PLACE(376, -257);
// &vss @WIRE(mode="straight") {#X69:5 %t346:p};
// %t347 = $IO_PORT @ATTACH &measured5 => @PLACE(406, -244) => @ORIENT("R0");
// %t347 @TEXT("measured5", key="name", size=0.75);
// &measured5 @WIRE(mode="straight") {#X70:1 %t347:p};
// %t348 = $IO_PORT @ATTACH &measured4 => @PLACE(406, -248) => @ORIENT("R0");
// %t348 @TEXT("measured4", key="name", size=0.75);
// &measured4 @WIRE(mode="straight") {#X70:2 %t348:p};
// %t349 = $IO_PORT @ATTACH &n114 => @PLACE(426, -246) => @ORIENT("MY");
// %t349 @TEXT("n114", key="name", size=0.75);
// &n114 @WIRE(mode="straight") {#X70:3 %t349:p};
// %t350 = $SUPPLY @ATTACH &vdd => @PLACE(416, -235);
// &vdd @WIRE(mode="straight") {#X70:4 %t350:p};
// %t351 = $GROUND @ATTACH &vss => @PLACE(416, -257);
// &vss @WIRE(mode="straight") {#X70:5 %t351:p};
// %t352 = $IO_PORT @ATTACH &measured3 => @PLACE(446, -244) => @ORIENT("R0");
// %t352 @TEXT("measured3", key="name", size=0.75);
// &measured3 @WIRE(mode="straight") {#X71:1 %t352:p};
// %t353 = $IO_PORT @ATTACH &measured2 => @PLACE(446, -248) => @ORIENT("R0");
// %t353 @TEXT("measured2", key="name", size=0.75);
// &measured2 @WIRE(mode="straight") {#X71:2 %t353:p};
// %t354 = $IO_PORT @ATTACH &n123 => @PLACE(466, -246) => @ORIENT("MY");
// %t354 @TEXT("n123", key="name", size=0.75);
// &n123 @WIRE(mode="straight") {#X71:3 %t354:p};
// %t355 = $SUPPLY @ATTACH &vdd => @PLACE(456, -235);
// &vdd @WIRE(mode="straight") {#X71:4 %t355:p};
// %t356 = $GROUND @ATTACH &vss => @PLACE(456, -257);
// &vss @WIRE(mode="straight") {#X71:5 %t356:p};
// %t357 = $IO_PORT @ATTACH &measured8 => @PLACE(494, -75) => @ORIENT("R0");
// %t357 @TEXT("measured8", key="name", size=0.75);
// &measured8 @WIRE(mode="straight") {#X72:1 %t357:p};
// %t358 = $IO_PORT @ATTACH &n113 => @PLACE(494, -79) => @ORIENT("R0");
// %t358 @TEXT("n113", key="name", size=0.75);
// &n113 @WIRE(mode="straight") {#X72:2 %t358:p};
// %t359 = $IO_PORT @ATTACH &n124 => @PLACE(514, -77) => @ORIENT("MY");
// %t359 @TEXT("n124", key="name", size=0.75);
// &n124 @WIRE(mode="straight") {#X72:3 %t359:p};
// %t360 = $SUPPLY @ATTACH &vdd => @PLACE(504, -66);
// &vdd @WIRE(mode="straight") {#X72:4 %t360:p};
// %t361 = $GROUND @ATTACH &vss => @PLACE(504, -88);
// &vss @WIRE(mode="straight") {#X72:5 %t361:p};
// %t362 = $IO_PORT @ATTACH &measured1 => @PLACE(534, -75) => @ORIENT("R0");
// %t362 @TEXT("measured1", key="name", size=0.75);
// &measured1 @WIRE(mode="straight") {#X73:1 %t362:p};
// %t363 = $IO_PORT @ATTACH &measured0 => @PLACE(534, -79) => @ORIENT("R0");
// %t363 @TEXT("measured0", key="name", size=0.75);
// &measured0 @WIRE(mode="straight") {#X73:2 %t363:p};
// %t364 = $IO_PORT @ATTACH &n108 => @PLACE(554, -77) => @ORIENT("MY");
// %t364 @TEXT("n108", key="name", size=0.75);
// &n108 @WIRE(mode="straight") {#X73:3 %t364:p};
// %t365 = $SUPPLY @ATTACH &vdd => @PLACE(544, -66);
// &vdd @WIRE(mode="straight") {#X73:4 %t365:p};
// %t366 = $GROUND @ATTACH &vss => @PLACE(544, -88);
// &vss @WIRE(mode="straight") {#X73:5 %t366:p};
// %t367 = $IO_PORT @ATTACH &n125 => @PLACE(574, -75) => @ORIENT("R0");
// %t367 @TEXT("n125", key="name", size=0.75);
// &n125 @WIRE(mode="straight") {#X74:1 %t367:p};
// %t368 = $IO_PORT @ATTACH &n77 => @PLACE(574, -79) => @ORIENT("R0");
// %t368 @TEXT("n77", key="name", size=0.75);
// &n77 @WIRE(mode="straight") {#X74:2 %t368:p};
// %t369 = $IO_PORT @ATTACH &n126 => @PLACE(594, -77) => @ORIENT("MY");
// %t369 @TEXT("n126", key="name", size=0.75);
// &n126 @WIRE(mode="straight") {#X74:3 %t369:p};
// %t370 = $SUPPLY @ATTACH &vdd => @PLACE(584, -66);
// &vdd @WIRE(mode="straight") {#X74:4 %t370:p};
// %t371 = $GROUND @ATTACH &vss => @PLACE(584, -88);
// &vss @WIRE(mode="straight") {#X74:5 %t371:p};
// %t372 = $IO_PORT @ATTACH &n127 => @PLACE(614, -75) => @ORIENT("R0");
// %t372 @TEXT("n127", key="name", size=0.75);
// &n127 @WIRE(mode="straight") {#X75:1 %t372:p};
// %t373 = $IO_PORT @ATTACH &n76 => @PLACE(614, -79) => @ORIENT("R0");
// %t373 @TEXT("n76", key="name", size=0.75);
// &n76 @WIRE(mode="straight") {#X75:2 %t373:p};
// %t374 = $IO_PORT @ATTACH &n128 => @PLACE(635, -77) => @ORIENT("MY");
// %t374 @TEXT("n128", key="name", size=0.75);
// &n128 @WIRE(mode="straight") {#X75:3 %t374:p};
// %t375 = $SUPPLY @ATTACH &vdd => @PLACE(624, -66);
// &vdd @WIRE(mode="straight") {#X75:4 %t375:p};
// %t376 = $GROUND @ATTACH &vss => @PLACE(624, -88);
// &vss @WIRE(mode="straight") {#X75:5 %t376:p};
// %t377 = $IO_PORT @ATTACH &n129 => @PLACE(494, -110) => @ORIENT("R0");
// %t377 @TEXT("n129", key="name", size=0.75);
// &n129 @WIRE(mode="straight") {#X76:1 %t377:p};
// %t378 = $IO_PORT @ATTACH &n130 => @PLACE(494, -114) => @ORIENT("R0");
// %t378 @TEXT("n130", key="name", size=0.75);
// &n130 @WIRE(mode="straight") {#X76:2 %t378:p};
// %t379 = $IO_PORT @ATTACH &n131 => @PLACE(514, -112) => @ORIENT("MY");
// %t379 @TEXT("n131", key="name", size=0.75);
// &n131 @WIRE(mode="straight") {#X76:3 %t379:p};
// %t380 = $SUPPLY @ATTACH &vdd => @PLACE(504, -101);
// &vdd @WIRE(mode="straight") {#X76:4 %t380:p};
// %t381 = $GROUND @ATTACH &vss => @PLACE(504, -123);
// &vss @WIRE(mode="straight") {#X76:5 %t381:p};
// %t382 = $IO_PORT @ATTACH &n132 => @PLACE(534, -110) => @ORIENT("R0");
// %t382 @TEXT("n132", key="name", size=0.75);
// &n132 @WIRE(mode="straight") {#X77:1 %t382:p};
// %t383 = $IO_PORT @ATTACH &n133 => @PLACE(534, -114) => @ORIENT("R0");
// %t383 @TEXT("n133", key="name", size=0.75);
// &n133 @WIRE(mode="straight") {#X77:2 %t383:p};
// %t384 = $IO_PORT @ATTACH &n134 => @PLACE(554, -112) => @ORIENT("MY");
// %t384 @TEXT("n134", key="name", size=0.75);
// &n134 @WIRE(mode="straight") {#X77:3 %t384:p};
// %t385 = $SUPPLY @ATTACH &vdd => @PLACE(544, -101);
// &vdd @WIRE(mode="straight") {#X77:4 %t385:p};
// %t386 = $GROUND @ATTACH &vss => @PLACE(544, -123);
// &vss @WIRE(mode="straight") {#X77:5 %t386:p};
// %t387 = $IO_PORT @ATTACH &n135 => @PLACE(574, -110) => @ORIENT("R0");
// %t387 @TEXT("n135", key="name", size=0.75);
// &n135 @WIRE(mode="straight") {#X78:1 %t387:p};
// %t388 = $IO_PORT @ATTACH &n100 => @PLACE(574, -114) => @ORIENT("R0");
// %t388 @TEXT("n100", key="name", size=0.75);
// &n100 @WIRE(mode="straight") {#X78:2 %t388:p};
// %t389 = $IO_PORT @ATTACH &n136 => @PLACE(594, -112) => @ORIENT("MY");
// %t389 @TEXT("n136", key="name", size=0.75);
// &n136 @WIRE(mode="straight") {#X78:3 %t389:p};
// %t390 = $SUPPLY @ATTACH &vdd => @PLACE(584, -101);
// &vdd @WIRE(mode="straight") {#X78:4 %t390:p};
// %t391 = $GROUND @ATTACH &vss => @PLACE(584, -123);
// &vss @WIRE(mode="straight") {#X78:5 %t391:p};
// %t392 = $IO_PORT @ATTACH &n137 => @PLACE(614, -110) => @ORIENT("R0");
// %t392 @TEXT("n137", key="name", size=0.75);
// &n137 @WIRE(mode="straight") {#X79:1 %t392:p};
// %t393 = $IO_PORT @ATTACH &n99 => @PLACE(614, -114) => @ORIENT("R0");
// %t393 @TEXT("n99", key="name", size=0.75);
// &n99 @WIRE(mode="straight") {#X79:2 %t393:p};
// %t394 = $IO_PORT @ATTACH &n138 => @PLACE(635, -112) => @ORIENT("MY");
// %t394 @TEXT("n138", key="name", size=0.75);
// &n138 @WIRE(mode="straight") {#X79:3 %t394:p};
// %t395 = $SUPPLY @ATTACH &vdd => @PLACE(624, -101);
// &vdd @WIRE(mode="straight") {#X79:4 %t395:p};
// %t396 = $GROUND @ATTACH &vss => @PLACE(624, -123);
// &vss @WIRE(mode="straight") {#X79:5 %t396:p};
// %t397 = $IO_PORT @ATTACH &n125 => @PLACE(494, -145) => @ORIENT("R0");
// %t397 @TEXT("n125", key="name", size=0.75);
// &n125 @WIRE(mode="straight") {#X80:1 %t397:p};
// %t398 = $IO_PORT @ATTACH &n77 => @PLACE(494, -149) => @ORIENT("R0");
// %t398 @TEXT("n77", key="name", size=0.75);
// &n77 @WIRE(mode="straight") {#X80:2 %t398:p};
// %t399 = $IO_PORT @ATTACH &n139 => @PLACE(514, -147) => @ORIENT("MY");
// %t399 @TEXT("n139", key="name", size=0.75);
// &n139 @WIRE(mode="straight") {#X80:3 %t399:p};
// %t400 = $SUPPLY @ATTACH &vdd => @PLACE(504, -136);
// &vdd @WIRE(mode="straight") {#X80:4 %t400:p};
// %t401 = $GROUND @ATTACH &vss => @PLACE(504, -158);
// &vss @WIRE(mode="straight") {#X80:5 %t401:p};
// %t402 = $IO_PORT @ATTACH &n127 => @PLACE(534, -145) => @ORIENT("R0");
// %t402 @TEXT("n127", key="name", size=0.75);
// &n127 @WIRE(mode="straight") {#X81:1 %t402:p};
// %t403 = $IO_PORT @ATTACH &n76 => @PLACE(534, -149) => @ORIENT("R0");
// %t403 @TEXT("n76", key="name", size=0.75);
// &n76 @WIRE(mode="straight") {#X81:2 %t403:p};
// %t404 = $IO_PORT @ATTACH &n140 => @PLACE(554, -147) => @ORIENT("MY");
// %t404 @TEXT("n140", key="name", size=0.75);
// &n140 @WIRE(mode="straight") {#X81:3 %t404:p};
// %t405 = $SUPPLY @ATTACH &vdd => @PLACE(544, -136);
// &vdd @WIRE(mode="straight") {#X81:4 %t405:p};
// %t406 = $GROUND @ATTACH &vss => @PLACE(544, -158);
// &vss @WIRE(mode="straight") {#X81:5 %t406:p};
// %t407 = $IO_PORT @ATTACH &n129 => @PLACE(574, -145) => @ORIENT("R0");
// %t407 @TEXT("n129", key="name", size=0.75);
// &n129 @WIRE(mode="straight") {#X82:1 %t407:p};
// %t408 = $IO_PORT @ATTACH &n130 => @PLACE(574, -149) => @ORIENT("R0");
// %t408 @TEXT("n130", key="name", size=0.75);
// &n130 @WIRE(mode="straight") {#X82:2 %t408:p};
// %t409 = $IO_PORT @ATTACH &n141 => @PLACE(594, -147) => @ORIENT("MY");
// %t409 @TEXT("n141", key="name", size=0.75);
// &n141 @WIRE(mode="straight") {#X82:3 %t409:p};
// %t410 = $SUPPLY @ATTACH &vdd => @PLACE(584, -136);
// &vdd @WIRE(mode="straight") {#X82:4 %t410:p};
// %t411 = $GROUND @ATTACH &vss => @PLACE(584, -158);
// &vss @WIRE(mode="straight") {#X82:5 %t411:p};
// %t412 = $IO_PORT @ATTACH &n132 => @PLACE(614, -145) => @ORIENT("R0");
// %t412 @TEXT("n132", key="name", size=0.75);
// &n132 @WIRE(mode="straight") {#X83:1 %t412:p};
// %t413 = $IO_PORT @ATTACH &n133 => @PLACE(614, -149) => @ORIENT("R0");
// %t413 @TEXT("n133", key="name", size=0.75);
// &n133 @WIRE(mode="straight") {#X83:2 %t413:p};
// %t414 = $IO_PORT @ATTACH &n142 => @PLACE(635, -147) => @ORIENT("MY");
// %t414 @TEXT("n142", key="name", size=0.75);
// &n142 @WIRE(mode="straight") {#X83:3 %t414:p};
// %t415 = $SUPPLY @ATTACH &vdd => @PLACE(624, -136);
// &vdd @WIRE(mode="straight") {#X83:4 %t415:p};
// %t416 = $GROUND @ATTACH &vss => @PLACE(624, -158);
// &vss @WIRE(mode="straight") {#X83:5 %t416:p};
// %t417 = $IO_PORT @ATTACH &n135 => @PLACE(494, -180) => @ORIENT("R0");
// %t417 @TEXT("n135", key="name", size=0.75);
// &n135 @WIRE(mode="straight") {#X84:1 %t417:p};
// %t418 = $IO_PORT @ATTACH &n100 => @PLACE(494, -184) => @ORIENT("R0");
// %t418 @TEXT("n100", key="name", size=0.75);
// &n100 @WIRE(mode="straight") {#X84:2 %t418:p};
// %t419 = $IO_PORT @ATTACH &n143 => @PLACE(514, -182) => @ORIENT("MY");
// %t419 @TEXT("n143", key="name", size=0.75);
// &n143 @WIRE(mode="straight") {#X84:3 %t419:p};
// %t420 = $SUPPLY @ATTACH &vdd => @PLACE(504, -171);
// &vdd @WIRE(mode="straight") {#X84:4 %t420:p};
// %t421 = $GROUND @ATTACH &vss => @PLACE(504, -193);
// &vss @WIRE(mode="straight") {#X84:5 %t421:p};
// %t422 = $IO_PORT @ATTACH &n137 => @PLACE(534, -180) => @ORIENT("R0");
// %t422 @TEXT("n137", key="name", size=0.75);
// &n137 @WIRE(mode="straight") {#X85:1 %t422:p};
// %t423 = $IO_PORT @ATTACH &n99 => @PLACE(534, -184) => @ORIENT("R0");
// %t423 @TEXT("n99", key="name", size=0.75);
// &n99 @WIRE(mode="straight") {#X85:2 %t423:p};
// %t424 = $IO_PORT @ATTACH &n144 => @PLACE(554, -182) => @ORIENT("MY");
// %t424 @TEXT("n144", key="name", size=0.75);
// &n144 @WIRE(mode="straight") {#X85:3 %t424:p};
// %t425 = $SUPPLY @ATTACH &vdd => @PLACE(544, -171);
// &vdd @WIRE(mode="straight") {#X85:4 %t425:p};
// %t426 = $GROUND @ATTACH &vss => @PLACE(544, -193);
// &vss @WIRE(mode="straight") {#X85:5 %t426:p};
// %t427 = $IO_PORT @ATTACH &n145 => @PLACE(574, -180) => @ORIENT("R0");
// %t427 @TEXT("n145", key="name", size=0.75);
// &n145 @WIRE(mode="straight") {#X86:1 %t427:p};
// %t428 = $IO_PORT @ATTACH &n146 => @PLACE(574, -184) => @ORIENT("R0");
// %t428 @TEXT("n146", key="name", size=0.75);
// &n146 @WIRE(mode="straight") {#X86:2 %t428:p};
// %t429 = $IO_PORT @ATTACH &n147 => @PLACE(594, -182) => @ORIENT("MY");
// %t429 @TEXT("n147", key="name", size=0.75);
// &n147 @WIRE(mode="straight") {#X86:3 %t429:p};
// %t430 = $SUPPLY @ATTACH &vdd => @PLACE(584, -171);
// &vdd @WIRE(mode="straight") {#X86:4 %t430:p};
// %t431 = $GROUND @ATTACH &vss => @PLACE(584, -193);
// &vss @WIRE(mode="straight") {#X86:5 %t431:p};
// %t432 = $IO_PORT @ATTACH &n148 => @PLACE(614, -180) => @ORIENT("R0");
// %t432 @TEXT("n148", key="name", size=0.75);
// &n148 @WIRE(mode="straight") {#X87:1 %t432:p};
// %t433 = $IO_PORT @ATTACH &n149 => @PLACE(614, -184) => @ORIENT("R0");
// %t433 @TEXT("n149", key="name", size=0.75);
// &n149 @WIRE(mode="straight") {#X87:2 %t433:p};
// %t434 = $IO_PORT @ATTACH &n146 => @PLACE(635, -182) => @ORIENT("MY");
// %t434 @TEXT("n146", key="name", size=0.75);
// &n146 @WIRE(mode="straight") {#X87:3 %t434:p};
// %t435 = $SUPPLY @ATTACH &vdd => @PLACE(624, -171);
// &vdd @WIRE(mode="straight") {#X87:4 %t435:p};
// %t436 = $GROUND @ATTACH &vss => @PLACE(624, -193);
// &vss @WIRE(mode="straight") {#X87:5 %t436:p};
// %t437 = $IO_PORT @ATTACH &n150 => @PLACE(494, -213) => @ORIENT("R0");
// %t437 @TEXT("n150", key="name", size=0.75);
// &n150 @WIRE(mode="straight") {#X88:1 %t437:p};
// %t438 = $IO_PORT @ATTACH &n151 => @PLACE(494, -217) => @ORIENT("R0");
// %t438 @TEXT("n151", key="name", size=0.75);
// &n151 @WIRE(mode="straight") {#X88:2 %t438:p};
// %t439 = $IO_PORT @ATTACH &n149 => @PLACE(514, -215) => @ORIENT("MY");
// %t439 @TEXT("n149", key="name", size=0.75);
// &n149 @WIRE(mode="straight") {#X88:3 %t439:p};
// %t440 = $SUPPLY @ATTACH &vdd => @PLACE(504, -204);
// &vdd @WIRE(mode="straight") {#X88:4 %t440:p};
// %t441 = $GROUND @ATTACH &vss => @PLACE(504, -226);
// &vss @WIRE(mode="straight") {#X88:5 %t441:p};
// %t442 = $IO_PORT @ATTACH &n152 => @PLACE(534, -213) => @ORIENT("R0");
// %t442 @TEXT("n152", key="name", size=0.75);
// &n152 @WIRE(mode="straight") {#X89:1 %t442:p};
// %t443 = $IO_PORT @ATTACH &n153 => @PLACE(534, -217) => @ORIENT("R0");
// %t443 @TEXT("n153", key="name", size=0.75);
// &n153 @WIRE(mode="straight") {#X89:2 %t443:p};
// %t444 = $IO_PORT @ATTACH &n151 => @PLACE(554, -215) => @ORIENT("MY");
// %t444 @TEXT("n151", key="name", size=0.75);
// &n151 @WIRE(mode="straight") {#X89:3 %t444:p};
// %t445 = $SUPPLY @ATTACH &vdd => @PLACE(544, -204);
// &vdd @WIRE(mode="straight") {#X89:4 %t445:p};
// %t446 = $GROUND @ATTACH &vss => @PLACE(544, -226);
// &vss @WIRE(mode="straight") {#X89:5 %t446:p};
// %t447 = $IO_PORT @ATTACH &n154 => @PLACE(574, -213) => @ORIENT("R0");
// %t447 @TEXT("n154", key="name", size=0.75);
// &n154 @WIRE(mode="straight") {#X90:1 %t447:p};
// %t448 = $IO_PORT @ATTACH &n155 => @PLACE(574, -217) => @ORIENT("R0");
// %t448 @TEXT("n155", key="name", size=0.75);
// &n155 @WIRE(mode="straight") {#X90:2 %t448:p};
// %t449 = $IO_PORT @ATTACH &n153 => @PLACE(594, -215) => @ORIENT("MY");
// %t449 @TEXT("n153", key="name", size=0.75);
// &n153 @WIRE(mode="straight") {#X90:3 %t449:p};
// %t450 = $SUPPLY @ATTACH &vdd => @PLACE(584, -204);
// &vdd @WIRE(mode="straight") {#X90:4 %t450:p};
// %t451 = $GROUND @ATTACH &vss => @PLACE(584, -226);
// &vss @WIRE(mode="straight") {#X90:5 %t451:p};
// %t452 = $IO_PORT @ATTACH &n156 => @PLACE(614, -213) => @ORIENT("R0");
// %t452 @TEXT("n156", key="name", size=0.75);
// &n156 @WIRE(mode="straight") {#X91:1 %t452:p};
// %t453 = $IO_PORT @ATTACH &n157 => @PLACE(614, -217) => @ORIENT("R0");
// %t453 @TEXT("n157", key="name", size=0.75);
// &n157 @WIRE(mode="straight") {#X91:2 %t453:p};
// %t454 = $IO_PORT @ATTACH &n155 => @PLACE(635, -215) => @ORIENT("MY");
// %t454 @TEXT("n155", key="name", size=0.75);
// &n155 @WIRE(mode="straight") {#X91:3 %t454:p};
// %t455 = $SUPPLY @ATTACH &vdd => @PLACE(624, -204);
// &vdd @WIRE(mode="straight") {#X91:4 %t455:p};
// %t456 = $GROUND @ATTACH &vss => @PLACE(624, -226);
// &vss @WIRE(mode="straight") {#X91:5 %t456:p};
// %t457 = $IO_PORT @ATTACH &n158 => @PLACE(494, -244) => @ORIENT("R0");
// %t457 @TEXT("n158", key="name", size=0.75);
// &n158 @WIRE(mode="straight") {#X92:1 %t457:p};
// %t458 = $IO_PORT @ATTACH &n159 => @PLACE(494, -248) => @ORIENT("R0");
// %t458 @TEXT("n159", key="name", size=0.75);
// &n159 @WIRE(mode="straight") {#X92:2 %t458:p};
// %t459 = $IO_PORT @ATTACH &n150 => @PLACE(514, -246) => @ORIENT("MY");
// %t459 @TEXT("n150", key="name", size=0.75);
// &n150 @WIRE(mode="straight") {#X92:3 %t459:p};
// %t460 = $SUPPLY @ATTACH &vdd => @PLACE(504, -235);
// &vdd @WIRE(mode="straight") {#X92:4 %t460:p};
// %t461 = $GROUND @ATTACH &vss => @PLACE(504, -257);
// &vss @WIRE(mode="straight") {#X92:5 %t461:p};
// %t462 = $IO_PORT @ATTACH &n160 => @PLACE(534, -244) => @ORIENT("R0");
// %t462 @TEXT("n160", key="name", size=0.75);
// &n160 @WIRE(mode="straight") {#X93:1 %t462:p};
// %t463 = $IO_PORT @ATTACH &n161 => @PLACE(534, -248) => @ORIENT("R0");
// %t463 @TEXT("n161", key="name", size=0.75);
// &n161 @WIRE(mode="straight") {#X93:2 %t463:p};
// %t464 = $IO_PORT @ATTACH &n159 => @PLACE(554, -246) => @ORIENT("MY");
// %t464 @TEXT("n159", key="name", size=0.75);
// &n159 @WIRE(mode="straight") {#X93:3 %t464:p};
// %t465 = $SUPPLY @ATTACH &vdd => @PLACE(544, -235);
// &vdd @WIRE(mode="straight") {#X93:4 %t465:p};
// %t466 = $GROUND @ATTACH &vss => @PLACE(544, -257);
// &vss @WIRE(mode="straight") {#X93:5 %t466:p};
// %t467 = $IO_PORT @ATTACH &n162 => @PLACE(574, -244) => @ORIENT("R0");
// %t467 @TEXT("n162", key="name", size=0.75);
// &n162 @WIRE(mode="straight") {#X94:1 %t467:p};
// %t468 = $IO_PORT @ATTACH &n163 => @PLACE(574, -248) => @ORIENT("R0");
// %t468 @TEXT("n163", key="name", size=0.75);
// &n163 @WIRE(mode="straight") {#X94:2 %t468:p};
// %t469 = $IO_PORT @ATTACH &n154 => @PLACE(594, -246) => @ORIENT("MY");
// %t469 @TEXT("n154", key="name", size=0.75);
// &n154 @WIRE(mode="straight") {#X94:3 %t469:p};
// %t470 = $SUPPLY @ATTACH &vdd => @PLACE(584, -235);
// &vdd @WIRE(mode="straight") {#X94:4 %t470:p};
// %t471 = $GROUND @ATTACH &vss => @PLACE(584, -257);
// &vss @WIRE(mode="straight") {#X94:5 %t471:p};
// %t472 = $IO_PORT @ATTACH &n164 => @PLACE(614, -244) => @ORIENT("R0");
// %t472 @TEXT("n164", key="name", size=0.75);
// &n164 @WIRE(mode="straight") {#X95:1 %t472:p};
// %t473 = $IO_PORT @ATTACH &n165 => @PLACE(614, -248) => @ORIENT("R0");
// %t473 @TEXT("n165", key="name", size=0.75);
// &n165 @WIRE(mode="straight") {#X95:2 %t473:p};
// %t474 = $IO_PORT @ATTACH &n163 => @PLACE(635, -246) => @ORIENT("MY");
// %t474 @TEXT("n163", key="name", size=0.75);
// &n163 @WIRE(mode="straight") {#X95:3 %t474:p};
// %t475 = $SUPPLY @ATTACH &vdd => @PLACE(624, -235);
// &vdd @WIRE(mode="straight") {#X95:4 %t475:p};
// %t476 = $GROUND @ATTACH &vss => @PLACE(624, -257);
// &vss @WIRE(mode="straight") {#X95:5 %t476:p};
// %t477 = $IO_PORT @ATTACH &n166 => @PLACE(-11, -287) => @ORIENT("R0");
// %t477 @TEXT("n166", key="name", size=0.75);
// &n166 @WIRE(mode="straight") {#X96:1 %t477:p};
// %t478 = $IO_PORT @ATTACH &n167 => @PLACE(-11, -291) => @ORIENT("R0");
// %t478 @TEXT("n167", key="name", size=0.75);
// &n167 @WIRE(mode="straight") {#X96:2 %t478:p};
// %t479 = $IO_PORT @ATTACH &n157 => @PLACE(10, -289) => @ORIENT("MY");
// %t479 @TEXT("n157", key="name", size=0.75);
// &n157 @WIRE(mode="straight") {#X96:3 %t479:p};
// %t480 = $SUPPLY @ATTACH &vdd => @PLACE(0, -278);
// &vdd @WIRE(mode="straight") {#X96:4 %t480:p};
// %t481 = $GROUND @ATTACH &vss => @PLACE(0, -300);
// &vss @WIRE(mode="straight") {#X96:5 %t481:p};
// %t482 = $IO_PORT @ATTACH &n72 => @PLACE(30, -287) => @ORIENT("R0");
// %t482 @TEXT("n72", key="name", size=0.75);
// &n72 @WIRE(mode="straight") {#X97:1 %t482:p};
// %t483 = $IO_PORT @ATTACH &n168 => @PLACE(30, -291) => @ORIENT("R0");
// %t483 @TEXT("n168", key="name", size=0.75);
// &n168 @WIRE(mode="straight") {#X97:2 %t483:p};
// %t484 = $IO_PORT @ATTACH &n145 => @PLACE(50, -289) => @ORIENT("MY");
// %t484 @TEXT("n145", key="name", size=0.75);
// &n145 @WIRE(mode="straight") {#X97:3 %t484:p};
// %t485 = $SUPPLY @ATTACH &vdd => @PLACE(40, -278);
// &vdd @WIRE(mode="straight") {#X97:4 %t485:p};
// %t486 = $GROUND @ATTACH &vss => @PLACE(40, -300);
// &vss @WIRE(mode="straight") {#X97:5 %t486:p};
// %t487 = $IO_PORT @ATTACH &n73 => @PLACE(70, -287) => @ORIENT("R0");
// %t487 @TEXT("n73", key="name", size=0.75);
// &n73 @WIRE(mode="straight") {#X98:1 %t487:p};
// %t488 = $IO_PORT @ATTACH &n74 => @PLACE(70, -291) => @ORIENT("R0");
// %t488 @TEXT("n74", key="name", size=0.75);
// &n74 @WIRE(mode="straight") {#X98:2 %t488:p};
// %t489 = $IO_PORT @ATTACH &n168 => @PLACE(90, -289) => @ORIENT("MY");
// %t489 @TEXT("n168", key="name", size=0.75);
// &n168 @WIRE(mode="straight") {#X98:3 %t489:p};
// %t490 = $SUPPLY @ATTACH &vdd => @PLACE(80, -278);
// &vdd @WIRE(mode="straight") {#X98:4 %t490:p};
// %t491 = $GROUND @ATTACH &vss => @PLACE(80, -300);
// &vss @WIRE(mode="straight") {#X98:5 %t491:p};
// %t492 = $IO_PORT @ATTACH &n71 => @PLACE(110, -287) => @ORIENT("R0");
// %t492 @TEXT("n71", key="name", size=0.75);
// &n71 @WIRE(mode="straight") {#X99:1 %t492:p};
// %t493 = $IO_PORT @ATTACH &n144 => @PLACE(110, -291) => @ORIENT("R0");
// %t493 @TEXT("n144", key="name", size=0.75);
// &n144 @WIRE(mode="straight") {#X99:2 %t493:p};
// %t494 = $IO_PORT @ATTACH &n160 => @PLACE(130, -289) => @ORIENT("MY");
// %t494 @TEXT("n160", key="name", size=0.75);
// &n160 @WIRE(mode="straight") {#X99:3 %t494:p};
// %t495 = $SUPPLY @ATTACH &vdd => @PLACE(120, -278);
// &vdd @WIRE(mode="straight") {#X99:4 %t495:p};
// %t496 = $GROUND @ATTACH &vss => @PLACE(120, -300);
// &vss @WIRE(mode="straight") {#X99:5 %t496:p};
// %t497 = $IO_PORT @ATTACH &n70 => @PLACE(-11, -318) => @ORIENT("R0");
// %t497 @TEXT("n70", key="name", size=0.75);
// &n70 @WIRE(mode="straight") {#X100:1 %t497:p};
// %t498 = $IO_PORT @ATTACH &n169 => @PLACE(-11, -322) => @ORIENT("R0");
// %t498 @TEXT("n169", key="name", size=0.75);
// &n169 @WIRE(mode="straight") {#X100:2 %t498:p};
// %t499 = $IO_PORT @ATTACH &n158 => @PLACE(10, -320) => @ORIENT("MY");
// %t499 @TEXT("n158", key="name", size=0.75);
// &n158 @WIRE(mode="straight") {#X100:3 %t499:p};
// %t500 = $SUPPLY @ATTACH &vdd => @PLACE(0, -309);
// &vdd @WIRE(mode="straight") {#X100:4 %t500:p};
// %t501 = $GROUND @ATTACH &vss => @PLACE(0, -331);
// &vss @WIRE(mode="straight") {#X100:5 %t501:p};
// %t502 = $IO_PORT @ATTACH &n71 => @PLACE(30, -318) => @ORIENT("R0");
// %t502 @TEXT("n71", key="name", size=0.75);
// &n71 @WIRE(mode="straight") {#X101:1 %t502:p};
// %t503 = $IO_PORT @ATTACH &n138 => @PLACE(30, -322) => @ORIENT("R0");
// %t503 @TEXT("n138", key="name", size=0.75);
// &n138 @WIRE(mode="straight") {#X101:2 %t503:p};
// %t504 = $IO_PORT @ATTACH &n169 => @PLACE(50, -320) => @ORIENT("MY");
// %t504 @TEXT("n169", key="name", size=0.75);
// &n169 @WIRE(mode="straight") {#X101:3 %t504:p};
// %t505 = $SUPPLY @ATTACH &vdd => @PLACE(40, -309);
// &vdd @WIRE(mode="straight") {#X101:4 %t505:p};
// %t506 = $GROUND @ATTACH &vss => @PLACE(40, -331);
// &vss @WIRE(mode="straight") {#X101:5 %t506:p};
// %t507 = $IO_PORT @ATTACH &n143 => @PLACE(70, -318) => @ORIENT("R0");
// %t507 @TEXT("n143", key="name", size=0.75);
// &n143 @WIRE(mode="straight") {#X102:1 %t507:p};
// %t508 = $IO_PORT @ATTACH &n142 => @PLACE(70, -322) => @ORIENT("R0");
// %t508 @TEXT("n142", key="name", size=0.75);
// &n142 @WIRE(mode="straight") {#X102:2 %t508:p};
// %t509 = $IO_PORT @ATTACH &n170 => @PLACE(90, -320) => @ORIENT("MY");
// %t509 @TEXT("n170", key="name", size=0.75);
// &n170 @WIRE(mode="straight") {#X102:3 %t509:p};
// %t510 = $SUPPLY @ATTACH &vdd => @PLACE(80, -309);
// &vdd @WIRE(mode="straight") {#X102:4 %t510:p};
// %t511 = $GROUND @ATTACH &vss => @PLACE(80, -331);
// &vss @WIRE(mode="straight") {#X102:5 %t511:p};
// %t512 = $IO_PORT @ATTACH &n136 => @PLACE(110, -318) => @ORIENT("R0");
// %t512 @TEXT("n136", key="name", size=0.75);
// &n136 @WIRE(mode="straight") {#X103:1 %t512:p};
// %t513 = $IO_PORT @ATTACH &n171 => @PLACE(110, -322) => @ORIENT("R0");
// %t513 @TEXT("n171", key="name", size=0.75);
// &n171 @WIRE(mode="straight") {#X103:2 %t513:p};
// %t514 = $IO_PORT @ATTACH &n161 => @PLACE(130, -320) => @ORIENT("MY");
// %t514 @TEXT("n161", key="name", size=0.75);
// &n161 @WIRE(mode="straight") {#X103:3 %t514:p};
// %t515 = $SUPPLY @ATTACH &vdd => @PLACE(120, -309);
// &vdd @WIRE(mode="straight") {#X103:4 %t515:p};
// %t516 = $GROUND @ATTACH &vss => @PLACE(120, -331);
// &vss @WIRE(mode="straight") {#X103:5 %t516:p};
// %t517 = $IO_PORT @ATTACH &n143 => @PLACE(-11, -349) => @ORIENT("R0");
// %t517 @TEXT("n143", key="name", size=0.75);
// &n143 @WIRE(mode="straight") {#X104:1 %t517:p};
// %t518 = $IO_PORT @ATTACH &n134 => @PLACE(-11, -353) => @ORIENT("R0");
// %t518 @TEXT("n134", key="name", size=0.75);
// &n134 @WIRE(mode="straight") {#X104:2 %t518:p};
// %t519 = $IO_PORT @ATTACH &n171 => @PLACE(10, -351) => @ORIENT("MY");
// %t519 @TEXT("n171", key="name", size=0.75);
// &n171 @WIRE(mode="straight") {#X104:3 %t519:p};
// %t520 = $SUPPLY @ATTACH &vdd => @PLACE(0, -340);
// &vdd @WIRE(mode="straight") {#X104:4 %t520:p};
// %t521 = $GROUND @ATTACH &vss => @PLACE(0, -362);
// &vss @WIRE(mode="straight") {#X104:5 %t521:p};
// %t522 = $IO_PORT @ATTACH &n131 => @PLACE(30, -349) => @ORIENT("R0");
// %t522 @TEXT("n131", key="name", size=0.75);
// &n131 @WIRE(mode="straight") {#X105:1 %t522:p};
// %t523 = $IO_PORT @ATTACH &n172 => @PLACE(30, -353) => @ORIENT("R0");
// %t523 @TEXT("n172", key="name", size=0.75);
// &n172 @WIRE(mode="straight") {#X105:2 %t523:p};
// %t524 = $IO_PORT @ATTACH &n162 => @PLACE(50, -351) => @ORIENT("MY");
// %t524 @TEXT("n162", key="name", size=0.75);
// &n162 @WIRE(mode="straight") {#X105:3 %t524:p};
// %t525 = $SUPPLY @ATTACH &vdd => @PLACE(40, -340);
// &vdd @WIRE(mode="straight") {#X105:4 %t525:p};
// %t526 = $GROUND @ATTACH &vss => @PLACE(40, -362);
// &vss @WIRE(mode="straight") {#X105:5 %t526:p};
// %t527 = $IO_PORT @ATTACH &n141 => @PLACE(70, -349) => @ORIENT("R0");
// %t527 @TEXT("n141", key="name", size=0.75);
// &n141 @WIRE(mode="straight") {#X106:1 %t527:p};
// %t528 = $IO_PORT @ATTACH &n128 => @PLACE(70, -353) => @ORIENT("R0");
// %t528 @TEXT("n128", key="name", size=0.75);
// &n128 @WIRE(mode="straight") {#X106:2 %t528:p};
// %t529 = $IO_PORT @ATTACH &n172 => @PLACE(90, -351) => @ORIENT("MY");
// %t529 @TEXT("n172", key="name", size=0.75);
// &n172 @WIRE(mode="straight") {#X106:3 %t529:p};
// %t530 = $SUPPLY @ATTACH &vdd => @PLACE(80, -340);
// &vdd @WIRE(mode="straight") {#X106:4 %t530:p};
// %t531 = $GROUND @ATTACH &vss => @PLACE(80, -362);
// &vss @WIRE(mode="straight") {#X106:5 %t531:p};
// %t532 = $IO_PORT @ATTACH &n126 => @PLACE(110, -349) => @ORIENT("R0");
// %t532 @TEXT("n126", key="name", size=0.75);
// &n126 @WIRE(mode="straight") {#X107:1 %t532:p};
// %t533 = $IO_PORT @ATTACH &n173 => @PLACE(110, -353) => @ORIENT("R0");
// %t533 @TEXT("n173", key="name", size=0.75);
// &n173 @WIRE(mode="straight") {#X107:2 %t533:p};
// %t534 = $IO_PORT @ATTACH &n165 => @PLACE(130, -351) => @ORIENT("MY");
// %t534 @TEXT("n165", key="name", size=0.75);
// &n165 @WIRE(mode="straight") {#X107:3 %t534:p};
// %t535 = $SUPPLY @ATTACH &vdd => @PLACE(120, -340);
// &vdd @WIRE(mode="straight") {#X107:4 %t535:p};
// %t536 = $GROUND @ATTACH &vss => @PLACE(120, -362);
// &vss @WIRE(mode="straight") {#X107:5 %t536:p};
// %t537 = $IO_PORT @ATTACH &n139 => @PLACE(-11, -380) => @ORIENT("R0");
// %t537 @TEXT("n139", key="name", size=0.75);
// &n139 @WIRE(mode="straight") {#X108:1 %t537:p};
// %t538 = $IO_PORT @ATTACH &n64 => @PLACE(-11, -384) => @ORIENT("R0");
// %t538 @TEXT("n64", key="name", size=0.75);
// &n64 @WIRE(mode="straight") {#X108:2 %t538:p};
// %t539 = $IO_PORT @ATTACH &n173 => @PLACE(10, -382) => @ORIENT("MY");
// %t539 @TEXT("n173", key="name", size=0.75);
// &n173 @WIRE(mode="straight") {#X108:3 %t539:p};
// %t540 = $SUPPLY @ATTACH &vdd => @PLACE(0, -371);
// &vdd @WIRE(mode="straight") {#X108:4 %t540:p};
// %t541 = $GROUND @ATTACH &vss => @PLACE(0, -393);
// &vss @WIRE(mode="straight") {#X108:5 %t541:p};
// %t542 = $IO_PORT @ATTACH &n67 => @PLACE(30, -380) => @ORIENT("R0");
// %t542 @TEXT("n67", key="name", size=0.75);
// &n67 @WIRE(mode="straight") {#X109:1 %t542:p};
// %t543 = $IO_PORT @ATTACH &n69 => @PLACE(30, -384) => @ORIENT("R0");
// %t543 @TEXT("n69", key="name", size=0.75);
// &n69 @WIRE(mode="straight") {#X109:2 %t543:p};
// %t544 = $IO_PORT @ATTACH &n167 => @PLACE(50, -382) => @ORIENT("MY");
// %t544 @TEXT("n167", key="name", size=0.75);
// &n167 @WIRE(mode="straight") {#X109:3 %t544:p};
// %t545 = $SUPPLY @ATTACH &vdd => @PLACE(40, -371);
// &vdd @WIRE(mode="straight") {#X109:4 %t545:p};
// %t546 = $GROUND @ATTACH &vss => @PLACE(40, -393);
// &vss @WIRE(mode="straight") {#X109:5 %t546:p};
// %t547 = $IO_PORT @ATTACH &n66 => @PLACE(70, -380) => @ORIENT("R0");
// %t547 @TEXT("n66", key="name", size=0.75);
// &n66 @WIRE(mode="straight") {#X110:1 %t547:p};
// %t548 = $IO_PORT @ATTACH &n174 => @PLACE(70, -384) => @ORIENT("R0");
// %t548 @TEXT("n174", key="name", size=0.75);
// &n174 @WIRE(mode="straight") {#X110:2 %t548:p};
// %t549 = $IO_PORT @ATTACH &n166 => @PLACE(90, -382) => @ORIENT("MY");
// %t549 @TEXT("n166", key="name", size=0.75);
// &n166 @WIRE(mode="straight") {#X110:3 %t549:p};
// %t550 = $SUPPLY @ATTACH &vdd => @PLACE(80, -371);
// &vdd @WIRE(mode="straight") {#X110:4 %t550:p};
// %t551 = $GROUND @ATTACH &vss => @PLACE(80, -393);
// &vss @WIRE(mode="straight") {#X110:5 %t551:p};
// %t552 = $IO_PORT @ATTACH &n67 => @PLACE(110, -380) => @ORIENT("R0");
// %t552 @TEXT("n67", key="name", size=0.75);
// &n67 @WIRE(mode="straight") {#X111:1 %t552:p};
// %t553 = $IO_PORT @ATTACH &n68 => @PLACE(110, -384) => @ORIENT("R0");
// %t553 @TEXT("n68", key="name", size=0.75);
// &n68 @WIRE(mode="straight") {#X111:2 %t553:p};
// %t554 = $IO_PORT @ATTACH &n174 => @PLACE(130, -382) => @ORIENT("MY");
// %t554 @TEXT("n174", key="name", size=0.75);
// &n174 @WIRE(mode="straight") {#X111:3 %t554:p};
// %t555 = $SUPPLY @ATTACH &vdd => @PLACE(120, -371);
// &vdd @WIRE(mode="straight") {#X111:4 %t555:p};
// %t556 = $GROUND @ATTACH &vss => @PLACE(120, -393);
// &vss @WIRE(mode="straight") {#X111:5 %t556:p};
// %t557 = $IO_PORT @ATTACH &measured5 => @PLACE(-11, -411) => @ORIENT("R0");
// %t557 @TEXT("measured5", key="name", size=0.75);
// &measured5 @WIRE(mode="straight") {#X112:1 %t557:p};
// %t558 = $IO_PORT @ATTACH &n77 => @PLACE(-11, -415) => @ORIENT("R0");
// %t558 @TEXT("n77", key="name", size=0.75);
// &n77 @WIRE(mode="straight") {#X112:2 %t558:p};
// %t559 = $IO_PORT @ATTACH &n175 => @PLACE(10, -413) => @ORIENT("MY");
// %t559 @TEXT("n175", key="name", size=0.75);
// &n175 @WIRE(mode="straight") {#X112:3 %t559:p};
// %t560 = $SUPPLY @ATTACH &vdd => @PLACE(0, -402);
// &vdd @WIRE(mode="straight") {#X112:4 %t560:p};
// %t561 = $GROUND @ATTACH &vss => @PLACE(0, -424);
// &vss @WIRE(mode="straight") {#X112:5 %t561:p};
// %t562 = $IO_PORT @ATTACH &measured6 => @PLACE(30, -411) => @ORIENT("R0");
// %t562 @TEXT("measured6", key="name", size=0.75);
// &measured6 @WIRE(mode="straight") {#X113:1 %t562:p};
// %t563 = $IO_PORT @ATTACH &n76 => @PLACE(30, -415) => @ORIENT("R0");
// %t563 @TEXT("n76", key="name", size=0.75);
// &n76 @WIRE(mode="straight") {#X113:2 %t563:p};
// %t564 = $IO_PORT @ATTACH &n176 => @PLACE(50, -413) => @ORIENT("MY");
// %t564 @TEXT("n176", key="name", size=0.75);
// &n176 @WIRE(mode="straight") {#X113:3 %t564:p};
// %t565 = $SUPPLY @ATTACH &vdd => @PLACE(40, -402);
// &vdd @WIRE(mode="straight") {#X113:4 %t565:p};
// %t566 = $GROUND @ATTACH &vss => @PLACE(40, -424);
// &vss @WIRE(mode="straight") {#X113:5 %t566:p};
// %t567 = $IO_PORT @ATTACH &measured7 => @PLACE(70, -411) => @ORIENT("R0");
// %t567 @TEXT("measured7", key="name", size=0.75);
// &measured7 @WIRE(mode="straight") {#X114:1 %t567:p};
// %t568 = $IO_PORT @ATTACH &n130 => @PLACE(70, -415) => @ORIENT("R0");
// %t568 @TEXT("n130", key="name", size=0.75);
// &n130 @WIRE(mode="straight") {#X114:2 %t568:p};
// %t569 = $IO_PORT @ATTACH &n177 => @PLACE(90, -413) => @ORIENT("MY");
// %t569 @TEXT("n177", key="name", size=0.75);
// &n177 @WIRE(mode="straight") {#X114:3 %t569:p};
// %t570 = $SUPPLY @ATTACH &vdd => @PLACE(80, -402);
// &vdd @WIRE(mode="straight") {#X114:4 %t570:p};
// %t571 = $GROUND @ATTACH &vss => @PLACE(80, -424);
// &vss @WIRE(mode="straight") {#X114:5 %t571:p};
// %t572 = $IO_PORT @ATTACH &measured8 => @PLACE(110, -411) => @ORIENT("R0");
// %t572 @TEXT("measured8", key="name", size=0.75);
// &measured8 @WIRE(mode="straight") {#X115:1 %t572:p};
// %t573 = $IO_PORT @ATTACH &n133 => @PLACE(110, -415) => @ORIENT("R0");
// %t573 @TEXT("n133", key="name", size=0.75);
// &n133 @WIRE(mode="straight") {#X115:2 %t573:p};
// %t574 = $IO_PORT @ATTACH &n178 => @PLACE(130, -413) => @ORIENT("MY");
// %t574 @TEXT("n178", key="name", size=0.75);
// &n178 @WIRE(mode="straight") {#X115:3 %t574:p};
// %t575 = $SUPPLY @ATTACH &vdd => @PLACE(120, -402);
// &vdd @WIRE(mode="straight") {#X115:4 %t575:p};
// %t576 = $GROUND @ATTACH &vss => @PLACE(120, -424);
// &vss @WIRE(mode="straight") {#X115:5 %t576:p};
// %t577 = $IO_PORT @ATTACH &measured9 => @PLACE(-11, -442) => @ORIENT("R0");
// %t577 @TEXT("measured9", key="name", size=0.75);
// &measured9 @WIRE(mode="straight") {#X116:1 %t577:p};
// %t578 = $IO_PORT @ATTACH &n100 => @PLACE(-11, -446) => @ORIENT("R0");
// %t578 @TEXT("n100", key="name", size=0.75);
// &n100 @WIRE(mode="straight") {#X116:2 %t578:p};
// %t579 = $IO_PORT @ATTACH &n179 => @PLACE(10, -444) => @ORIENT("MY");
// %t579 @TEXT("n179", key="name", size=0.75);
// &n179 @WIRE(mode="straight") {#X116:3 %t579:p};
// %t580 = $SUPPLY @ATTACH &vdd => @PLACE(0, -433);
// &vdd @WIRE(mode="straight") {#X116:4 %t580:p};
// %t581 = $GROUND @ATTACH &vss => @PLACE(0, -455);
// &vss @WIRE(mode="straight") {#X116:5 %t581:p};
// %t582 = $IO_PORT @ATTACH &measured10 => @PLACE(30, -442) => @ORIENT("R0");
// %t582 @TEXT("measured10", key="name", size=0.75);
// &measured10 @WIRE(mode="straight") {#X117:1 %t582:p};
// %t583 = $IO_PORT @ATTACH &n99 => @PLACE(30, -446) => @ORIENT("R0");
// %t583 @TEXT("n99", key="name", size=0.75);
// &n99 @WIRE(mode="straight") {#X117:2 %t583:p};
// %t584 = $IO_PORT @ATTACH &n180 => @PLACE(50, -444) => @ORIENT("MY");
// %t584 @TEXT("n180", key="name", size=0.75);
// &n180 @WIRE(mode="straight") {#X117:3 %t584:p};
// %t585 = $SUPPLY @ATTACH &vdd => @PLACE(40, -433);
// &vdd @WIRE(mode="straight") {#X117:4 %t585:p};
// %t586 = $GROUND @ATTACH &vss => @PLACE(40, -455);
// &vss @WIRE(mode="straight") {#X117:5 %t586:p};
// %t587 = $IO_PORT @ATTACH &measured5 => @PLACE(70, -442) => @ORIENT("R0");
// %t587 @TEXT("measured5", key="name", size=0.75);
// &measured5 @WIRE(mode="straight") {#X118:1 %t587:p};
// %t588 = $IO_PORT @ATTACH &n77 => @PLACE(70, -446) => @ORIENT("R0");
// %t588 @TEXT("n77", key="name", size=0.75);
// &n77 @WIRE(mode="straight") {#X118:2 %t588:p};
// %t589 = $IO_PORT @ATTACH &n181 => @PLACE(90, -444) => @ORIENT("MY");
// %t589 @TEXT("n181", key="name", size=0.75);
// &n181 @WIRE(mode="straight") {#X118:3 %t589:p};
// %t590 = $SUPPLY @ATTACH &vdd => @PLACE(80, -433);
// &vdd @WIRE(mode="straight") {#X118:4 %t590:p};
// %t591 = $GROUND @ATTACH &vss => @PLACE(80, -455);
// &vss @WIRE(mode="straight") {#X118:5 %t591:p};
// %t592 = $IO_PORT @ATTACH &measured6 => @PLACE(110, -442) => @ORIENT("R0");
// %t592 @TEXT("measured6", key="name", size=0.75);
// &measured6 @WIRE(mode="straight") {#X119:1 %t592:p};
// %t593 = $IO_PORT @ATTACH &n76 => @PLACE(110, -446) => @ORIENT("R0");
// %t593 @TEXT("n76", key="name", size=0.75);
// &n76 @WIRE(mode="straight") {#X119:2 %t593:p};
// %t594 = $IO_PORT @ATTACH &n182 => @PLACE(130, -444) => @ORIENT("MY");
// %t594 @TEXT("n182", key="name", size=0.75);
// &n182 @WIRE(mode="straight") {#X119:3 %t594:p};
// %t595 = $SUPPLY @ATTACH &vdd => @PLACE(120, -433);
// &vdd @WIRE(mode="straight") {#X119:4 %t595:p};
// %t596 = $GROUND @ATTACH &vss => @PLACE(120, -455);
// &vss @WIRE(mode="straight") {#X119:5 %t596:p};
// %t597 = $IO_PORT @ATTACH &measured7 => @PLACE(158, -287) => @ORIENT("R0");
// %t597 @TEXT("measured7", key="name", size=0.75);
// &measured7 @WIRE(mode="straight") {#X120:1 %t597:p};
// %t598 = $IO_PORT @ATTACH &n130 => @PLACE(158, -291) => @ORIENT("R0");
// %t598 @TEXT("n130", key="name", size=0.75);
// &n130 @WIRE(mode="straight") {#X120:2 %t598:p};
// %t599 = $IO_PORT @ATTACH &n183 => @PLACE(178, -289) => @ORIENT("MY");
// %t599 @TEXT("n183", key="name", size=0.75);
// &n183 @WIRE(mode="straight") {#X120:3 %t599:p};
// %t600 = $SUPPLY @ATTACH &vdd => @PLACE(168, -278);
// &vdd @WIRE(mode="straight") {#X120:4 %t600:p};
// %t601 = $GROUND @ATTACH &vss => @PLACE(168, -300);
// &vss @WIRE(mode="straight") {#X120:5 %t601:p};
// %t602 = $IO_PORT @ATTACH &measured8 => @PLACE(198, -287) => @ORIENT("R0");
// %t602 @TEXT("measured8", key="name", size=0.75);
// &measured8 @WIRE(mode="straight") {#X121:1 %t602:p};
// %t603 = $IO_PORT @ATTACH &n133 => @PLACE(198, -291) => @ORIENT("R0");
// %t603 @TEXT("n133", key="name", size=0.75);
// &n133 @WIRE(mode="straight") {#X121:2 %t603:p};
// %t604 = $IO_PORT @ATTACH &n184 => @PLACE(218, -289) => @ORIENT("MY");
// %t604 @TEXT("n184", key="name", size=0.75);
// &n184 @WIRE(mode="straight") {#X121:3 %t604:p};
// %t605 = $SUPPLY @ATTACH &vdd => @PLACE(208, -278);
// &vdd @WIRE(mode="straight") {#X121:4 %t605:p};
// %t606 = $GROUND @ATTACH &vss => @PLACE(208, -300);
// &vss @WIRE(mode="straight") {#X121:5 %t606:p};
// %t607 = $IO_PORT @ATTACH &measured9 => @PLACE(238, -287) => @ORIENT("R0");
// %t607 @TEXT("measured9", key="name", size=0.75);
// &measured9 @WIRE(mode="straight") {#X122:1 %t607:p};
// %t608 = $IO_PORT @ATTACH &n100 => @PLACE(238, -291) => @ORIENT("R0");
// %t608 @TEXT("n100", key="name", size=0.75);
// &n100 @WIRE(mode="straight") {#X122:2 %t608:p};
// %t609 = $IO_PORT @ATTACH &n185 => @PLACE(258, -289) => @ORIENT("MY");
// %t609 @TEXT("n185", key="name", size=0.75);
// &n185 @WIRE(mode="straight") {#X122:3 %t609:p};
// %t610 = $SUPPLY @ATTACH &vdd => @PLACE(248, -278);
// &vdd @WIRE(mode="straight") {#X122:4 %t610:p};
// %t611 = $GROUND @ATTACH &vss => @PLACE(248, -300);
// &vss @WIRE(mode="straight") {#X122:5 %t611:p};
// %t612 = $IO_PORT @ATTACH &measured10 => @PLACE(278, -287) => @ORIENT("R0");
// %t612 @TEXT("measured10", key="name", size=0.75);
// &measured10 @WIRE(mode="straight") {#X123:1 %t612:p};
// %t613 = $IO_PORT @ATTACH &n99 => @PLACE(278, -291) => @ORIENT("R0");
// %t613 @TEXT("n99", key="name", size=0.75);
// &n99 @WIRE(mode="straight") {#X123:2 %t613:p};
// %t614 = $IO_PORT @ATTACH &n186 => @PLACE(298, -289) => @ORIENT("MY");
// %t614 @TEXT("n186", key="name", size=0.75);
// &n186 @WIRE(mode="straight") {#X123:3 %t614:p};
// %t615 = $SUPPLY @ATTACH &vdd => @PLACE(288, -278);
// &vdd @WIRE(mode="straight") {#X123:4 %t615:p};
// %t616 = $GROUND @ATTACH &vss => @PLACE(288, -300);
// &vss @WIRE(mode="straight") {#X123:5 %t616:p};
// %t617 = $IO_PORT @ATTACH &n187 => @PLACE(158, -318) => @ORIENT("R0");
// %t617 @TEXT("n187", key="name", size=0.75);
// &n187 @WIRE(mode="straight") {#X124:1 %t617:p};
// %t618 = $IO_PORT @ATTACH &n188 => @PLACE(158, -322) => @ORIENT("R0");
// %t618 @TEXT("n188", key="name", size=0.75);
// &n188 @WIRE(mode="straight") {#X124:2 %t618:p};
// %t619 = $IO_PORT @ATTACH &n189 => @PLACE(178, -320) => @ORIENT("MY");
// %t619 @TEXT("n189", key="name", size=0.75);
// &n189 @WIRE(mode="straight") {#X124:3 %t619:p};
// %t620 = $SUPPLY @ATTACH &vdd => @PLACE(168, -309);
// &vdd @WIRE(mode="straight") {#X124:4 %t620:p};
// %t621 = $GROUND @ATTACH &vss => @PLACE(168, -331);
// &vss @WIRE(mode="straight") {#X124:5 %t621:p};
// %t622 = $IO_PORT @ATTACH &n190 => @PLACE(198, -318) => @ORIENT("R0");
// %t622 @TEXT("n190", key="name", size=0.75);
// &n190 @WIRE(mode="straight") {#X125:1 %t622:p};
// %t623 = $IO_PORT @ATTACH &n191 => @PLACE(198, -322) => @ORIENT("R0");
// %t623 @TEXT("n191", key="name", size=0.75);
// &n191 @WIRE(mode="straight") {#X125:2 %t623:p};
// %t624 = $IO_PORT @ATTACH &n188 => @PLACE(218, -320) => @ORIENT("MY");
// %t624 @TEXT("n188", key="name", size=0.75);
// &n188 @WIRE(mode="straight") {#X125:3 %t624:p};
// %t625 = $SUPPLY @ATTACH &vdd => @PLACE(208, -309);
// &vdd @WIRE(mode="straight") {#X125:4 %t625:p};
// %t626 = $GROUND @ATTACH &vss => @PLACE(208, -331);
// &vss @WIRE(mode="straight") {#X125:5 %t626:p};
// %t627 = $IO_PORT @ATTACH &n192 => @PLACE(238, -318) => @ORIENT("R0");
// %t627 @TEXT("n192", key="name", size=0.75);
// &n192 @WIRE(mode="straight") {#X126:1 %t627:p};
// %t628 = $IO_PORT @ATTACH &n193 => @PLACE(238, -322) => @ORIENT("R0");
// %t628 @TEXT("n193", key="name", size=0.75);
// &n193 @WIRE(mode="straight") {#X126:2 %t628:p};
// %t629 = $IO_PORT @ATTACH &n191 => @PLACE(258, -320) => @ORIENT("MY");
// %t629 @TEXT("n191", key="name", size=0.75);
// &n191 @WIRE(mode="straight") {#X126:3 %t629:p};
// %t630 = $SUPPLY @ATTACH &vdd => @PLACE(248, -309);
// &vdd @WIRE(mode="straight") {#X126:4 %t630:p};
// %t631 = $GROUND @ATTACH &vss => @PLACE(248, -331);
// &vss @WIRE(mode="straight") {#X126:5 %t631:p};
// %t632 = $IO_PORT @ATTACH &n194 => @PLACE(278, -318) => @ORIENT("R0");
// %t632 @TEXT("n194", key="name", size=0.75);
// &n194 @WIRE(mode="straight") {#X127:1 %t632:p};
// %t633 = $IO_PORT @ATTACH &n195 => @PLACE(278, -322) => @ORIENT("R0");
// %t633 @TEXT("n195", key="name", size=0.75);
// &n195 @WIRE(mode="straight") {#X127:2 %t633:p};
// %t634 = $IO_PORT @ATTACH &n193 => @PLACE(298, -320) => @ORIENT("MY");
// %t634 @TEXT("n193", key="name", size=0.75);
// &n193 @WIRE(mode="straight") {#X127:3 %t634:p};
// %t635 = $SUPPLY @ATTACH &vdd => @PLACE(288, -309);
// &vdd @WIRE(mode="straight") {#X127:4 %t635:p};
// %t636 = $GROUND @ATTACH &vss => @PLACE(288, -331);
// &vss @WIRE(mode="straight") {#X127:5 %t636:p};
// %t637 = $IO_PORT @ATTACH &n196 => @PLACE(158, -349) => @ORIENT("R0");
// %t637 @TEXT("n196", key="name", size=0.75);
// &n196 @WIRE(mode="straight") {#X128:1 %t637:p};
// %t638 = $IO_PORT @ATTACH &n197 => @PLACE(158, -353) => @ORIENT("R0");
// %t638 @TEXT("n197", key="name", size=0.75);
// &n197 @WIRE(mode="straight") {#X128:2 %t638:p};
// %t639 = $IO_PORT @ATTACH &n195 => @PLACE(178, -351) => @ORIENT("MY");
// %t639 @TEXT("n195", key="name", size=0.75);
// &n195 @WIRE(mode="straight") {#X128:3 %t639:p};
// %t640 = $SUPPLY @ATTACH &vdd => @PLACE(168, -340);
// &vdd @WIRE(mode="straight") {#X128:4 %t640:p};
// %t641 = $GROUND @ATTACH &vss => @PLACE(168, -362);
// &vss @WIRE(mode="straight") {#X128:5 %t641:p};
// %t642 = $IO_PORT @ATTACH &n198 => @PLACE(198, -349) => @ORIENT("R0");
// %t642 @TEXT("n198", key="name", size=0.75);
// &n198 @WIRE(mode="straight") {#X129:1 %t642:p};
// %t643 = $IO_PORT @ATTACH &n199 => @PLACE(198, -353) => @ORIENT("R0");
// %t643 @TEXT("n199", key="name", size=0.75);
// &n199 @WIRE(mode="straight") {#X129:2 %t643:p};
// %t644 = $IO_PORT @ATTACH &n197 => @PLACE(218, -351) => @ORIENT("MY");
// %t644 @TEXT("n197", key="name", size=0.75);
// &n197 @WIRE(mode="straight") {#X129:3 %t644:p};
// %t645 = $SUPPLY @ATTACH &vdd => @PLACE(208, -340);
// &vdd @WIRE(mode="straight") {#X129:4 %t645:p};
// %t646 = $GROUND @ATTACH &vss => @PLACE(208, -362);
// &vss @WIRE(mode="straight") {#X129:5 %t646:p};
// %t647 = $IO_PORT @ATTACH &n200 => @PLACE(238, -349) => @ORIENT("R0");
// %t647 @TEXT("n200", key="name", size=0.75);
// &n200 @WIRE(mode="straight") {#X130:1 %t647:p};
// %t648 = $IO_PORT @ATTACH &n201 => @PLACE(238, -353) => @ORIENT("R0");
// %t648 @TEXT("n201", key="name", size=0.75);
// &n201 @WIRE(mode="straight") {#X130:2 %t648:p};
// %t649 = $IO_PORT @ATTACH &n192 => @PLACE(258, -351) => @ORIENT("MY");
// %t649 @TEXT("n192", key="name", size=0.75);
// &n192 @WIRE(mode="straight") {#X130:3 %t649:p};
// %t650 = $SUPPLY @ATTACH &vdd => @PLACE(248, -340);
// &vdd @WIRE(mode="straight") {#X130:4 %t650:p};
// %t651 = $GROUND @ATTACH &vss => @PLACE(248, -362);
// &vss @WIRE(mode="straight") {#X130:5 %t651:p};
// %t652 = $IO_PORT @ATTACH &n202 => @PLACE(278, -349) => @ORIENT("R0");
// %t652 @TEXT("n202", key="name", size=0.75);
// &n202 @WIRE(mode="straight") {#X131:1 %t652:p};
// %t653 = $IO_PORT @ATTACH &n203 => @PLACE(278, -353) => @ORIENT("R0");
// %t653 @TEXT("n203", key="name", size=0.75);
// &n203 @WIRE(mode="straight") {#X131:2 %t653:p};
// %t654 = $IO_PORT @ATTACH &n201 => @PLACE(298, -351) => @ORIENT("MY");
// %t654 @TEXT("n201", key="name", size=0.75);
// &n201 @WIRE(mode="straight") {#X131:3 %t654:p};
// %t655 = $SUPPLY @ATTACH &vdd => @PLACE(288, -340);
// &vdd @WIRE(mode="straight") {#X131:4 %t655:p};
// %t656 = $GROUND @ATTACH &vss => @PLACE(288, -362);
// &vss @WIRE(mode="straight") {#X131:5 %t656:p};
// %t657 = $IO_PORT @ATTACH &n204 => @PLACE(158, -380) => @ORIENT("R0");
// %t657 @TEXT("n204", key="name", size=0.75);
// &n204 @WIRE(mode="straight") {#X132:1 %t657:p};
// %t658 = $IO_PORT @ATTACH &n205 => @PLACE(158, -384) => @ORIENT("R0");
// %t658 @TEXT("n205", key="name", size=0.75);
// &n205 @WIRE(mode="straight") {#X132:2 %t658:p};
// %t659 = $IO_PORT @ATTACH &n196 => @PLACE(178, -382) => @ORIENT("MY");
// %t659 @TEXT("n196", key="name", size=0.75);
// &n196 @WIRE(mode="straight") {#X132:3 %t659:p};
// %t660 = $SUPPLY @ATTACH &vdd => @PLACE(168, -371);
// &vdd @WIRE(mode="straight") {#X132:4 %t660:p};
// %t661 = $GROUND @ATTACH &vss => @PLACE(168, -393);
// &vss @WIRE(mode="straight") {#X132:5 %t661:p};
// %t662 = $IO_PORT @ATTACH &n206 => @PLACE(198, -380) => @ORIENT("R0");
// %t662 @TEXT("n206", key="name", size=0.75);
// &n206 @WIRE(mode="straight") {#X133:1 %t662:p};
// %t663 = $IO_PORT @ATTACH &n207 => @PLACE(198, -384) => @ORIENT("R0");
// %t663 @TEXT("n207", key="name", size=0.75);
// &n207 @WIRE(mode="straight") {#X133:2 %t663:p};
// %t664 = $IO_PORT @ATTACH &n205 => @PLACE(218, -382) => @ORIENT("MY");
// %t664 @TEXT("n205", key="name", size=0.75);
// &n205 @WIRE(mode="straight") {#X133:3 %t664:p};
// %t665 = $SUPPLY @ATTACH &vdd => @PLACE(208, -371);
// &vdd @WIRE(mode="straight") {#X133:4 %t665:p};
// %t666 = $GROUND @ATTACH &vss => @PLACE(208, -393);
// &vss @WIRE(mode="straight") {#X133:5 %t666:p};
// %t667 = $IO_PORT @ATTACH &n208 => @PLACE(238, -380) => @ORIENT("R0");
// %t667 @TEXT("n208", key="name", size=0.75);
// &n208 @WIRE(mode="straight") {#X134:1 %t667:p};
// %t668 = $IO_PORT @ATTACH &n209 => @PLACE(238, -384) => @ORIENT("R0");
// %t668 @TEXT("n209", key="name", size=0.75);
// &n209 @WIRE(mode="straight") {#X134:2 %t668:p};
// %t669 = $IO_PORT @ATTACH &n199 => @PLACE(258, -382) => @ORIENT("MY");
// %t669 @TEXT("n199", key="name", size=0.75);
// &n199 @WIRE(mode="straight") {#X134:3 %t669:p};
// %t670 = $SUPPLY @ATTACH &vdd => @PLACE(248, -371);
// &vdd @WIRE(mode="straight") {#X134:4 %t670:p};
// %t671 = $GROUND @ATTACH &vss => @PLACE(248, -393);
// &vss @WIRE(mode="straight") {#X134:5 %t671:p};
// %t672 = $IO_PORT @ATTACH &n210 => @PLACE(278, -380) => @ORIENT("R0");
// %t672 @TEXT("n210", key="name", size=0.75);
// &n210 @WIRE(mode="straight") {#X135:1 %t672:p};
// %t673 = $IO_PORT @ATTACH &n211 => @PLACE(278, -384) => @ORIENT("R0");
// %t673 @TEXT("n211", key="name", size=0.75);
// &n211 @WIRE(mode="straight") {#X135:2 %t673:p};
// %t674 = $IO_PORT @ATTACH &n209 => @PLACE(298, -382) => @ORIENT("MY");
// %t674 @TEXT("n209", key="name", size=0.75);
// &n209 @WIRE(mode="straight") {#X135:3 %t674:p};
// %t675 = $SUPPLY @ATTACH &vdd => @PLACE(288, -371);
// &vdd @WIRE(mode="straight") {#X135:4 %t675:p};
// %t676 = $GROUND @ATTACH &vss => @PLACE(288, -393);
// &vss @WIRE(mode="straight") {#X135:5 %t676:p};
// %t677 = $IO_PORT @ATTACH &measured13 => @PLACE(158, -411) => @ORIENT("R0");
// %t677 @TEXT("measured13", key="name", size=0.75);
// &measured13 @WIRE(mode="straight") {#X136:1 %t677:p};
// %t678 = $IO_PORT @ATTACH &n212 => @PLACE(158, -415) => @ORIENT("R0");
// %t678 @TEXT("n212", key="name", size=0.75);
// &n212 @WIRE(mode="straight") {#X136:2 %t678:p};
// %t679 = $IO_PORT @ATTACH &n187 => @PLACE(178, -413) => @ORIENT("MY");
// %t679 @TEXT("n187", key="name", size=0.75);
// &n187 @WIRE(mode="straight") {#X136:3 %t679:p};
// %t680 = $SUPPLY @ATTACH &vdd => @PLACE(168, -402);
// &vdd @WIRE(mode="straight") {#X136:4 %t680:p};
// %t681 = $GROUND @ATTACH &vss => @PLACE(168, -424);
// &vss @WIRE(mode="straight") {#X136:5 %t681:p};
// %t682 = $IO_PORT @ATTACH &n60 => @PLACE(198, -411) => @ORIENT("R0");
// %t682 @TEXT("n60", key="name", size=0.75);
// &n60 @WIRE(mode="straight") {#X137:1 %t682:p};
// %t683 = $IO_PORT @ATTACH &measured12 => @PLACE(198, -415) => @ORIENT("R0");
// %t683 @TEXT("measured12", key="name", size=0.75);
// &measured12 @WIRE(mode="straight") {#X137:2 %t683:p};
// %t684 = $IO_PORT @ATTACH &n212 => @PLACE(218, -413) => @ORIENT("MY");
// %t684 @TEXT("n212", key="name", size=0.75);
// &n212 @WIRE(mode="straight") {#X137:3 %t684:p};
// %t685 = $SUPPLY @ATTACH &vdd => @PLACE(208, -402);
// &vdd @WIRE(mode="straight") {#X137:4 %t685:p};
// %t686 = $GROUND @ATTACH &vss => @PLACE(208, -424);
// &vss @WIRE(mode="straight") {#X137:5 %t686:p};
// %t687 = $IO_PORT @ATTACH &measured11 => @PLACE(238, -411) => @ORIENT("R0");
// %t687 @TEXT("measured11", key="name", size=0.75);
// &measured11 @WIRE(mode="straight") {#X138:1 %t687:p};
// %t688 = $IO_PORT @ATTACH &n213 => @PLACE(238, -415) => @ORIENT("R0");
// %t688 @TEXT("n213", key="name", size=0.75);
// &n213 @WIRE(mode="straight") {#X138:2 %t688:p};
// %t689 = $IO_PORT @ATTACH &n200 => @PLACE(258, -413) => @ORIENT("MY");
// %t689 @TEXT("n200", key="name", size=0.75);
// &n200 @WIRE(mode="straight") {#X138:3 %t689:p};
// %t690 = $SUPPLY @ATTACH &vdd => @PLACE(248, -402);
// &vdd @WIRE(mode="straight") {#X138:4 %t690:p};
// %t691 = $GROUND @ATTACH &vss => @PLACE(248, -424);
// &vss @WIRE(mode="straight") {#X138:5 %t691:p};
// %t692 = $IO_PORT @ATTACH &n59 => @PLACE(278, -411) => @ORIENT("R0");
// %t692 @TEXT("n59", key="name", size=0.75);
// &n59 @WIRE(mode="straight") {#X139:1 %t692:p};
// %t693 = $IO_PORT @ATTACH &n180 => @PLACE(278, -415) => @ORIENT("R0");
// %t693 @TEXT("n180", key="name", size=0.75);
// &n180 @WIRE(mode="straight") {#X139:2 %t693:p};
// %t694 = $IO_PORT @ATTACH &n213 => @PLACE(298, -413) => @ORIENT("MY");
// %t694 @TEXT("n213", key="name", size=0.75);
// &n213 @WIRE(mode="straight") {#X139:3 %t694:p};
// %t695 = $SUPPLY @ATTACH &vdd => @PLACE(288, -402);
// &vdd @WIRE(mode="straight") {#X139:4 %t695:p};
// %t696 = $GROUND @ATTACH &vss => @PLACE(288, -424);
// &vss @WIRE(mode="straight") {#X139:5 %t696:p};
// %t697 = $IO_PORT @ATTACH &n185 => @PLACE(158, -442) => @ORIENT("R0");
// %t697 @TEXT("n185", key="name", size=0.75);
// &n185 @WIRE(mode="straight") {#X140:1 %t697:p};
// %t698 = $IO_PORT @ATTACH &n184 => @PLACE(158, -446) => @ORIENT("R0");
// %t698 @TEXT("n184", key="name", size=0.75);
// &n184 @WIRE(mode="straight") {#X140:2 %t698:p};
// %t699 = $IO_PORT @ATTACH &n214 => @PLACE(178, -444) => @ORIENT("MY");
// %t699 @TEXT("n214", key="name", size=0.75);
// &n214 @WIRE(mode="straight") {#X140:3 %t699:p};
// %t700 = $SUPPLY @ATTACH &vdd => @PLACE(168, -433);
// &vdd @WIRE(mode="straight") {#X140:4 %t700:p};
// %t701 = $GROUND @ATTACH &vss => @PLACE(168, -455);
// &vss @WIRE(mode="straight") {#X140:5 %t701:p};
// %t702 = $IO_PORT @ATTACH &n179 => @PLACE(198, -442) => @ORIENT("R0");
// %t702 @TEXT("n179", key="name", size=0.75);
// &n179 @WIRE(mode="straight") {#X141:1 %t702:p};
// %t703 = $IO_PORT @ATTACH &n215 => @PLACE(198, -446) => @ORIENT("R0");
// %t703 @TEXT("n215", key="name", size=0.75);
// &n215 @WIRE(mode="straight") {#X141:2 %t703:p};
// %t704 = $IO_PORT @ATTACH &n203 => @PLACE(218, -444) => @ORIENT("MY");
// %t704 @TEXT("n203", key="name", size=0.75);
// &n203 @WIRE(mode="straight") {#X141:3 %t704:p};
// %t705 = $SUPPLY @ATTACH &vdd => @PLACE(208, -433);
// &vdd @WIRE(mode="straight") {#X141:4 %t705:p};
// %t706 = $GROUND @ATTACH &vss => @PLACE(208, -455);
// &vss @WIRE(mode="straight") {#X141:5 %t706:p};
// %t707 = $IO_PORT @ATTACH &n185 => @PLACE(238, -442) => @ORIENT("R0");
// %t707 @TEXT("n185", key="name", size=0.75);
// &n185 @WIRE(mode="straight") {#X142:1 %t707:p};
// %t708 = $IO_PORT @ATTACH &n178 => @PLACE(238, -446) => @ORIENT("R0");
// %t708 @TEXT("n178", key="name", size=0.75);
// &n178 @WIRE(mode="straight") {#X142:2 %t708:p};
// %t709 = $IO_PORT @ATTACH &n215 => @PLACE(258, -444) => @ORIENT("MY");
// %t709 @TEXT("n215", key="name", size=0.75);
// &n215 @WIRE(mode="straight") {#X142:3 %t709:p};
// %t710 = $SUPPLY @ATTACH &vdd => @PLACE(248, -433);
// &vdd @WIRE(mode="straight") {#X142:4 %t710:p};
// %t711 = $GROUND @ATTACH &vss => @PLACE(248, -455);
// &vss @WIRE(mode="straight") {#X142:5 %t711:p};
// %t712 = $IO_PORT @ATTACH &n183 => @PLACE(278, -442) => @ORIENT("R0");
// %t712 @TEXT("n183", key="name", size=0.75);
// &n183 @WIRE(mode="straight") {#X143:1 %t712:p};
// %t713 = $IO_PORT @ATTACH &n182 => @PLACE(278, -446) => @ORIENT("R0");
// %t713 @TEXT("n182", key="name", size=0.75);
// &n182 @WIRE(mode="straight") {#X143:2 %t713:p};
// %t714 = $IO_PORT @ATTACH &n206 => @PLACE(298, -444) => @ORIENT("MY");
// %t714 @TEXT("n206", key="name", size=0.75);
// &n206 @WIRE(mode="straight") {#X143:3 %t714:p};
// %t715 = $SUPPLY @ATTACH &vdd => @PLACE(288, -433);
// &vdd @WIRE(mode="straight") {#X143:4 %t715:p};
// %t716 = $GROUND @ATTACH &vss => @PLACE(288, -455);
// &vss @WIRE(mode="straight") {#X143:5 %t716:p};
// %t717 = $IO_PORT @ATTACH &n177 => @PLACE(326, -287) => @ORIENT("R0");
// %t717 @TEXT("n177", key="name", size=0.75);
// &n177 @WIRE(mode="straight") {#X144:1 %t717:p};
// %t718 = $IO_PORT @ATTACH &n216 => @PLACE(326, -291) => @ORIENT("R0");
// %t718 @TEXT("n216", key="name", size=0.75);
// &n216 @WIRE(mode="straight") {#X144:2 %t718:p};
// %t719 = $IO_PORT @ATTACH &n204 => @PLACE(346, -289) => @ORIENT("MY");
// %t719 @TEXT("n204", key="name", size=0.75);
// &n204 @WIRE(mode="straight") {#X144:3 %t719:p};
// %t720 = $SUPPLY @ATTACH &vdd => @PLACE(336, -278);
// &vdd @WIRE(mode="straight") {#X144:4 %t720:p};
// %t721 = $GROUND @ATTACH &vss => @PLACE(336, -300);
// &vss @WIRE(mode="straight") {#X144:5 %t721:p};
// %t722 = $IO_PORT @ATTACH &n183 => @PLACE(366, -287) => @ORIENT("R0");
// %t722 @TEXT("n183", key="name", size=0.75);
// &n183 @WIRE(mode="straight") {#X145:1 %t722:p};
// %t723 = $IO_PORT @ATTACH &n176 => @PLACE(366, -291) => @ORIENT("R0");
// %t723 @TEXT("n176", key="name", size=0.75);
// &n176 @WIRE(mode="straight") {#X145:2 %t723:p};
// %t724 = $IO_PORT @ATTACH &n216 => @PLACE(386, -289) => @ORIENT("MY");
// %t724 @TEXT("n216", key="name", size=0.75);
// &n216 @WIRE(mode="straight") {#X145:3 %t724:p};
// %t725 = $SUPPLY @ATTACH &vdd => @PLACE(376, -278);
// &vdd @WIRE(mode="straight") {#X145:4 %t725:p};
// %t726 = $GROUND @ATTACH &vss => @PLACE(376, -300);
// &vss @WIRE(mode="straight") {#X145:5 %t726:p};
// %t727 = $IO_PORT @ATTACH &n181 => @PLACE(406, -287) => @ORIENT("R0");
// %t727 @TEXT("n181", key="name", size=0.75);
// &n181 @WIRE(mode="straight") {#X146:1 %t727:p};
// %t728 = $IO_PORT @ATTACH &n56 => @PLACE(406, -291) => @ORIENT("R0");
// %t728 @TEXT("n56", key="name", size=0.75);
// &n56 @WIRE(mode="straight") {#X146:2 %t728:p};
// %t729 = $IO_PORT @ATTACH &n217 => @PLACE(426, -289) => @ORIENT("MY");
// %t729 @TEXT("n217", key="name", size=0.75);
// &n217 @WIRE(mode="straight") {#X146:3 %t729:p};
// %t730 = $SUPPLY @ATTACH &vdd => @PLACE(416, -278);
// &vdd @WIRE(mode="straight") {#X146:4 %t730:p};
// %t731 = $GROUND @ATTACH &vss => @PLACE(416, -300);
// &vss @WIRE(mode="straight") {#X146:5 %t731:p};
// %t732 = $IO_PORT @ATTACH &n175 => @PLACE(446, -287) => @ORIENT("R0");
// %t732 @TEXT("n175", key="name", size=0.75);
// &n175 @WIRE(mode="straight") {#X147:1 %t732:p};
// %t733 = $IO_PORT @ATTACH &n218 => @PLACE(446, -291) => @ORIENT("R0");
// %t733 @TEXT("n218", key="name", size=0.75);
// &n218 @WIRE(mode="straight") {#X147:2 %t733:p};
// %t734 = $IO_PORT @ATTACH &n207 => @PLACE(466, -289) => @ORIENT("MY");
// %t734 @TEXT("n207", key="name", size=0.75);
// &n207 @WIRE(mode="straight") {#X147:3 %t734:p};
// %t735 = $SUPPLY @ATTACH &vdd => @PLACE(456, -278);
// &vdd @WIRE(mode="straight") {#X147:4 %t735:p};
// %t736 = $GROUND @ATTACH &vss => @PLACE(456, -300);
// &vss @WIRE(mode="straight") {#X147:5 %t736:p};
// %t737 = $IO_PORT @ATTACH &n181 => @PLACE(326, -318) => @ORIENT("R0");
// %t737 @TEXT("n181", key="name", size=0.75);
// &n181 @WIRE(mode="straight") {#X148:1 %t737:p};
// %t738 = $IO_PORT @ATTACH &measured4 => @PLACE(326, -322) => @ORIENT("R0");
// %t738 @TEXT("measured4", key="name", size=0.75);
// &measured4 @WIRE(mode="straight") {#X148:2 %t738:p};
// %t739 = $IO_PORT @ATTACH &n218 => @PLACE(346, -320) => @ORIENT("MY");
// %t739 @TEXT("n218", key="name", size=0.75);
// &n218 @WIRE(mode="straight") {#X148:3 %t739:p};
// %t740 = $SUPPLY @ATTACH &vdd => @PLACE(336, -309);
// &vdd @WIRE(mode="straight") {#X148:4 %t740:p};
// %t741 = $GROUND @ATTACH &vss => @PLACE(336, -331);
// &vss @WIRE(mode="straight") {#X148:5 %t741:p};
// %t742 = $IO_PORT @ATTACH &measured3 => @PLACE(366, -318) => @ORIENT("R0");
// %t742 @TEXT("measured3", key="name", size=0.75);
// &measured3 @WIRE(mode="straight") {#X149:1 %t742:p};
// %t743 = $IO_PORT @ATTACH &n219 => @PLACE(366, -322) => @ORIENT("R0");
// %t743 @TEXT("n219", key="name", size=0.75);
// &n219 @WIRE(mode="straight") {#X149:2 %t743:p};
// %t744 = $IO_PORT @ATTACH &n208 => @PLACE(386, -320) => @ORIENT("MY");
// %t744 @TEXT("n208", key="name", size=0.75);
// &n208 @WIRE(mode="straight") {#X149:3 %t744:p};
// %t745 = $SUPPLY @ATTACH &vdd => @PLACE(376, -309);
// &vdd @WIRE(mode="straight") {#X149:4 %t745:p};
// %t746 = $GROUND @ATTACH &vss => @PLACE(376, -331);
// &vss @WIRE(mode="straight") {#X149:5 %t746:p};
// %t747 = $IO_PORT @ATTACH &n57 => @PLACE(406, -318) => @ORIENT("R0");
// %t747 @TEXT("n57", key="name", size=0.75);
// &n57 @WIRE(mode="straight") {#X150:1 %t747:p};
// %t748 = $IO_PORT @ATTACH &measured2 => @PLACE(406, -322) => @ORIENT("R0");
// %t748 @TEXT("measured2", key="name", size=0.75);
// &measured2 @WIRE(mode="straight") {#X150:2 %t748:p};
// %t749 = $IO_PORT @ATTACH &n219 => @PLACE(426, -320) => @ORIENT("MY");
// %t749 @TEXT("n219", key="name", size=0.75);
// &n219 @WIRE(mode="straight") {#X150:3 %t749:p};
// %t750 = $SUPPLY @ATTACH &vdd => @PLACE(416, -309);
// &vdd @WIRE(mode="straight") {#X150:4 %t750:p};
// %t751 = $GROUND @ATTACH &vss => @PLACE(416, -331);
// &vss @WIRE(mode="straight") {#X150:5 %t751:p};
// %t752 = $IO_PORT @ATTACH &measured1 => @PLACE(446, -318) => @ORIENT("R0");
// %t752 @TEXT("measured1", key="name", size=0.75);
// &measured1 @WIRE(mode="straight") {#X151:1 %t752:p};
// %t753 = $IO_PORT @ATTACH &n220 => @PLACE(446, -322) => @ORIENT("R0");
// %t753 @TEXT("n220", key="name", size=0.75);
// &n220 @WIRE(mode="straight") {#X151:2 %t753:p};
// %t754 = $IO_PORT @ATTACH &n211 => @PLACE(466, -320) => @ORIENT("MY");
// %t754 @TEXT("n211", key="name", size=0.75);
// &n211 @WIRE(mode="straight") {#X151:3 %t754:p};
// %t755 = $SUPPLY @ATTACH &vdd => @PLACE(456, -309);
// &vdd @WIRE(mode="straight") {#X151:4 %t755:p};
// %t756 = $GROUND @ATTACH &vss => @PLACE(456, -331);
// &vss @WIRE(mode="straight") {#X151:5 %t756:p};
// %t757 = $IO_PORT @ATTACH &n55 => @PLACE(326, -349) => @ORIENT("R0");
// %t757 @TEXT("n55", key="name", size=0.75);
// &n55 @WIRE(mode="straight") {#X152:1 %t757:p};
// %t758 = $IO_PORT @ATTACH &measured0 => @PLACE(326, -353) => @ORIENT("R0");
// %t758 @TEXT("measured0", key="name", size=0.75);
// &measured0 @WIRE(mode="straight") {#X152:2 %t758:p};
// %t759 = $IO_PORT @ATTACH &n220 => @PLACE(346, -351) => @ORIENT("MY");
// %t759 @TEXT("n220", key="name", size=0.75);
// &n220 @WIRE(mode="straight") {#X152:3 %t759:p};
// %t760 = $SUPPLY @ATTACH &vdd => @PLACE(336, -340);
// &vdd @WIRE(mode="straight") {#X152:4 %t760:p};
// %t761 = $GROUND @ATTACH &vss => @PLACE(336, -362);
// &vss @WIRE(mode="straight") {#X152:5 %t761:p};
// %t762 = $IO_PORT @ATTACH &n82 => @PLACE(366, -349) => @ORIENT("R0");
// %t762 @TEXT("n82", key="name", size=0.75);
// &n82 @WIRE(mode="straight") {#X153:1 %t762:p};
// %t763 = $IO_PORT @ATTACH &n221 => @PLACE(366, -353) => @ORIENT("R0");
// %t763 @TEXT("n221", key="name", size=0.75);
// &n221 @WIRE(mode="straight") {#X153:2 %t763:p};
// %t764 = $IO_PORT @ATTACH &n222 => @PLACE(386, -351) => @ORIENT("MY");
// %t764 @TEXT("n222", key="name", size=0.75);
// &n222 @WIRE(mode="straight") {#X153:3 %t764:p};
// %t765 = $SUPPLY @ATTACH &vdd => @PLACE(376, -340);
// &vdd @WIRE(mode="straight") {#X153:4 %t765:p};
// %t766 = $GROUND @ATTACH &vss => @PLACE(376, -362);
// &vss @WIRE(mode="straight") {#X153:5 %t766:p};
// %t767 = $IO_PORT @ATTACH &n223 => @PLACE(406, -349) => @ORIENT("R0");
// %t767 @TEXT("n223", key="name", size=0.75);
// &n223 @WIRE(mode="straight") {#X154:1 %t767:p};
// %t768 = $IO_PORT @ATTACH &n224 => @PLACE(406, -353) => @ORIENT("R0");
// %t768 @TEXT("n224", key="name", size=0.75);
// &n224 @WIRE(mode="straight") {#X154:2 %t768:p};
// %t769 = $IO_PORT @ATTACH &n225 => @PLACE(426, -351) => @ORIENT("MY");
// %t769 @TEXT("n225", key="name", size=0.75);
// &n225 @WIRE(mode="straight") {#X154:3 %t769:p};
// %t770 = $SUPPLY @ATTACH &vdd => @PLACE(416, -340);
// &vdd @WIRE(mode="straight") {#X154:4 %t770:p};
// %t771 = $GROUND @ATTACH &vss => @PLACE(416, -362);
// &vss @WIRE(mode="straight") {#X154:5 %t771:p};
// %t772 = $IO_PORT @ATTACH &n36 => @PLACE(446, -349) => @ORIENT("R0");
// %t772 @TEXT("n36", key="name", size=0.75);
// &n36 @WIRE(mode="straight") {#X155:1 %t772:p};
// %t773 = $IO_PORT @ATTACH &n34 => @PLACE(446, -353) => @ORIENT("R0");
// %t773 @TEXT("n34", key="name", size=0.75);
// &n34 @WIRE(mode="straight") {#X155:2 %t773:p};
// %t774 = $IO_PORT @ATTACH &n226 => @PLACE(466, -351) => @ORIENT("MY");
// %t774 @TEXT("n226", key="name", size=0.75);
// &n226 @WIRE(mode="straight") {#X155:3 %t774:p};
// %t775 = $SUPPLY @ATTACH &vdd => @PLACE(456, -340);
// &vdd @WIRE(mode="straight") {#X155:4 %t775:p};
// %t776 = $GROUND @ATTACH &vss => @PLACE(456, -362);
// &vss @WIRE(mode="straight") {#X155:5 %t776:p};
// %t777 = $IO_PORT @ATTACH &n38 => @PLACE(326, -380) => @ORIENT("R0");
// %t777 @TEXT("n38", key="name", size=0.75);
// &n38 @WIRE(mode="straight") {#X156:1 %t777:p};
// %t778 = $IO_PORT @ATTACH &n83 => @PLACE(326, -384) => @ORIENT("R0");
// %t778 @TEXT("n83", key="name", size=0.75);
// &n83 @WIRE(mode="straight") {#X156:2 %t778:p};
// %t779 = $IO_PORT @ATTACH &n227 => @PLACE(346, -382) => @ORIENT("MY");
// %t779 @TEXT("n227", key="name", size=0.75);
// &n227 @WIRE(mode="straight") {#X156:3 %t779:p};
// %t780 = $SUPPLY @ATTACH &vdd => @PLACE(336, -371);
// &vdd @WIRE(mode="straight") {#X156:4 %t780:p};
// %t781 = $GROUND @ATTACH &vss => @PLACE(336, -393);
// &vss @WIRE(mode="straight") {#X156:5 %t781:p};
// %t782 = $IO_PORT @ATTACH &n40 => @PLACE(366, -380) => @ORIENT("R0");
// %t782 @TEXT("n40", key="name", size=0.75);
// &n40 @WIRE(mode="straight") {#X157:1 %t782:p};
// %t783 = $IO_PORT @ATTACH &n84 => @PLACE(366, -384) => @ORIENT("R0");
// %t783 @TEXT("n84", key="name", size=0.75);
// &n84 @WIRE(mode="straight") {#X157:2 %t783:p};
// %t784 = $IO_PORT @ATTACH &n228 => @PLACE(386, -382) => @ORIENT("MY");
// %t784 @TEXT("n228", key="name", size=0.75);
// &n228 @WIRE(mode="straight") {#X157:3 %t784:p};
// %t785 = $SUPPLY @ATTACH &vdd => @PLACE(376, -371);
// &vdd @WIRE(mode="straight") {#X157:4 %t785:p};
// %t786 = $GROUND @ATTACH &vss => @PLACE(376, -393);
// &vss @WIRE(mode="straight") {#X157:5 %t786:p};
// %t787 = $IO_PORT @ATTACH &n42 => @PLACE(406, -380) => @ORIENT("R0");
// %t787 @TEXT("n42", key="name", size=0.75);
// &n42 @WIRE(mode="straight") {#X158:1 %t787:p};
// %t788 = $IO_PORT @ATTACH &n85 => @PLACE(406, -384) => @ORIENT("R0");
// %t788 @TEXT("n85", key="name", size=0.75);
// &n85 @WIRE(mode="straight") {#X158:2 %t788:p};
// %t789 = $IO_PORT @ATTACH &n229 => @PLACE(426, -382) => @ORIENT("MY");
// %t789 @TEXT("n229", key="name", size=0.75);
// &n229 @WIRE(mode="straight") {#X158:3 %t789:p};
// %t790 = $SUPPLY @ATTACH &vdd => @PLACE(416, -371);
// &vdd @WIRE(mode="straight") {#X158:4 %t790:p};
// %t791 = $GROUND @ATTACH &vss => @PLACE(416, -393);
// &vss @WIRE(mode="straight") {#X158:5 %t791:p};
// %t792 = $IO_PORT @ATTACH &n44 => @PLACE(446, -380) => @ORIENT("R0");
// %t792 @TEXT("n44", key="name", size=0.75);
// &n44 @WIRE(mode="straight") {#X159:1 %t792:p};
// %t793 = $IO_PORT @ATTACH &n86 => @PLACE(446, -384) => @ORIENT("R0");
// %t793 @TEXT("n86", key="name", size=0.75);
// &n86 @WIRE(mode="straight") {#X159:2 %t793:p};
// %t794 = $IO_PORT @ATTACH &n230 => @PLACE(466, -382) => @ORIENT("MY");
// %t794 @TEXT("n230", key="name", size=0.75);
// &n230 @WIRE(mode="straight") {#X159:3 %t794:p};
// %t795 = $SUPPLY @ATTACH &vdd => @PLACE(456, -371);
// &vdd @WIRE(mode="straight") {#X159:4 %t795:p};
// %t796 = $GROUND @ATTACH &vss => @PLACE(456, -393);
// &vss @WIRE(mode="straight") {#X159:5 %t796:p};
// %t797 = $IO_PORT @ATTACH &n46 => @PLACE(326, -411) => @ORIENT("R0");
// %t797 @TEXT("n46", key="name", size=0.75);
// &n46 @WIRE(mode="straight") {#X160:1 %t797:p};
// %t798 = $IO_PORT @ATTACH &n88 => @PLACE(326, -415) => @ORIENT("R0");
// %t798 @TEXT("n88", key="name", size=0.75);
// &n88 @WIRE(mode="straight") {#X160:2 %t798:p};
// %t799 = $IO_PORT @ATTACH &n231 => @PLACE(346, -413) => @ORIENT("MY");
// %t799 @TEXT("n231", key="name", size=0.75);
// &n231 @WIRE(mode="straight") {#X160:3 %t799:p};
// %t800 = $SUPPLY @ATTACH &vdd => @PLACE(336, -402);
// &vdd @WIRE(mode="straight") {#X160:4 %t800:p};
// %t801 = $GROUND @ATTACH &vss => @PLACE(336, -424);
// &vss @WIRE(mode="straight") {#X160:5 %t801:p};
// %t802 = $IO_PORT @ATTACH &n48 => @PLACE(366, -411) => @ORIENT("R0");
// %t802 @TEXT("n48", key="name", size=0.75);
// &n48 @WIRE(mode="straight") {#X161:1 %t802:p};
// %t803 = $IO_PORT @ATTACH &n89 => @PLACE(366, -415) => @ORIENT("R0");
// %t803 @TEXT("n89", key="name", size=0.75);
// &n89 @WIRE(mode="straight") {#X161:2 %t803:p};
// %t804 = $IO_PORT @ATTACH &n232 => @PLACE(386, -413) => @ORIENT("MY");
// %t804 @TEXT("n232", key="name", size=0.75);
// &n232 @WIRE(mode="straight") {#X161:3 %t804:p};
// %t805 = $SUPPLY @ATTACH &vdd => @PLACE(376, -402);
// &vdd @WIRE(mode="straight") {#X161:4 %t805:p};
// %t806 = $GROUND @ATTACH &vss => @PLACE(376, -424);
// &vss @WIRE(mode="straight") {#X161:5 %t806:p};
// %t807 = $IO_PORT @ATTACH &measured1 => @PLACE(406, -411) => @ORIENT("R0");
// %t807 @TEXT("measured1", key="name", size=0.75);
// &measured1 @WIRE(mode="straight") {#X162:1 %t807:p};
// %t808 = $IO_PORT @ATTACH &measured0 => @PLACE(406, -415) => @ORIENT("R0");
// %t808 @TEXT("measured0", key="name", size=0.75);
// &measured0 @WIRE(mode="straight") {#X162:2 %t808:p};
// %t809 = $IO_PORT @ATTACH &n62 => @PLACE(426, -413) => @ORIENT("MY");
// %t809 @TEXT("n62", key="name", size=0.75);
// &n62 @WIRE(mode="straight") {#X162:3 %t809:p};
// %t810 = $SUPPLY @ATTACH &vdd => @PLACE(416, -402);
// &vdd @WIRE(mode="straight") {#X162:4 %t810:p};
// %t811 = $GROUND @ATTACH &vss => @PLACE(416, -424);
// &vss @WIRE(mode="straight") {#X162:5 %t811:p};
// %t812 = $IO_PORT @ATTACH &measured2 => @PLACE(446, -411) => @ORIENT("R0");
// %t812 @TEXT("measured2", key="name", size=0.75);
// &measured2 @WIRE(mode="straight") {#X163:1 %t812:p};
// %t813 = $IO_PORT @ATTACH &n108 => @PLACE(446, -415) => @ORIENT("R0");
// %t813 @TEXT("n108", key="name", size=0.75);
// &n108 @WIRE(mode="straight") {#X163:2 %t813:p};
// %t814 = $IO_PORT @ATTACH &n68 => @PLACE(466, -413) => @ORIENT("MY");
// %t814 @TEXT("n68", key="name", size=0.75);
// &n68 @WIRE(mode="straight") {#X163:3 %t814:p};
// %t815 = $SUPPLY @ATTACH &vdd => @PLACE(456, -402);
// &vdd @WIRE(mode="straight") {#X163:4 %t815:p};
// %t816 = $GROUND @ATTACH &vss => @PLACE(456, -424);
// &vss @WIRE(mode="straight") {#X163:5 %t816:p};
// %t817 = $IO_PORT @ATTACH &measured3 => @PLACE(326, -442) => @ORIENT("R0");
// %t817 @TEXT("measured3", key="name", size=0.75);
// &measured3 @WIRE(mode="straight") {#X164:1 %t817:p};
// %t818 = $IO_PORT @ATTACH &n109 => @PLACE(326, -446) => @ORIENT("R0");
// %t818 @TEXT("n109", key="name", size=0.75);
// &n109 @WIRE(mode="straight") {#X164:2 %t818:p};
// %t819 = $IO_PORT @ATTACH &n66 => @PLACE(346, -444) => @ORIENT("MY");
// %t819 @TEXT("n66", key="name", size=0.75);
// &n66 @WIRE(mode="straight") {#X164:3 %t819:p};
// %t820 = $SUPPLY @ATTACH &vdd => @PLACE(336, -433);
// &vdd @WIRE(mode="straight") {#X164:4 %t820:p};
// %t821 = $GROUND @ATTACH &vss => @PLACE(336, -455);
// &vss @WIRE(mode="straight") {#X164:5 %t821:p};
// %t822 = $IO_PORT @ATTACH &measured4 => @PLACE(366, -442) => @ORIENT("R0");
// %t822 @TEXT("measured4", key="name", size=0.75);
// &measured4 @WIRE(mode="straight") {#X165:1 %t822:p};
// %t823 = $IO_PORT @ATTACH &n106 => @PLACE(366, -446) => @ORIENT("R0");
// %t823 @TEXT("n106", key="name", size=0.75);
// &n106 @WIRE(mode="straight") {#X165:2 %t823:p};
// %t824 = $IO_PORT @ATTACH &n64 => @PLACE(386, -444) => @ORIENT("MY");
// %t824 @TEXT("n64", key="name", size=0.75);
// &n64 @WIRE(mode="straight") {#X165:3 %t824:p};
// %t825 = $SUPPLY @ATTACH &vdd => @PLACE(376, -433);
// &vdd @WIRE(mode="straight") {#X165:4 %t825:p};
// %t826 = $GROUND @ATTACH &vss => @PLACE(376, -455);
// &vss @WIRE(mode="straight") {#X165:5 %t826:p};
// %t827 = $IO_PORT @ATTACH &measured5 => @PLACE(406, -442) => @ORIENT("R0");
// %t827 @TEXT("measured5", key="name", size=0.75);
// &measured5 @WIRE(mode="straight") {#X166:1 %t827:p};
// %t828 = $IO_PORT @ATTACH &n107 => @PLACE(406, -446) => @ORIENT("R0");
// %t828 @TEXT("n107", key="name", size=0.75);
// &n107 @WIRE(mode="straight") {#X166:2 %t828:p};
// %t829 = $IO_PORT @ATTACH &n125 => @PLACE(426, -444) => @ORIENT("MY");
// %t829 @TEXT("n125", key="name", size=0.75);
// &n125 @WIRE(mode="straight") {#X166:3 %t829:p};
// %t830 = $SUPPLY @ATTACH &vdd => @PLACE(416, -433);
// &vdd @WIRE(mode="straight") {#X166:4 %t830:p};
// %t831 = $GROUND @ATTACH &vss => @PLACE(416, -455);
// &vss @WIRE(mode="straight") {#X166:5 %t831:p};
// %t832 = $IO_PORT @ATTACH &measured6 => @PLACE(446, -442) => @ORIENT("R0");
// %t832 @TEXT("measured6", key="name", size=0.75);
// &measured6 @WIRE(mode="straight") {#X167:1 %t832:p};
// %t833 = $IO_PORT @ATTACH &n115 => @PLACE(446, -446) => @ORIENT("R0");
// %t833 @TEXT("n115", key="name", size=0.75);
// &n115 @WIRE(mode="straight") {#X167:2 %t833:p};
// %t834 = $IO_PORT @ATTACH &n127 => @PLACE(466, -444) => @ORIENT("MY");
// %t834 @TEXT("n127", key="name", size=0.75);
// &n127 @WIRE(mode="straight") {#X167:3 %t834:p};
// %t835 = $SUPPLY @ATTACH &vdd => @PLACE(456, -433);
// &vdd @WIRE(mode="straight") {#X167:4 %t835:p};
// %t836 = $GROUND @ATTACH &vss => @PLACE(456, -455);
// &vss @WIRE(mode="straight") {#X167:5 %t836:p};
// %t837 = $IO_PORT @ATTACH &measured7 => @PLACE(494, -287) => @ORIENT("R0");
// %t837 @TEXT("measured7", key="name", size=0.75);
// &measured7 @WIRE(mode="straight") {#X168:1 %t837:p};
// %t838 = $IO_PORT @ATTACH &n116 => @PLACE(494, -291) => @ORIENT("R0");
// %t838 @TEXT("n116", key="name", size=0.75);
// &n116 @WIRE(mode="straight") {#X168:2 %t838:p};
// %t839 = $IO_PORT @ATTACH &n129 => @PLACE(514, -289) => @ORIENT("MY");
// %t839 @TEXT("n129", key="name", size=0.75);
// &n129 @WIRE(mode="straight") {#X168:3 %t839:p};
// %t840 = $SUPPLY @ATTACH &vdd => @PLACE(504, -278);
// &vdd @WIRE(mode="straight") {#X168:4 %t840:p};
// %t841 = $GROUND @ATTACH &vss => @PLACE(504, -300);
// &vss @WIRE(mode="straight") {#X168:5 %t841:p};
// %t842 = $IO_PORT @ATTACH &measured8 => @PLACE(534, -287) => @ORIENT("R0");
// %t842 @TEXT("measured8", key="name", size=0.75);
// &measured8 @WIRE(mode="straight") {#X169:1 %t842:p};
// %t843 = $IO_PORT @ATTACH &n113 => @PLACE(534, -291) => @ORIENT("R0");
// %t843 @TEXT("n113", key="name", size=0.75);
// &n113 @WIRE(mode="straight") {#X169:2 %t843:p};
// %t844 = $IO_PORT @ATTACH &n132 => @PLACE(554, -289) => @ORIENT("MY");
// %t844 @TEXT("n132", key="name", size=0.75);
// &n132 @WIRE(mode="straight") {#X169:3 %t844:p};
// %t845 = $SUPPLY @ATTACH &vdd => @PLACE(544, -278);
// &vdd @WIRE(mode="straight") {#X169:4 %t845:p};
// %t846 = $GROUND @ATTACH &vss => @PLACE(544, -300);
// &vss @WIRE(mode="straight") {#X169:5 %t846:p};
// %t847 = $IO_PORT @ATTACH &measured9 => @PLACE(574, -287) => @ORIENT("R0");
// %t847 @TEXT("measured9", key="name", size=0.75);
// &measured9 @WIRE(mode="straight") {#X170:1 %t847:p};
// %t848 = $IO_PORT @ATTACH &n124 => @PLACE(574, -291) => @ORIENT("R0");
// %t848 @TEXT("n124", key="name", size=0.75);
// &n124 @WIRE(mode="straight") {#X170:2 %t848:p};
// %t849 = $IO_PORT @ATTACH &n135 => @PLACE(594, -289) => @ORIENT("MY");
// %t849 @TEXT("n135", key="name", size=0.75);
// &n135 @WIRE(mode="straight") {#X170:3 %t849:p};
// %t850 = $SUPPLY @ATTACH &vdd => @PLACE(584, -278);
// &vdd @WIRE(mode="straight") {#X170:4 %t850:p};
// %t851 = $GROUND @ATTACH &vss => @PLACE(584, -300);
// &vss @WIRE(mode="straight") {#X170:5 %t851:p};
// %t852 = $IO_PORT @ATTACH &measured10 => @PLACE(614, -287) => @ORIENT("R0");
// %t852 @TEXT("measured10", key="name", size=0.75);
// &measured10 @WIRE(mode="straight") {#X171:1 %t852:p};
// %t853 = $IO_PORT @ATTACH &n110 => @PLACE(614, -291) => @ORIENT("R0");
// %t853 @TEXT("n110", key="name", size=0.75);
// &n110 @WIRE(mode="straight") {#X171:2 %t853:p};
// %t854 = $IO_PORT @ATTACH &n137 => @PLACE(635, -289) => @ORIENT("MY");
// %t854 @TEXT("n137", key="name", size=0.75);
// &n137 @WIRE(mode="straight") {#X171:3 %t854:p};
// %t855 = $SUPPLY @ATTACH &vdd => @PLACE(624, -278);
// &vdd @WIRE(mode="straight") {#X171:4 %t855:p};
// %t856 = $GROUND @ATTACH &vss => @PLACE(624, -300);
// &vss @WIRE(mode="straight") {#X171:5 %t856:p};
// %t857 = $IO_PORT @ATTACH &measured11 => @PLACE(494, -318) => @ORIENT("R0");
// %t857 @TEXT("measured11", key="name", size=0.75);
// &measured11 @WIRE(mode="straight") {#X172:1 %t857:p};
// %t858 = $IO_PORT @ATTACH &n111 => @PLACE(494, -322) => @ORIENT("R0");
// %t858 @TEXT("n111", key="name", size=0.75);
// &n111 @WIRE(mode="straight") {#X172:2 %t858:p};
// %t859 = $IO_PORT @ATTACH &n70 => @PLACE(514, -320) => @ORIENT("MY");
// %t859 @TEXT("n70", key="name", size=0.75);
// &n70 @WIRE(mode="straight") {#X172:3 %t859:p};
// %t860 = $SUPPLY @ATTACH &vdd => @PLACE(504, -309);
// &vdd @WIRE(mode="straight") {#X172:4 %t860:p};
// %t861 = $GROUND @ATTACH &vss => @PLACE(504, -331);
// &vss @WIRE(mode="straight") {#X172:5 %t861:p};
// %t862 = $IO_PORT @ATTACH &measured12 => @PLACE(534, -318) => @ORIENT("R0");
// %t862 @TEXT("measured12", key="name", size=0.75);
// &measured12 @WIRE(mode="straight") {#X173:1 %t862:p};
// %t863 = $IO_PORT @ATTACH &n118 => @PLACE(534, -322) => @ORIENT("R0");
// %t863 @TEXT("n118", key="name", size=0.75);
// &n118 @WIRE(mode="straight") {#X173:2 %t863:p};
// %t864 = $IO_PORT @ATTACH &n74 => @PLACE(554, -320) => @ORIENT("MY");
// %t864 @TEXT("n74", key="name", size=0.75);
// &n74 @WIRE(mode="straight") {#X173:3 %t864:p};
// %t865 = $SUPPLY @ATTACH &vdd => @PLACE(544, -309);
// &vdd @WIRE(mode="straight") {#X173:4 %t865:p};
// %t866 = $GROUND @ATTACH &vss => @PLACE(544, -331);
// &vss @WIRE(mode="straight") {#X173:5 %t866:p};
// %t867 = $IO_PORT @ATTACH &measured13 => @PLACE(574, -318) => @ORIENT("R0");
// %t867 @TEXT("measured13", key="name", size=0.75);
// &measured13 @WIRE(mode="straight") {#X174:1 %t867:p};
// %t868 = $IO_PORT @ATTACH &n119 => @PLACE(574, -322) => @ORIENT("R0");
// %t868 @TEXT("n119", key="name", size=0.75);
// &n119 @WIRE(mode="straight") {#X174:2 %t868:p};
// %t869 = $IO_PORT @ATTACH &n72 => @PLACE(594, -320) => @ORIENT("MY");
// %t869 @TEXT("n72", key="name", size=0.75);
// &n72 @WIRE(mode="straight") {#X174:3 %t869:p};
// %t870 = $SUPPLY @ATTACH &vdd => @PLACE(584, -309);
// &vdd @WIRE(mode="straight") {#X174:4 %t870:p};
// %t871 = $GROUND @ATTACH &vss => @PLACE(584, -331);
// &vss @WIRE(mode="straight") {#X174:5 %t871:p};
// %t872 = $IO_PORT @ATTACH &n78 => @PLACE(614, -318) => @ORIENT("R0");
// %t872 @TEXT("n78", key="name", size=0.75);
// &n78 @WIRE(mode="straight") {#X175:1 %t872:p};
// %t873 = $IO_PORT @ATTACH &n233 => @PLACE(614, -322) => @ORIENT("R0");
// %t873 @TEXT("n233", key="name", size=0.75);
// &n233 @WIRE(mode="straight") {#X175:2 %t873:p};
// %t874 = $IO_PORT @ATTACH &n234 => @PLACE(635, -320) => @ORIENT("MY");
// %t874 @TEXT("n234", key="name", size=0.75);
// &n234 @WIRE(mode="straight") {#X175:3 %t874:p};
// %t875 = $SUPPLY @ATTACH &vdd => @PLACE(624, -309);
// &vdd @WIRE(mode="straight") {#X175:4 %t875:p};
// %t876 = $GROUND @ATTACH &vss => @PLACE(624, -331);
// &vss @WIRE(mode="straight") {#X175:5 %t876:p};
// %t877 = $IO_PORT @ATTACH &n234 => @PLACE(494, -349) => @ORIENT("R0");
// %t877 @TEXT("n234", key="name", size=0.75);
// &n234 @WIRE(mode="straight") {#X176:1 %t877:p};
// %t878 = $IO_PORT @ATTACH &n235 => @PLACE(494, -353) => @ORIENT("R0");
// %t878 @TEXT("n235", key="name", size=0.75);
// &n235 @WIRE(mode="straight") {#X176:2 %t878:p};
// %t879 = $IO_PORT @ATTACH &n50 => @PLACE(514, -351) => @ORIENT("MY");
// %t879 @TEXT("n50", key="name", size=0.75);
// &n50 @WIRE(mode="straight") {#X176:3 %t879:p};
// %t880 = $SUPPLY @ATTACH &vdd => @PLACE(504, -340);
// &vdd @WIRE(mode="straight") {#X176:4 %t880:p};
// %t881 = $GROUND @ATTACH &vss => @PLACE(504, -362);
// &vss @WIRE(mode="straight") {#X176:5 %t881:p};
// %t882 = $IO_PORT @ATTACH &n78 => @PLACE(534, -349) => @ORIENT("R0");
// %t882 @TEXT("n78", key="name", size=0.75);
// &n78 @WIRE(mode="straight") {#X177:1 %t882:p};
// %t883 = $IO_PORT @ATTACH &n236 => @PLACE(534, -353) => @ORIENT("R0");
// %t883 @TEXT("n236", key="name", size=0.75);
// &n236 @WIRE(mode="straight") {#X177:2 %t883:p};
// %t884 = $IO_PORT @ATTACH &n237 => @PLACE(554, -351) => @ORIENT("MY");
// %t884 @TEXT("n237", key="name", size=0.75);
// &n237 @WIRE(mode="straight") {#X177:3 %t884:p};
// %t885 = $SUPPLY @ATTACH &vdd => @PLACE(544, -340);
// &vdd @WIRE(mode="straight") {#X177:4 %t885:p};
// %t886 = $GROUND @ATTACH &vss => @PLACE(544, -362);
// &vss @WIRE(mode="straight") {#X177:5 %t886:p};
// %t887 = $IO_PORT @ATTACH &n237 => @PLACE(574, -349) => @ORIENT("R0");
// %t887 @TEXT("n237", key="name", size=0.75);
// &n237 @WIRE(mode="straight") {#X178:1 %t887:p};
// %t888 = $IO_PORT @ATTACH &n238 => @PLACE(574, -353) => @ORIENT("R0");
// %t888 @TEXT("n238", key="name", size=0.75);
// &n238 @WIRE(mode="straight") {#X178:2 %t888:p};
// %t889 = $IO_PORT @ATTACH &n52 => @PLACE(594, -351) => @ORIENT("MY");
// %t889 @TEXT("n52", key="name", size=0.75);
// &n52 @WIRE(mode="straight") {#X178:3 %t889:p};
// %t890 = $SUPPLY @ATTACH &vdd => @PLACE(584, -340);
// &vdd @WIRE(mode="straight") {#X178:4 %t890:p};
// %t891 = $GROUND @ATTACH &vss => @PLACE(584, -362);
// &vss @WIRE(mode="straight") {#X178:5 %t891:p};
// %t892 = $IO_PORT @ATTACH &n78 => @PLACE(614, -349) => @ORIENT("R0");
// %t892 @TEXT("n78", key="name", size=0.75);
// &n78 @WIRE(mode="straight") {#X179:1 %t892:p};
// %t893 = $IO_PORT @ATTACH &n239 => @PLACE(614, -353) => @ORIENT("R0");
// %t893 @TEXT("n239", key="name", size=0.75);
// &n239 @WIRE(mode="straight") {#X179:2 %t893:p};
// %t894 = $IO_PORT @ATTACH &n54 => @PLACE(635, -351) => @ORIENT("MY");
// %t894 @TEXT("n54", key="name", size=0.75);
// &n54 @WIRE(mode="straight") {#X179:3 %t894:p};
// %t895 = $SUPPLY @ATTACH &vdd => @PLACE(624, -340);
// &vdd @WIRE(mode="straight") {#X179:4 %t895:p};
// %t896 = $GROUND @ATTACH &vss => @PLACE(624, -362);
// &vss @WIRE(mode="straight") {#X179:5 %t896:p};
// %t897 = $IO_PORT @ATTACH &n240 => @PLACE(494, -380) => @ORIENT("R0");
// %t897 @TEXT("n240", key="name", size=0.75);
// &n240 @WIRE(mode="straight") {#X180:1 %t897:p};
// %t898 = $IO_PORT @ATTACH &n36 => @PLACE(494, -384) => @ORIENT("R0");
// %t898 @TEXT("n36", key="name", size=0.75);
// &n36 @WIRE(mode="straight") {#X180:2 %t898:p};
// %t899 = $IO_PORT @ATTACH &n241 => @PLACE(514, -382) => @ORIENT("MY");
// %t899 @TEXT("n241", key="name", size=0.75);
// &n241 @WIRE(mode="straight") {#X180:3 %t899:p};
// %t900 = $SUPPLY @ATTACH &vdd => @PLACE(504, -371);
// &vdd @WIRE(mode="straight") {#X180:4 %t900:p};
// %t901 = $GROUND @ATTACH &vss => @PLACE(504, -393);
// &vss @WIRE(mode="straight") {#X180:5 %t901:p};
// %t902 = $IO_PORT @ATTACH &n241 => @PLACE(534, -380) => @ORIENT("R0");
// %t902 @TEXT("n241", key="name", size=0.75);
// &n241 @WIRE(mode="straight") {#X181:1 %t902:p};
// %t903 = $IO_PORT @ATTACH &n242 => @PLACE(534, -384) => @ORIENT("R0");
// %t903 @TEXT("n242", key="name", size=0.75);
// &n242 @WIRE(mode="straight") {#X181:2 %t903:p};
// %t904 = $IO_PORT @ATTACH &n243 => @PLACE(554, -382) => @ORIENT("MY");
// %t904 @TEXT("n243", key="name", size=0.75);
// &n243 @WIRE(mode="straight") {#X181:3 %t904:p};
// %t905 = $SUPPLY @ATTACH &vdd => @PLACE(544, -371);
// &vdd @WIRE(mode="straight") {#X181:4 %t905:p};
// %t906 = $GROUND @ATTACH &vss => @PLACE(544, -393);
// &vss @WIRE(mode="straight") {#X181:5 %t906:p};
// %t907 = $IO_PORT @ATTACH &n243 => @PLACE(574, -380) => @ORIENT("R0");
// %t907 @TEXT("n243", key="name", size=0.75);
// &n243 @WIRE(mode="straight") {#X182:1 %t907:p};
// %t908 = $IO_PORT @ATTACH &n244 => @PLACE(574, -384) => @ORIENT("R0");
// %t908 @TEXT("n244", key="name", size=0.75);
// &n244 @WIRE(mode="straight") {#X182:2 %t908:p};
// %t909 = $IO_PORT @ATTACH &n245 => @PLACE(594, -382) => @ORIENT("MY");
// %t909 @TEXT("n245", key="name", size=0.75);
// &n245 @WIRE(mode="straight") {#X182:3 %t909:p};
// %t910 = $SUPPLY @ATTACH &vdd => @PLACE(584, -371);
// &vdd @WIRE(mode="straight") {#X182:4 %t910:p};
// %t911 = $GROUND @ATTACH &vss => @PLACE(584, -393);
// &vss @WIRE(mode="straight") {#X182:5 %t911:p};
// %t912 = $IO_PORT @ATTACH &n246 => @PLACE(614, -380) => @ORIENT("R0");
// %t912 @TEXT("n246", key="name", size=0.75);
// &n246 @WIRE(mode="straight") {#X183:1 %t912:p};
// %t913 = $IO_PORT @ATTACH &n40 => @PLACE(614, -384) => @ORIENT("R0");
// %t913 @TEXT("n40", key="name", size=0.75);
// &n40 @WIRE(mode="straight") {#X183:2 %t913:p};
// %t914 = $IO_PORT @ATTACH &n242 => @PLACE(635, -382) => @ORIENT("MY");
// %t914 @TEXT("n242", key="name", size=0.75);
// &n242 @WIRE(mode="straight") {#X183:3 %t914:p};
// %t915 = $SUPPLY @ATTACH &vdd => @PLACE(624, -371);
// &vdd @WIRE(mode="straight") {#X183:4 %t915:p};
// %t916 = $GROUND @ATTACH &vss => @PLACE(624, -393);
// &vss @WIRE(mode="straight") {#X183:5 %t916:p};
// %t917 = $IO_PORT @ATTACH &n247 => @PLACE(494, -411) => @ORIENT("R0");
// %t917 @TEXT("n247", key="name", size=0.75);
// &n247 @WIRE(mode="straight") {#X184:1 %t917:p};
// %t918 = $IO_PORT @ATTACH &n242 => @PLACE(494, -415) => @ORIENT("R0");
// %t918 @TEXT("n242", key="name", size=0.75);
// &n242 @WIRE(mode="straight") {#X184:2 %t918:p};
// %t919 = $IO_PORT @ATTACH &n248 => @PLACE(514, -413) => @ORIENT("MY");
// %t919 @TEXT("n248", key="name", size=0.75);
// &n248 @WIRE(mode="straight") {#X184:3 %t919:p};
// %t920 = $SUPPLY @ATTACH &vdd => @PLACE(504, -402);
// &vdd @WIRE(mode="straight") {#X184:4 %t920:p};
// %t921 = $GROUND @ATTACH &vss => @PLACE(504, -424);
// &vss @WIRE(mode="straight") {#X184:5 %t921:p};
// %t922 = $IO_PORT @ATTACH &n248 => @PLACE(534, -411) => @ORIENT("R0");
// %t922 @TEXT("n248", key="name", size=0.75);
// &n248 @WIRE(mode="straight") {#X185:1 %t922:p};
// %t923 = $IO_PORT @ATTACH &n244 => @PLACE(534, -415) => @ORIENT("R0");
// %t923 @TEXT("n244", key="name", size=0.75);
// &n244 @WIRE(mode="straight") {#X185:2 %t923:p};
// %t924 = $IO_PORT @ATTACH &n249 => @PLACE(554, -413) => @ORIENT("MY");
// %t924 @TEXT("n249", key="name", size=0.75);
// &n249 @WIRE(mode="straight") {#X185:3 %t924:p};
// %t925 = $SUPPLY @ATTACH &vdd => @PLACE(544, -402);
// &vdd @WIRE(mode="straight") {#X185:4 %t925:p};
// %t926 = $GROUND @ATTACH &vss => @PLACE(544, -424);
// &vss @WIRE(mode="straight") {#X185:5 %t926:p};
// %t927 = $IO_PORT @ATTACH &n42 => @PLACE(574, -411) => @ORIENT("R0");
// %t927 @TEXT("n42", key="name", size=0.75);
// &n42 @WIRE(mode="straight") {#X186:1 %t927:p};
// %t928 = $IO_PORT @ATTACH &n250 => @PLACE(574, -415) => @ORIENT("R0");
// %t928 @TEXT("n250", key="name", size=0.75);
// &n250 @WIRE(mode="straight") {#X186:2 %t928:p};
// %t929 = $IO_PORT @ATTACH &n251 => @PLACE(594, -413) => @ORIENT("MY");
// %t929 @TEXT("n251", key="name", size=0.75);
// &n251 @WIRE(mode="straight") {#X186:3 %t929:p};
// %t930 = $SUPPLY @ATTACH &vdd => @PLACE(584, -402);
// &vdd @WIRE(mode="straight") {#X186:4 %t930:p};
// %t931 = $GROUND @ATTACH &vss => @PLACE(584, -424);
// &vss @WIRE(mode="straight") {#X186:5 %t931:p};
// %t932 = $IO_PORT @ATTACH &n251 => @PLACE(614, -411) => @ORIENT("R0");
// %t932 @TEXT("n251", key="name", size=0.75);
// &n251 @WIRE(mode="straight") {#X187:1 %t932:p};
// %t933 = $IO_PORT @ATTACH &n252 => @PLACE(614, -415) => @ORIENT("R0");
// %t933 @TEXT("n252", key="name", size=0.75);
// &n252 @WIRE(mode="straight") {#X187:2 %t933:p};
// %t934 = $IO_PORT @ATTACH &n244 => @PLACE(635, -413) => @ORIENT("MY");
// %t934 @TEXT("n244", key="name", size=0.75);
// &n244 @WIRE(mode="straight") {#X187:3 %t934:p};
// %t935 = $SUPPLY @ATTACH &vdd => @PLACE(624, -402);
// &vdd @WIRE(mode="straight") {#X187:4 %t935:p};
// %t936 = $GROUND @ATTACH &vss => @PLACE(624, -424);
// &vss @WIRE(mode="straight") {#X187:5 %t936:p};
// %t937 = $IO_PORT @ATTACH &n253 => @PLACE(494, -442) => @ORIENT("R0");
// %t937 @TEXT("n253", key="name", size=0.75);
// &n253 @WIRE(mode="straight") {#X188:1 %t937:p};
// %t938 = $IO_PORT @ATTACH &n244 => @PLACE(494, -446) => @ORIENT("R0");
// %t938 @TEXT("n244", key="name", size=0.75);
// &n244 @WIRE(mode="straight") {#X188:2 %t938:p};
// %t939 = $IO_PORT @ATTACH &n254 => @PLACE(514, -444) => @ORIENT("MY");
// %t939 @TEXT("n254", key="name", size=0.75);
// &n254 @WIRE(mode="straight") {#X188:3 %t939:p};
// %t940 = $SUPPLY @ATTACH &vdd => @PLACE(504, -433);
// &vdd @WIRE(mode="straight") {#X188:4 %t940:p};
// %t941 = $GROUND @ATTACH &vss => @PLACE(504, -455);
// &vss @WIRE(mode="straight") {#X188:5 %t941:p};
// %t942 = $IO_PORT @ATTACH &n34 => @PLACE(534, -442) => @ORIENT("R0");
// %t942 @TEXT("n34", key="name", size=0.75);
// &n34 @WIRE(mode="straight") {#X189:1 %t942:p};
// %t943 = $IO_PORT @ATTACH &n255 => @PLACE(534, -446) => @ORIENT("R0");
// %t943 @TEXT("n255", key="name", size=0.75);
// &n255 @WIRE(mode="straight") {#X189:2 %t943:p};
// %t944 = $IO_PORT @ATTACH &n247 => @PLACE(554, -444) => @ORIENT("MY");
// %t944 @TEXT("n247", key="name", size=0.75);
// &n247 @WIRE(mode="straight") {#X189:3 %t944:p};
// %t945 = $SUPPLY @ATTACH &vdd => @PLACE(544, -433);
// &vdd @WIRE(mode="straight") {#X189:4 %t945:p};
// %t946 = $GROUND @ATTACH &vss => @PLACE(544, -455);
// &vss @WIRE(mode="straight") {#X189:5 %t946:p};
// %t947 = $IO_PORT @ATTACH &n38 => @PLACE(574, -442) => @ORIENT("R0");
// %t947 @TEXT("n38", key="name", size=0.75);
// &n38 @WIRE(mode="straight") {#X190:1 %t947:p};
// %t948 = $IO_PORT @ATTACH &n40 => @PLACE(574, -446) => @ORIENT("R0");
// %t948 @TEXT("n40", key="name", size=0.75);
// &n40 @WIRE(mode="straight") {#X190:2 %t948:p};
// %t949 = $IO_PORT @ATTACH &n256 => @PLACE(594, -444) => @ORIENT("MY");
// %t949 @TEXT("n256", key="name", size=0.75);
// &n256 @WIRE(mode="straight") {#X190:3 %t949:p};
// %t950 = $SUPPLY @ATTACH &vdd => @PLACE(584, -433);
// &vdd @WIRE(mode="straight") {#X190:4 %t950:p};
// %t951 = $GROUND @ATTACH &vss => @PLACE(584, -455);
// &vss @WIRE(mode="straight") {#X190:5 %t951:p};
// %t952 = $IO_PORT @ATTACH &n42 => @PLACE(614, -442) => @ORIENT("R0");
// %t952 @TEXT("n42", key="name", size=0.75);
// &n42 @WIRE(mode="straight") {#X191:1 %t952:p};
// %t953 = $IO_PORT @ATTACH &n44 => @PLACE(614, -446) => @ORIENT("R0");
// %t953 @TEXT("n44", key="name", size=0.75);
// &n44 @WIRE(mode="straight") {#X191:2 %t953:p};
// %t954 = $IO_PORT @ATTACH &n257 => @PLACE(635, -444) => @ORIENT("MY");
// %t954 @TEXT("n257", key="name", size=0.75);
// &n257 @WIRE(mode="straight") {#X191:3 %t954:p};
// %t955 = $SUPPLY @ATTACH &vdd => @PLACE(624, -433);
// &vdd @WIRE(mode="straight") {#X191:4 %t955:p};
// %t956 = $GROUND @ATTACH &vss => @PLACE(624, -455);
// &vss @WIRE(mode="straight") {#X191:5 %t956:p};
// %t957 = $IO_PORT @ATTACH &n46 => @PLACE(-11, -486) => @ORIENT("R0");
// %t957 @TEXT("n46", key="name", size=0.75);
// &n46 @WIRE(mode="straight") {#X192:1 %t957:p};
// %t958 = $IO_PORT @ATTACH &n48 => @PLACE(-11, -490) => @ORIENT("R0");
// %t958 @TEXT("n48", key="name", size=0.75);
// &n48 @WIRE(mode="straight") {#X192:2 %t958:p};
// %t959 = $IO_PORT @ATTACH &n252 => @PLACE(10, -488) => @ORIENT("MY");
// %t959 @TEXT("n252", key="name", size=0.75);
// &n252 @WIRE(mode="straight") {#X192:3 %t959:p};
// %t960 = $SUPPLY @ATTACH &vdd => @PLACE(0, -477);
// &vdd @WIRE(mode="straight") {#X192:4 %t960:p};
// %t961 = $GROUND @ATTACH &vss => @PLACE(0, -499);
// &vss @WIRE(mode="straight") {#X192:5 %t961:p};
// %t962 = $IO_PORT @ATTACH &n247 => @PLACE(30, -486) => @ORIENT("R0");
// %t962 @TEXT("n247", key="name", size=0.75);
// &n247 @WIRE(mode="straight") {#X193:1 %t962:p};
// %t963 = $IO_PORT @ATTACH &n256 => @PLACE(30, -490) => @ORIENT("R0");
// %t963 @TEXT("n256", key="name", size=0.75);
// &n256 @WIRE(mode="straight") {#X193:2 %t963:p};
// %t964 = $IO_PORT @ATTACH &n253 => @PLACE(50, -488) => @ORIENT("MY");
// %t964 @TEXT("n253", key="name", size=0.75);
// &n253 @WIRE(mode="straight") {#X193:3 %t964:p};
// %t965 = $SUPPLY @ATTACH &vdd => @PLACE(40, -477);
// &vdd @WIRE(mode="straight") {#X193:4 %t965:p};
// %t966 = $GROUND @ATTACH &vss => @PLACE(40, -499);
// &vss @WIRE(mode="straight") {#X193:5 %t966:p};
// %t967 = $IO_PORT @ATTACH &n257 => @PLACE(70, -486) => @ORIENT("R0");
// %t967 @TEXT("n257", key="name", size=0.75);
// &n257 @WIRE(mode="straight") {#X194:1 %t967:p};
// %t968 = $IO_PORT @ATTACH &n252 => @PLACE(70, -490) => @ORIENT("R0");
// %t968 @TEXT("n252", key="name", size=0.75);
// &n252 @WIRE(mode="straight") {#X194:2 %t968:p};
// %t969 = $IO_PORT @ATTACH &n258 => @PLACE(90, -488) => @ORIENT("MY");
// %t969 @TEXT("n258", key="name", size=0.75);
// &n258 @WIRE(mode="straight") {#X194:3 %t969:p};
// %t970 = $SUPPLY @ATTACH &vdd => @PLACE(80, -477);
// &vdd @WIRE(mode="straight") {#X194:4 %t970:p};
// %t971 = $GROUND @ATTACH &vss => @PLACE(80, -499);
// &vss @WIRE(mode="straight") {#X194:5 %t971:p};
// %t972 = $IO_PORT @ATTACH &n253 => @PLACE(110, -486) => @ORIENT("R0");
// %t972 @TEXT("n253", key="name", size=0.75);
// &n253 @WIRE(mode="straight") {#X195:1 %t972:p};
// %t973 = $IO_PORT @ATTACH &n258 => @PLACE(110, -490) => @ORIENT("R0");
// %t973 @TEXT("n258", key="name", size=0.75);
// &n258 @WIRE(mode="straight") {#X195:2 %t973:p};
// %t974 = $IO_PORT @ATTACH &n259 => @PLACE(130, -488) => @ORIENT("MY");
// %t974 @TEXT("n259", key="name", size=0.75);
// &n259 @WIRE(mode="straight") {#X195:3 %t974:p};
// %t975 = $SUPPLY @ATTACH &vdd => @PLACE(120, -477);
// &vdd @WIRE(mode="straight") {#X195:4 %t975:p};
// %t976 = $GROUND @ATTACH &vss => @PLACE(120, -499);
// &vss @WIRE(mode="straight") {#X195:5 %t976:p};
// %t977 = $IO_PORT @ATTACH &n260 => @PLACE(-11, -521) => @ORIENT("R0");
// %t977 @TEXT("n260", key="name", size=0.75);
// &n260 @WIRE(mode="straight") {#X196:1 %t977:p};
// %t978 = $IO_PORT @ATTACH &n93 => @PLACE(-11, -525) => @ORIENT("R0");
// %t978 @TEXT("n93", key="name", size=0.75);
// &n93 @WIRE(mode="straight") {#X196:2 %t978:p};
// %t979 = $IO_PORT @ATTACH &n221 => @PLACE(10, -523) => @ORIENT("MY");
// %t979 @TEXT("n221", key="name", size=0.75);
// &n221 @WIRE(mode="straight") {#X196:3 %t979:p};
// %t980 = $SUPPLY @ATTACH &vdd => @PLACE(0, -512);
// &vdd @WIRE(mode="straight") {#X196:4 %t980:p};
// %t981 = $GROUND @ATTACH &vss => @PLACE(0, -534);
// &vss @WIRE(mode="straight") {#X196:5 %t981:p};
// %t982 = $IO_PORT @ATTACH &n261 => @PLACE(30, -521) => @ORIENT("R0");
// %t982 @TEXT("n261", key="name", size=0.75);
// &n261 @WIRE(mode="straight") {#X197:1 %t982:p};
// %t983 = $IO_PORT @ATTACH &n221 => @PLACE(30, -525) => @ORIENT("R0");
// %t983 @TEXT("n221", key="name", size=0.75);
// &n221 @WIRE(mode="straight") {#X197:2 %t983:p};
// %t984 = $IO_PORT @ATTACH &n262 => @PLACE(50, -523) => @ORIENT("MY");
// %t984 @TEXT("n262", key="name", size=0.75);
// &n262 @WIRE(mode="straight") {#X197:3 %t984:p};
// %t985 = $SUPPLY @ATTACH &vdd => @PLACE(40, -512);
// &vdd @WIRE(mode="straight") {#X197:4 %t985:p};
// %t986 = $GROUND @ATTACH &vss => @PLACE(40, -534);
// &vss @WIRE(mode="straight") {#X197:5 %t986:p};
// %t987 = $IO_PORT @ATTACH &n130 => @PLACE(70, -521) => @ORIENT("R0");
// %t987 @TEXT("n130", key="name", size=0.75);
// &n130 @WIRE(mode="straight") {#X198:1 %t987:p};
// %t988 = $IO_PORT @ATTACH &target_k3 => @PLACE(70, -525) => @ORIENT("R0");
// %t988 @TEXT("target_k3", key="name", size=0.75);
// &target_k3 @WIRE(mode="straight") {#X198:2 %t988:p};
// %t989 = $IO_PORT @ATTACH &n97 => @PLACE(90, -523) => @ORIENT("MY");
// %t989 @TEXT("n97", key="name", size=0.75);
// &n97 @WIRE(mode="straight") {#X198:3 %t989:p};
// %t990 = $SUPPLY @ATTACH &vdd => @PLACE(80, -512);
// &vdd @WIRE(mode="straight") {#X198:4 %t990:p};
// %t991 = $GROUND @ATTACH &vss => @PLACE(80, -534);
// &vss @WIRE(mode="straight") {#X198:5 %t991:p};
// %t992 = $IO_PORT @ATTACH &n100 => @PLACE(110, -521) => @ORIENT("R0");
// %t992 @TEXT("n100", key="name", size=0.75);
// &n100 @WIRE(mode="straight") {#X199:1 %t992:p};
// %t993 = $IO_PORT @ATTACH &target_k5 => @PLACE(110, -525) => @ORIENT("R0");
// %t993 @TEXT("target_k5", key="name", size=0.75);
// &target_k5 @WIRE(mode="straight") {#X199:2 %t993:p};
// %t994 = $IO_PORT @ATTACH &n102 => @PLACE(130, -523) => @ORIENT("MY");
// %t994 @TEXT("n102", key="name", size=0.75);
// &n102 @WIRE(mode="straight") {#X199:3 %t994:p};
// %t995 = $SUPPLY @ATTACH &vdd => @PLACE(120, -512);
// &vdd @WIRE(mode="straight") {#X199:4 %t995:p};
// %t996 = $GROUND @ATTACH &vss => @PLACE(120, -534);
// &vss @WIRE(mode="straight") {#X199:5 %t996:p};
// %t997 = $IO_PORT @ATTACH &n105 => @PLACE(-11, -556) => @ORIENT("R0");
// %t997 @TEXT("n105", key="name", size=0.75);
// &n105 @WIRE(mode="straight") {#X200:1 %t997:p};
// %t998 = $IO_PORT @ATTACH &n97 => @PLACE(-11, -560) => @ORIENT("R0");
// %t998 @TEXT("n97", key="name", size=0.75);
// &n97 @WIRE(mode="straight") {#X200:2 %t998:p};
// %t999 = $IO_PORT @ATTACH &n260 => @PLACE(10, -558) => @ORIENT("MY");
// %t999 @TEXT("n260", key="name", size=0.75);
// &n260 @WIRE(mode="straight") {#X200:3 %t999:p};
// %t1000 = $SUPPLY @ATTACH &vdd => @PLACE(0, -547);
// &vdd @WIRE(mode="straight") {#X200:4 %t1000:p};
// %t1001 = $GROUND @ATTACH &vss => @PLACE(0, -569);
// &vss @WIRE(mode="straight") {#X200:5 %t1001:p};
// %t1002 = $IO_PORT @ATTACH &n260 => @PLACE(30, -556) => @ORIENT("R0");
// %t1002 @TEXT("n260", key="name", size=0.75);
// &n260 @WIRE(mode="straight") {#X201:1 %t1002:p};
// %t1003 = $IO_PORT @ATTACH &n102 => @PLACE(30, -560) => @ORIENT("R0");
// %t1003 @TEXT("n102", key="name", size=0.75);
// &n102 @WIRE(mode="straight") {#X201:2 %t1003:p};
// %t1004 = $IO_PORT @ATTACH &n263 => @PLACE(50, -558) => @ORIENT("MY");
// %t1004 @TEXT("n263", key="name", size=0.75);
// &n263 @WIRE(mode="straight") {#X201:3 %t1004:p};
// %t1005 = $SUPPLY @ATTACH &vdd => @PLACE(40, -547);
// &vdd @WIRE(mode="straight") {#X201:4 %t1005:p};
// %t1006 = $GROUND @ATTACH &vss => @PLACE(40, -569);
// &vss @WIRE(mode="straight") {#X201:5 %t1006:p};
// %t1007 = $IO_PORT @ATTACH &n80 => @PLACE(70, -556) => @ORIENT("R0");
// %t1007 @TEXT("n80", key="name", size=0.75);
// &n80 @WIRE(mode="straight") {#X202:1 %t1007:p};
// %t1008 = $IO_PORT @ATTACH &n263 => @PLACE(70, -560) => @ORIENT("R0");
// %t1008 @TEXT("n263", key="name", size=0.75);
// &n263 @WIRE(mode="straight") {#X202:2 %t1008:p};
// %t1009 = $IO_PORT @ATTACH &n264 => @PLACE(90, -558) => @ORIENT("MY");
// %t1009 @TEXT("n264", key="name", size=0.75);
// &n264 @WIRE(mode="straight") {#X202:3 %t1009:p};
// %t1010 = $SUPPLY @ATTACH &vdd => @PLACE(80, -547);
// &vdd @WIRE(mode="straight") {#X202:4 %t1010:p};
// %t1011 = $GROUND @ATTACH &vss => @PLACE(80, -569);
// &vss @WIRE(mode="straight") {#X202:5 %t1011:p};
// %t1012 = $IO_PORT @ATTACH &measured0 => @PLACE(110, -556) => @ORIENT("R0");
// %t1012 @TEXT("measured0", key="name", size=0.75);
// &measured0 @WIRE(mode="straight") {#X203:1 %t1012:p};
// %t1013 = $IO_PORT @ATTACH &n63 => @PLACE(110, -560) => @ORIENT("R0");
// %t1013 @TEXT("n63", key="name", size=0.75);
// &n63 @WIRE(mode="straight") {#X203:2 %t1013:p};
// %t1014 = $IO_PORT @ATTACH &n265 => @PLACE(130, -558) => @ORIENT("MY");
// %t1014 @TEXT("n265", key="name", size=0.75);
// &n265 @WIRE(mode="straight") {#X203:3 %t1014:p};
// %t1015 = $SUPPLY @ATTACH &vdd => @PLACE(120, -547);
// &vdd @WIRE(mode="straight") {#X203:4 %t1015:p};
// %t1016 = $GROUND @ATTACH &vss => @PLACE(120, -569);
// &vss @WIRE(mode="straight") {#X203:5 %t1016:p};
// %t1017 = $IO_PORT @ATTACH &n65 => @PLACE(-11, -589) => @ORIENT("R0");
// %t1017 @TEXT("n65", key="name", size=0.75);
// &n65 @WIRE(mode="straight") {#X204:1 %t1017:p};
// %t1018 = $IO_PORT @ATTACH &n139 => @PLACE(-11, -593) => @ORIENT("R0");
// %t1018 @TEXT("n139", key="name", size=0.75);
// &n139 @WIRE(mode="straight") {#X204:2 %t1018:p};
// %t1019 = $IO_PORT @ATTACH &n266 => @PLACE(10, -591) => @ORIENT("MY");
// %t1019 @TEXT("n266", key="name", size=0.75);
// &n266 @WIRE(mode="straight") {#X204:3 %t1019:p};
// %t1020 = $SUPPLY @ATTACH &vdd => @PLACE(0, -580);
// &vdd @WIRE(mode="straight") {#X204:4 %t1020:p};
// %t1021 = $GROUND @ATTACH &vss => @PLACE(0, -602);
// &vss @WIRE(mode="straight") {#X204:5 %t1021:p};
// %t1022 = $IO_PORT @ATTACH &n140 => @PLACE(30, -589) => @ORIENT("R0");
// %t1022 @TEXT("n140", key="name", size=0.75);
// &n140 @WIRE(mode="straight") {#X205:1 %t1022:p};
// %t1023 = $IO_PORT @ATTACH &n141 => @PLACE(30, -593) => @ORIENT("R0");
// %t1023 @TEXT("n141", key="name", size=0.75);
// &n141 @WIRE(mode="straight") {#X205:2 %t1023:p};
// %t1024 = $IO_PORT @ATTACH &n164 => @PLACE(50, -591) => @ORIENT("MY");
// %t1024 @TEXT("n164", key="name", size=0.75);
// &n164 @WIRE(mode="straight") {#X205:3 %t1024:p};
// %t1025 = $SUPPLY @ATTACH &vdd => @PLACE(40, -580);
// &vdd @WIRE(mode="straight") {#X205:4 %t1025:p};
// %t1026 = $GROUND @ATTACH &vss => @PLACE(40, -602);
// &vss @WIRE(mode="straight") {#X205:5 %t1026:p};
// %t1027 = $IO_PORT @ATTACH &n75 => @PLACE(70, -589) => @ORIENT("R0");
// %t1027 @TEXT("n75", key="name", size=0.75);
// &n75 @WIRE(mode="straight") {#X206:1 %t1027:p};
// %t1028 = $IO_PORT @ATTACH &n73 => @PLACE(70, -593) => @ORIENT("R0");
// %t1028 @TEXT("n73", key="name", size=0.75);
// &n73 @WIRE(mode="straight") {#X206:2 %t1028:p};
// %t1029 = $IO_PORT @ATTACH &n148 => @PLACE(90, -591) => @ORIENT("MY");
// %t1029 @TEXT("n148", key="name", size=0.75);
// &n148 @WIRE(mode="straight") {#X206:3 %t1029:p};
// %t1030 = $SUPPLY @ATTACH &vdd => @PLACE(80, -580);
// &vdd @WIRE(mode="straight") {#X206:4 %t1030:p};
// %t1031 = $GROUND @ATTACH &vss => @PLACE(80, -602);
// &vss @WIRE(mode="straight") {#X206:5 %t1031:p};
// %t1032 = $IO_PORT @ATTACH &n265 => @PLACE(110, -589) => @ORIENT("R0");
// %t1032 @TEXT("n265", key="name", size=0.75);
// &n265 @WIRE(mode="straight") {#X207:1 %t1032:p};
// %t1033 = $IO_PORT @ATTACH &n167 => @PLACE(110, -593) => @ORIENT("R0");
// %t1033 @TEXT("n167", key="name", size=0.75);
// &n167 @WIRE(mode="straight") {#X207:2 %t1033:p};
// %t1034 = $IO_PORT @ATTACH &n267 => @PLACE(130, -591) => @ORIENT("MY");
// %t1034 @TEXT("n267", key="name", size=0.75);
// &n267 @WIRE(mode="straight") {#X207:3 %t1034:p};
// %t1035 = $SUPPLY @ATTACH &vdd => @PLACE(120, -580);
// &vdd @WIRE(mode="straight") {#X207:4 %t1035:p};
// %t1036 = $GROUND @ATTACH &vss => @PLACE(120, -602);
// &vss @WIRE(mode="straight") {#X207:5 %t1036:p};
// %t1037 = $IO_PORT @ATTACH &n266 => @PLACE(-11, -620) => @ORIENT("R0");
// %t1037 @TEXT("n266", key="name", size=0.75);
// &n266 @WIRE(mode="straight") {#X208:1 %t1037:p};
// %t1038 = $IO_PORT @ATTACH &n164 => @PLACE(-11, -624) => @ORIENT("R0");
// %t1038 @TEXT("n164", key="name", size=0.75);
// &n164 @WIRE(mode="straight") {#X208:2 %t1038:p};
// %t1039 = $IO_PORT @ATTACH &n156 => @PLACE(10, -622) => @ORIENT("MY");
// %t1039 @TEXT("n156", key="name", size=0.75);
// &n156 @WIRE(mode="straight") {#X208:3 %t1039:p};
// %t1040 = $SUPPLY @ATTACH &vdd => @PLACE(0, -611);
// &vdd @WIRE(mode="straight") {#X208:4 %t1040:p};
// %t1041 = $GROUND @ATTACH &vss => @PLACE(0, -633);
// &vss @WIRE(mode="straight") {#X208:5 %t1041:p};
// %t1042 = $IO_PORT @ATTACH &n170 => @PLACE(30, -620) => @ORIENT("R0");
// %t1042 @TEXT("n170", key="name", size=0.75);
// &n170 @WIRE(mode="straight") {#X209:1 %t1042:p};
// %t1043 = $IO_PORT @ATTACH &n160 => @PLACE(30, -624) => @ORIENT("R0");
// %t1043 @TEXT("n160", key="name", size=0.75);
// &n160 @WIRE(mode="straight") {#X209:2 %t1043:p};
// %t1044 = $IO_PORT @ATTACH &n152 => @PLACE(50, -622) => @ORIENT("MY");
// %t1044 @TEXT("n152", key="name", size=0.75);
// &n152 @WIRE(mode="straight") {#X209:3 %t1044:p};
// %t1045 = $SUPPLY @ATTACH &vdd => @PLACE(40, -611);
// &vdd @WIRE(mode="straight") {#X209:4 %t1045:p};
// %t1046 = $GROUND @ATTACH &vss => @PLACE(40, -633);
// &vss @WIRE(mode="straight") {#X209:5 %t1046:p};
// %t1047 = $IO_PORT @ATTACH &n267 => @PLACE(70, -620) => @ORIENT("R0");
// %t1047 @TEXT("n267", key="name", size=0.75);
// &n267 @WIRE(mode="straight") {#X210:1 %t1047:p};
// %t1048 = $IO_PORT @ATTACH &n156 => @PLACE(70, -624) => @ORIENT("R0");
// %t1048 @TEXT("n156", key="name", size=0.75);
// &n156 @WIRE(mode="straight") {#X210:2 %t1048:p};
// %t1049 = $IO_PORT @ATTACH &n268 => @PLACE(90, -622) => @ORIENT("MY");
// %t1049 @TEXT("n268", key="name", size=0.75);
// &n268 @WIRE(mode="straight") {#X210:3 %t1049:p};
// %t1050 = $SUPPLY @ATTACH &vdd => @PLACE(80, -611);
// &vdd @WIRE(mode="straight") {#X210:4 %t1050:p};
// %t1051 = $GROUND @ATTACH &vss => @PLACE(80, -633);
// &vss @WIRE(mode="straight") {#X210:5 %t1051:p};
// %t1052 = $IO_PORT @ATTACH &n152 => @PLACE(110, -620) => @ORIENT("R0");
// %t1052 @TEXT("n152", key="name", size=0.75);
// &n152 @WIRE(mode="straight") {#X211:1 %t1052:p};
// %t1053 = $IO_PORT @ATTACH &n148 => @PLACE(110, -624) => @ORIENT("R0");
// %t1053 @TEXT("n148", key="name", size=0.75);
// &n148 @WIRE(mode="straight") {#X211:2 %t1053:p};
// %t1054 = $IO_PORT @ATTACH &n269 => @PLACE(130, -622) => @ORIENT("MY");
// %t1054 @TEXT("n269", key="name", size=0.75);
// &n269 @WIRE(mode="straight") {#X211:3 %t1054:p};
// %t1055 = $SUPPLY @ATTACH &vdd => @PLACE(120, -611);
// &vdd @WIRE(mode="straight") {#X211:4 %t1055:p};
// %t1056 = $GROUND @ATTACH &vss => @PLACE(120, -633);
// &vss @WIRE(mode="straight") {#X211:5 %t1056:p};
// %t1057 = $IO_PORT @ATTACH &n268 => @PLACE(-11, -653) => @ORIENT("R0");
// %t1057 @TEXT("n268", key="name", size=0.75);
// &n268 @WIRE(mode="straight") {#X212:1 %t1057:p};
// %t1058 = $IO_PORT @ATTACH &n269 => @PLACE(-11, -657) => @ORIENT("R0");
// %t1058 @TEXT("n269", key="name", size=0.75);
// &n269 @WIRE(mode="straight") {#X212:2 %t1058:p};
// %t1059 = $IO_PORT @ATTACH &n224 => @PLACE(10, -655) => @ORIENT("MY");
// %t1059 @TEXT("n224", key="name", size=0.75);
// &n224 @WIRE(mode="straight") {#X212:3 %t1059:p};
// %t1060 = $SUPPLY @ATTACH &vdd => @PLACE(0, -644);
// &vdd @WIRE(mode="straight") {#X212:4 %t1060:p};
// %t1061 = $GROUND @ATTACH &vss => @PLACE(0, -666);
// &vss @WIRE(mode="straight") {#X212:5 %t1061:p};
// %t1062 = $IO_PORT @ATTACH &n270 => @PLACE(30, -653) => @ORIENT("R0");
// %t1062 @TEXT("n270", key="name", size=0.75);
// &n270 @WIRE(mode="straight") {#X213:1 %t1062:p};
// %t1063 = $IO_PORT @ATTACH &n224 => @PLACE(30, -657) => @ORIENT("R0");
// %t1063 @TEXT("n224", key="name", size=0.75);
// &n224 @WIRE(mode="straight") {#X213:2 %t1063:p};
// %t1064 = $IO_PORT @ATTACH &n271 => @PLACE(50, -655) => @ORIENT("MY");
// %t1064 @TEXT("n271", key="name", size=0.75);
// &n271 @WIRE(mode="straight") {#X213:3 %t1064:p};
// %t1065 = $SUPPLY @ATTACH &vdd => @PLACE(40, -644);
// &vdd @WIRE(mode="straight") {#X213:4 %t1065:p};
// %t1066 = $GROUND @ATTACH &vss => @PLACE(40, -666);
// &vss @WIRE(mode="straight") {#X213:5 %t1066:p};
// %t1067 = $IO_PORT @ATTACH &n58 => @PLACE(70, -653) => @ORIENT("R0");
// %t1067 @TEXT("n58", key="name", size=0.75);
// &n58 @WIRE(mode="straight") {#X214:1 %t1067:p};
// %t1068 = $IO_PORT @ATTACH &n57 => @PLACE(70, -657) => @ORIENT("R0");
// %t1068 @TEXT("n57", key="name", size=0.75);
// &n57 @WIRE(mode="straight") {#X214:2 %t1068:p};
// %t1069 = $IO_PORT @ATTACH &n210 => @PLACE(90, -655) => @ORIENT("MY");
// %t1069 @TEXT("n210", key="name", size=0.75);
// &n210 @WIRE(mode="straight") {#X214:3 %t1069:p};
// %t1070 = $SUPPLY @ATTACH &vdd => @PLACE(80, -644);
// &vdd @WIRE(mode="straight") {#X214:4 %t1070:p};
// %t1071 = $GROUND @ATTACH &vss => @PLACE(80, -666);
// &vss @WIRE(mode="straight") {#X214:5 %t1071:p};
// %t1072 = $IO_PORT @ATTACH &n186 => @PLACE(110, -653) => @ORIENT("R0");
// %t1072 @TEXT("n186", key="name", size=0.75);
// &n186 @WIRE(mode="straight") {#X215:1 %t1072:p};
// %t1073 = $IO_PORT @ATTACH &n59 => @PLACE(110, -657) => @ORIENT("R0");
// %t1073 @TEXT("n59", key="name", size=0.75);
// &n59 @WIRE(mode="straight") {#X215:2 %t1073:p};
// %t1074 = $IO_PORT @ATTACH &n202 => @PLACE(130, -655) => @ORIENT("MY");
// %t1074 @TEXT("n202", key="name", size=0.75);
// &n202 @WIRE(mode="straight") {#X215:3 %t1074:p};
// %t1075 = $SUPPLY @ATTACH &vdd => @PLACE(120, -644);
// &vdd @WIRE(mode="straight") {#X215:4 %t1075:p};
// %t1076 = $GROUND @ATTACH &vss => @PLACE(120, -666);
// &vss @WIRE(mode="straight") {#X215:5 %t1076:p};
// %t1077 = $IO_PORT @ATTACH &n61 => @PLACE(158, -486) => @ORIENT("R0");
// %t1077 @TEXT("n61", key="name", size=0.75);
// &n61 @WIRE(mode="straight") {#X216:1 %t1077:p};
// %t1078 = $IO_PORT @ATTACH &n60 => @PLACE(158, -490) => @ORIENT("R0");
// %t1078 @TEXT("n60", key="name", size=0.75);
// &n60 @WIRE(mode="straight") {#X216:2 %t1078:p};
// %t1079 = $IO_PORT @ATTACH &n190 => @PLACE(178, -488) => @ORIENT("MY");
// %t1079 @TEXT("n190", key="name", size=0.75);
// &n190 @WIRE(mode="straight") {#X216:3 %t1079:p};
// %t1080 = $SUPPLY @ATTACH &vdd => @PLACE(168, -477);
// &vdd @WIRE(mode="straight") {#X216:4 %t1080:p};
// %t1081 = $GROUND @ATTACH &vss => @PLACE(168, -499);
// &vss @WIRE(mode="straight") {#X216:5 %t1081:p};
// %t1082 = $IO_PORT @ATTACH &n220 => @PLACE(198, -486) => @ORIENT("R0");
// %t1082 @TEXT("n220", key="name", size=0.75);
// &n220 @WIRE(mode="straight") {#X217:1 %t1082:p};
// %t1083 = $IO_PORT @ATTACH &n210 => @PLACE(198, -490) => @ORIENT("R0");
// %t1083 @TEXT("n210", key="name", size=0.75);
// &n210 @WIRE(mode="straight") {#X217:2 %t1083:p};
// %t1084 = $IO_PORT @ATTACH &n272 => @PLACE(218, -488) => @ORIENT("MY");
// %t1084 @TEXT("n272", key="name", size=0.75);
// &n272 @WIRE(mode="straight") {#X217:3 %t1084:p};
// %t1085 = $SUPPLY @ATTACH &vdd => @PLACE(208, -477);
// &vdd @WIRE(mode="straight") {#X217:4 %t1085:p};
// %t1086 = $GROUND @ATTACH &vss => @PLACE(208, -499);
// &vss @WIRE(mode="straight") {#X217:5 %t1086:p};
// %t1087 = $IO_PORT @ATTACH &n217 => @PLACE(238, -486) => @ORIENT("R0");
// %t1087 @TEXT("n217", key="name", size=0.75);
// &n217 @WIRE(mode="straight") {#X218:1 %t1087:p};
// %t1088 = $IO_PORT @ATTACH &n206 => @PLACE(238, -490) => @ORIENT("R0");
// %t1088 @TEXT("n206", key="name", size=0.75);
// &n206 @WIRE(mode="straight") {#X218:2 %t1088:p};
// %t1089 = $IO_PORT @ATTACH &n198 => @PLACE(258, -488) => @ORIENT("MY");
// %t1089 @TEXT("n198", key="name", size=0.75);
// &n198 @WIRE(mode="straight") {#X218:3 %t1089:p};
// %t1090 = $SUPPLY @ATTACH &vdd => @PLACE(248, -477);
// &vdd @WIRE(mode="straight") {#X218:4 %t1090:p};
// %t1091 = $GROUND @ATTACH &vss => @PLACE(248, -499);
// &vss @WIRE(mode="straight") {#X218:5 %t1091:p};
// %t1092 = $IO_PORT @ATTACH &n214 => @PLACE(278, -486) => @ORIENT("R0");
// %t1092 @TEXT("n214", key="name", size=0.75);
// &n214 @WIRE(mode="straight") {#X219:1 %t1092:p};
// %t1093 = $IO_PORT @ATTACH &n202 => @PLACE(278, -490) => @ORIENT("R0");
// %t1093 @TEXT("n202", key="name", size=0.75);
// &n202 @WIRE(mode="straight") {#X219:2 %t1093:p};
// %t1094 = $IO_PORT @ATTACH &n194 => @PLACE(298, -488) => @ORIENT("MY");
// %t1094 @TEXT("n194", key="name", size=0.75);
// &n194 @WIRE(mode="straight") {#X219:3 %t1094:p};
// %t1095 = $SUPPLY @ATTACH &vdd => @PLACE(288, -477);
// &vdd @WIRE(mode="straight") {#X219:4 %t1095:p};
// %t1096 = $GROUND @ATTACH &vss => @PLACE(288, -499);
// &vss @WIRE(mode="straight") {#X219:5 %t1096:p};
// %t1097 = $IO_PORT @ATTACH &n272 => @PLACE(158, -521) => @ORIENT("R0");
// %t1097 @TEXT("n272", key="name", size=0.75);
// &n272 @WIRE(mode="straight") {#X220:1 %t1097:p};
// %t1098 = $IO_PORT @ATTACH &n198 => @PLACE(158, -525) => @ORIENT("R0");
// %t1098 @TEXT("n198", key="name", size=0.75);
// &n198 @WIRE(mode="straight") {#X220:2 %t1098:p};
// %t1099 = $IO_PORT @ATTACH &n273 => @PLACE(178, -523) => @ORIENT("MY");
// %t1099 @TEXT("n273", key="name", size=0.75);
// &n273 @WIRE(mode="straight") {#X220:3 %t1099:p};
// %t1100 = $SUPPLY @ATTACH &vdd => @PLACE(168, -512);
// &vdd @WIRE(mode="straight") {#X220:4 %t1100:p};
// %t1101 = $GROUND @ATTACH &vss => @PLACE(168, -534);
// &vss @WIRE(mode="straight") {#X220:5 %t1101:p};
// %t1102 = $IO_PORT @ATTACH &n194 => @PLACE(198, -521) => @ORIENT("R0");
// %t1102 @TEXT("n194", key="name", size=0.75);
// &n194 @WIRE(mode="straight") {#X221:1 %t1102:p};
// %t1103 = $IO_PORT @ATTACH &n190 => @PLACE(198, -525) => @ORIENT("R0");
// %t1103 @TEXT("n190", key="name", size=0.75);
// &n190 @WIRE(mode="straight") {#X221:2 %t1103:p};
// %t1104 = $IO_PORT @ATTACH &n274 => @PLACE(218, -523) => @ORIENT("MY");
// %t1104 @TEXT("n274", key="name", size=0.75);
// &n274 @WIRE(mode="straight") {#X221:3 %t1104:p};
// %t1105 = $SUPPLY @ATTACH &vdd => @PLACE(208, -512);
// &vdd @WIRE(mode="straight") {#X221:4 %t1105:p};
// %t1106 = $GROUND @ATTACH &vss => @PLACE(208, -534);
// &vss @WIRE(mode="straight") {#X221:5 %t1106:p};
// %t1107 = $IO_PORT @ATTACH &n273 => @PLACE(238, -521) => @ORIENT("R0");
// %t1107 @TEXT("n273", key="name", size=0.75);
// &n273 @WIRE(mode="straight") {#X222:1 %t1107:p};
// %t1108 = $IO_PORT @ATTACH &n274 => @PLACE(238, -525) => @ORIENT("R0");
// %t1108 @TEXT("n274", key="name", size=0.75);
// &n274 @WIRE(mode="straight") {#X222:2 %t1108:p};
// %t1109 = $IO_PORT @ATTACH &n275 => @PLACE(258, -523) => @ORIENT("MY");
// %t1109 @TEXT("n275", key="name", size=0.75);
// &n275 @WIRE(mode="straight") {#X222:3 %t1109:p};
// %t1110 = $SUPPLY @ATTACH &vdd => @PLACE(248, -512);
// &vdd @WIRE(mode="straight") {#X222:4 %t1110:p};
// %t1111 = $GROUND @ATTACH &vss => @PLACE(248, -534);
// &vss @WIRE(mode="straight") {#X222:5 %t1111:p};
// %t1112 = $IO_PORT @ATTACH &n276 => @PLACE(278, -521) => @ORIENT("R0");
// %t1112 @TEXT("n276", key="name", size=0.75);
// &n276 @WIRE(mode="straight") {#X223:1 %t1112:p};
// %t1113 = $IO_PORT @ATTACH &n275 => @PLACE(278, -525) => @ORIENT("R0");
// %t1113 @TEXT("n275", key="name", size=0.75);
// &n275 @WIRE(mode="straight") {#X223:2 %t1113:p};
// %t1114 = $IO_PORT @ATTACH &n277 => @PLACE(298, -523) => @ORIENT("MY");
// %t1114 @TEXT("n277", key="name", size=0.75);
// &n277 @WIRE(mode="straight") {#X223:3 %t1114:p};
// %t1115 = $SUPPLY @ATTACH &vdd => @PLACE(288, -512);
// &vdd @WIRE(mode="straight") {#X223:4 %t1115:p};
// %t1116 = $GROUND @ATTACH &vss => @PLACE(288, -534);
// &vss @WIRE(mode="straight") {#X223:5 %t1116:p};
// %t1117 = $IO_PORT @ATTACH &n233 => @PLACE(158, -556) => @ORIENT("R0");
// %t1117 @TEXT("n233", key="name", size=0.75);
// &n233 @WIRE(mode="straight") {#X224:1 %t1117:p};
// %t1118 = $IO_PORT @ATTACH &n235 => @PLACE(158, -560) => @ORIENT("R0");
// %t1118 @TEXT("n235", key="name", size=0.75);
// &n235 @WIRE(mode="straight") {#X224:2 %t1118:p};
// %t1119 = $IO_PORT @ATTACH &n278 => @PLACE(178, -558) => @ORIENT("MY");
// %t1119 @TEXT("n278", key="name", size=0.75);
// &n278 @WIRE(mode="straight") {#X224:3 %t1119:p};
// %t1120 = $SUPPLY @ATTACH &vdd => @PLACE(168, -547);
// &vdd @WIRE(mode="straight") {#X224:4 %t1120:p};
// %t1121 = $GROUND @ATTACH &vss => @PLACE(168, -569);
// &vss @WIRE(mode="straight") {#X224:5 %t1121:p};
// %t1122 = $IO_PORT @ATTACH &n34 => @PLACE(198, -556) => @ORIENT("R0");
// %t1122 @TEXT("n34", key="name", size=0.75);
// &n34 @WIRE(mode="straight") {#X225:1 %t1122:p};
// %t1123 = $IO_PORT @ATTACH &n36 => @PLACE(198, -560) => @ORIENT("R0");
// %t1123 @TEXT("n36", key="name", size=0.75);
// &n36 @WIRE(mode="straight") {#X225:2 %t1123:p};
// %t1124 = $IO_PORT @ATTACH &n279 => @PLACE(218, -558) => @ORIENT("MY");
// %t1124 @TEXT("n279", key="name", size=0.75);
// &n279 @WIRE(mode="straight") {#X225:3 %t1124:p};
// %t1125 = $SUPPLY @ATTACH &vdd => @PLACE(208, -547);
// &vdd @WIRE(mode="straight") {#X225:4 %t1125:p};
// %t1126 = $GROUND @ATTACH &vss => @PLACE(208, -569);
// &vss @WIRE(mode="straight") {#X225:5 %t1126:p};
// %t1127 = $IO_PORT @ATTACH &n279 => @PLACE(238, -556) => @ORIENT("R0");
// %t1127 @TEXT("n279", key="name", size=0.75);
// &n279 @WIRE(mode="straight") {#X226:1 %t1127:p};
// %t1128 = $IO_PORT @ATTACH &n256 => @PLACE(238, -560) => @ORIENT("R0");
// %t1128 @TEXT("n256", key="name", size=0.75);
// &n256 @WIRE(mode="straight") {#X226:2 %t1128:p};
// %t1129 = $IO_PORT @ATTACH &n280 => @PLACE(258, -558) => @ORIENT("MY");
// %t1129 @TEXT("n280", key="name", size=0.75);
// &n280 @WIRE(mode="straight") {#X226:3 %t1129:p};
// %t1130 = $SUPPLY @ATTACH &vdd => @PLACE(248, -547);
// &vdd @WIRE(mode="straight") {#X226:4 %t1130:p};
// %t1131 = $GROUND @ATTACH &vss => @PLACE(248, -569);
// &vss @WIRE(mode="straight") {#X226:5 %t1131:p};
// %t1132 = $IO_PORT @ATTACH &n280 => @PLACE(278, -556) => @ORIENT("R0");
// %t1132 @TEXT("n280", key="name", size=0.75);
// &n280 @WIRE(mode="straight") {#X227:1 %t1132:p};
// %t1133 = $IO_PORT @ATTACH &n258 => @PLACE(278, -560) => @ORIENT("R0");
// %t1133 @TEXT("n258", key="name", size=0.75);
// &n258 @WIRE(mode="straight") {#X227:2 %t1133:p};
// %t1134 = $IO_PORT @ATTACH &n281 => @PLACE(298, -558) => @ORIENT("MY");
// %t1134 @TEXT("n281", key="name", size=0.75);
// &n281 @WIRE(mode="straight") {#X227:3 %t1134:p};
// %t1135 = $SUPPLY @ATTACH &vdd => @PLACE(288, -547);
// &vdd @WIRE(mode="straight") {#X227:4 %t1135:p};
// %t1136 = $GROUND @ATTACH &vss => @PLACE(288, -569);
// &vss @WIRE(mode="straight") {#X227:5 %t1136:p};
// %t1137 = $IO_PORT @ATTACH &n236 => @PLACE(158, -589) => @ORIENT("R0");
// %t1137 @TEXT("n236", key="name", size=0.75);
// &n236 @WIRE(mode="straight") {#X228:1 %t1137:p};
// %t1138 = $IO_PORT @ATTACH &n238 => @PLACE(158, -593) => @ORIENT("R0");
// %t1138 @TEXT("n238", key="name", size=0.75);
// &n238 @WIRE(mode="straight") {#X228:2 %t1138:p};
// %t1139 = $IO_PORT @ATTACH &n282 => @PLACE(178, -591) => @ORIENT("MY");
// %t1139 @TEXT("n282", key="name", size=0.75);
// &n282 @WIRE(mode="straight") {#X228:3 %t1139:p};
// %t1140 = $SUPPLY @ATTACH &vdd => @PLACE(168, -580);
// &vdd @WIRE(mode="straight") {#X228:4 %t1140:p};
// %t1141 = $GROUND @ATTACH &vss => @PLACE(168, -602);
// &vss @WIRE(mode="straight") {#X228:5 %t1141:p};
// %t1142 = $IO_PORT @ATTACH &n245 => @PLACE(198, -591) => @ORIENT("R0");
// %t1142 @TEXT("n245", key="name", size=0.75);
// &n245 @WIRE(mode="straight") {#X229:1 %t1142:p};
// %t1143 = $IO_PORT @ATTACH &n239 => @PLACE(218, -591) => @ORIENT("MY");
// %t1143 @TEXT("n239", key="name", size=0.75);
// &n239 @WIRE(mode="straight") {#X229:2 %t1143:p};
// %t1144 = $SUPPLY @ATTACH &vdd => @PLACE(208, -582);
// &vdd @WIRE(mode="straight") {#X229:3 %t1144:p};
// %t1145 = $GROUND @ATTACH &vss => @PLACE(208, -600);
// &vss @WIRE(mode="straight") {#X229:4 %t1145:p};
// %t1146 = $IO_PORT @ATTACH &n249 => @PLACE(238, -591) => @ORIENT("R0");
// %t1146 @TEXT("n249", key="name", size=0.75);
// &n249 @WIRE(mode="straight") {#X230:1 %t1146:p};
// %t1147 = $IO_PORT @ATTACH &n233 => @PLACE(258, -591) => @ORIENT("MY");
// %t1147 @TEXT("n233", key="name", size=0.75);
// &n233 @WIRE(mode="straight") {#X230:2 %t1147:p};
// %t1148 = $SUPPLY @ATTACH &vdd => @PLACE(248, -582);
// &vdd @WIRE(mode="straight") {#X230:3 %t1148:p};
// %t1149 = $GROUND @ATTACH &vss => @PLACE(248, -600);
// &vss @WIRE(mode="straight") {#X230:4 %t1149:p};
// %t1150 = $IO_PORT @ATTACH &n281 => @PLACE(278, -591) => @ORIENT("R0");
// %t1150 @TEXT("n281", key="name", size=0.75);
// &n281 @WIRE(mode="straight") {#X231:1 %t1150:p};
// %t1151 = $IO_PORT @ATTACH &n235 => @PLACE(298, -591) => @ORIENT("MY");
// %t1151 @TEXT("n235", key="name", size=0.75);
// &n235 @WIRE(mode="straight") {#X231:2 %t1151:p};
// %t1152 = $SUPPLY @ATTACH &vdd => @PLACE(288, -582);
// &vdd @WIRE(mode="straight") {#X231:3 %t1152:p};
// %t1153 = $GROUND @ATTACH &vss => @PLACE(288, -600);
// &vss @WIRE(mode="straight") {#X231:4 %t1153:p};
// %t1154 = $IO_PORT @ATTACH &n254 => @PLACE(158, -622) => @ORIENT("R0");
// %t1154 @TEXT("n254", key="name", size=0.75);
// &n254 @WIRE(mode="straight") {#X232:1 %t1154:p};
// %t1155 = $IO_PORT @ATTACH &n236 => @PLACE(178, -622) => @ORIENT("MY");
// %t1155 @TEXT("n236", key="name", size=0.75);
// &n236 @WIRE(mode="straight") {#X232:2 %t1155:p};
// %t1156 = $SUPPLY @ATTACH &vdd => @PLACE(168, -613);
// &vdd @WIRE(mode="straight") {#X232:3 %t1156:p};
// %t1157 = $GROUND @ATTACH &vss => @PLACE(168, -631);
// &vss @WIRE(mode="straight") {#X232:4 %t1157:p};
// %t1158 = $IO_PORT @ATTACH &n259 => @PLACE(198, -622) => @ORIENT("R0");
// %t1158 @TEXT("n259", key="name", size=0.75);
// &n259 @WIRE(mode="straight") {#X233:1 %t1158:p};
// %t1159 = $IO_PORT @ATTACH &n238 => @PLACE(218, -622) => @ORIENT("MY");
// %t1159 @TEXT("n238", key="name", size=0.75);
// &n238 @WIRE(mode="straight") {#X233:2 %t1159:p};
// %t1160 = $SUPPLY @ATTACH &vdd => @PLACE(208, -613);
// &vdd @WIRE(mode="straight") {#X233:3 %t1160:p};
// %t1161 = $GROUND @ATTACH &vss => @PLACE(208, -631);
// &vss @WIRE(mode="straight") {#X233:4 %t1161:p};
// %t1162 = $IO_PORT @ATTACH &n262 => @PLACE(238, -620) => @ORIENT("R0");
// %t1162 @TEXT("n262", key="name", size=0.75);
// &n262 @WIRE(mode="straight") {#X234:1 %t1162:p};
// %t1163 = $IO_PORT @ATTACH &n264 => @PLACE(238, -624) => @ORIENT("R0");
// %t1163 @TEXT("n264", key="name", size=0.75);
// &n264 @WIRE(mode="straight") {#X234:2 %t1163:p};
// %t1164 = $IO_PORT @ATTACH &n283 => @PLACE(258, -622) => @ORIENT("MY");
// %t1164 @TEXT("n283", key="name", size=0.75);
// &n283 @WIRE(mode="straight") {#X234:3 %t1164:p};
// %t1165 = $SUPPLY @ATTACH &vdd => @PLACE(248, -611);
// &vdd @WIRE(mode="straight") {#X234:4 %t1165:p};
// %t1166 = $GROUND @ATTACH &vss => @PLACE(248, -633);
// &vss @WIRE(mode="straight") {#X234:5 %t1166:p};
// %t1167 = $IO_PORT @ATTACH &n283 => @PLACE(278, -620) => @ORIENT("R0");
// %t1167 @TEXT("n283", key="name", size=0.75);
// &n283 @WIRE(mode="straight") {#X235:1 %t1167:p};
// %t1168 = $IO_PORT @ATTACH &n271 => @PLACE(278, -624) => @ORIENT("R0");
// %t1168 @TEXT("n271", key="name", size=0.75);
// &n271 @WIRE(mode="straight") {#X235:2 %t1168:p};
// %t1169 = $IO_PORT @ATTACH &n284 => @PLACE(298, -622) => @ORIENT("MY");
// %t1169 @TEXT("n284", key="name", size=0.75);
// &n284 @WIRE(mode="straight") {#X235:3 %t1169:p};
// %t1170 = $SUPPLY @ATTACH &vdd => @PLACE(288, -611);
// &vdd @WIRE(mode="straight") {#X235:4 %t1170:p};
// %t1171 = $GROUND @ATTACH &vss => @PLACE(288, -633);
// &vss @WIRE(mode="straight") {#X235:5 %t1171:p};
// %t1172 = $IO_PORT @ATTACH &n284 => @PLACE(158, -653) => @ORIENT("R0");
// %t1172 @TEXT("n284", key="name", size=0.75);
// &n284 @WIRE(mode="straight") {#X236:1 %t1172:p};
// %t1173 = $IO_PORT @ATTACH &n277 => @PLACE(158, -657) => @ORIENT("R0");
// %t1173 @TEXT("n277", key="name", size=0.75);
// &n277 @WIRE(mode="straight") {#X236:2 %t1173:p};
// %t1174 = $IO_PORT @ATTACH &n285 => @PLACE(178, -655) => @ORIENT("MY");
// %t1174 @TEXT("n285", key="name", size=0.75);
// &n285 @WIRE(mode="straight") {#X236:3 %t1174:p};
// %t1175 = $SUPPLY @ATTACH &vdd => @PLACE(168, -644);
// &vdd @WIRE(mode="straight") {#X236:4 %t1175:p};
// %t1176 = $GROUND @ATTACH &vss => @PLACE(168, -666);
// &vss @WIRE(mode="straight") {#X236:5 %t1176:p};
// %t1177 = $IO_PORT @ATTACH &vss => @PLACE(198, -651) => @ORIENT("R0");
// %t1177 @TEXT("vss", key="name", size=0.75);
// &vss @WIRE(mode="straight") {#X237:1 %t1177:p};
// %t1178 = $IO_PORT @ATTACH &n239 => @PLACE(198, -655) => @ORIENT("R0");
// %t1178 @TEXT("n239", key="name", size=0.75);
// &n239 @WIRE(mode="straight") {#X237:2 %t1178:p};
// %t1179 = $IO_PORT @ATTACH &active => @PLACE(198, -659) => @ORIENT("R0");
// %t1179 @TEXT("active", key="name", size=0.75);
// &active @WIRE(mode="straight") {#X237:3 %t1179:p};
// %t1180 = $IO_PORT @ATTACH &n32 => @PLACE(218, -655) => @ORIENT("MY");
// %t1180 @TEXT("n32", key="name", size=0.75);
// &n32 @WIRE(mode="straight") {#X237:4 %t1180:p};
// %t1181 = $SUPPLY @ATTACH &vdd => @PLACE(208, -642);
// &vdd @WIRE(mode="straight") {#X237:5 %t1181:p};
// %t1182 = $GROUND @ATTACH &vss => @PLACE(208, -668);
// &vss @WIRE(mode="straight") {#X237:6 %t1182:p};
// %t1183 = $IO_PORT @ATTACH &vss => @PLACE(238, -651) => @ORIENT("R0");
// %t1183 @TEXT("vss", key="name", size=0.75);
// &vss @WIRE(mode="straight") {#X238:1 %t1183:p};
// %t1184 = $IO_PORT @ATTACH &n240 => @PLACE(238, -655) => @ORIENT("R0");
// %t1184 @TEXT("n240", key="name", size=0.75);
// &n240 @WIRE(mode="straight") {#X238:2 %t1184:p};
// %t1185 = $IO_PORT @ATTACH &active => @PLACE(238, -659) => @ORIENT("R0");
// %t1185 @TEXT("active", key="name", size=0.75);
// &active @WIRE(mode="straight") {#X238:3 %t1185:p};
// %t1186 = $IO_PORT @ATTACH &n33 => @PLACE(258, -655) => @ORIENT("MY");
// %t1186 @TEXT("n33", key="name", size=0.75);
// &n33 @WIRE(mode="straight") {#X238:4 %t1186:p};
// %t1187 = $SUPPLY @ATTACH &vdd => @PLACE(248, -642);
// &vdd @WIRE(mode="straight") {#X238:5 %t1187:p};
// %t1188 = $GROUND @ATTACH &vss => @PLACE(248, -668);
// &vss @WIRE(mode="straight") {#X238:6 %t1188:p};
// %t1189 = $IO_PORT @ATTACH &vss => @PLACE(278, -651) => @ORIENT("R0");
// %t1189 @TEXT("vss", key="name", size=0.75);
// &vss @WIRE(mode="straight") {#X239:1 %t1189:p};
// %t1190 = $IO_PORT @ATTACH &n226 => @PLACE(278, -655) => @ORIENT("R0");
// %t1190 @TEXT("n226", key="name", size=0.75);
// &n226 @WIRE(mode="straight") {#X239:2 %t1190:p};
// %t1191 = $IO_PORT @ATTACH &active => @PLACE(278, -659) => @ORIENT("R0");
// %t1191 @TEXT("active", key="name", size=0.75);
// &active @WIRE(mode="straight") {#X239:3 %t1191:p};
// %t1192 = $IO_PORT @ATTACH &n35 => @PLACE(298, -655) => @ORIENT("MY");
// %t1192 @TEXT("n35", key="name", size=0.75);
// &n35 @WIRE(mode="straight") {#X239:4 %t1192:p};
// %t1193 = $SUPPLY @ATTACH &vdd => @PLACE(288, -642);
// &vdd @WIRE(mode="straight") {#X239:5 %t1193:p};
// %t1194 = $GROUND @ATTACH &vss => @PLACE(288, -668);
// &vss @WIRE(mode="straight") {#X239:6 %t1194:p};
// %t1195 = $IO_PORT @ATTACH &vss => @PLACE(326, -484) => @ORIENT("R0");
// %t1195 @TEXT("vss", key="name", size=0.75);
// &vss @WIRE(mode="straight") {#X240:1 %t1195:p};
// %t1196 = $IO_PORT @ATTACH &n227 => @PLACE(326, -488) => @ORIENT("R0");
// %t1196 @TEXT("n227", key="name", size=0.75);
// &n227 @WIRE(mode="straight") {#X240:2 %t1196:p};
// %t1197 = $IO_PORT @ATTACH &active => @PLACE(326, -492) => @ORIENT("R0");
// %t1197 @TEXT("active", key="name", size=0.75);
// &active @WIRE(mode="straight") {#X240:3 %t1197:p};
// %t1198 = $IO_PORT @ATTACH &n37 => @PLACE(346, -488) => @ORIENT("MY");
// %t1198 @TEXT("n37", key="name", size=0.75);
// &n37 @WIRE(mode="straight") {#X240:4 %t1198:p};
// %t1199 = $SUPPLY @ATTACH &vdd => @PLACE(336, -475);
// &vdd @WIRE(mode="straight") {#X240:5 %t1199:p};
// %t1200 = $GROUND @ATTACH &vss => @PLACE(336, -501);
// &vss @WIRE(mode="straight") {#X240:6 %t1200:p};
// %t1201 = $IO_PORT @ATTACH &vss => @PLACE(366, -484) => @ORIENT("R0");
// %t1201 @TEXT("vss", key="name", size=0.75);
// &vss @WIRE(mode="straight") {#X241:1 %t1201:p};
// %t1202 = $IO_PORT @ATTACH &n228 => @PLACE(366, -488) => @ORIENT("R0");
// %t1202 @TEXT("n228", key="name", size=0.75);
// &n228 @WIRE(mode="straight") {#X241:2 %t1202:p};
// %t1203 = $IO_PORT @ATTACH &active => @PLACE(366, -492) => @ORIENT("R0");
// %t1203 @TEXT("active", key="name", size=0.75);
// &active @WIRE(mode="straight") {#X241:3 %t1203:p};
// %t1204 = $IO_PORT @ATTACH &n39 => @PLACE(386, -488) => @ORIENT("MY");
// %t1204 @TEXT("n39", key="name", size=0.75);
// &n39 @WIRE(mode="straight") {#X241:4 %t1204:p};
// %t1205 = $SUPPLY @ATTACH &vdd => @PLACE(376, -475);
// &vdd @WIRE(mode="straight") {#X241:5 %t1205:p};
// %t1206 = $GROUND @ATTACH &vss => @PLACE(376, -501);
// &vss @WIRE(mode="straight") {#X241:6 %t1206:p};
// %t1207 = $IO_PORT @ATTACH &vss => @PLACE(406, -484) => @ORIENT("R0");
// %t1207 @TEXT("vss", key="name", size=0.75);
// &vss @WIRE(mode="straight") {#X242:1 %t1207:p};
// %t1208 = $IO_PORT @ATTACH &n229 => @PLACE(406, -488) => @ORIENT("R0");
// %t1208 @TEXT("n229", key="name", size=0.75);
// &n229 @WIRE(mode="straight") {#X242:2 %t1208:p};
// %t1209 = $IO_PORT @ATTACH &active => @PLACE(406, -492) => @ORIENT("R0");
// %t1209 @TEXT("active", key="name", size=0.75);
// &active @WIRE(mode="straight") {#X242:3 %t1209:p};
// %t1210 = $IO_PORT @ATTACH &n41 => @PLACE(426, -488) => @ORIENT("MY");
// %t1210 @TEXT("n41", key="name", size=0.75);
// &n41 @WIRE(mode="straight") {#X242:4 %t1210:p};
// %t1211 = $SUPPLY @ATTACH &vdd => @PLACE(416, -475);
// &vdd @WIRE(mode="straight") {#X242:5 %t1211:p};
// %t1212 = $GROUND @ATTACH &vss => @PLACE(416, -501);
// &vss @WIRE(mode="straight") {#X242:6 %t1212:p};
// %t1213 = $IO_PORT @ATTACH &vss => @PLACE(446, -484) => @ORIENT("R0");
// %t1213 @TEXT("vss", key="name", size=0.75);
// &vss @WIRE(mode="straight") {#X243:1 %t1213:p};
// %t1214 = $IO_PORT @ATTACH &n230 => @PLACE(446, -488) => @ORIENT("R0");
// %t1214 @TEXT("n230", key="name", size=0.75);
// &n230 @WIRE(mode="straight") {#X243:2 %t1214:p};
// %t1215 = $IO_PORT @ATTACH &active => @PLACE(446, -492) => @ORIENT("R0");
// %t1215 @TEXT("active", key="name", size=0.75);
// &active @WIRE(mode="straight") {#X243:3 %t1215:p};
// %t1216 = $IO_PORT @ATTACH &n43 => @PLACE(466, -488) => @ORIENT("MY");
// %t1216 @TEXT("n43", key="name", size=0.75);
// &n43 @WIRE(mode="straight") {#X243:4 %t1216:p};
// %t1217 = $SUPPLY @ATTACH &vdd => @PLACE(456, -475);
// &vdd @WIRE(mode="straight") {#X243:5 %t1217:p};
// %t1218 = $GROUND @ATTACH &vss => @PLACE(456, -501);
// &vss @WIRE(mode="straight") {#X243:6 %t1218:p};
// %t1219 = $IO_PORT @ATTACH &vss => @PLACE(326, -519) => @ORIENT("R0");
// %t1219 @TEXT("vss", key="name", size=0.75);
// &vss @WIRE(mode="straight") {#X244:1 %t1219:p};
// %t1220 = $IO_PORT @ATTACH &n231 => @PLACE(326, -523) => @ORIENT("R0");
// %t1220 @TEXT("n231", key="name", size=0.75);
// &n231 @WIRE(mode="straight") {#X244:2 %t1220:p};
// %t1221 = $IO_PORT @ATTACH &active => @PLACE(326, -527) => @ORIENT("R0");
// %t1221 @TEXT("active", key="name", size=0.75);
// &active @WIRE(mode="straight") {#X244:3 %t1221:p};
// %t1222 = $IO_PORT @ATTACH &n45 => @PLACE(346, -523) => @ORIENT("MY");
// %t1222 @TEXT("n45", key="name", size=0.75);
// &n45 @WIRE(mode="straight") {#X244:4 %t1222:p};
// %t1223 = $SUPPLY @ATTACH &vdd => @PLACE(336, -510);
// &vdd @WIRE(mode="straight") {#X244:5 %t1223:p};
// %t1224 = $GROUND @ATTACH &vss => @PLACE(336, -536);
// &vss @WIRE(mode="straight") {#X244:6 %t1224:p};
// %t1225 = $IO_PORT @ATTACH &vss => @PLACE(366, -519) => @ORIENT("R0");
// %t1225 @TEXT("vss", key="name", size=0.75);
// &vss @WIRE(mode="straight") {#X245:1 %t1225:p};
// %t1226 = $IO_PORT @ATTACH &n232 => @PLACE(366, -523) => @ORIENT("R0");
// %t1226 @TEXT("n232", key="name", size=0.75);
// &n232 @WIRE(mode="straight") {#X245:2 %t1226:p};
// %t1227 = $IO_PORT @ATTACH &active => @PLACE(366, -527) => @ORIENT("R0");
// %t1227 @TEXT("active", key="name", size=0.75);
// &active @WIRE(mode="straight") {#X245:3 %t1227:p};
// %t1228 = $IO_PORT @ATTACH &n47 => @PLACE(386, -523) => @ORIENT("MY");
// %t1228 @TEXT("n47", key="name", size=0.75);
// &n47 @WIRE(mode="straight") {#X245:4 %t1228:p};
// %t1229 = $SUPPLY @ATTACH &vdd => @PLACE(376, -510);
// &vdd @WIRE(mode="straight") {#X245:5 %t1229:p};
// %t1230 = $GROUND @ATTACH &vss => @PLACE(376, -536);
// &vss @WIRE(mode="straight") {#X245:6 %t1230:p};
// %t1231 = $IO_PORT @ATTACH &n285 => @PLACE(406, -519) => @ORIENT("R0");
// %t1231 @TEXT("n285", key="name", size=0.75);
// &n285 @WIRE(mode="straight") {#X246:1 %t1231:p};
// %t1232 = $IO_PORT @ATTACH &nx => @PLACE(406, -523) => @ORIENT("R0");
// %t1232 @TEXT("nx", key="name", size=0.75);
// &nx @WIRE(mode="straight") {#X246:2 %t1232:p};
// %t1233 = $IO_PORT @ATTACH &n245 => @PLACE(406, -527) => @ORIENT("R0");
// %t1233 @TEXT("n245", key="name", size=0.75);
// &n245 @WIRE(mode="straight") {#X246:3 %t1233:p};
// %t1234 = $IO_PORT @ATTACH &n286 => @PLACE(426, -523) => @ORIENT("MY");
// %t1234 @TEXT("n286", key="name", size=0.75);
// &n286 @WIRE(mode="straight") {#X246:4 %t1234:p};
// %t1235 = $SUPPLY @ATTACH &vdd => @PLACE(416, -510);
// &vdd @WIRE(mode="straight") {#X246:5 %t1235:p};
// %t1236 = $GROUND @ATTACH &vss => @PLACE(416, -536);
// &vss @WIRE(mode="straight") {#X246:6 %t1236:p};
// %t1237 = $IO_PORT @ATTACH &vss => @PLACE(446, -519) => @ORIENT("R0");
// %t1237 @TEXT("vss", key="name", size=0.75);
// &vss @WIRE(mode="straight") {#X247:1 %t1237:p};
// %t1238 = $IO_PORT @ATTACH &n286 => @PLACE(446, -523) => @ORIENT("R0");
// %t1238 @TEXT("n286", key="name", size=0.75);
// &n286 @WIRE(mode="straight") {#X247:2 %t1238:p};
// %t1239 = $IO_PORT @ATTACH &active => @PLACE(446, -527) => @ORIENT("R0");
// %t1239 @TEXT("active", key="name", size=0.75);
// &active @WIRE(mode="straight") {#X247:3 %t1239:p};
// %t1240 = $IO_PORT @ATTACH &n53 => @PLACE(466, -523) => @ORIENT("MY");
// %t1240 @TEXT("n53", key="name", size=0.75);
// &n53 @WIRE(mode="straight") {#X247:4 %t1240:p};
// %t1241 = $SUPPLY @ATTACH &vdd => @PLACE(456, -510);
// &vdd @WIRE(mode="straight") {#X247:5 %t1241:p};
// %t1242 = $GROUND @ATTACH &vss => @PLACE(456, -536);
// &vss @WIRE(mode="straight") {#X247:6 %t1242:p};
// %t1243 = $IO_PORT @ATTACH &vdd => @PLACE(326, -554) => @ORIENT("R0");
// %t1243 @TEXT("vdd", key="name", size=0.75);
// &vdd @WIRE(mode="straight") {#X248:1 %t1243:p};
// %t1244 = $IO_PORT @ATTACH &n287 => @PLACE(326, -558) => @ORIENT("R0");
// %t1244 @TEXT("n287", key="name", size=0.75);
// &n287 @WIRE(mode="straight") {#X248:2 %t1244:p};
// %t1245 = $IO_PORT @ATTACH &active => @PLACE(326, -562) => @ORIENT("R0");
// %t1245 @TEXT("active", key="name", size=0.75);
// &active @WIRE(mode="straight") {#X248:3 %t1245:p};
// %t1246 = $IO_PORT @ATTACH &n49 => @PLACE(346, -558) => @ORIENT("MY");
// %t1246 @TEXT("n49", key="name", size=0.75);
// &n49 @WIRE(mode="straight") {#X248:4 %t1246:p};
// %t1247 = $SUPPLY @ATTACH &vdd => @PLACE(336, -545);
// &vdd @WIRE(mode="straight") {#X248:5 %t1247:p};
// %t1248 = $GROUND @ATTACH &vss => @PLACE(336, -571);
// &vss @WIRE(mode="straight") {#X248:6 %t1248:p};
// %t1249 = $IO_PORT @ATTACH &vss => @PLACE(366, -554) => @ORIENT("R0");
// %t1249 @TEXT("vss", key="name", size=0.75);
// &vss @WIRE(mode="straight") {#X249:1 %t1249:p};
// %t1250 = $IO_PORT @ATTACH &n288 => @PLACE(366, -558) => @ORIENT("R0");
// %t1250 @TEXT("n288", key="name", size=0.75);
// &n288 @WIRE(mode="straight") {#X249:2 %t1250:p};
// %t1251 = $IO_PORT @ATTACH &active => @PLACE(366, -562) => @ORIENT("R0");
// %t1251 @TEXT("active", key="name", size=0.75);
// &active @WIRE(mode="straight") {#X249:3 %t1251:p};
// %t1252 = $IO_PORT @ATTACH &n51 => @PLACE(386, -558) => @ORIENT("MY");
// %t1252 @TEXT("n51", key="name", size=0.75);
// &n51 @WIRE(mode="straight") {#X249:4 %t1252:p};
// %t1253 = $SUPPLY @ATTACH &vdd => @PLACE(376, -545);
// &vdd @WIRE(mode="straight") {#X249:5 %t1253:p};
// %t1254 = $GROUND @ATTACH &vss => @PLACE(376, -571);
// &vss @WIRE(mode="straight") {#X249:6 %t1254:p};
// %t1255 = $IO_PORT @ATTACH &target_k2 => @PLACE(406, -558) => @ORIENT("R0");
// %t1255 @TEXT("target_k2", key="name", size=0.75);
// &target_k2 @WIRE(mode="straight") {#X250:1 %t1255:p};
// %t1256 = $IO_PORT @ATTACH &n130 => @PLACE(426, -558) => @ORIENT("MY");
// %t1256 @TEXT("n130", key="name", size=0.75);
// &n130 @WIRE(mode="straight") {#X250:2 %t1256:p};
// %t1257 = $SUPPLY @ATTACH &vdd => @PLACE(416, -549);
// &vdd @WIRE(mode="straight") {#X250:3 %t1257:p};
// %t1258 = $GROUND @ATTACH &vss => @PLACE(416, -567);
// &vss @WIRE(mode="straight") {#X250:4 %t1258:p};
// %t1259 = $IO_PORT @ATTACH &target_k3 => @PLACE(446, -558) => @ORIENT("R0");
// %t1259 @TEXT("target_k3", key="name", size=0.75);
// &target_k3 @WIRE(mode="straight") {#X251:1 %t1259:p};
// %t1260 = $IO_PORT @ATTACH &n133 => @PLACE(466, -558) => @ORIENT("MY");
// %t1260 @TEXT("n133", key="name", size=0.75);
// &n133 @WIRE(mode="straight") {#X251:2 %t1260:p};
// %t1261 = $SUPPLY @ATTACH &vdd => @PLACE(456, -549);
// &vdd @WIRE(mode="straight") {#X251:3 %t1261:p};
// %t1262 = $GROUND @ATTACH &vss => @PLACE(456, -567);
// &vss @WIRE(mode="straight") {#X251:4 %t1262:p};
// %t1263 = $IO_PORT @ATTACH &target_k4 => @PLACE(326, -591) => @ORIENT("R0");
// %t1263 @TEXT("target_k4", key="name", size=0.75);
// &target_k4 @WIRE(mode="straight") {#X252:1 %t1263:p};
// %t1264 = $IO_PORT @ATTACH &n100 => @PLACE(346, -591) => @ORIENT("MY");
// %t1264 @TEXT("n100", key="name", size=0.75);
// &n100 @WIRE(mode="straight") {#X252:2 %t1264:p};
// %t1265 = $SUPPLY @ATTACH &vdd => @PLACE(336, -582);
// &vdd @WIRE(mode="straight") {#X252:3 %t1265:p};
// %t1266 = $GROUND @ATTACH &vss => @PLACE(336, -600);
// &vss @WIRE(mode="straight") {#X252:4 %t1266:p};
// %t1267 = $IO_PORT @ATTACH &target_k5 => @PLACE(366, -591) => @ORIENT("R0");
// %t1267 @TEXT("target_k5", key="name", size=0.75);
// &target_k5 @WIRE(mode="straight") {#X253:1 %t1267:p};
// %t1268 = $IO_PORT @ATTACH &n99 => @PLACE(386, -591) => @ORIENT("MY");
// %t1268 @TEXT("n99", key="name", size=0.75);
// &n99 @WIRE(mode="straight") {#X253:2 %t1268:p};
// %t1269 = $SUPPLY @ATTACH &vdd => @PLACE(376, -582);
// &vdd @WIRE(mode="straight") {#X253:3 %t1269:p};
// %t1270 = $GROUND @ATTACH &vss => @PLACE(376, -600);
// &vss @WIRE(mode="straight") {#X253:4 %t1270:p};
// %t1271 = $IO_PORT @ATTACH &n222 => @PLACE(406, -591) => @ORIENT("R0");
// %t1271 @TEXT("n222", key="name", size=0.75);
// &n222 @WIRE(mode="straight") {#X254:1 %t1271:p};
// %t1272 = $IO_PORT @ATTACH &n261 => @PLACE(426, -591) => @ORIENT("MY");
// %t1272 @TEXT("n261", key="name", size=0.75);
// &n261 @WIRE(mode="straight") {#X254:2 %t1272:p};
// %t1273 = $SUPPLY @ATTACH &vdd => @PLACE(416, -582);
// &vdd @WIRE(mode="straight") {#X254:3 %t1273:p};
// %t1274 = $GROUND @ATTACH &vss => @PLACE(416, -600);
// &vss @WIRE(mode="straight") {#X254:4 %t1274:p};
// %t1275 = $IO_PORT @ATTACH &n225 => @PLACE(446, -591) => @ORIENT("R0");
// %t1275 @TEXT("n225", key="name", size=0.75);
// &n225 @WIRE(mode="straight") {#X255:1 %t1275:p};
// %t1276 = $IO_PORT @ATTACH &n270 => @PLACE(466, -591) => @ORIENT("MY");
// %t1276 @TEXT("n270", key="name", size=0.75);
// &n270 @WIRE(mode="straight") {#X255:2 %t1276:p};
// %t1277 = $SUPPLY @ATTACH &vdd => @PLACE(456, -582);
// &vdd @WIRE(mode="straight") {#X255:3 %t1277:p};
// %t1278 = $GROUND @ATTACH &vss => @PLACE(456, -600);
// &vss @WIRE(mode="straight") {#X255:4 %t1278:p};
// %t1279 = $IO_PORT @ATTACH &n147 => @PLACE(326, -622) => @ORIENT("R0");
// %t1279 @TEXT("n147", key="name", size=0.75);
// &n147 @WIRE(mode="straight") {#X256:1 %t1279:p};
// %t1280 = $IO_PORT @ATTACH &n223 => @PLACE(346, -622) => @ORIENT("MY");
// %t1280 @TEXT("n223", key="name", size=0.75);
// &n223 @WIRE(mode="straight") {#X256:2 %t1280:p};
// %t1281 = $SUPPLY @ATTACH &vdd => @PLACE(336, -613);
// &vdd @WIRE(mode="straight") {#X256:3 %t1281:p};
// %t1282 = $GROUND @ATTACH &vss => @PLACE(336, -631);
// &vss @WIRE(mode="straight") {#X256:4 %t1282:p};
// %t1283 = $IO_PORT @ATTACH &n189 => @PLACE(366, -622) => @ORIENT("R0");
// %t1283 @TEXT("n189", key="name", size=0.75);
// &n189 @WIRE(mode="straight") {#X257:1 %t1283:p};
// %t1284 = $IO_PORT @ATTACH &n276 => @PLACE(386, -622) => @ORIENT("MY");
// %t1284 @TEXT("n276", key="name", size=0.75);
// &n276 @WIRE(mode="straight") {#X257:2 %t1284:p};
// %t1285 = $SUPPLY @ATTACH &vdd => @PLACE(376, -613);
// &vdd @WIRE(mode="straight") {#X257:3 %t1285:p};
// %t1286 = $GROUND @ATTACH &vss => @PLACE(376, -631);
// &vss @WIRE(mode="straight") {#X257:4 %t1286:p};
// %t1287 = $IO_PORT @ATTACH &n34 => @PLACE(406, -622) => @ORIENT("R0");
// %t1287 @TEXT("n34", key="name", size=0.75);
// &n34 @WIRE(mode="straight") {#X258:1 %t1287:p};
// %t1288 = $IO_PORT @ATTACH &n240 => @PLACE(426, -622) => @ORIENT("MY");
// %t1288 @TEXT("n240", key="name", size=0.75);
// &n240 @WIRE(mode="straight") {#X258:2 %t1288:p};
// %t1289 = $SUPPLY @ATTACH &vdd => @PLACE(416, -613);
// &vdd @WIRE(mode="straight") {#X258:3 %t1289:p};
// %t1290 = $GROUND @ATTACH &vss => @PLACE(416, -631);
// &vss @WIRE(mode="straight") {#X258:4 %t1290:p};
// %t1291 = $IO_PORT @ATTACH &n36 => @PLACE(446, -622) => @ORIENT("R0");
// %t1291 @TEXT("n36", key="name", size=0.75);
// &n36 @WIRE(mode="straight") {#X259:1 %t1291:p};
// %t1292 = $IO_PORT @ATTACH &n255 => @PLACE(466, -622) => @ORIENT("MY");
// %t1292 @TEXT("n255", key="name", size=0.75);
// &n255 @WIRE(mode="straight") {#X259:2 %t1292:p};
// %t1293 = $SUPPLY @ATTACH &vdd => @PLACE(456, -613);
// &vdd @WIRE(mode="straight") {#X259:3 %t1293:p};
// %t1294 = $GROUND @ATTACH &vss => @PLACE(456, -631);
// &vss @WIRE(mode="straight") {#X259:4 %t1294:p};
// %t1295 = $IO_PORT @ATTACH &n38 => @PLACE(326, -655) => @ORIENT("R0");
// %t1295 @TEXT("n38", key="name", size=0.75);
// &n38 @WIRE(mode="straight") {#X260:1 %t1295:p};
// %t1296 = $IO_PORT @ATTACH &n246 => @PLACE(346, -655) => @ORIENT("MY");
// %t1296 @TEXT("n246", key="name", size=0.75);
// &n246 @WIRE(mode="straight") {#X260:2 %t1296:p};
// %t1297 = $SUPPLY @ATTACH &vdd => @PLACE(336, -646);
// &vdd @WIRE(mode="straight") {#X260:3 %t1297:p};
// %t1298 = $GROUND @ATTACH &vss => @PLACE(336, -664);
// &vss @WIRE(mode="straight") {#X260:4 %t1298:p};
// %t1299 = $IO_PORT @ATTACH &n44 => @PLACE(366, -655) => @ORIENT("R0");
// %t1299 @TEXT("n44", key="name", size=0.75);
// &n44 @WIRE(mode="straight") {#X261:1 %t1299:p};
// %t1300 = $IO_PORT @ATTACH &n250 => @PLACE(386, -655) => @ORIENT("MY");
// %t1300 @TEXT("n250", key="name", size=0.75);
// &n250 @WIRE(mode="straight") {#X261:2 %t1300:p};
// %t1301 = $SUPPLY @ATTACH &vdd => @PLACE(376, -646);
// &vdd @WIRE(mode="straight") {#X261:3 %t1301:p};
// %t1302 = $GROUND @ATTACH &vss => @PLACE(376, -664);
// &vss @WIRE(mode="straight") {#X261:4 %t1302:p};
// %t1303 = $IO_PORT @ATTACH &nx => @PLACE(406, -651) => @ORIENT("R0");
// %t1303 @TEXT("nx", key="name", size=0.75);
// &nx @WIRE(mode="straight") {#X262:1 %t1303:p};
// %t1304 = $IO_PORT @ATTACH &n233 => @PLACE(406, -655) => @ORIENT("R0");
// %t1304 @TEXT("n233", key="name", size=0.75);
// &n233 @WIRE(mode="straight") {#X262:2 %t1304:p};
// %t1305 = $IO_PORT @ATTACH &n278 => @PLACE(406, -659) => @ORIENT("R0");
// %t1305 @TEXT("n278", key="name", size=0.75);
// &n278 @WIRE(mode="straight") {#X262:3 %t1305:p};
// %t1306 = $IO_PORT @ATTACH &n287 => @PLACE(426, -655) => @ORIENT("MY");
// %t1306 @TEXT("n287", key="name", size=0.75);
// &n287 @WIRE(mode="straight") {#X262:4 %t1306:p};
// %t1307 = $SUPPLY @ATTACH &vdd => @PLACE(416, -642);
// &vdd @WIRE(mode="straight") {#X262:5 %t1307:p};
// %t1308 = $GROUND @ATTACH &vss => @PLACE(416, -668);
// &vss @WIRE(mode="straight") {#X262:6 %t1308:p};
// %t1309 = $IO_PORT @ATTACH &nx => @PLACE(446, -651) => @ORIENT("R0");
// %t1309 @TEXT("nx", key="name", size=0.75);
// &nx @WIRE(mode="straight") {#X263:1 %t1309:p};
// %t1310 = $IO_PORT @ATTACH &n238 => @PLACE(446, -655) => @ORIENT("R0");
// %t1310 @TEXT("n238", key="name", size=0.75);
// &n238 @WIRE(mode="straight") {#X263:2 %t1310:p};
// %t1311 = $IO_PORT @ATTACH &n282 => @PLACE(446, -659) => @ORIENT("R0");
// %t1311 @TEXT("n282", key="name", size=0.75);
// &n282 @WIRE(mode="straight") {#X263:3 %t1311:p};
// %t1312 = $IO_PORT @ATTACH &n288 => @PLACE(466, -655) => @ORIENT("MY");
// %t1312 @TEXT("n288", key="name", size=0.75);
// &n288 @WIRE(mode="straight") {#X263:4 %t1312:p};
// %t1313 = $SUPPLY @ATTACH &vdd => @PLACE(456, -642);
// &vdd @WIRE(mode="straight") {#X263:5 %t1313:p};
// %t1314 = $GROUND @ATTACH &vss => @PLACE(456, -668);
// &vss @WIRE(mode="straight") {#X263:6 %t1314:p};
// (-16, -45) @TEXT("80  Watchdog | 264 instances", size=1.2, halign="start");
// (-16, -49) @TEXT("Same-name tags connect locally. Open blocks for transistor details.", size=0.8, halign="start");
// }
ends tx_frequency_watchdog_pdk110_80
