// Ring latch | frozen callback110 / recenter109 | RNL 0.3
// @RNL(type="header") { @VERSION("0.3"); @USE-PACKAGE(name="rnl-std-fill") {} }
simulator lang=spectre
subckt ring_inv_latch_v14_pdk110_34 (d ck ckb qb vdd vss)
XT (d x ck ckb vdd vss) pll_tg_pdk110_16
XO (x qb vdd vss) pll_inv_pdk110_27
XFI (qb fb vdd vss) pll_inv_pdk110_29
XFB (fb x ckb ck vdd vss) pll_tg_pdk110_35
// @RNL(author="manual-schematic126") {
// $CELL = @DEFINE-SYMBOL {
// @LINE {(-6, 8) (6, 8) (6, -8) (-6, -8) (-6, 8)};
// (-8, 4) @PIN(terminal="d", direction="left");
// @LINE {(-8, 4) (-6, 4)};
// (-5.4, 4) @TEXT("d", size=0.7, halign="start");
// (-8, 0) @PIN(terminal="ck", direction="left");
// @LINE {(-8, 0) (-6, 0)};
// (-5.4, 0) @TEXT("ck", size=0.7, halign="start");
// (-8, -4) @PIN(terminal="ckb", direction="left");
// @LINE {(-8, -4) (-6, -4)};
// (-5.4, -4) @TEXT("ckb", size=0.7, halign="start");
// (8, 0) @PIN(terminal="qb", direction="right");
// @LINE {(8, 0) (6, 0)};
// (5.4, 0) @TEXT("qb", size=0.7, halign="end");
// (0, 10) @PIN(terminal="vdd", direction="up");
// @LINE {(0, 10) (0, 8)};
// (0, -10) @PIN(terminal="vss", direction="down");
// @LINE {(0, -10) (0, -8)};
// ? @TEXT("${name}", key="name", size=1, halign="middle") => @PLACE(8, 11.5);
// (0, 7.1) @TEXT("Ring latch", size=0.85, halign="middle");
// };
// # @SET-SYMBOL $CELL;
// #XT @PLACE(0, 0) => @ORIENT("R0");
// #XO @PLACE(40, 0) => @ORIENT("R0");
// #XFI @PLACE(80, 0) => @ORIENT("R0");
// #XFB @PLACE(40, -35) => @ORIENT("R0");
// &x @WIRE(mode="straight") {#XT:2 (20, 0) (20, 0) #XO:1};
// &qb @WIRE(mode="straight") {#XO:2 (60, 0) (60, 0) #XFI:1};
// &fb @WIRE(mode="straight") {#XFI:2 (88, -20) (32, -20) #XFB:1};
// &x @WIRE(mode="straight") {#XFB:2 (55, -35) (55, -55) (20, -55) (20, 0) #XT:2};
// %t1 = $IO_PORT @ATTACH &d => @PLACE(-11, 4) => @ORIENT("R0");
// %t1 @TEXT("d", key="name", size=0.75);
// &d @WIRE(mode="straight") {#XT:1 %t1:p};
// %t2 = $IO_PORT @ATTACH &ck => @PLACE(-11, 0) => @ORIENT("R0");
// %t2 @TEXT("ck", key="name", size=0.75);
// &ck @WIRE(mode="straight") {#XT:3 %t2:p};
// %t3 = $IO_PORT @ATTACH &ckb => @PLACE(-11, -4) => @ORIENT("R0");
// %t3 @TEXT("ckb", key="name", size=0.75);
// &ckb @WIRE(mode="straight") {#XT:4 %t3:p};
// %t4 = $SUPPLY @ATTACH &vdd => @PLACE(0, 13);
// &vdd @WIRE(mode="straight") {#XT:5 %t4:p};
// %t5 = $GROUND @ATTACH &vss => @PLACE(0, -13);
// &vss @WIRE(mode="straight") {#XT:6 %t5:p};
// %t6 = $SUPPLY @ATTACH &vdd => @PLACE(40, 9);
// &vdd @WIRE(mode="straight") {#XO:3 %t6:p};
// %t7 = $GROUND @ATTACH &vss => @PLACE(40, -9);
// &vss @WIRE(mode="straight") {#XO:4 %t7:p};
// %t8 = $SUPPLY @ATTACH &vdd => @PLACE(80, 9);
// &vdd @WIRE(mode="straight") {#XFI:3 %t8:p};
// %t9 = $GROUND @ATTACH &vss => @PLACE(80, -9);
// &vss @WIRE(mode="straight") {#XFI:4 %t9:p};
// %t10 = $IO_PORT @ATTACH &ckb => @PLACE(29, -35) => @ORIENT("R0");
// %t10 @TEXT("ckb", key="name", size=0.75);
// &ckb @WIRE(mode="straight") {#XFB:3 %t10:p};
// %t11 = $IO_PORT @ATTACH &ck => @PLACE(29, -39) => @ORIENT("R0");
// %t11 @TEXT("ck", key="name", size=0.75);
// &ck @WIRE(mode="straight") {#XFB:4 %t11:p};
// %t12 = $SUPPLY @ATTACH &vdd => @PLACE(40, -22);
// &vdd @WIRE(mode="straight") {#XFB:5 %t12:p};
// %t13 = $GROUND @ATTACH &vss => @PLACE(40, -48);
// &vss @WIRE(mode="straight") {#XFB:6 %t13:p};
// %t14 = $IO_PORT @ATTACH &qb => @PLACE(51, 0) => @ORIENT("MY");
// %t14 @TEXT("qb", key="name", size=0.75);
// &qb @WIRE(mode="straight") {#XO:2 %t14:p};
// (-16, 32) @TEXT("34  Ring latch | 4 instances", size=1.2, halign="start");
// }
ends ring_inv_latch_v14_pdk110_34
