// Feedback DFF | frozen callback110 / recenter109 | RNL 0.3
// @RNL(type="header") { @VERSION("0.3"); @USE-PACKAGE(name="rnl-std-fill") {} }
simulator lang=spectre
subckt ff_fbdelay50_v14_pdk110_22 (d ck qb vdd vss)
MP0 (p0 d vdd vdd) pch w=2e-06 l=1.8e-07 ad=9.599999999999999e-13 as=9.599999999999999e-13 pd=4.96e-06 ps=4.96e-06 nrd=0.135 nrs=0.135 sa=4.8e-07 sb=4.8e-07 sd=5.4e-07 sca=0 scb=0 scc=0
MPC0 (b ck p0 vdd) pch w=2e-06 l=1.8e-07 ad=9.599999999999999e-13 as=9.599999999999999e-13 pd=4.96e-06 ps=4.96e-06 nrd=0.135 nrs=0.135 sa=4.8e-07 sb=4.8e-07 sd=5.4e-07 sca=0 scb=0 scc=0
MN0 (b dn vss vss) nch w=8e-07 l=1.8e-07 ad=3.84e-13 as=3.84e-13 pd=2.56e-06 ps=2.56e-06 nrd=0.3375 nrs=0.3375 sa=4.8e-07 sb=4.8e-07 sd=5.4e-07 sca=0 scb=0 scc=0
MP1 (a ck vdd vdd) pch w=2e-06 l=1.8e-07 ad=9.599999999999999e-13 as=9.599999999999999e-13 pd=4.96e-06 ps=4.96e-06 nrd=0.135 nrs=0.135 sa=4.8e-07 sb=4.8e-07 sd=5.4e-07 sca=0 scb=0 scc=0
MN1 (a b n1 vss) nch w=1.6e-06 l=1.8e-07 ad=7.68e-13 as=7.68e-13 pd=4.16e-06 ps=4.16e-06 nrd=0.16875 nrs=0.16875 sa=4.8e-07 sb=4.8e-07 sd=5.4e-07 sca=0 scb=0 scc=0
MNC1 (n1 ck vss vss) nch w=1.6e-06 l=1.8e-07 ad=7.68e-13 as=7.68e-13 pd=4.16e-06 ps=4.16e-06 nrd=0.16875 nrs=0.16875 sa=4.8e-07 sb=4.8e-07 sd=5.4e-07 sca=0 scb=0 scc=0
MP2 (qb a vdd vdd) pch w=2e-06 l=1.8e-07 ad=9.599999999999999e-13 as=9.599999999999999e-13 pd=4.96e-06 ps=4.96e-06 nrd=0.135 nrs=0.135 sa=4.8e-07 sb=4.8e-07 sd=5.4e-07 sca=0 scb=0 scc=0
MNC2 (qb ck n2 vss) nch w=1.6e-06 l=1.8e-07 ad=7.68e-13 as=7.68e-13 pd=4.16e-06 ps=4.16e-06 nrd=0.16875 nrs=0.16875 sa=4.8e-07 sb=4.8e-07 sd=5.4e-07 sca=0 scb=0 scc=0
MN2 (n2 a vss vss) nch w=1.6e-06 l=1.8e-07 ad=7.68e-13 as=7.68e-13 pd=4.16e-06 ps=4.16e-06 nrd=0.16875 nrs=0.16875 sa=4.8e-07 sb=4.8e-07 sd=5.4e-07 sca=0 scb=0 scc=0
RD (d dn) resistor r=50000
// @RNL(author="functional-compact127") {
// $CELL = @DEFINE-SYMBOL {
// @LINE {(-6, -6) (6, -6) (6, 6) (-6, 6) (-6, -6)};
// (-2, 1) @TEXT("D", size=1.15, halign="middle");
// (2, 1) @TEXT("Q", size=1.15, halign="middle");
// @LINE {(-2, -1) (2, -1)};
// @LINE {(0.946901, -0.424689) (2, -1) (0.946901, -1.57531)};
// (0, -3) @TEXT("FF", size=0.8, halign="middle");
// @LINE {(-6, -1) (-4.5, -2) (-6, -3)};
// (-8, 2) @PIN(terminal="d", direction="left");
// @LINE {(-8, 2) (-6, 2)};
// (-5.4, 2) @TEXT("d", size=0.7, halign="start");
// (-8, -2) @PIN(terminal="ck", direction="left");
// @LINE {(-8, -2) (-6, -2)};
// (-5.4, -2) @TEXT("ck", size=0.7, halign="start");
// (8, 0) @PIN(terminal="qb", direction="right");
// @LINE {(8, 0) (6, 0)};
// (5.4, 0) @TEXT("qb", size=0.7, halign="end");
// (0, 8) @PIN(terminal="vdd", direction="up");
// @LINE {(0, 8) (0, 6)};
// (0, -8) @PIN(terminal="vss", direction="down");
// @LINE {(0, -8) (0, -6)};
// ? @TEXT("${name}", key="name", size=1, halign="middle") => @PLACE(8, 9.5);
// (0, 5.1) @TEXT("Feedback DFF", size=0.85, halign="middle");
// };
// # @SET-SYMBOL $CELL;
// #MP0 @PLACE(-7, 30) => @ORIENT("R0");
// #MP0 @SET-SYMBOL $PMOS_4TERM;
// #MP0 @TEXT("MP0", key="name", dx=5, dy=1.5, size=0.9, halign="start");
// #MP0 @TEXT("2u / 180n", key="model", dx=5, dy=-1.5, size=0.75, halign="start");
// #MPC0 @PLACE(-7, 15) => @ORIENT("R0");
// #MPC0 @SET-SYMBOL $PMOS_4TERM;
// #MPC0 @TEXT("MPC0", key="name", dx=5, dy=1.5, size=0.9, halign="start");
// #MPC0 @TEXT("2u / 180n", key="model", dx=5, dy=-1.5, size=0.75, halign="start");
// #MN0 @PLACE(-7, -8) => @ORIENT("R0");
// #MN0 @SET-SYMBOL $NMOS_4TERM;
// #MN0 @TEXT("MN0", key="name", dx=5, dy=1.5, size=0.9, halign="start");
// #MN0 @TEXT("800n / 180n", key="model", dx=5, dy=-1.5, size=0.75, halign="start");
// #MP1 @PLACE(18, 30) => @ORIENT("R0");
// #MP1 @SET-SYMBOL $PMOS_4TERM;
// #MP1 @TEXT("MP1", key="name", dx=5, dy=1.5, size=0.9, halign="start");
// #MP1 @TEXT("2u / 180n", key="model", dx=5, dy=-1.5, size=0.75, halign="start");
// #MN1 @PLACE(18, 0) => @ORIENT("R0");
// #MN1 @SET-SYMBOL $NMOS_4TERM;
// #MN1 @TEXT("MN1", key="name", dx=5, dy=1.5, size=0.9, halign="start");
// #MN1 @TEXT("1.6u / 180n", key="model", dx=5, dy=-1.5, size=0.75, halign="start");
// #MNC1 @PLACE(18, -16) => @ORIENT("R0");
// #MNC1 @SET-SYMBOL $NMOS_4TERM;
// #MNC1 @TEXT("MNC1", key="name", dx=5, dy=1.5, size=0.9, halign="start");
// #MNC1 @TEXT("1.6u / 180n", key="model", dx=5, dy=-1.5, size=0.75, halign="start");
// #MP2 @PLACE(43, 30) => @ORIENT("R0");
// #MP2 @SET-SYMBOL $PMOS_4TERM;
// #MP2 @TEXT("MP2", key="name", dx=5, dy=1.5, size=0.9, halign="start");
// #MP2 @TEXT("2u / 180n", key="model", dx=5, dy=-1.5, size=0.75, halign="start");
// #MNC2 @PLACE(43, 0) => @ORIENT("R0");
// #MNC2 @SET-SYMBOL $NMOS_4TERM;
// #MNC2 @TEXT("MNC2", key="name", dx=5, dy=1.5, size=0.9, halign="start");
// #MNC2 @TEXT("1.6u / 180n", key="model", dx=5, dy=-1.5, size=0.75, halign="start");
// #MN2 @PLACE(43, -16) => @ORIENT("R0");
// #MN2 @SET-SYMBOL $NMOS_4TERM;
// #MN2 @TEXT("MN2", key="name", dx=5, dy=1.5, size=0.9, halign="start");
// #MN2 @TEXT("1.6u / 180n", key="model", dx=5, dy=-1.5, size=0.75, halign="start");
// #RD @PLACE(-25, -8) => @ORIENT("R90");
// #RD @SET-SYMBOL $RESISTOR;
// #RD @TEXT("50k", key="value", dx=3, dy=-1, size=0.8, halign="start");
// #RD @TEXT("RD", key="name", dx=3, dy=1, size=0.9, halign="start");
// &p0 @WIRE(mode="straight") {#MP0:1 #MPC0:3};
// &b @WIRE(mode="straight") {#MPC0:1 #MN0:1};
// &a @WIRE(mode="straight") {#MP1:1 #MN1:1};
// &n1 @WIRE(mode="straight") {#MN1:3 #MNC1:1};
// &qb @WIRE(mode="straight") {#MP2:1 #MNC2:1};
// &n2 @WIRE(mode="straight") {#MNC2:3 #MN2:1};
// &b @WIRE(mode="straight") {#MPC0:1 (-7, 6) (8, 6) (8, 0) #MN1:2};
// &a @WIRE(mode="straight") {#MP1:1 (18, 9) (33, 9) (33, 30) #MP2:2};
// &a @WIRE(mode="straight") {#MN1:1 (18, 9) (33, 9) (33, -16) #MN2:2};
// &dn @WIRE(mode="straight") {#RD:2 #MN0:2};
// %t1 = $IO_PORT @ATTACH &d => @PLACE(-13, 30) => @ORIENT("R0");
// %t1 @TEXT("d", key="name", size=0.75);
// &d @WIRE(mode="straight") {#MP0:2 %t1:p};
// %t2 = $SUPPLY @ATTACH &vdd => @PLACE(-7, 35);
// &vdd @WIRE(mode="straight") {#MP0:3 %t2:p};
// %t3 = $IO_PORT @ATTACH &vdd => @PLACE(-3, 30) => @ORIENT("MY");
// %t3 @TEXT("vdd", key="name", size=0.75);
// &vdd @WIRE(mode="straight") {#MP0:4 %t3:p};
// %t4 = $IO_PORT @ATTACH &ck => @PLACE(-13, 15) => @ORIENT("R0");
// %t4 @TEXT("ck", key="name", size=0.75);
// &ck @WIRE(mode="straight") {#MPC0:2 %t4:p};
// %t5 = $IO_PORT @ATTACH &vdd => @PLACE(-3, 15) => @ORIENT("MY");
// %t5 @TEXT("vdd", key="name", size=0.75);
// &vdd @WIRE(mode="straight") {#MPC0:4 %t5:p};
// %t6 = $GROUND @ATTACH &vss => @PLACE(-7, -13);
// &vss @WIRE(mode="straight") {#MN0:3 %t6:p};
// %t7 = $IO_PORT @ATTACH &vss => @PLACE(-3, -8) => @ORIENT("MY");
// %t7 @TEXT("vss", key="name", size=0.75);
// &vss @WIRE(mode="straight") {#MN0:4 %t7:p};
// %t8 = $IO_PORT @ATTACH &ck => @PLACE(12, 30) => @ORIENT("R0");
// %t8 @TEXT("ck", key="name", size=0.75);
// &ck @WIRE(mode="straight") {#MP1:2 %t8:p};
// %t9 = $SUPPLY @ATTACH &vdd => @PLACE(18, 35);
// &vdd @WIRE(mode="straight") {#MP1:3 %t9:p};
// %t10 = $IO_PORT @ATTACH &vdd => @PLACE(22, 30) => @ORIENT("MY");
// %t10 @TEXT("vdd", key="name", size=0.75);
// &vdd @WIRE(mode="straight") {#MP1:4 %t10:p};
// %t11 = $IO_PORT @ATTACH &vss => @PLACE(22, 0) => @ORIENT("MY");
// %t11 @TEXT("vss", key="name", size=0.75);
// &vss @WIRE(mode="straight") {#MN1:4 %t11:p};
// %t12 = $IO_PORT @ATTACH &ck => @PLACE(12, -16) => @ORIENT("R0");
// %t12 @TEXT("ck", key="name", size=0.75);
// &ck @WIRE(mode="straight") {#MNC1:2 %t12:p};
// %t13 = $GROUND @ATTACH &vss => @PLACE(18, -21);
// &vss @WIRE(mode="straight") {#MNC1:3 %t13:p};
// %t14 = $IO_PORT @ATTACH &vss => @PLACE(22, -16) => @ORIENT("MY");
// %t14 @TEXT("vss", key="name", size=0.75);
// &vss @WIRE(mode="straight") {#MNC1:4 %t14:p};
// %t15 = $SUPPLY @ATTACH &vdd => @PLACE(43, 35);
// &vdd @WIRE(mode="straight") {#MP2:3 %t15:p};
// %t16 = $IO_PORT @ATTACH &vdd => @PLACE(47, 30) => @ORIENT("MY");
// %t16 @TEXT("vdd", key="name", size=0.75);
// &vdd @WIRE(mode="straight") {#MP2:4 %t16:p};
// %t17 = $IO_PORT @ATTACH &ck => @PLACE(37, 0) => @ORIENT("R0");
// %t17 @TEXT("ck", key="name", size=0.75);
// &ck @WIRE(mode="straight") {#MNC2:2 %t17:p};
// %t18 = $IO_PORT @ATTACH &vss => @PLACE(47, 0) => @ORIENT("MY");
// %t18 @TEXT("vss", key="name", size=0.75);
// &vss @WIRE(mode="straight") {#MNC2:4 %t18:p};
// %t19 = $GROUND @ATTACH &vss => @PLACE(43, -21);
// &vss @WIRE(mode="straight") {#MN2:3 %t19:p};
// %t20 = $IO_PORT @ATTACH &vss => @PLACE(47, -16) => @ORIENT("MY");
// %t20 @TEXT("vss", key="name", size=0.75);
// &vss @WIRE(mode="straight") {#MN2:4 %t20:p};
// %t21 = $IO_PORT @ATTACH &d => @PLACE(-30, -8) => @ORIENT("R0");
// %t21 @TEXT("d", key="name", size=0.75);
// &d @WIRE(mode="straight") {#RD:1 %t21:p};
// %t22 = $IO_PORT @ATTACH &qb => @PLACE(39, 25) => @ORIENT("R0");
// %t22 @TEXT("qb", key="name", size=0.75);
// &qb @WIRE(mode="straight") {#MP2:1 (43, 25) %t22:p};
// (-35, 54) @TEXT("22  Feedback DFF | 10 instances", size=1.2, halign="start");
// }
ends ff_fbdelay50_v14_pdk110_22
