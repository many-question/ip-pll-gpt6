// Reset latch | frozen callback110 / recenter109 | RNL 0.3
// @RNL(type="header") { @VERSION("0.3"); @USE-PACKAGE(name="rnl-std-fill") {} }
simulator lang=spectre
subckt tx_latch_r_pdk110_60 (d gate gateb resetb q vdd vss)
XT (d x gate gateb vdd vss) pll_tg_pdk110_61
XN (x resetb qb vdd vss) pll_nand2_pdk110_15
XO (qb q vdd vss) pll_inv_pdk110_62
XF (q x gateb gate vdd vss) pll_tg_pdk110_63
// @RNL(author="functional-compact127") {
// $CELL = @DEFINE-SYMBOL {
// @LINE {(-6, -10) (6, -10) (6, 10) (-6, 10) (-6, -10)};
// (-2, 1) @TEXT("D", size=1.15, halign="middle");
// (2, 1) @TEXT("Q", size=1.15, halign="middle");
// @LINE {(-2, -1) (2, -1)};
// @LINE {(0.946901, -0.424689) (2, -1) (0.946901, -1.57531)};
// (0, -3) @TEXT("LATCH", size=0.8, halign="middle");
// (-8, 6) @PIN(terminal="d", direction="left");
// @LINE {(-8, 6) (-6, 6)};
// (-5.4, 6) @TEXT("d", size=0.7, halign="start");
// (-8, 2) @PIN(terminal="gate", direction="left");
// @LINE {(-8, 2) (-6, 2)};
// (-5.4, 2) @TEXT("gate", size=0.7, halign="start");
// (-8, -2) @PIN(terminal="gateb", direction="left");
// @LINE {(-8, -2) (-6, -2)};
// (-5.4, -2) @TEXT("gateb", size=0.7, halign="start");
// (-8, -6) @PIN(terminal="resetb", direction="left");
// @LINE {(-8, -6) (-6, -6)};
// (-5.4, -6) @TEXT("resetb", size=0.7, halign="start");
// (8, 0) @PIN(terminal="q", direction="right");
// @LINE {(8, 0) (6, 0)};
// (5.4, 0) @TEXT("q", size=0.7, halign="end");
// (0, 12) @PIN(terminal="vdd", direction="up");
// @LINE {(0, 12) (0, 10)};
// (0, -12) @PIN(terminal="vss", direction="down");
// @LINE {(0, -12) (0, -10)};
// ? @TEXT("${name}", key="name", size=1, halign="middle") => @PLACE(8, 13.5);
// (0, 9.1) @TEXT("Reset latch", size=0.85, halign="middle");
// };
// # @SET-SYMBOL $CELL;
// #XT @PLACE(0, 0) => @ORIENT("R0");
// #XN @PLACE(28, 0) => @ORIENT("R0");
// #XO @PLACE(56, 0) => @ORIENT("R0");
// #XF @PLACE(28, -35) => @ORIENT("R0");
// &x @WIRE(mode="straight") {#XT:2 (14, 0) (14, 2) #XN:1};
// &qb @WIRE(mode="straight") {#XN:3 (42, 0) (42, 0) #XO:1};
// &q @WIRE(mode="straight") {#XO:2 (64, -20) (20, -20) #XF:1};
// &x @WIRE(mode="straight") {#XF:2 (40, -35) (40, -55) (14, -55) (14, 0) #XT:2};
// %t1 = $IO_PORT @ATTACH &d => @PLACE(-11, 4) => @ORIENT("R0");
// %t1 @TEXT("d", key="name", size=0.75);
// &d @WIRE(mode="straight") {#XT:1 %t1:p};
// %t2 = $IO_PORT @ATTACH &gate => @PLACE(-11, 0) => @ORIENT("R0");
// %t2 @TEXT("gate", key="name", size=0.75);
// &gate @WIRE(mode="straight") {#XT:3 %t2:p};
// %t3 = $IO_PORT @ATTACH &gateb => @PLACE(-11, -4) => @ORIENT("R0");
// %t3 @TEXT("gateb", key="name", size=0.75);
// &gateb @WIRE(mode="straight") {#XT:4 %t3:p};
// %t4 = $SUPPLY @ATTACH &vdd => @PLACE(0, 13);
// &vdd @WIRE(mode="straight") {#XT:5 %t4:p};
// %t5 = $GROUND @ATTACH &vss => @PLACE(0, -13);
// &vss @WIRE(mode="straight") {#XT:6 %t5:p};
// %t6 = $IO_PORT @ATTACH &resetb => @PLACE(18, -2) => @ORIENT("R0");
// %t6 @TEXT("resetb", key="name", size=0.75);
// &resetb @WIRE(mode="straight") {#XN:2 %t6:p};
// %t7 = $SUPPLY @ATTACH &vdd => @PLACE(28, 11);
// &vdd @WIRE(mode="straight") {#XN:4 %t7:p};
// %t8 = $GROUND @ATTACH &vss => @PLACE(28, -11);
// &vss @WIRE(mode="straight") {#XN:5 %t8:p};
// %t9 = $SUPPLY @ATTACH &vdd => @PLACE(56, 9);
// &vdd @WIRE(mode="straight") {#XO:3 %t9:p};
// %t10 = $GROUND @ATTACH &vss => @PLACE(56, -9);
// &vss @WIRE(mode="straight") {#XO:4 %t10:p};
// %t11 = $IO_PORT @ATTACH &gateb => @PLACE(18, -35) => @ORIENT("R0");
// %t11 @TEXT("gateb", key="name", size=0.75);
// &gateb @WIRE(mode="straight") {#XF:3 %t11:p};
// %t12 = $IO_PORT @ATTACH &gate => @PLACE(18, -39) => @ORIENT("R0");
// %t12 @TEXT("gate", key="name", size=0.75);
// &gate @WIRE(mode="straight") {#XF:4 %t12:p};
// %t13 = $SUPPLY @ATTACH &vdd => @PLACE(28, -22);
// &vdd @WIRE(mode="straight") {#XF:5 %t13:p};
// %t14 = $GROUND @ATTACH &vss => @PLACE(28, -48);
// &vss @WIRE(mode="straight") {#XF:6 %t14:p};
// %t15 = $IO_PORT @ATTACH &q => @PLACE(67, 0) => @ORIENT("MY");
// %t15 @TEXT("q", key="name", size=0.75);
// &q @WIRE(mode="straight") {#XO:2 %t15:p};
// (-16, 32) @TEXT("60  Reset latch | 4 instances", size=1.2, halign="start");
// }
ends tx_latch_r_pdk110_60
