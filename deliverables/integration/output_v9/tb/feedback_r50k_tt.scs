simulator lang=spectre
global 0
include "/home/process/tsmc180bcd_gen2_2022/PDK/TSMC180BCD/models/spectre/c018bcd_gen2_v1d6.scs" section=tt
include "/home/process/tsmc180bcd_gen2_2022/PDK/TSMC180BCD/models/spectre/c018bcd_gen2_v1d6.scs" section=stat_noise
simulator lang=spectre insensitive=no
include "/home/process/tsmc180bcd_gen2_2022/PDK/TSMC180BCD/models/spectre/c018bcd_gen2_v1d6.scs" section=tt_bbmvar
simulator lang=spectre insensitive=no
include "cells.scs"
include "divider_v2.scs"
include "limiter_chain.scs"
include "limiter4_v9.scs"
include "divider_bank_v6_clamp.scs"
simulatorOptions options reltol=1e-5 vabstol=1e-7 iabstol=1e-13 temp=27
VDD (vdd 0) vsource dc=1.2
ahdl_include "tank_waveform_v5.va"
XRF (vp vn 0) tank_waveform_v5
VRST (rst 0) vsource type=pwl wave=[0 1.2 20n 1.2 20.02n 0]
XD (vp vn rst vdd 0 0 0 0 0 data vdd 0) tx_divider_bank_v6_clamp rb_input=50k rb_clock=50k cdec=10p
include "retimer_scaled.scs"
VRX (rx_vdd vdd) vsource dc=0
VRT (rt_vdd vdd) vsource dc=0
XRX (vp clk rx_vdd 0) tx_limiter4_v9 wn=4u wp=10u rfb=50k
XRT (data clk out rt_vdd 0) tx_retimer_scaled scale=2 oscale=4 sp=2.5u
CL (out 0) capacitor c=10f
tran tran stop=100n maxstep=1p method=traponly errpreset=conservative
save vp vn data clk out XRX.g0 XRX.o0 XRX.g1 XRX.o1 XRX.g2 XRX.o2 XRX.g3 XRX.o3 XRT.clkb XRT.q XRT.qb VDD:p VRX:p VRT:p
saveOptions options save=selected
