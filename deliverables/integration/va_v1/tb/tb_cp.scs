simulator lang=spectre
global 0
ahdl_include "auxiliary_fll.va"
ahdl_include "bias_control.va"
ahdl_include "charge_pump.va"
ahdl_include "even_divider.va"
ahdl_include "lc_vco.va"
ahdl_include "loop_filter.va"
ahdl_include "output_buffer.va"
ahdl_include "output_retimer.va"
ahdl_include "pll_monitor.va"
ahdl_include "reference_buffer.va"
ahdl_include "subsampling_detector.va"

parameters vddval=1.2
VDD (vdd 0) vsource dc=vddval
simulatorOptions options reltol=1e-5 vabstol=1e-7 iabstol=1e-13 temp=27

VS (sample 0) vsource dc=.2
VP (pulse 0) vsource type=pulse val0=0 val1=1.2 period=41.6666666666667n width=2.073333333333n rise=10p fall=10p delay=2n
VE (en 0) vsource dc=1.2
XC (sample pulse en out vdd 0) charge_pump
VR (out 0) vsource dc=.6
tran tran stop=130n errpreset=conservative maxstep=100p
save pulse VR:p
saveOptions options save=selected
