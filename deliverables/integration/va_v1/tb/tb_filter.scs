simulator lang=spectre
global 0
ahdl_include "auxiliary_fll.va"
ahdl_include "bias_control.va"
ahdl_include "charge_pump.va"
ahdl_include "even_divider.va"
ahdl_include "lc_vco.va"
ahdl_include "loop_filter.va"
ahdl_include "output_buffer.va"
ahdl_include "output_retimer.va"
ahdl_include "pll_monitor.va"
ahdl_include "reference_buffer.va"
ahdl_include "subsampling_detector.va"

parameters vddval=1.2
VDD (vdd 0) vsource dc=vddval
simulatorOptions options reltol=1e-5 vabstol=1e-7 iabstol=1e-13 temp=27

VE (en 0) vsource dc=1.2
VP (pre 0) vsource dc=.6
XF (ctrl vc1 en pre 0) loop_filter
IIN (0 ctrl) isource type=pulse val0=0 val1=1u delay=1n rise=10p fall=10p width=100n period=1u
IIN2 (0 ctrl2) isource type=pulse val0=0 val1=1u delay=1n rise=10p fall=10p width=100n period=1u
R (ctrl2 vc12) resistor r=22222.2222222222
C1 (vc12 0) capacitor c=28.6478897565412p
C2 (ctrl2 0) capacitor c=1.90985931710274p
ic ctrl=.6 vc1=.6 ctrl2=.6 vc12=.6
tran tran stop=300n errpreset=conservative maxstep=100p
save ctrl vc1 ctrl2 vc12
saveOptions options save=selected
