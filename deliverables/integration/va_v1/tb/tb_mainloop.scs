simulator lang=spectre
global 0
ahdl_include "auxiliary_fll.va"
ahdl_include "bias_control.va"
ahdl_include "charge_pump.va"
ahdl_include "even_divider.va"
ahdl_include "lc_vco.va"
ahdl_include "loop_filter.va"
ahdl_include "output_buffer.va"
ahdl_include "output_retimer.va"
ahdl_include "pll_monitor.va"
ahdl_include "reference_buffer.va"
ahdl_include "subsampling_detector.va"

parameters vddval=1.2
VDD (vdd 0) vsource dc=vddval
simulatorOptions options reltol=1e-5 vabstol=1e-7 iabstol=1e-13 temp=27

VR (ref 0) vsource type=pulse val0=0 val1=1.2 period=41.6666666666667n width=20n rise=10p fall=10p delay=1n
XR (ref refb vdd 0) reference_buffer
XB (vdd 0 vmid) bias_control
VCODE (code 0) vsource dc=6
VDIST (dist 0) vsource dc=0
VEN (en 0) vsource dc=1.2
VPRE (pre 0) vsource dc=0.3806856424844265
XV (ctrl code dist vmid vp vn clk fmon vdd 0) lc_vco phase_initial=0.8240754943091897
XP (refb vp vn sample pulse vdd 0) subsampling_detector
XC (sample pulse en ctrl vdd 0) charge_pump
XF (ctrl vc1 en pre 0) loop_filter
XM (clk refb vp vn ctrl fm dm em phaseerr vmax vmin vdd 0) pll_monitor start=0
ic ctrl=0.3806856424844265 vc1=0.3806856424844265
tran tran stop=6u errpreset=conservative strobeperiod=41.6666666666667n strobedelay=1.066n strobeoutput=strobeonly
save ctrl vc1 phaseerr
saveOptions options save=selected
