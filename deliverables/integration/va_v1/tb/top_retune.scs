simulator lang=spectre
global 0
ahdl_include "auxiliary_fll.va"
ahdl_include "bias_control.va"
ahdl_include "charge_pump.va"
ahdl_include "even_divider.va"
ahdl_include "lc_vco.va"
ahdl_include "loop_filter.va"
ahdl_include "output_buffer.va"
ahdl_include "output_retimer.va"
ahdl_include "pll_monitor.va"
ahdl_include "reference_buffer.va"
ahdl_include "subsampling_detector.va"

parameters vddval=1.2
VDD (vdd 0) vsource dc=vddval
simulatorOptions options reltol=1e-5 vabstol=1e-7 iabstol=1e-13 temp=27

VREF (ref 0) vsource type=pulse val0=0 val1=1.2 period=41.6666666666667n width=20.8233333333333n rise=10p fall=10p delay=1n
VN (target 0) vsource type=pwl wave=[0 126 20u 126 20.00002u 164]
VM (ratio 0) vsource type=pwl wave=[0 14 20u 14 20.00002u 4]
VDIST (dist 0) vsource dc=0
XREF (ref refb vdd 0) reference_buffer
XBIAS (vdd 0 vmid) bias_control
XVCO (ctrl code dist vmid vp vn vcoclk fvco vdd 0) lc_vco points_per_cycle=16
XPD (refb vp vn sample pulse vdd 0) subsampling_detector
XCP (sample pulse enable ctrl vdd 0) charge_pump
XLF (ctrl vc1 enable preset 0) loop_filter
XFLL (refb vcoclk target sample vmid code preset enable status locked measured vdd 0) auxiliary_fll
XDIV (vcoclk ratio enable div vdd 0) even_divider
XRT (div vcoclk enable retimed violations vdd 0) output_retimer
XOUT (retimed out vdd 0) output_buffer
CLOAD (out 0) capacitor c=10f
XMEAS (out refb vp vn ctrl freqout dutyout edgecount phaseerr vmax vmin vdd 0) pll_monitor start=38u
tran tran stop=40u errpreset=conservative strobeperiod=10n strobeoutput=strobeonly
save ctrl vc1 code enable status locked measured sample fvco freqout dutyout edgecount phaseerr violations vmax vmin
saveOptions options save=selected
