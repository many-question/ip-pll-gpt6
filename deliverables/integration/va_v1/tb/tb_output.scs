simulator lang=spectre
global 0
ahdl_include "auxiliary_fll.va"
ahdl_include "bias_control.va"
ahdl_include "charge_pump.va"
ahdl_include "even_divider.va"
ahdl_include "lc_vco.va"
ahdl_include "loop_filter.va"
ahdl_include "output_buffer.va"
ahdl_include "output_retimer.va"
ahdl_include "pll_monitor.va"
ahdl_include "reference_buffer.va"
ahdl_include "subsampling_detector.va"

parameters vddval=1.2
VDD (vdd 0) vsource dc=vddval
simulatorOptions options reltol=1e-5 vabstol=1e-7 iabstol=1e-13 temp=27

VI (inp 0) vsource type=pulse val0=0 val1=1.2 period=1n width=490p rise=10p fall=10p delay=20p
XO (inp out vdd 0) output_buffer
CL (out 0) capacitor c=10f
tran tran stop=20n errpreset=conservative maxstep=10p
save inp out
saveOptions options save=selected
