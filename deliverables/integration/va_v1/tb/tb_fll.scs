simulator lang=spectre
global 0
ahdl_include "auxiliary_fll.va"
ahdl_include "bias_control.va"
ahdl_include "charge_pump.va"
ahdl_include "even_divider.va"
ahdl_include "lc_vco.va"
ahdl_include "loop_filter.va"
ahdl_include "output_buffer.va"
ahdl_include "output_retimer.va"
ahdl_include "pll_monitor.va"
ahdl_include "reference_buffer.va"
ahdl_include "subsampling_detector.va"

parameters vddval=1.2
VDD (vdd 0) vsource dc=vddval
simulatorOptions options reltol=1e-5 vabstol=1e-7 iabstol=1e-13 temp=27

VR (ref 0) vsource type=pulse val0=0 val1=1.2 period=41.6666666666667n width=20n rise=10p fall=10p delay=1n
VC (clk 0) vsource type=pulse val0=0 val1=1.2 period=333.333333333333p width=164.666666666667p rise=2p fall=2p delay=20p
VT (target 0) vsource dc=125
VS (sample 0) vsource dc=0
VBIAS (vmid 0) vsource dc=.6
XF (ref clk target sample vmid code preset en status locked measured vdd 0) auxiliary_fll
tran tran stop=8u errpreset=conservative strobeperiod=10n strobeoutput=strobeonly
save code preset en status locked measured
saveOptions options save=selected
