simulator lang=spectre
global 0
ahdl_include "auxiliary_fll.va"
ahdl_include "bias_control.va"
ahdl_include "charge_pump.va"
ahdl_include "even_divider.va"
ahdl_include "lc_vco.va"
ahdl_include "loop_filter.va"
ahdl_include "output_buffer.va"
ahdl_include "output_retimer.va"
ahdl_include "pll_monitor.va"
ahdl_include "reference_buffer.va"
ahdl_include "subsampling_detector.va"

parameters vddval=1.2
VDD (vdd 0) vsource dc=vddval
simulatorOptions options reltol=1e-5 vabstol=1e-7 iabstol=1e-13 temp=27

VC (ctrl 0) vsource dc=.7
VB (code 0) vsource dc=127
VD (dist 0) vsource dc=0
VBIAS (vmid 0) vsource dc=.6
XV (ctrl code dist vmid vp vn clk fmon vdd 0) lc_vco
tran tran stop=20n errpreset=conservative
save vp vn clk fmon
saveOptions options save=selected
