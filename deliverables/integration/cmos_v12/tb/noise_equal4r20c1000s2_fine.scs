simulator lang=spectre
global 0
include "/home/process/tsmc180bcd_gen2_2022/PDK/TSMC180BCD/models/spectre/c018bcd_gen2_v1d6.scs" section=tt
include "/home/process/tsmc180bcd_gen2_2022/PDK/TSMC180BCD/models/spectre/c018bcd_gen2_v1d6.scs" section=stat_noise
simulator lang=spectre insensitive=no
include "cells.scs"
simulatorOptions options reltol=1e-5 vabstol=1e-7 iabstol=1e-13 temp=27
VDD (vdd 0) vsource dc=1.2
ahdl_include "tank_waveform_v5.va"
XRF (vp vn 0) tank_waveform_v5
include "rf_equal4r20c1000s2_v12.scs"
include "cmos_tspc_buffered_v11.scs"
include "retimer_scaled.scs"
VRX (rx_vdd vdd) vsource dc=0
VRT (rt_vdd vdd) vsource dc=0
XRX (vp clk rx_vdd 0) rf_equal4r20c1000s2_v12
XD (clk q1 data vdd 0) cmos_tspc_buffered_v11
XR (data clk out rt_vdd 0) tx_retimer_scaled scale=2 oscale=4 sp=2.5u
CL (out 0) capacitor c=10f
pss pss fund=984M harms=127 tstab=300n maxstep=0.5p method=traponly errpreset=conservative maxperiods=30 saveinit=yes writefinal="__FINAL_STATE__"
pn pnoise start=10k stop=492M dec=30 pnoisemethod=fullspectrum noisetype=sampled measurement=[edge] sampleratio=1 maxsideband=127
edge jitterevent trigger=[out] triggerthresh=0.6 triggernum=1 triggerdir=rise target=[out] jittercal=[Jee]
save vp vn clk q1 data out XRX.g0 XRX.a XRX.b XRX.c XRX.d XR.qb XR.q XR.clkb VDD:p VRX:p VRT:p
saveOptions options save=selected
