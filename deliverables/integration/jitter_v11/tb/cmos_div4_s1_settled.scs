simulator lang=spectre
global 0
include "/home/process/tsmc180bcd_gen2_2022/PDK/TSMC180BCD/models/spectre/c018bcd_gen2_v1d6.scs" section=tt
include "/home/process/tsmc180bcd_gen2_2022/PDK/TSMC180BCD/models/spectre/c018bcd_gen2_v1d6.scs" section=stat_noise
simulator lang=spectre insensitive=no
include "cells.scs"
simulatorOptions options reltol=1e-5 vabstol=1e-7 iabstol=1e-13 temp=27
VDD (vdd 0) vsource dc=1.2
include "cmos_cells_v11.scs"
VC (clk 0) vsource type=pulse val0=0 val1=1.2 delay=0 rise=10p fall=10p width=1.170325203252033e-10 period=2.540650406504065e-10
VR (rst 0) vsource type=pwl wave=[0 1.2 10n 1.2 10.02n 0]
XD (clk rst q1 out vdd 0) cmos_div4_v11 s=1
CL (out 0) capacitor c=10f
tran tran stop=60n start=0 outputstart=50n maxstep=1p method=traponly errpreset=conservative
save clk q1 out XD.X0.qb XD.X1.qb XD.X0.clkb XD.X0.qm VDD:p
saveOptions options save=selected
