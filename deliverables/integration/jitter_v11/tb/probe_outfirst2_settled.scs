simulator lang=spectre
global 0
include "/home/process/tsmc180bcd_gen2_2022/PDK/TSMC180BCD/models/spectre/c018bcd_gen2_v1d6.scs" section=tt
include "/home/process/tsmc180bcd_gen2_2022/PDK/TSMC180BCD/models/spectre/c018bcd_gen2_v1d6.scs" section=stat_noise
simulator lang=spectre insensitive=no
include "/home/process/tsmc180bcd_gen2_2022/PDK/TSMC180BCD/models/spectre/c018bcd_gen2_v1d6.scs" section=tt_bbmvar
simulator lang=spectre insensitive=no
include "cells.scs"
include "divider_v2.scs"
include "limiter_chain.scs"
include "divider_raw_v9.scs"
simulatorOptions options reltol=1e-5 vabstol=1e-7 iabstol=1e-13 temp=27
VDD (vdd 0) vsource dc=1.2
ahdl_include "tank_waveform_v5.va"
XRF (vp vn 0) tank_waveform_v5
VRST (rst 0) vsource type=pwl wave=[0 1.2 20n 1.2 20.02n 0]
XD (vp vn rst vdd 0 0 0 0 0 dp dn vdd 0) tx_divider_raw_v9 rb_input=50k rb_clock=50k cdec=10p
include "cml_v10_outfirst2.scs"
VRT (rt_vdd vdd) vsource dc=0
XRT (dp dn vp vn out rt_vdd 0) tx_cml_v10_outfirst2 scale=2 lscale=2
CL (out 0) capacitor c=10f
tran tran stop=80n start=0 outputstart=76n maxstep=1p method=traponly errpreset=conservative
save XRT.mp XRT.mn XRT.XL.g0 XRT.XL.o0 vp vn dp dn out XRT.ckp XRT.ckn XRT.cm XRT.nb XRT.qp XRT.qn VDD:p VRT:p
saveOptions options save=selected
save XD.ckp2 XD.ckn2 XD.nb2 XD.cm XD.m2_0p XD.m2_0n XD.m2_1p XD.m2_1n XD.q2_0p XD.q2_0n XD.q2_1p XD.q2_1n XD.XM2_0.st XD.XM2_0.ht XD.XM2_0.tail XD.XS2_0.st XD.XS2_0.ht XD.XS2_0.tail XD.XM2_1.st XD.XM2_1.ht XD.XM2_1.tail XD.XS2_1.st XD.XS2_1.ht XD.XS2_1.tail XRT.XM.st XRT.XM.ht XRT.XM.tail XRT.XS.st XRT.XS.ht XRT.XS.tail XRT.XL.g0 XRT.XL.o0 XRT.XL.g1 XRT.XL.o1 XRT.XL.g2 XRT.XL.o2 XRT.XL.g3 XRT.XL.o3 XD.XM2_0.MDP:ids XD.XM2_0.MDP:gm XD.XM2_0.MDP:gds XD.XM2_0.MDP:vds XD.XM2_0.MDP:vdsat XD.XM2_0.MDP:vgs XD.XM2_0.MDP:vth XD.XM2_0.MDN:ids XD.XM2_0.MDN:gm XD.XM2_0.MDN:gds XD.XM2_0.MDN:vds XD.XM2_0.MDN:vdsat XD.XM2_0.MDN:vgs XD.XM2_0.MDN:vth XD.XM2_0.MHP:ids XD.XM2_0.MHP:gm XD.XM2_0.MHP:gds XD.XM2_0.MHP:vds XD.XM2_0.MHP:vdsat XD.XM2_0.MHP:vgs XD.XM2_0.MHP:vth XD.XM2_0.MHN:ids XD.XM2_0.MHN:gm XD.XM2_0.MHN:gds XD.XM2_0.MHN:vds XD.XM2_0.MHN:vdsat XD.XM2_0.MHN:vgs XD.XM2_0.MHN:vth XD.XM2_0.MCS:ids XD.XM2_0.MCS:gm XD.XM2_0.MCS:gds XD.XM2_0.MCS:vds XD.XM2_0.MCS:vdsat XD.XM2_0.MCS:vgs XD.XM2_0.MCS:vth XD.XM2_0.MCH:ids XD.XM2_0.MCH:gm XD.XM2_0.MCH:gds XD.XM2_0.MCH:vds XD.XM2_0.MCH:vdsat XD.XM2_0.MCH:vgs XD.XM2_0.MCH:vth XD.XM2_0.MT:ids XD.XM2_0.MT:gm XD.XM2_0.MT:gds XD.XM2_0.MT:vds XD.XM2_0.MT:vdsat XD.XM2_0.MT:vgs XD.XM2_0.MT:vth XD.XS2_0.MDP:ids XD.XS2_0.MDP:gm XD.XS2_0.MDP:gds XD.XS2_0.MDP:vds XD.XS2_0.MDP:vdsat XD.XS2_0.MDP:vgs XD.XS2_0.MDP:vth XD.XS2_0.MDN:ids XD.XS2_0.MDN:gm XD.XS2_0.MDN:gds XD.XS2_0.MDN:vds XD.XS2_0.MDN:vdsat XD.XS2_0.MDN:vgs XD.XS2_0.MDN:vth XD.XS2_0.MHP:ids XD.XS2_0.MHP:gm XD.XS2_0.MHP:gds XD.XS2_0.MHP:vds XD.XS2_0.MHP:vdsat XD.XS2_0.MHP:vgs XD.XS2_0.MHP:vth XD.XS2_0.MHN:ids XD.XS2_0.MHN:gm XD.XS2_0.MHN:gds XD.XS2_0.MHN:vds XD.XS2_0.MHN:vdsat XD.XS2_0.MHN:vgs XD.XS2_0.MHN:vth XD.XS2_0.MCS:ids XD.XS2_0.MCS:gm XD.XS2_0.MCS:gds XD.XS2_0.MCS:vds XD.XS2_0.MCS:vdsat XD.XS2_0.MCS:vgs XD.XS2_0.MCS:vth XD.XS2_0.MCH:ids XD.XS2_0.MCH:gm XD.XS2_0.MCH:gds XD.XS2_0.MCH:vds XD.XS2_0.MCH:vdsat XD.XS2_0.MCH:vgs XD.XS2_0.MCH:vth XD.XS2_0.MT:ids XD.XS2_0.MT:gm XD.XS2_0.MT:gds XD.XS2_0.MT:vds XD.XS2_0.MT:vdsat XD.XS2_0.MT:vgs XD.XS2_0.MT:vth XD.XM2_1.MDP:ids XD.XM2_1.MDP:gm XD.XM2_1.MDP:gds XD.XM2_1.MDP:vds XD.XM2_1.MDP:vdsat XD.XM2_1.MDP:vgs XD.XM2_1.MDP:vth XD.XM2_1.MDN:ids XD.XM2_1.MDN:gm XD.XM2_1.MDN:gds XD.XM2_1.MDN:vds XD.XM2_1.MDN:vdsat XD.XM2_1.MDN:vgs XD.XM2_1.MDN:vth XD.XM2_1.MHP:ids XD.XM2_1.MHP:gm XD.XM2_1.MHP:gds XD.XM2_1.MHP:vds XD.XM2_1.MHP:vdsat XD.XM2_1.MHP:vgs XD.XM2_1.MHP:vth XD.XM2_1.MHN:ids XD.XM2_1.MHN:gm XD.XM2_1.MHN:gds XD.XM2_1.MHN:vds XD.XM2_1.MHN:vdsat XD.XM2_1.MHN:vgs XD.XM2_1.MHN:vth XD.XM2_1.MCS:ids XD.XM2_1.MCS:gm XD.XM2_1.MCS:gds XD.XM2_1.MCS:vds XD.XM2_1.MCS:vdsat XD.XM2_1.MCS:vgs XD.XM2_1.MCS:vth XD.XM2_1.MCH:ids XD.XM2_1.MCH:gm XD.XM2_1.MCH:gds XD.XM2_1.MCH:vds XD.XM2_1.MCH:vdsat XD.XM2_1.MCH:vgs XD.XM2_1.MCH:vth XD.XM2_1.MT:ids XD.XM2_1.MT:gm XD.XM2_1.MT:gds XD.XM2_1.MT:vds XD.XM2_1.MT:vdsat XD.XM2_1.MT:vgs XD.XM2_1.MT:vth XD.XS2_1.MDP:ids XD.XS2_1.MDP:gm XD.XS2_1.MDP:gds XD.XS2_1.MDP:vds XD.XS2_1.MDP:vdsat XD.XS2_1.MDP:vgs XD.XS2_1.MDP:vth XD.XS2_1.MDN:ids XD.XS2_1.MDN:gm XD.XS2_1.MDN:gds XD.XS2_1.MDN:vds XD.XS2_1.MDN:vdsat XD.XS2_1.MDN:vgs XD.XS2_1.MDN:vth XD.XS2_1.MHP:ids XD.XS2_1.MHP:gm XD.XS2_1.MHP:gds XD.XS2_1.MHP:vds XD.XS2_1.MHP:vdsat XD.XS2_1.MHP:vgs XD.XS2_1.MHP:vth XD.XS2_1.MHN:ids XD.XS2_1.MHN:gm XD.XS2_1.MHN:gds XD.XS2_1.MHN:vds XD.XS2_1.MHN:vdsat XD.XS2_1.MHN:vgs XD.XS2_1.MHN:vth XD.XS2_1.MCS:ids XD.XS2_1.MCS:gm XD.XS2_1.MCS:gds XD.XS2_1.MCS:vds XD.XS2_1.MCS:vdsat XD.XS2_1.MCS:vgs XD.XS2_1.MCS:vth XD.XS2_1.MCH:ids XD.XS2_1.MCH:gm XD.XS2_1.MCH:gds XD.XS2_1.MCH:vds XD.XS2_1.MCH:vdsat XD.XS2_1.MCH:vgs XD.XS2_1.MCH:vth XD.XS2_1.MT:ids XD.XS2_1.MT:gm XD.XS2_1.MT:gds XD.XS2_1.MT:vds XD.XS2_1.MT:vdsat XD.XS2_1.MT:vgs XD.XS2_1.MT:vth XRT.XM.MDP:ids XRT.XM.MDP:gm XRT.XM.MDP:gds XRT.XM.MDP:vds XRT.XM.MDP:vdsat XRT.XM.MDP:vgs XRT.XM.MDP:vth XRT.XM.MDN:ids XRT.XM.MDN:gm XRT.XM.MDN:gds XRT.XM.MDN:vds XRT.XM.MDN:vdsat XRT.XM.MDN:vgs XRT.XM.MDN:vth XRT.XM.MHP:ids XRT.XM.MHP:gm XRT.XM.MHP:gds XRT.XM.MHP:vds XRT.XM.MHP:vdsat XRT.XM.MHP:vgs XRT.XM.MHP:vth XRT.XM.MHN:ids XRT.XM.MHN:gm XRT.XM.MHN:gds XRT.XM.MHN:vds XRT.XM.MHN:vdsat XRT.XM.MHN:vgs XRT.XM.MHN:vth XRT.XM.MCS:ids XRT.XM.MCS:gm XRT.XM.MCS:gds XRT.XM.MCS:vds XRT.XM.MCS:vdsat XRT.XM.MCS:vgs XRT.XM.MCS:vth XRT.XM.MCH:ids XRT.XM.MCH:gm XRT.XM.MCH:gds XRT.XM.MCH:vds XRT.XM.MCH:vdsat XRT.XM.MCH:vgs XRT.XM.MCH:vth XRT.XM.MT:ids XRT.XM.MT:gm XRT.XM.MT:gds XRT.XM.MT:vds XRT.XM.MT:vdsat XRT.XM.MT:vgs XRT.XM.MT:vth XRT.XS.MDP:ids XRT.XS.MDP:gm XRT.XS.MDP:gds XRT.XS.MDP:vds XRT.XS.MDP:vdsat XRT.XS.MDP:vgs XRT.XS.MDP:vth XRT.XS.MDN:ids XRT.XS.MDN:gm XRT.XS.MDN:gds XRT.XS.MDN:vds XRT.XS.MDN:vdsat XRT.XS.MDN:vgs XRT.XS.MDN:vth XRT.XS.MHP:ids XRT.XS.MHP:gm XRT.XS.MHP:gds XRT.XS.MHP:vds XRT.XS.MHP:vdsat XRT.XS.MHP:vgs XRT.XS.MHP:vth XRT.XS.MHN:ids XRT.XS.MHN:gm XRT.XS.MHN:gds XRT.XS.MHN:vds XRT.XS.MHN:vdsat XRT.XS.MHN:vgs XRT.XS.MHN:vth XRT.XS.MCS:ids XRT.XS.MCS:gm XRT.XS.MCS:gds XRT.XS.MCS:vds XRT.XS.MCS:vdsat XRT.XS.MCS:vgs XRT.XS.MCS:vth XRT.XS.MCH:ids XRT.XS.MCH:gm XRT.XS.MCH:gds XRT.XS.MCH:vds XRT.XS.MCH:vdsat XRT.XS.MCH:vgs XRT.XS.MCH:vth XRT.XS.MT:ids XRT.XS.MT:gm XRT.XS.MT:gds XRT.XS.MT:vds XRT.XS.MT:vdsat XRT.XS.MT:vgs XRT.XS.MT:vth
