simulator lang=spectre
global 0
include "/home/process/tsmc180bcd_gen2_2022/PDK/TSMC180BCD/models/spectre/c018bcd_gen2_v1d6.scs" section=tt
include "/home/process/tsmc180bcd_gen2_2022/PDK/TSMC180BCD/models/spectre/c018bcd_gen2_v1d6.scs" section=stat_noise
simulator lang=spectre insensitive=no
include "/home/process/tsmc180bcd_gen2_2022/PDK/TSMC180BCD/models/spectre/c018bcd_gen2_v1d6.scs" section=tt_bbmvar
simulator lang=spectre insensitive=no
include "cells.scs"
simulatorOptions options reltol=1e-5 vabstol=1e-7 iabstol=1e-13 temp=27
include "lc_vco_v4r.scs"
VDD (vdd 0) vsource dc=1.2
VVCO (vco_vdd vdd) vsource dc=0
VC (ctrl 0) vsource dc=0.6
VB0 (b0 0) vsource type=pwl wave=[0 0 8e-08 0 8.01e-08 1.2 1.6e-07 1.2 1.601e-07 0 2.4e-07 0 2.401e-07 1.2 3.2e-07 1.2 3.201e-07 0 4e-07 0 4.001e-07 1.2 4.8e-07 1.2 4.801e-07 0 5.6e-07 0 5.601e-07 1.2 6.4e-07 1.2 6.401e-07 0 7.2e-07 0 7.201e-07 1.2 8e-07 1.2 8.001e-07 0 8.8e-07 0 8.801e-07 1.2 9.6e-07 1.2 9.601e-07 0 1.04e-06 0 1.0401e-06 1.2 1.12e-06 1.2 1.1201e-06 0 1.2e-06 0 1.2001e-06 1.2 1.28e-06 1.2 1.2801e-06 0 1.36e-06 0 1.3601e-06 1.2]
VB1 (b1 0) vsource type=pwl wave=[0 0 8e-08 0 8.01e-08 1.2 1.6e-07 1.2 1.601e-07 0 2.4e-07 0 2.401e-07 1.2 3.2e-07 1.2 3.201e-07 0 4e-07 0 4.001e-07 1.2 4.8e-07 1.2 4.801e-07 0 5.6e-07 0 5.601e-07 1.2 6.4e-07 1.2 6.401e-07 0 7.2e-07 0 7.201e-07 1.2 8e-07 1.2 8.001e-07 0 8.8e-07 0 8.801e-07 1.2 9.6e-07 1.2 9.601e-07 0 1.04e-06 0 1.0401e-06 1.2 1.12e-06 1.2 1.1201e-06 0 1.2e-06 0 1.2001e-06 1.2 1.28e-06 1.2 1.2801e-06 0 1.36e-06 0 1.3601e-06 1.2]
VB2 (b2 0) vsource type=pwl wave=[0 0 8e-08 0 8.01e-08 1.2 1.6e-07 1.2 1.601e-07 0 2.4e-07 0 2.401e-07 1.2 3.2e-07 1.2 3.201e-07 0 4e-07 0 4.001e-07 1.2 4.8e-07 1.2 4.801e-07 0 5.6e-07 0 5.601e-07 1.2 6.4e-07 1.2 6.401e-07 0 7.2e-07 0 7.201e-07 1.2 8e-07 1.2 8.001e-07 0 8.8e-07 0 8.801e-07 1.2 9.6e-07 1.2 9.601e-07 0 1.04e-06 0 1.0401e-06 1.2 1.12e-06 1.2 1.1201e-06 0 1.2e-06 0 1.2001e-06 1.2 1.28e-06 1.2 1.2801e-06 0 1.36e-06 0 1.3601e-06 1.2]
VB3 (b3 0) vsource type=pwl wave=[0 0 1.6e-07 0 1.601e-07 1.2 3.2e-07 1.2 3.201e-07 0 4e-07 0 4.001e-07 1.2 4.8e-07 1.2 4.801e-07 0 5.6e-07 0 5.601e-07 1.2 6.4e-07 1.2 6.401e-07 0 8e-07 0 8.001e-07 1.2 9.6e-07 1.2 9.601e-07 0 1.12e-06 0 1.1201e-06 1.2 1.28e-06 1.2 1.2801e-06 0 1.36e-06 0 1.3601e-06 1.2]
VB4 (b4 0) vsource type=pwl wave=[0 0 3.2e-07 0 3.201e-07 1.2 4.8e-07 1.2 4.801e-07 0 5.6e-07 0 5.601e-07 1.2 6.4e-07 1.2 6.401e-07 0 8.8e-07 0 8.801e-07 1.2 9.6e-07 1.2 9.601e-07 0 1.04e-06 0 1.0401e-06 1.2 1.28e-06 1.2 1.2801e-06 0 1.36e-06 0 1.3601e-06 1.2]
VB5 (b5 0) vsource type=pwl wave=[0 0 4.8e-07 0 4.801e-07 1.2 6.4e-07 1.2 6.401e-07 0 7.2e-07 0 7.201e-07 1.2 9.6e-07 1.2 9.601e-07 0 1.04e-06 0 1.0401e-06 1.2 1.28e-06 1.2 1.2801e-06 0 1.36e-06 0 1.3601e-06 1.2]
VB6 (b6 0) vsource type=pwl wave=[0 0 6.4e-07 0 6.401e-07 1.2 9.6e-07 1.2 9.601e-07 0 1.04e-06 0 1.0401e-06 1.2 1.28e-06 1.2 1.2801e-06 0 1.36e-06 0 1.3601e-06 1.2]
VB7 (b7 0) vsource type=pwl wave=[0 0 9.6e-07 0 9.601e-07 1.2 1.28e-06 1.2 1.2801e-06 0 1.36e-06 0 1.3601e-06 1.2]
XV (vp vn ctrl b0 b1 b2 b3 b4 b5 b6 b7 vco_vdd 0) tx_lc_vco_v4r fixed_c=1e-14 tank_l=2e-09 series_r=6.822430344006 cscale=1 core_w=0.00012 pcore_w=8e-05 ibias=8e-05 unit_c=4.4e-15 unit_w=1.2e-06 fine_w=4.5e-06
CPROX (vp 0) capacitor c=1.4e-13
CNROX (vn 0) capacitor c=1.4e-13
ic vp=1.20001 vn=1.2
tran tran stop=1.44e-06 maxstep=5e-12 errpreset=conservative
save vp vn XV.XL.tail VDD:p VVCO:p
saveOptions options save=selected
