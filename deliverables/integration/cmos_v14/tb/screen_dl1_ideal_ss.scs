simulator lang=spectre
global 0
include "/home/process/tsmc180bcd_gen2_2022/PDK/TSMC180BCD/models/spectre/c018bcd_gen2_v1d6.scs" section=ss
include "/home/process/tsmc180bcd_gen2_2022/PDK/TSMC180BCD/models/spectre/c018bcd_gen2_v1d6.scs" section=stat_noise
simulator lang=spectre insensitive=no
include "cells.scs"
simulatorOptions options reltol=1e-5 vabstol=1e-7 iabstol=1e-13 temp=60
VDD (vdd 0) vsource dc=1.2
ahdl_include "tank_waveform_v5.va"
XRF (vp vn 0) tank_waveform_v5
include "rf_cc4_v13.scs"
include "div_dl1_v14.scs"
include "rtcomb_v13.scs"
VRX (rx_vdd vdd) vsource dc=0
VRT (rt_vdd vdd) vsource dc=0
VCLK (clk 0) vsource type=pulse val0=0 val1=1.2 period=1/3.936G rise=30p fall=30p width=0.5/3.936G-30p
XD (clk rst q1 data vdd 0) div_dl1_v14
XR (data clk out rt_vdd 0) rtcomb_v13 scale=2 oscale=2
VRST (rst 0) vsource type=pulse val0=1.2 val1=0 delay=2n rise=20p fall=20p width=1u period=2u
CL (out 0) capacitor c=10f
tran tran stop=100n start=0 outputstart=70n maxstep=1p method=traponly errpreset=conservative
save vp vn clk rst q1 data out XD.clkb XD.mp XD.mn XD.sp XD.sn XD.XM.tail XD.XS.tail XD.q2 XR.qb XR.ob VDD:p VRX:p VRT:p
saveOptions options save=selected
