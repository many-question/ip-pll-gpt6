simulator lang=spectre
global 0
include "/home/process/tsmc180bcd_gen2_2022/PDK/TSMC180BCD/models/spectre/c018bcd_gen2_v1d6.scs" section=tt
include "/home/process/tsmc180bcd_gen2_2022/PDK/TSMC180BCD/models/spectre/c018bcd_gen2_v1d6.scs" section=stat_noise
simulator lang=spectre insensitive=no
include "/home/process/tsmc180bcd_gen2_2022/PDK/TSMC180BCD/models/spectre/c018bcd_gen2_v1d6.scs" section=tt_bbmvar
simulator lang=spectre insensitive=no
include "cells.scs"
include "divider_v2.scs"
include "limiter_chain.scs"
include "divider_bank_v6_clamp.scs"
simulatorOptions options reltol=1e-5 vabstol=1e-7 iabstol=1e-13 temp=27
VDD (vdd 0) vsource dc=1.2
ahdl_include "tank_waveform_v5.va"
XRF (vp vn 0) tank_waveform_v5
VRST (rst 0) vsource type=pwl wave=[0 1.2 20n 1.2 20.02n 0]
XD (vp vn rst vdd 0 0 0 0 0 data vdd 0) tx_divider_bank_v6_clamp rb_input=50k rb_clock=50k cdec=10p
include "rf_mirror_gain4small_v8.scs"
include "retimer_scaled.scs"
VRX (rx_vdd vdd) vsource dc=0
VRT (rt_vdd vdd) vsource dc=0
XRX (vp vn clk rx_vdd 0) tx_rf_mirror_gain4small_v8 wn=8u wp=4u ibias=40u
XRT (data clk out rt_vdd 0) tx_retimer_scaled scale=2 oscale=4 sp=2.5u
CL (out 0) capacitor c=10f
pss pss fund=984M harms=127 tstab=200n maxstep=500f method=traponly errpreset=conservative maxperiods=30 saveinit=yes writefinal="__FINAL_STATE__"
save vp vn data clk out XRX.gp XRX.gn XRX.dp XRX.dn XRX.tail XRX.nb XRX.XGAIN.g0 XRX.XGAIN.o0 XRX.XGAIN.g1 XRX.XGAIN.o1 XRT.clkb VDD:p VRX:p VRT:p
saveOptions options save=selected
pn pnoise start=10k stop=492M dec=30 pnoisemethod=fullspectrum noisetype=sampled measurement=[edge] sampleratio=1 maxsideband=127
edge jitterevent trigger=[out] triggerthresh=0.6 triggernum=1 triggerdir=rise target=[out] jittercal=[Jee]
save XRF:vp_vss_flow XRF:vn_vss_flow
