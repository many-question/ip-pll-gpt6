simulator lang=spectre
global 0
include "/home/process/tsmc180bcd_gen2_2022/PDK/TSMC180BCD/models/spectre/c018bcd_gen2_v1d6.scs" section=ss
include "/home/process/tsmc180bcd_gen2_2022/PDK/TSMC180BCD/models/spectre/c018bcd_gen2_v1d6.scs" section=stat_noise
simulator lang=spectre insensitive=no
include "cells.scs"
simulatorOptions options reltol=1e-5 vabstol=1e-7 iabstol=1e-13 temp=60
VDD (vdd 0) vsource dc=1.2
ahdl_include "tank_scaled_v13.va"
XRF (vp vn 0) tank_scaled_v13 amplitude=1.8
include "rf_one32_v12.scs"
include "cmos_tspc_buffered_v11.scs"
include "tspc_retimer_v12.scs"
VRX (rx_vdd vdd) vsource dc=0
VRT (rt_vdd vdd) vsource dc=0
XRX (vp clk rx_vdd 0) rf_one32_v12
XD (clk q1 data vdd 0) cmos_tspc_buffered_v11
XR (data clk out rt_vdd 0) tspc_retimer_v12 scale=2 oscale=2
CL (out 0) capacitor c=10f
ic XD.q0=0 XD.q2=0
tran tran stop=100n start=0 outputstart=70n maxstep=1p method=traponly errpreset=conservative
save vp vn clk q1 data out XRX.g0 XD.q0 XD.q2 XR.XFF.b XR.XFF.a XR.XFF.n1 XR.qb XR.ob VDD:p VRX:p VRT:p
saveOptions options save=selected
