simulator lang=spectre
global 0
include "/home/process/tsmc180bcd_gen2_2022/PDK/TSMC180BCD/models/spectre/c018bcd_gen2_v1d6.scs" section=ss
include "/home/process/tsmc180bcd_gen2_2022/PDK/TSMC180BCD/models/spectre/c018bcd_gen2_v1d6.scs" section=stat_noise
simulator lang=spectre insensitive=no
include "cells.scs"
include "receiver.scs"
simulatorOptions options reltol=1e-3 vabstol=1e-5 iabstol=1e-12 temp=60

include "digital_cells_v2.scs"
VDD (vdd 0) vsource dc=1.2
VREF (refclk 0) vsource type=pulse val0=0 val1=1.2 delay=10n rise=50p fall=50p width=2.0783333333333334e-08 period=4.166666666666667e-08
Vreset (reset 0) vsource type=pwl wave=[0 1.2 1e-07 1.2 1.0005e-07 0.0]
include "frequency_watchdog.scs"
Vactive (active 0) vsource type=pwl wave=[0 0.0 2e-07 0.0 2.0005e-07 1.2 1.95e-06 1.2 1.95005e-06 0.0 2.2e-06 0.0 2.20005e-06 1.2 3.95e-06 1.2 3.95005e-06 0.0 4.2e-06 0.0 4.20005e-06 1.2 5.95e-06 1.2 5.95005e-06 0.0 6.2e-06 0.0 6.20005e-06 1.2 7.95e-06 1.2 7.95005e-06 0.0 8.2e-06 0.0 8.20005e-06 1.2 9.95e-06 1.2 9.95005e-06 0.0 1.02e-05 0.0 1.020005e-05 1.2 1.195e-05 1.2 1.195005e-05 0.0 1.22e-05 0.0 1.220005e-05 1.2 1.395e-05 1.2 1.395005e-05 0.0 1.42e-05 0.0 1.420005e-05 1.2 1.595e-05 1.2 1.595005e-05 0.0 1.62e-05 0.0 1.620005e-05 1.2 1.795e-05 1.2 1.795005e-05 0.0 1.82e-05 0.0 1.820005e-05 1.2 1.995e-05 1.2 1.995005e-05 0.0 2.02e-05 0.0 2.020005e-05 1.2 2.195e-05 1.2 2.195005e-05 0.0]
Vtarget_k0 (target_k0 0) vsource type=pwl wave=[0 0.0 1.5e-07 0.0 1.5005e-07 1.2 2.15e-06 1.2 2.15005e-06 1.2 4.15e-06 1.2 4.15005e-06 1.2 6.15e-06 1.2 6.15005e-06 1.2 8.15e-06 1.2 8.15005e-06 1.2 1.015e-05 1.2 1.015005e-05 0.0 1.215e-05 0.0 1.215005e-05 1.2 1.415e-05 1.2 1.415005e-05 1.2 1.615e-05 1.2 1.615005e-05 1.2 1.815e-05 1.2 1.815005e-05 0.0 2.015e-05 0.0 2.015005e-05 0.0]
Vtarget_k1 (target_k1 0) vsource type=pwl wave=[0 0.0 1.5e-07 0.0 1.5005e-07 0.0 2.15e-06 0.0 2.15005e-06 0.0 4.15e-06 0.0 4.15005e-06 0.0 6.15e-06 0.0 6.15005e-06 0.0 8.15e-06 0.0 8.15005e-06 0.0 1.015e-05 0.0 1.015005e-05 1.2 1.215e-05 1.2 1.215005e-05 0.0 1.415e-05 0.0 1.415005e-05 0.0 1.615e-05 0.0 1.615005e-05 0.0 1.815e-05 0.0 1.815005e-05 0.0 2.015e-05 0.0 2.015005e-05 1.2]
Vtarget_k2 (target_k2 0) vsource type=pwl wave=[0 0.0 1.5e-07 0.0 1.5005e-07 0.0 2.15e-06 0.0 2.15005e-06 0.0 4.15e-06 0.0 4.15005e-06 0.0 6.15e-06 0.0 6.15005e-06 0.0 8.15e-06 0.0 8.15005e-06 0.0 1.015e-05 0.0 1.015005e-05 1.2 1.215e-05 1.2 1.215005e-05 0.0 1.415e-05 0.0 1.415005e-05 0.0 1.615e-05 0.0 1.615005e-05 0.0 1.815e-05 0.0 1.815005e-05 0.0 2.015e-05 0.0 2.015005e-05 0.0]
Vtarget_k3 (target_k3 0) vsource type=pwl wave=[0 0.0 1.5e-07 0.0 1.5005e-07 1.2 2.15e-06 1.2 2.15005e-06 1.2 4.15e-06 1.2 4.15005e-06 1.2 6.15e-06 1.2 6.15005e-06 1.2 8.15e-06 1.2 8.15005e-06 1.2 1.015e-05 1.2 1.015005e-05 1.2 1.215e-05 1.2 1.215005e-05 1.2 1.415e-05 1.2 1.415005e-05 1.2 1.615e-05 1.2 1.615005e-05 1.2 1.815e-05 1.2 1.815005e-05 1.2 2.015e-05 1.2 2.015005e-05 1.2]
Vtarget_k4 (target_k4 0) vsource type=pwl wave=[0 0.0 1.5e-07 0.0 1.5005e-07 0.0 2.15e-06 0.0 2.15005e-06 0.0 4.15e-06 0.0 4.15005e-06 0.0 6.15e-06 0.0 6.15005e-06 0.0 8.15e-06 0.0 8.15005e-06 0.0 1.015e-05 0.0 1.015005e-05 0.0 1.215e-05 0.0 1.215005e-05 0.0 1.415e-05 0.0 1.415005e-05 0.0 1.615e-05 0.0 1.615005e-05 0.0 1.815e-05 0.0 1.815005e-05 0.0 2.015e-05 0.0 2.015005e-05 0.0]
Vtarget_k5 (target_k5 0) vsource type=pwl wave=[0 0.0 1.5e-07 0.0 1.5005e-07 1.2 2.15e-06 1.2 2.15005e-06 1.2 4.15e-06 1.2 4.15005e-06 1.2 6.15e-06 1.2 6.15005e-06 1.2 8.15e-06 1.2 8.15005e-06 1.2 1.015e-05 1.2 1.015005e-05 0.0 1.215e-05 0.0 1.215005e-05 0.0 1.415e-05 0.0 1.415005e-05 0.0 1.615e-05 0.0 1.615005e-05 1.2 1.815e-05 1.2 1.815005e-05 0.0 2.015e-05 0.0 2.015005e-05 1.2]
Vmeasured0 (measured0 0) vsource type=pwl wave=[0 0.0 1.5e-07 0.0 1.5005e-07 0.0 2.15e-06 0.0 2.15005e-06 1.2 4.15e-06 1.2 4.15005e-06 1.2 6.15e-06 1.2 6.15005e-06 0.0 8.15e-06 0.0 8.15005e-06 0.0 1.015e-05 0.0 1.015005e-05 0.0 1.215e-05 0.0 1.215005e-05 0.0 1.415e-05 0.0 1.415005e-05 0.0 1.615e-05 0.0 1.615005e-05 1.2 1.815e-05 1.2 1.815005e-05 0.0 2.015e-05 0.0 2.015005e-05 0.0]
Vmeasured1 (measured1 0) vsource type=pwl wave=[0 0.0 1.5e-07 0.0 1.5005e-07 0.0 2.15e-06 0.0 2.15005e-06 1.2 4.15e-06 1.2 4.15005e-06 0.0 6.15e-06 0.0 6.15005e-06 1.2 8.15e-06 1.2 8.15005e-06 1.2 1.015e-05 1.2 1.015005e-05 0.0 1.215e-05 0.0 1.215005e-05 0.0 1.415e-05 0.0 1.415005e-05 0.0 1.615e-05 0.0 1.615005e-05 1.2 1.815e-05 1.2 1.815005e-05 0.0 2.015e-05 0.0 2.015005e-05 0.0]
Vmeasured2 (measured2 0) vsource type=pwl wave=[0 0.0 1.5e-07 0.0 1.5005e-07 0.0 2.15e-06 0.0 2.15005e-06 1.2 4.15e-06 1.2 4.15005e-06 0.0 6.15e-06 0.0 6.15005e-06 1.2 8.15e-06 1.2 8.15005e-06 0.0 1.015e-05 0.0 1.015005e-05 0.0 1.215e-05 0.0 1.215005e-05 0.0 1.415e-05 0.0 1.415005e-05 0.0 1.615e-05 0.0 1.615005e-05 1.2 1.815e-05 1.2 1.815005e-05 0.0 2.015e-05 0.0 2.015005e-05 0.0]
Vmeasured3 (measured3 0) vsource type=pwl wave=[0 0.0 1.5e-07 0.0 1.5005e-07 0.0 2.15e-06 0.0 2.15005e-06 1.2 4.15e-06 1.2 4.15005e-06 0.0 6.15e-06 0.0 6.15005e-06 1.2 8.15e-06 1.2 8.15005e-06 0.0 1.015e-05 0.0 1.015005e-05 0.0 1.215e-05 0.0 1.215005e-05 0.0 1.415e-05 0.0 1.415005e-05 0.0 1.615e-05 0.0 1.615005e-05 1.2 1.815e-05 1.2 1.815005e-05 0.0 2.015e-05 0.0 2.015005e-05 0.0]
Vmeasured4 (measured4 0) vsource type=pwl wave=[0 0.0 1.5e-07 0.0 1.5005e-07 0.0 2.15e-06 0.0 2.15005e-06 1.2 4.15e-06 1.2 4.15005e-06 0.0 6.15e-06 0.0 6.15005e-06 1.2 8.15e-06 1.2 8.15005e-06 0.0 1.015e-05 0.0 1.015005e-05 0.0 1.215e-05 0.0 1.215005e-05 0.0 1.415e-05 0.0 1.415005e-05 0.0 1.615e-05 0.0 1.615005e-05 1.2 1.815e-05 1.2 1.815005e-05 0.0 2.015e-05 0.0 2.015005e-05 0.0]
Vmeasured5 (measured5 0) vsource type=pwl wave=[0 0.0 1.5e-07 0.0 1.5005e-07 1.2 2.15e-06 1.2 2.15005e-06 0.0 4.15e-06 0.0 4.15005e-06 1.2 6.15e-06 1.2 6.15005e-06 0.0 8.15e-06 0.0 8.15005e-06 1.2 1.015e-05 1.2 1.015005e-05 0.0 1.215e-05 0.0 1.215005e-05 1.2 1.415e-05 1.2 1.415005e-05 0.0 1.615e-05 0.0 1.615005e-05 1.2 1.815e-05 1.2 1.815005e-05 0.0 2.015e-05 0.0 2.015005e-05 0.0]
Vmeasured6 (measured6 0) vsource type=pwl wave=[0 0.0 1.5e-07 0.0 1.5005e-07 0.0 2.15e-06 0.0 2.15005e-06 0.0 4.15e-06 0.0 4.15005e-06 0.0 6.15e-06 0.0 6.15005e-06 0.0 8.15e-06 0.0 8.15005e-06 0.0 1.015e-05 0.0 1.015005e-05 1.2 1.215e-05 1.2 1.215005e-05 0.0 1.415e-05 0.0 1.415005e-05 0.0 1.615e-05 0.0 1.615005e-05 1.2 1.815e-05 1.2 1.815005e-05 0.0 2.015e-05 0.0 2.015005e-05 1.2]
Vmeasured7 (measured7 0) vsource type=pwl wave=[0 0.0 1.5e-07 0.0 1.5005e-07 0.0 2.15e-06 0.0 2.15005e-06 0.0 4.15e-06 0.0 4.15005e-06 0.0 6.15e-06 0.0 6.15005e-06 0.0 8.15e-06 0.0 8.15005e-06 0.0 1.015e-05 0.0 1.015005e-05 1.2 1.215e-05 1.2 1.215005e-05 0.0 1.415e-05 0.0 1.415005e-05 0.0 1.615e-05 0.0 1.615005e-05 1.2 1.815e-05 1.2 1.815005e-05 0.0 2.015e-05 0.0 2.015005e-05 0.0]
Vmeasured8 (measured8 0) vsource type=pwl wave=[0 0.0 1.5e-07 0.0 1.5005e-07 1.2 2.15e-06 1.2 2.15005e-06 1.2 4.15e-06 1.2 4.15005e-06 1.2 6.15e-06 1.2 6.15005e-06 1.2 8.15e-06 1.2 8.15005e-06 1.2 1.015e-05 1.2 1.015005e-05 1.2 1.215e-05 1.2 1.215005e-05 1.2 1.415e-05 1.2 1.415005e-05 0.0 1.615e-05 0.0 1.615005e-05 1.2 1.815e-05 1.2 1.815005e-05 1.2 2.015e-05 1.2 2.015005e-05 1.2]
Vmeasured9 (measured9 0) vsource type=pwl wave=[0 0.0 1.5e-07 0.0 1.5005e-07 0.0 2.15e-06 0.0 2.15005e-06 0.0 4.15e-06 0.0 4.15005e-06 0.0 6.15e-06 0.0 6.15005e-06 0.0 8.15e-06 0.0 8.15005e-06 0.0 1.015e-05 0.0 1.015005e-05 0.0 1.215e-05 0.0 1.215005e-05 0.0 1.415e-05 0.0 1.415005e-05 0.0 1.615e-05 0.0 1.615005e-05 1.2 1.815e-05 1.2 1.815005e-05 0.0 2.015e-05 0.0 2.015005e-05 0.0]
Vmeasured10 (measured10 0) vsource type=pwl wave=[0 0.0 1.5e-07 0.0 1.5005e-07 1.2 2.15e-06 1.2 2.15005e-06 1.2 4.15e-06 1.2 4.15005e-06 1.2 6.15e-06 1.2 6.15005e-06 1.2 8.15e-06 1.2 8.15005e-06 1.2 1.015e-05 1.2 1.015005e-05 0.0 1.215e-05 0.0 1.215005e-05 0.0 1.415e-05 0.0 1.415005e-05 0.0 1.615e-05 0.0 1.615005e-05 1.2 1.815e-05 1.2 1.815005e-05 0.0 2.015e-05 0.0 2.015005e-05 1.2]
Vmeasured11 (measured11 0) vsource type=pwl wave=[0 0.0 1.5e-07 0.0 1.5005e-07 0.0 2.15e-06 0.0 2.15005e-06 0.0 4.15e-06 0.0 4.15005e-06 0.0 6.15e-06 0.0 6.15005e-06 0.0 8.15e-06 0.0 8.15005e-06 0.0 1.015e-05 0.0 1.015005e-05 0.0 1.215e-05 0.0 1.215005e-05 0.0 1.415e-05 0.0 1.415005e-05 0.0 1.615e-05 0.0 1.615005e-05 1.2 1.815e-05 1.2 1.815005e-05 0.0 2.015e-05 0.0 2.015005e-05 0.0]
Vmeasured12 (measured12 0) vsource type=pwl wave=[0 0.0 1.5e-07 0.0 1.5005e-07 0.0 2.15e-06 0.0 2.15005e-06 0.0 4.15e-06 0.0 4.15005e-06 0.0 6.15e-06 0.0 6.15005e-06 0.0 8.15e-06 0.0 8.15005e-06 0.0 1.015e-05 0.0 1.015005e-05 0.0 1.215e-05 0.0 1.215005e-05 0.0 1.415e-05 0.0 1.415005e-05 0.0 1.615e-05 0.0 1.615005e-05 1.2 1.815e-05 1.2 1.815005e-05 0.0 2.015e-05 0.0 2.015005e-05 0.0]
Vmeasured13 (measured13 0) vsource type=pwl wave=[0 0.0 1.5e-07 0.0 1.5005e-07 0.0 2.15e-06 0.0 2.15005e-06 0.0 4.15e-06 0.0 4.15005e-06 0.0 6.15e-06 0.0 6.15005e-06 0.0 8.15e-06 0.0 8.15005e-06 0.0 1.015e-05 0.0 1.015005e-05 0.0 1.215e-05 0.0 1.215005e-05 0.0 1.415e-05 0.0 1.415005e-05 0.0 1.615e-05 0.0 1.615005e-05 1.2 1.815e-05 1.2 1.815005e-05 0.0 2.015e-05 0.0 2.015005e-05 0.0]
XD (refclk reset active target_k0 target_k1 target_k2 target_k3 target_k4 target_k5 measured0 measured1 measured2 measured3 measured4 measured5 measured6 measured7 measured8 measured9 measured10 measured11 measured12 measured13 count_gate count_reset frequency_good valid vdd 0) tx_frequency_watchdog
Ccount_gate (count_gate 0) capacitor c=20f
Ccount_reset (count_reset 0) capacitor c=20f
Cfrequency_good (frequency_good 0) capacitor c=20f
Cvalid (valid 0) capacitor c=20f
tran tran stop=22.2u maxstep=2n method=gear2only errpreset=moderate strobeperiod=1n strobeoutput=strobeonly
save refclk reset active target_k0 target_k1 target_k2 target_k3 target_k4 target_k5 measured0 measured1 measured2 measured3 measured4 measured5 measured6 measured7 measured8 measured9 measured10 measured11 measured12 measured13 count_gate count_reset frequency_good valid VDD:p
saveOptions options save=selected
