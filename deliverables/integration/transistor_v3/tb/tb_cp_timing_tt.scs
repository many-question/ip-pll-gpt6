simulator lang=spectre
global 0
include "/home/process/tsmc180bcd_gen2_2022/PDK/TSMC180BCD/models/spectre/c018bcd_gen2_v1d6.scs" section=tt
include "/home/process/tsmc180bcd_gen2_2022/PDK/TSMC180BCD/models/spectre/c018bcd_gen2_v1d6.scs" section=stat_noise
simulator lang=spectre insensitive=no
include "cells.scs"
include "receiver.scs"
simulatorOptions options reltol=1e-5 vabstol=1e-7 iabstol=1e-13 temp=27

include "digital_cells_v2.scs"
include "cp_timing.scs"
include "cp_experiment.scs"
VDD (vdd 0) vsource dc=1.2
VR (ref 0) vsource type=pulse val0=0 val1=1.2 delay=10n rise=50p fall=50p width=20.7833333333n period=41.6666666667n
VE (enable 0) vsource type=pwl wave=[0 0 40n 0 40.05n 1.2 96n 1.2 96.05n 0 210n 0 210.05n 1.2]
VRESET (reset 0) vsource type=pwl wave=[0 1.2 5n 1.2 5.05n 0 263n 0 263.05n 1.2 264n 1.2 264.05n 0]
VP (hp 0) vsource dc=.6002
VN (hn 0) vsource dc=.6
VO (out 0) vsource dc=.6
XT (ref enable reset pulse vdd 0) tx_cp_timing
XP (hp hn pulse vdd out vdd 0) tx_cp_experiment
tran tran stop=400n maxstep=20p errpreset=conservative
save ref enable reset pulse XT.d12 XT.d24 XT.en_hold VO:p VDD:p
saveOptions options save=selected
