simulator lang=spectre
global 0
include "/home/process/tsmc180bcd_gen2_2022/PDK/TSMC180BCD/models/spectre/c018bcd_gen2_v1d6.scs" section=tt
include "/home/process/tsmc180bcd_gen2_2022/PDK/TSMC180BCD/models/spectre/c018bcd_gen2_v1d6.scs" section=stat_noise
simulator lang=spectre insensitive=no
include "cells.scs"
include "pll_config.scs"
include "pll_supervisor.scs"
parameters vddval=1.2
VDD (vdd_supply 0) vsource dc=vddval
simulatorOptions options reltol=1e-4 vabstol=1e-7 iabstol=1e-13 temp=27
ahdl_include "auxiliary_fll.va"
ahdl_include "bias_control.va"
ahdl_include "charge_pump.va"
ahdl_include "even_divider.va"
ahdl_include "lc_vco.va"
ahdl_include "loop_filter.va"
ahdl_include "output_buffer.va"
ahdl_include "output_retimer.va"
ahdl_include "pll_monitor.va"
ahdl_include "reference_buffer.va"
ahdl_include "subsampling_detector.va"
include "digital_cells_v2.scs"
include "cp_timing.scs"
ahdl_include "supply_meter.va"
XMETER (vdd_supply vdd 0 power_mw) supply_meter start=4u
VREF (ref 0) vsource type=pulse val0=0 val1=1.2 period=41.6666666666667n width=20.8233333333333n rise=10p fall=10p delay=1n
VN (target 0) vsource dc=164
VM (ratio 0) vsource dc=4
VDIST (dist 0) vsource dc=0
XREF (ref refb vdd 0) tx_reference_buffer
CREFLOAD (refb 0) capacitor c=60f
XBIAS (vdd 0 vmid) tx_bias_mid
XVCO (ctrl code dist vmid vp vn vcoclk fvco vdd 0) lc_vco points_per_cycle=16
XPD (refb vp vn hp hn vdd 0) tx_sampler
XTIME (refb enable rst pulse vdd 0) tx_cp_timing
include "cp_experiment.scs"
XCP (hp hn pulse enable ctrl vdd 0) tx_cp_experiment
XLF (ctrl vc1 enable preset vdd 0) tx_loop_filter rlf=100k
VCODE (code 0) vsource dc=6
VEN (fll_enable 0) vsource dc=1.2
VPRE (preset 0) vsource dc=0.3806856424844265
// Fixed-code isolation test: no claim of acquisition or qualified FLL lock.
ic ctrl=0.3806856424844265 vc1=0.3806856424844265
include "divider_v2.scs"
include "limiter_chain.scs"
include "bank_divider_v2.scs"
VRST (reset 0) vsource type=pulse val0=1.2 val1=0 delay=20n rise=20p fall=20p width=1m period=2m
XDIV (vp vn rst s0 s1 s2 s3 s4 s5 div vdd 0) tx_divider_bank
include "retimer_scaled.scs"
XRT (div vcoclk out vdd 0) tx_retimer_scaled scale=4 oscale=4 sp=2.5u
VAPPLY (apply 0) vsource type=pulse val0=0 val1=1.2 delay=60n rise=50p fall=50p width=300n period=100u
VK0 (k0 0) vsource dc=1.2
VK1 (k1 0) vsource dc=0
VK2 (k2 0) vsource dc=0
VK3 (k3 0) vsource dc=1.2
VK4 (k4 0) vsource dc=0
VK5 (k5 0) vsource dc=1.2
XCONFIG (refb reset apply k0 k1 k2 k3 k4 k5 ak0 ak1 ak2 ak3 ak4 ak5 s0 s1 s2 s3 s4 s5 ready invalid rst vdd 0) tx_pll_config
XSUP (refb reset ready fll_enable 0 0 0 enable qualified restart fault vdd 0) tx_pll_supervisor
CLOAD (out 0) capacitor c=10f
XMEAS (out refb vp vn ctrl freqout dutyout edgecount phaseerr vmax vmin vdd 0) pll_monitor start=4u
ahdl_include "loop_observer.va"
XOBS (refb ctrl vc1 cycle_ctrl cycle_vc1 0) loop_observer
tran tran method=gear2only stop=6u errpreset=moderate strobeperiod=10n strobeoutput=strobeonly
save ready invalid rst enable qualified restart fault cycle_ctrl cycle_vc1 power_mw preset vmid hp hn ctrl vc1 code enable fvco freqout dutyout edgecount phaseerr vmax vmin
saveOptions options save=selected
