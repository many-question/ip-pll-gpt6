simulator lang=spectre
global 0
include "/home/process/tsmc180bcd_gen2_2022/PDK/TSMC180BCD/models/spectre/c018bcd_gen2_v1d6.scs" section=tt
include "/home/process/tsmc180bcd_gen2_2022/PDK/TSMC180BCD/models/spectre/c018bcd_gen2_v1d6.scs" section=stat_noise
simulator lang=spectre insensitive=no
include "/home/process/tsmc180bcd_gen2_2022/PDK/TSMC180BCD/models/spectre/c018bcd_gen2_v1d6.scs" section=tt_bbmvar
simulator lang=spectre insensitive=no
include "cells.scs"
parameters vddval=1.2
VDD (vdd 0) vsource dc=vddval
simulatorOptions options reltol=1e-5 vabstol=1e-7 iabstol=1e-13 temp=27
include "lc_vco_rlc.scs"
VC (ctrl 0) vsource dc=0.2
VB0 (b0 0) vsource dc=1.2
VB1 (b1 0) vsource dc=1.2
VB2 (b2 0) vsource dc=1.2
VB3 (b3 0) vsource dc=1.2
VB4 (b4 0) vsource dc=1.2
VB5 (b5 0) vsource dc=1.2
VB6 (b6 0) vsource dc=1.2
VB7 (b7 0) vsource dc=1.2
XV (vp vn ctrl b0 b1 b2 b3 b4 b5 b6 b7 vdd 0) tx_lc_vco_rlc fixed_c=60f series_r=6.8224303440060226
include "divider_v2.scs"
include "limiter_chain.scs"
include "bank_divider_light.scs"
include "cp_experiment.scs"
include "digital_cells_v2.scs"
include "cp_timing.scs"
XBM (vdd 0 vmid) tx_bias_mid
CCP (vp sp) capacitor c=120f
CCN (vn sn) capacitor c=120f
RBP (sp vmid) resistor r=100k
RBN (sn vmid) resistor r=100k
VR (ref 0) vsource type=pulse val0=0 val1=1.2 period=41.6666666666667n width=20.8233333333333n rise=10p fall=10p delay=1n
XR (ref refb vdd 0) tx_reference_buffer
CR (refb 0) capacitor c=60f
XS (refb sp sn hp hn vdd 0) tx_sampler
XA (refb en rst pulse vdd 0) tx_cp_timing
VE (en 0) vsource dc=1.2
XCP (hp hn pulse en cpout vdd 0) tx_cp_experiment
VO (cpout 0) vsource dc=.6
VRST (rst 0) vsource type=pulse val0=1.2 val1=0 delay=20n rise=20p fall=20p width=1u period=2u
XD (vp vn rst 0 0 vdd 0 0 0 out vdd 0) tx_divider_bank_light
CL (out 0) capacitor c=10f
ic vp=1.20001 vn=1.2
tran tran stop=300n errpreset=conservative maxstep=5p
save XD.XCP4.MP:b XD.XCN4.MP:b vp vn sp sn vmid hp hn out XD.selected XD.icp XD.icn VO:p XV.XL.tail VDD:p
saveOptions options save=selected
