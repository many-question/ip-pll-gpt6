simulator lang=spectre
global 0
include "/home/process/tsmc180bcd_gen2_2022/PDK/TSMC180BCD/models/spectre/c018bcd_gen2_v1d6.scs" section=tt
include "/home/process/tsmc180bcd_gen2_2022/PDK/TSMC180BCD/models/spectre/c018bcd_gen2_v1d6.scs" section=stat_noise
simulator lang=spectre insensitive=no
include "cells.scs"
include "receiver.scs"
simulatorOptions options reltol=1e-3 vabstol=1e-5 iabstol=1e-12 temp=27

include "digital_cells_v2.scs"
VDD (vdd 0) vsource dc=1.2
VREF (refclk 0) vsource type=pulse val0=0 val1=1.2 delay=10n rise=50p fall=50p width=2.0783333333333334e-08 period=4.166666666666667e-08
Vreset (reset 0) vsource type=pwl wave=[0 1.2 1e-07 1.2 1.0005e-07 0.0]
include "pll_config.scs"
Vcfg_k0 (cfg_k0 0) vsource type=pwl wave=[0 0.0 1.5e-07 0.0 1.5005e-07 0.0 1.15e-06 0.0 1.15005e-06 1.2 2.15e-06 1.2 2.15005e-06 0.0 3.15e-06 0.0 3.15005e-06 1.2 4.15e-06 1.2 4.15005e-06 0.0 5.15e-06 0.0 5.15005e-06 1.2 6.15e-06 1.2 6.15005e-06 0.0 7.15e-06 0.0 7.15005e-06 1.2 8.15e-06 1.2 8.15005e-06 0.0 9.15e-06 0.0 9.15005e-06 1.2 1.015e-05 1.2 1.015005e-05 0.0 1.115e-05 0.0 1.115005e-05 1.2 1.215e-05 1.2 1.215005e-05 0.0 1.315e-05 0.0 1.315005e-05 1.2 1.415e-05 1.2 1.415005e-05 0.0 1.515e-05 0.0 1.515005e-05 1.2 1.615e-05 1.2 1.615005e-05 0.0 1.715e-05 0.0 1.715005e-05 1.2 1.815e-05 1.2 1.815005e-05 0.0 1.915e-05 0.0 1.915005e-05 1.2 2.015e-05 1.2 2.015005e-05 0.0 2.115e-05 0.0 2.115005e-05 1.2 2.215e-05 1.2 2.215005e-05 0.0 2.315e-05 0.0 2.315005e-05 1.2 2.415e-05 1.2 2.415005e-05 0.0 2.515e-05 0.0 2.515005e-05 1.2 2.615e-05 1.2 2.615005e-05 0.0 2.715e-05 0.0 2.715005e-05 1.2 2.815e-05 1.2 2.815005e-05 0.0 2.915e-05 0.0 2.915005e-05 1.2 3.015e-05 1.2 3.015005e-05 0.0 3.115e-05 0.0 3.115005e-05 1.2 3.215e-05 1.2 3.215005e-05 0.0 3.315e-05 0.0 3.315005e-05 1.2 3.415e-05 1.2 3.415005e-05 0.0 3.515e-05 0.0 3.515005e-05 1.2 3.615e-05 1.2 3.615005e-05 0.0 3.715e-05 0.0 3.715005e-05 1.2 3.815e-05 1.2 3.815005e-05 0.0 3.915e-05 0.0 3.915005e-05 1.2 4.015e-05 1.2 4.015005e-05 0.0 4.115e-05 0.0 4.115005e-05 1.2 4.215e-05 1.2 4.215005e-05 0.0 4.315e-05 0.0 4.315005e-05 1.2 4.415e-05 1.2 4.415005e-05 0.0 4.515e-05 0.0 4.515005e-05 1.2 4.615e-05 1.2 4.615005e-05 0.0 4.715e-05 0.0 4.715005e-05 1.2 4.815e-05 1.2 4.815005e-05 0.0 4.915e-05 0.0 4.915005e-05 1.2 5.015e-05 1.2 5.015005e-05 0.0 5.115e-05 0.0 5.115005e-05 1.2 5.215e-05 1.2 5.215005e-05 0.0 5.315e-05 0.0 5.315005e-05 1.2 5.415e-05 1.2 5.415005e-05 0.0 5.515e-05 0.0 5.515005e-05 1.2 5.615e-05 1.2 5.615005e-05 0.0 5.715e-05 0.0 5.715005e-05 1.2 5.815e-05 1.2 5.815005e-05 0.0 5.915e-05 0.0 5.915005e-05 1.2 6.015e-05 1.2 6.015005e-05 0.0 6.115e-05 0.0 6.115005e-05 1.2 6.215e-05 1.2 6.215005e-05 0.0 6.315e-05 0.0 6.315005e-05 1.2 6.415e-05 1.2 6.415005e-05 1.2 6.515e-05 1.2 6.515005e-05 1.2 6.615e-05 1.2 6.615005e-05 0.0 6.715e-05 0.0 6.715005e-05 0.0 6.815e-05 0.0 6.815005e-05 1.2 6.915e-05 1.2 6.915005e-05 0.0 7.015e-05 0.0 7.015005e-05 1.2 7.115e-05 1.2 7.115005e-05 0.0]
Vcfg_k1 (cfg_k1 0) vsource type=pwl wave=[0 0.0 1.5e-07 0.0 1.5005e-07 0.0 1.15e-06 0.0 1.15005e-06 0.0 2.15e-06 0.0 2.15005e-06 1.2 3.15e-06 1.2 3.15005e-06 1.2 4.15e-06 1.2 4.15005e-06 0.0 5.15e-06 0.0 5.15005e-06 0.0 6.15e-06 0.0 6.15005e-06 1.2 7.15e-06 1.2 7.15005e-06 1.2 8.15e-06 1.2 8.15005e-06 0.0 9.15e-06 0.0 9.15005e-06 0.0 1.015e-05 0.0 1.015005e-05 1.2 1.115e-05 1.2 1.115005e-05 1.2 1.215e-05 1.2 1.215005e-05 0.0 1.315e-05 0.0 1.315005e-05 0.0 1.415e-05 0.0 1.415005e-05 1.2 1.515e-05 1.2 1.515005e-05 1.2 1.615e-05 1.2 1.615005e-05 0.0 1.715e-05 0.0 1.715005e-05 0.0 1.815e-05 0.0 1.815005e-05 1.2 1.915e-05 1.2 1.915005e-05 1.2 2.015e-05 1.2 2.015005e-05 0.0 2.115e-05 0.0 2.115005e-05 0.0 2.215e-05 0.0 2.215005e-05 1.2 2.315e-05 1.2 2.315005e-05 1.2 2.415e-05 1.2 2.415005e-05 0.0 2.515e-05 0.0 2.515005e-05 0.0 2.615e-05 0.0 2.615005e-05 1.2 2.715e-05 1.2 2.715005e-05 1.2 2.815e-05 1.2 2.815005e-05 0.0 2.915e-05 0.0 2.915005e-05 0.0 3.015e-05 0.0 3.015005e-05 1.2 3.115e-05 1.2 3.115005e-05 1.2 3.215e-05 1.2 3.215005e-05 0.0 3.315e-05 0.0 3.315005e-05 0.0 3.415e-05 0.0 3.415005e-05 1.2 3.515e-05 1.2 3.515005e-05 1.2 3.615e-05 1.2 3.615005e-05 0.0 3.715e-05 0.0 3.715005e-05 0.0 3.815e-05 0.0 3.815005e-05 1.2 3.915e-05 1.2 3.915005e-05 1.2 4.015e-05 1.2 4.015005e-05 0.0 4.115e-05 0.0 4.115005e-05 0.0 4.215e-05 0.0 4.215005e-05 1.2 4.315e-05 1.2 4.315005e-05 1.2 4.415e-05 1.2 4.415005e-05 0.0 4.515e-05 0.0 4.515005e-05 0.0 4.615e-05 0.0 4.615005e-05 1.2 4.715e-05 1.2 4.715005e-05 1.2 4.815e-05 1.2 4.815005e-05 0.0 4.915e-05 0.0 4.915005e-05 0.0 5.015e-05 0.0 5.015005e-05 1.2 5.115e-05 1.2 5.115005e-05 1.2 5.215e-05 1.2 5.215005e-05 0.0 5.315e-05 0.0 5.315005e-05 0.0 5.415e-05 0.0 5.415005e-05 1.2 5.515e-05 1.2 5.515005e-05 1.2 5.615e-05 1.2 5.615005e-05 0.0 5.715e-05 0.0 5.715005e-05 0.0 5.815e-05 0.0 5.815005e-05 1.2 5.915e-05 1.2 5.915005e-05 1.2 6.015e-05 1.2 6.015005e-05 0.0 6.115e-05 0.0 6.115005e-05 0.0 6.215e-05 0.0 6.215005e-05 1.2 6.315e-05 1.2 6.315005e-05 1.2 6.415e-05 1.2 6.415005e-05 0.0 6.515e-05 0.0 6.515005e-05 0.0 6.615e-05 0.0 6.615005e-05 0.0 6.715e-05 0.0 6.715005e-05 1.2 6.815e-05 1.2 6.815005e-05 1.2 6.915e-05 1.2 6.915005e-05 1.2 7.015e-05 1.2 7.015005e-05 0.0 7.115e-05 0.0 7.115005e-05 1.2]
Vcfg_k2 (cfg_k2 0) vsource type=pwl wave=[0 0.0 1.5e-07 0.0 1.5005e-07 0.0 1.15e-06 0.0 1.15005e-06 0.0 2.15e-06 0.0 2.15005e-06 0.0 3.15e-06 0.0 3.15005e-06 0.0 4.15e-06 0.0 4.15005e-06 1.2 5.15e-06 1.2 5.15005e-06 1.2 6.15e-06 1.2 6.15005e-06 1.2 7.15e-06 1.2 7.15005e-06 1.2 8.15e-06 1.2 8.15005e-06 0.0 9.15e-06 0.0 9.15005e-06 0.0 1.015e-05 0.0 1.015005e-05 0.0 1.115e-05 0.0 1.115005e-05 0.0 1.215e-05 0.0 1.215005e-05 1.2 1.315e-05 1.2 1.315005e-05 1.2 1.415e-05 1.2 1.415005e-05 1.2 1.515e-05 1.2 1.515005e-05 1.2 1.615e-05 1.2 1.615005e-05 0.0 1.715e-05 0.0 1.715005e-05 0.0 1.815e-05 0.0 1.815005e-05 0.0 1.915e-05 0.0 1.915005e-05 0.0 2.015e-05 0.0 2.015005e-05 1.2 2.115e-05 1.2 2.115005e-05 1.2 2.215e-05 1.2 2.215005e-05 1.2 2.315e-05 1.2 2.315005e-05 1.2 2.415e-05 1.2 2.415005e-05 0.0 2.515e-05 0.0 2.515005e-05 0.0 2.615e-05 0.0 2.615005e-05 0.0 2.715e-05 0.0 2.715005e-05 0.0 2.815e-05 0.0 2.815005e-05 1.2 2.915e-05 1.2 2.915005e-05 1.2 3.015e-05 1.2 3.015005e-05 1.2 3.115e-05 1.2 3.115005e-05 1.2 3.215e-05 1.2 3.215005e-05 0.0 3.315e-05 0.0 3.315005e-05 0.0 3.415e-05 0.0 3.415005e-05 0.0 3.515e-05 0.0 3.515005e-05 0.0 3.615e-05 0.0 3.615005e-05 1.2 3.715e-05 1.2 3.715005e-05 1.2 3.815e-05 1.2 3.815005e-05 1.2 3.915e-05 1.2 3.915005e-05 1.2 4.015e-05 1.2 4.015005e-05 0.0 4.115e-05 0.0 4.115005e-05 0.0 4.215e-05 0.0 4.215005e-05 0.0 4.315e-05 0.0 4.315005e-05 0.0 4.415e-05 0.0 4.415005e-05 1.2 4.515e-05 1.2 4.515005e-05 1.2 4.615e-05 1.2 4.615005e-05 1.2 4.715e-05 1.2 4.715005e-05 1.2 4.815e-05 1.2 4.815005e-05 0.0 4.915e-05 0.0 4.915005e-05 0.0 5.015e-05 0.0 5.015005e-05 0.0 5.115e-05 0.0 5.115005e-05 0.0 5.215e-05 0.0 5.215005e-05 1.2 5.315e-05 1.2 5.315005e-05 1.2 5.415e-05 1.2 5.415005e-05 1.2 5.515e-05 1.2 5.515005e-05 1.2 5.615e-05 1.2 5.615005e-05 0.0 5.715e-05 0.0 5.715005e-05 0.0 5.815e-05 0.0 5.815005e-05 0.0 5.915e-05 0.0 5.915005e-05 0.0 6.015e-05 0.0 6.015005e-05 1.2 6.115e-05 1.2 6.115005e-05 1.2 6.215e-05 1.2 6.215005e-05 1.2 6.315e-05 1.2 6.315005e-05 1.2 6.415e-05 1.2 6.415005e-05 0.0 6.515e-05 0.0 6.515005e-05 0.0 6.615e-05 0.0 6.615005e-05 1.2 6.715e-05 1.2 6.715005e-05 0.0 6.815e-05 0.0 6.815005e-05 0.0 6.915e-05 0.0 6.915005e-05 0.0 7.015e-05 0.0 7.015005e-05 1.2 7.115e-05 1.2 7.115005e-05 1.2]
Vcfg_k3 (cfg_k3 0) vsource type=pwl wave=[0 0.0 1.5e-07 0.0 1.5005e-07 0.0 1.15e-06 0.0 1.15005e-06 0.0 2.15e-06 0.0 2.15005e-06 0.0 3.15e-06 0.0 3.15005e-06 0.0 4.15e-06 0.0 4.15005e-06 0.0 5.15e-06 0.0 5.15005e-06 0.0 6.15e-06 0.0 6.15005e-06 0.0 7.15e-06 0.0 7.15005e-06 0.0 8.15e-06 0.0 8.15005e-06 1.2 9.15e-06 1.2 9.15005e-06 1.2 1.015e-05 1.2 1.015005e-05 1.2 1.115e-05 1.2 1.115005e-05 1.2 1.215e-05 1.2 1.215005e-05 1.2 1.315e-05 1.2 1.315005e-05 1.2 1.415e-05 1.2 1.415005e-05 1.2 1.515e-05 1.2 1.515005e-05 1.2 1.615e-05 1.2 1.615005e-05 0.0 1.715e-05 0.0 1.715005e-05 0.0 1.815e-05 0.0 1.815005e-05 0.0 1.915e-05 0.0 1.915005e-05 0.0 2.015e-05 0.0 2.015005e-05 0.0 2.115e-05 0.0 2.115005e-05 0.0 2.215e-05 0.0 2.215005e-05 0.0 2.315e-05 0.0 2.315005e-05 0.0 2.415e-05 0.0 2.415005e-05 1.2 2.515e-05 1.2 2.515005e-05 1.2 2.615e-05 1.2 2.615005e-05 1.2 2.715e-05 1.2 2.715005e-05 1.2 2.815e-05 1.2 2.815005e-05 1.2 2.915e-05 1.2 2.915005e-05 1.2 3.015e-05 1.2 3.015005e-05 1.2 3.115e-05 1.2 3.115005e-05 1.2 3.215e-05 1.2 3.215005e-05 0.0 3.315e-05 0.0 3.315005e-05 0.0 3.415e-05 0.0 3.415005e-05 0.0 3.515e-05 0.0 3.515005e-05 0.0 3.615e-05 0.0 3.615005e-05 0.0 3.715e-05 0.0 3.715005e-05 0.0 3.815e-05 0.0 3.815005e-05 0.0 3.915e-05 0.0 3.915005e-05 0.0 4.015e-05 0.0 4.015005e-05 1.2 4.115e-05 1.2 4.115005e-05 1.2 4.215e-05 1.2 4.215005e-05 1.2 4.315e-05 1.2 4.315005e-05 1.2 4.415e-05 1.2 4.415005e-05 1.2 4.515e-05 1.2 4.515005e-05 1.2 4.615e-05 1.2 4.615005e-05 1.2 4.715e-05 1.2 4.715005e-05 1.2 4.815e-05 1.2 4.815005e-05 0.0 4.915e-05 0.0 4.915005e-05 0.0 5.015e-05 0.0 5.015005e-05 0.0 5.115e-05 0.0 5.115005e-05 0.0 5.215e-05 0.0 5.215005e-05 0.0 5.315e-05 0.0 5.315005e-05 0.0 5.415e-05 0.0 5.415005e-05 0.0 5.515e-05 0.0 5.515005e-05 0.0 5.615e-05 0.0 5.615005e-05 1.2 5.715e-05 1.2 5.715005e-05 1.2 5.815e-05 1.2 5.815005e-05 1.2 5.915e-05 1.2 5.915005e-05 1.2 6.015e-05 1.2 6.015005e-05 1.2 6.115e-05 1.2 6.115005e-05 1.2 6.215e-05 1.2 6.215005e-05 1.2 6.315e-05 1.2 6.315005e-05 1.2 6.415e-05 1.2 6.415005e-05 1.2 6.515e-05 1.2 6.515005e-05 1.2 6.615e-05 1.2 6.615005e-05 1.2 6.715e-05 1.2 6.715005e-05 0.0 6.815e-05 0.0 6.815005e-05 1.2 6.915e-05 1.2 6.915005e-05 1.2 7.015e-05 1.2 7.015005e-05 1.2 7.115e-05 1.2 7.115005e-05 1.2]
Vcfg_k4 (cfg_k4 0) vsource type=pwl wave=[0 0.0 1.5e-07 0.0 1.5005e-07 0.0 1.15e-06 0.0 1.15005e-06 0.0 2.15e-06 0.0 2.15005e-06 0.0 3.15e-06 0.0 3.15005e-06 0.0 4.15e-06 0.0 4.15005e-06 0.0 5.15e-06 0.0 5.15005e-06 0.0 6.15e-06 0.0 6.15005e-06 0.0 7.15e-06 0.0 7.15005e-06 0.0 8.15e-06 0.0 8.15005e-06 0.0 9.15e-06 0.0 9.15005e-06 0.0 1.015e-05 0.0 1.015005e-05 0.0 1.115e-05 0.0 1.115005e-05 0.0 1.215e-05 0.0 1.215005e-05 0.0 1.315e-05 0.0 1.315005e-05 0.0 1.415e-05 0.0 1.415005e-05 0.0 1.515e-05 0.0 1.515005e-05 0.0 1.615e-05 0.0 1.615005e-05 1.2 1.715e-05 1.2 1.715005e-05 1.2 1.815e-05 1.2 1.815005e-05 1.2 1.915e-05 1.2 1.915005e-05 1.2 2.015e-05 1.2 2.015005e-05 1.2 2.115e-05 1.2 2.115005e-05 1.2 2.215e-05 1.2 2.215005e-05 1.2 2.315e-05 1.2 2.315005e-05 1.2 2.415e-05 1.2 2.415005e-05 1.2 2.515e-05 1.2 2.515005e-05 1.2 2.615e-05 1.2 2.615005e-05 1.2 2.715e-05 1.2 2.715005e-05 1.2 2.815e-05 1.2 2.815005e-05 1.2 2.915e-05 1.2 2.915005e-05 1.2 3.015e-05 1.2 3.015005e-05 1.2 3.115e-05 1.2 3.115005e-05 1.2 3.215e-05 1.2 3.215005e-05 0.0 3.315e-05 0.0 3.315005e-05 0.0 3.415e-05 0.0 3.415005e-05 0.0 3.515e-05 0.0 3.515005e-05 0.0 3.615e-05 0.0 3.615005e-05 0.0 3.715e-05 0.0 3.715005e-05 0.0 3.815e-05 0.0 3.815005e-05 0.0 3.915e-05 0.0 3.915005e-05 0.0 4.015e-05 0.0 4.015005e-05 0.0 4.115e-05 0.0 4.115005e-05 0.0 4.215e-05 0.0 4.215005e-05 0.0 4.315e-05 0.0 4.315005e-05 0.0 4.415e-05 0.0 4.415005e-05 0.0 4.515e-05 0.0 4.515005e-05 0.0 4.615e-05 0.0 4.615005e-05 0.0 4.715e-05 0.0 4.715005e-05 0.0 4.815e-05 0.0 4.815005e-05 1.2 4.915e-05 1.2 4.915005e-05 1.2 5.015e-05 1.2 5.015005e-05 1.2 5.115e-05 1.2 5.115005e-05 1.2 5.215e-05 1.2 5.215005e-05 1.2 5.315e-05 1.2 5.315005e-05 1.2 5.415e-05 1.2 5.415005e-05 1.2 5.515e-05 1.2 5.515005e-05 1.2 5.615e-05 1.2 5.615005e-05 1.2 5.715e-05 1.2 5.715005e-05 1.2 5.815e-05 1.2 5.815005e-05 1.2 5.915e-05 1.2 5.915005e-05 1.2 6.015e-05 1.2 6.015005e-05 1.2 6.115e-05 1.2 6.115005e-05 1.2 6.215e-05 1.2 6.215005e-05 1.2 6.315e-05 1.2 6.315005e-05 1.2 6.415e-05 1.2 6.415005e-05 0.0 6.515e-05 0.0 6.515005e-05 0.0 6.615e-05 0.0 6.615005e-05 1.2 6.715e-05 1.2 6.715005e-05 1.2 6.815e-05 1.2 6.815005e-05 1.2 6.915e-05 1.2 6.915005e-05 0.0 7.015e-05 0.0 7.015005e-05 0.0 7.115e-05 0.0 7.115005e-05 0.0]
Vcfg_k5 (cfg_k5 0) vsource type=pwl wave=[0 0.0 1.5e-07 0.0 1.5005e-07 0.0 1.15e-06 0.0 1.15005e-06 0.0 2.15e-06 0.0 2.15005e-06 0.0 3.15e-06 0.0 3.15005e-06 0.0 4.15e-06 0.0 4.15005e-06 0.0 5.15e-06 0.0 5.15005e-06 0.0 6.15e-06 0.0 6.15005e-06 0.0 7.15e-06 0.0 7.15005e-06 0.0 8.15e-06 0.0 8.15005e-06 0.0 9.15e-06 0.0 9.15005e-06 0.0 1.015e-05 0.0 1.015005e-05 0.0 1.115e-05 0.0 1.115005e-05 0.0 1.215e-05 0.0 1.215005e-05 0.0 1.315e-05 0.0 1.315005e-05 0.0 1.415e-05 0.0 1.415005e-05 0.0 1.515e-05 0.0 1.515005e-05 0.0 1.615e-05 0.0 1.615005e-05 0.0 1.715e-05 0.0 1.715005e-05 0.0 1.815e-05 0.0 1.815005e-05 0.0 1.915e-05 0.0 1.915005e-05 0.0 2.015e-05 0.0 2.015005e-05 0.0 2.115e-05 0.0 2.115005e-05 0.0 2.215e-05 0.0 2.215005e-05 0.0 2.315e-05 0.0 2.315005e-05 0.0 2.415e-05 0.0 2.415005e-05 0.0 2.515e-05 0.0 2.515005e-05 0.0 2.615e-05 0.0 2.615005e-05 0.0 2.715e-05 0.0 2.715005e-05 0.0 2.815e-05 0.0 2.815005e-05 0.0 2.915e-05 0.0 2.915005e-05 0.0 3.015e-05 0.0 3.015005e-05 0.0 3.115e-05 0.0 3.115005e-05 0.0 3.215e-05 0.0 3.215005e-05 1.2 3.315e-05 1.2 3.315005e-05 1.2 3.415e-05 1.2 3.415005e-05 1.2 3.515e-05 1.2 3.515005e-05 1.2 3.615e-05 1.2 3.615005e-05 1.2 3.715e-05 1.2 3.715005e-05 1.2 3.815e-05 1.2 3.815005e-05 1.2 3.915e-05 1.2 3.915005e-05 1.2 4.015e-05 1.2 4.015005e-05 1.2 4.115e-05 1.2 4.115005e-05 1.2 4.215e-05 1.2 4.215005e-05 1.2 4.315e-05 1.2 4.315005e-05 1.2 4.415e-05 1.2 4.415005e-05 1.2 4.515e-05 1.2 4.515005e-05 1.2 4.615e-05 1.2 4.615005e-05 1.2 4.715e-05 1.2 4.715005e-05 1.2 4.815e-05 1.2 4.815005e-05 1.2 4.915e-05 1.2 4.915005e-05 1.2 5.015e-05 1.2 5.015005e-05 1.2 5.115e-05 1.2 5.115005e-05 1.2 5.215e-05 1.2 5.215005e-05 1.2 5.315e-05 1.2 5.315005e-05 1.2 5.415e-05 1.2 5.415005e-05 1.2 5.515e-05 1.2 5.515005e-05 1.2 5.615e-05 1.2 5.615005e-05 1.2 5.715e-05 1.2 5.715005e-05 1.2 5.815e-05 1.2 5.815005e-05 1.2 5.915e-05 1.2 5.915005e-05 1.2 6.015e-05 1.2 6.015005e-05 1.2 6.115e-05 1.2 6.115005e-05 1.2 6.215e-05 1.2 6.215005e-05 1.2 6.315e-05 1.2 6.315005e-05 1.2 6.415e-05 1.2 6.415005e-05 1.2 6.515e-05 1.2 6.515005e-05 0.0 6.615e-05 0.0 6.615005e-05 0.0 6.715e-05 0.0 6.715005e-05 0.0 6.815e-05 0.0 6.815005e-05 0.0 6.915e-05 0.0 6.915005e-05 0.0 7.015e-05 0.0 7.015005e-05 0.0 7.115e-05 0.0 7.115005e-05 0.0]
Vapply (apply 0) vsource type=pwl wave=[0 0.0 2e-07 0.0 2.0005e-07 1.2 4e-07 1.2 4.0005e-07 0.0 1.2e-06 0.0 1.20005e-06 1.2 1.4e-06 1.2 1.40005e-06 0.0 2.2e-06 0.0 2.20005e-06 1.2 2.4e-06 1.2 2.40005e-06 0.0 3.2e-06 0.0 3.20005e-06 1.2 3.4e-06 1.2 3.40005e-06 0.0 4.2e-06 0.0 4.20005e-06 1.2 4.4e-06 1.2 4.40005e-06 0.0 5.2e-06 0.0 5.20005e-06 1.2 5.4e-06 1.2 5.40005e-06 0.0 6.2e-06 0.0 6.20005e-06 1.2 6.4e-06 1.2 6.40005e-06 0.0 7.2e-06 0.0 7.20005e-06 1.2 7.4e-06 1.2 7.40005e-06 0.0 8.2e-06 0.0 8.20005e-06 1.2 8.4e-06 1.2 8.40005e-06 0.0 9.2e-06 0.0 9.20005e-06 1.2 9.4e-06 1.2 9.40005e-06 0.0 1.02e-05 0.0 1.020005e-05 1.2 1.04e-05 1.2 1.040005e-05 0.0 1.12e-05 0.0 1.120005e-05 1.2 1.14e-05 1.2 1.140005e-05 0.0 1.22e-05 0.0 1.220005e-05 1.2 1.24e-05 1.2 1.240005e-05 0.0 1.32e-05 0.0 1.320005e-05 1.2 1.34e-05 1.2 1.340005e-05 0.0 1.42e-05 0.0 1.420005e-05 1.2 1.44e-05 1.2 1.440005e-05 0.0 1.52e-05 0.0 1.520005e-05 1.2 1.54e-05 1.2 1.540005e-05 0.0 1.62e-05 0.0 1.620005e-05 1.2 1.64e-05 1.2 1.640005e-05 0.0 1.72e-05 0.0 1.720005e-05 1.2 1.74e-05 1.2 1.740005e-05 0.0 1.82e-05 0.0 1.820005e-05 1.2 1.84e-05 1.2 1.840005e-05 0.0 1.92e-05 0.0 1.920005e-05 1.2 1.94e-05 1.2 1.940005e-05 0.0 2.02e-05 0.0 2.020005e-05 1.2 2.04e-05 1.2 2.040005e-05 0.0 2.12e-05 0.0 2.120005e-05 1.2 2.14e-05 1.2 2.140005e-05 0.0 2.22e-05 0.0 2.220005e-05 1.2 2.24e-05 1.2 2.240005e-05 0.0 2.32e-05 0.0 2.320005e-05 1.2 2.34e-05 1.2 2.340005e-05 0.0 2.42e-05 0.0 2.420005e-05 1.2 2.44e-05 1.2 2.440005e-05 0.0 2.52e-05 0.0 2.520005e-05 1.2 2.54e-05 1.2 2.540005e-05 0.0 2.62e-05 0.0 2.620005e-05 1.2 2.64e-05 1.2 2.640005e-05 0.0 2.72e-05 0.0 2.720005e-05 1.2 2.74e-05 1.2 2.740005e-05 0.0 2.82e-05 0.0 2.820005e-05 1.2 2.84e-05 1.2 2.840005e-05 0.0 2.92e-05 0.0 2.920005e-05 1.2 2.94e-05 1.2 2.940005e-05 0.0 3.02e-05 0.0 3.020005e-05 1.2 3.04e-05 1.2 3.040005e-05 0.0 3.12e-05 0.0 3.120005e-05 1.2 3.14e-05 1.2 3.140005e-05 0.0 3.22e-05 0.0 3.220005e-05 1.2 3.24e-05 1.2 3.240005e-05 0.0 3.32e-05 0.0 3.320005e-05 1.2 3.34e-05 1.2 3.340005e-05 0.0 3.42e-05 0.0 3.420005e-05 1.2 3.44e-05 1.2 3.440005e-05 0.0 3.52e-05 0.0 3.520005e-05 1.2 3.54e-05 1.2 3.540005e-05 0.0 3.62e-05 0.0 3.620005e-05 1.2 3.64e-05 1.2 3.640005e-05 0.0 3.72e-05 0.0 3.720005e-05 1.2 3.74e-05 1.2 3.740005e-05 0.0 3.82e-05 0.0 3.820005e-05 1.2 3.84e-05 1.2 3.840005e-05 0.0 3.92e-05 0.0 3.920005e-05 1.2 3.94e-05 1.2 3.940005e-05 0.0 4.02e-05 0.0 4.020005e-05 1.2 4.04e-05 1.2 4.040005e-05 0.0 4.12e-05 0.0 4.120005e-05 1.2 4.14e-05 1.2 4.140005e-05 0.0 4.22e-05 0.0 4.220005e-05 1.2 4.24e-05 1.2 4.240005e-05 0.0 4.32e-05 0.0 4.320005e-05 1.2 4.34e-05 1.2 4.340005e-05 0.0 4.42e-05 0.0 4.420005e-05 1.2 4.44e-05 1.2 4.440005e-05 0.0 4.52e-05 0.0 4.520005e-05 1.2 4.54e-05 1.2 4.540005e-05 0.0 4.62e-05 0.0 4.620005e-05 1.2 4.64e-05 1.2 4.640005e-05 0.0 4.72e-05 0.0 4.720005e-05 1.2 4.74e-05 1.2 4.740005e-05 0.0 4.82e-05 0.0 4.820005e-05 1.2 4.84e-05 1.2 4.840005e-05 0.0 4.92e-05 0.0 4.920005e-05 1.2 4.94e-05 1.2 4.940005e-05 0.0 5.02e-05 0.0 5.020005e-05 1.2 5.04e-05 1.2 5.040005e-05 0.0 5.12e-05 0.0 5.120005e-05 1.2 5.14e-05 1.2 5.140005e-05 0.0 5.22e-05 0.0 5.220005e-05 1.2 5.24e-05 1.2 5.240005e-05 0.0 5.32e-05 0.0 5.320005e-05 1.2 5.34e-05 1.2 5.340005e-05 0.0 5.42e-05 0.0 5.420005e-05 1.2 5.44e-05 1.2 5.440005e-05 0.0 5.52e-05 0.0 5.520005e-05 1.2 5.54e-05 1.2 5.540005e-05 0.0 5.62e-05 0.0 5.620005e-05 1.2 5.64e-05 1.2 5.640005e-05 0.0 5.72e-05 0.0 5.720005e-05 1.2 5.74e-05 1.2 5.740005e-05 0.0 5.82e-05 0.0 5.820005e-05 1.2 5.84e-05 1.2 5.840005e-05 0.0 5.92e-05 0.0 5.920005e-05 1.2 5.94e-05 1.2 5.940005e-05 0.0 6.02e-05 0.0 6.020005e-05 1.2 6.04e-05 1.2 6.040005e-05 0.0 6.12e-05 0.0 6.120005e-05 1.2 6.14e-05 1.2 6.140005e-05 0.0 6.22e-05 0.0 6.220005e-05 1.2 6.24e-05 1.2 6.240005e-05 0.0 6.32e-05 0.0 6.320005e-05 1.2 6.34e-05 1.2 6.340005e-05 0.0 6.42e-05 0.0 6.420005e-05 1.2 6.44e-05 1.2 6.440005e-05 0.0 6.52e-05 0.0 6.520005e-05 1.2 6.54e-05 1.2 6.540005e-05 0.0 6.62e-05 0.0 6.620005e-05 1.2 6.64e-05 1.2 6.640005e-05 0.0 6.72e-05 0.0 6.720005e-05 1.2 6.74e-05 1.2 6.740005e-05 0.0 6.82e-05 0.0 6.820005e-05 1.2 6.84e-05 1.2 6.840005e-05 0.0 6.92e-05 0.0 6.920005e-05 1.2 6.94e-05 1.2 6.940005e-05 0.0 7.02e-05 0.0 7.020005e-05 1.2 7.04e-05 1.2 7.040005e-05 0.0 7.12e-05 0.0 7.120005e-05 1.2 7.14e-05 1.2 7.140005e-05 0.0]
XD (refclk reset apply cfg_k0 cfg_k1 cfg_k2 cfg_k3 cfg_k4 cfg_k5 active_k0 active_k1 active_k2 active_k3 active_k4 active_k5 select_m0 select_m1 select_m2 select_m3 select_m4 select_m5 ready invalid divider_reset vdd 0) tx_pll_config
Cdivider_reset (divider_reset 0) capacitor c=20f
Cready (ready 0) capacitor c=20f
Cselect_m0 (select_m0 0) capacitor c=20f
Cselect_m1 (select_m1 0) capacitor c=20f
Cselect_m2 (select_m2 0) capacitor c=20f
Cselect_m3 (select_m3 0) capacitor c=20f
Cselect_m4 (select_m4 0) capacitor c=20f
Cselect_m5 (select_m5 0) capacitor c=20f
tran tran stop=72.5u maxstep=2n method=gear2only errpreset=moderate strobeperiod=2n strobeoutput=strobeonly
save refclk reset apply cfg_k0 cfg_k1 cfg_k2 cfg_k3 cfg_k4 cfg_k5 active_k0 active_k1 active_k2 active_k3 active_k4 active_k5 select_m0 select_m1 select_m2 select_m3 select_m4 select_m5 ready invalid divider_reset VDD:p
saveOptions options save=selected
