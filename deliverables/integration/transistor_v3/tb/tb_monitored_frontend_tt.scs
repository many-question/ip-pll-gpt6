simulator lang=spectre
global 0
include "/home/process/tsmc180bcd_gen2_2022/PDK/TSMC180BCD/models/spectre/c018bcd_gen2_v1d6.scs" section=tt
include "/home/process/tsmc180bcd_gen2_2022/PDK/TSMC180BCD/models/spectre/c018bcd_gen2_v1d6.scs" section=stat_noise
simulator lang=spectre insensitive=no
include "cells.scs"
include "receiver.scs"
simulatorOptions options reltol=1e-3 vabstol=1e-5 iabstol=1e-12 temp=27

include "digital_cells_v2.scs"
include "fll_circuit.scs"
include "pll_config.scs"
include "pll_supervisor.scs"
include "cp_timing.scs"
include "frequency_watchdog.scs"
include "pll_control_monitored.scs"
VDD (vdd 0) vsource dc=1.2
VREF (refclk 0) vsource type=pulse val0=0 val1=1.2 delay=10n rise=50p fall=50p width=20.7833333333n period=41.6666666667n
VR (reset 0) vsource type=pulse val0=1.2 val1=0 delay=20n rise=50p fall=50p width=1m period=2m
VA (apply 0) vsource type=pulse val0=0 val1=1.2 delay=60n rise=50p fall=50p width=300n period=2u
VC (outclk 0) vsource type=pwl wave=[0 0 2.025e-08 0 2.027e-08 1.2 2.075813e-08 1.2 2.077813e-08 0 2.12662601626e-08 0 2.12862601626e-08 1.2 2.17743901626e-08 1.2 2.17943901626e-08 0 2.22825203252e-08 0 2.23025203252e-08 1.2 2.27906503252e-08 1.2 2.28106503252e-08 0 2.32987804878e-08 0 2.33187804878e-08 1.2 2.38069104878e-08 1.2 2.38269104878e-08 0 2.43150406504e-08 0 2.43350406504e-08 1.2 2.48231706504e-08 1.2 2.48431706504e-08 0 2.5331300813e-08 0 2.5351300813e-08 1.2 2.5839430813e-08 1.2 2.5859430813e-08 0 2.63475609756e-08 0 2.63675609756e-08 1.2 2.68556909756e-08 1.2 2.68756909756e-08 0 2.73638211382e-08 0 2.73838211382e-08 1.2 2.78719511382e-08 1.2 2.78919511382e-08 0 2.83800813008e-08 0 2.84000813008e-08 1.2 2.88882113008e-08 1.2 2.89082113008e-08 0 2.93963414634e-08 0 2.94163414634e-08 1.2 2.99044714634e-08 1.2 2.99244714634e-08 0 3.0412601626e-08 0 3.0432601626e-08 1.2 3.0920731626e-08 1.2 3.0940731626e-08 0 3.14288617886e-08 0 3.14488617886e-08 1.2 3.19369917886e-08 1.2 3.19569917886e-08 0 3.24451219512e-08 0 3.24651219512e-08 1.2 3.29532519512e-08 1.2 3.29732519512e-08 0 3.34613821138e-08 0 3.34813821138e-08 1.2 3.39695121138e-08 1.2 3.39895121138e-08 0 3.44776422764e-08 0 3.44976422764e-08 1.2 3.49857722764e-08 1.2 3.50057722764e-08 0 3.5493902439e-08 0 3.5513902439e-08 1.2 3.6002032439e-08 1.2 3.6022032439e-08 0 3.65101626016e-08 0 3.65301626016e-08 1.2 3.70182926016e-08 1.2 3.70382926016e-08 0 3.75264227642e-08 0 3.75464227642e-08 1.2 3.80345527642e-08 1.2 3.80545527642e-08 0 3.85426829268e-08 0 3.85626829268e-08 1.2 3.90508129268e-08 1.2 3.90708129268e-08 0 3.95589430894e-08 0 3.95789430894e-08 1.2 4.00670730894e-08 1.2 4.00870730894e-08 0 4.0575203252e-08 0 4.0595203252e-08 1.2 4.1083333252e-08 1.2 4.1103333252e-08 0 4.15914634146e-08 0 4.16114634146e-08 1.2 4.20995934146e-08 1.2 4.21195934146e-08 0 4.26077235772e-08 0 4.26277235772e-08 1.2 4.31158535772e-08 1.2 4.31358535772e-08 0 4.36239837398e-08 0 4.36439837398e-08 1.2 4.41321137398e-08 1.2 4.41521137398e-08 0 4.46402439024e-08 0 4.46602439024e-08 1.2 4.51483739024e-08 1.2 4.51683739024e-08 0 4.5656504065e-08 0 4.5676504065e-08 1.2 4.6164634065e-08 1.2 4.6184634065e-08 0 4.66727642276e-08 0 4.66927642276e-08 1.2 4.71808942276e-08 1.2 4.72008942276e-08 0 4.76890243902e-08 0 4.77090243902e-08 1.2 4.81971543902e-08 1.2 4.82171543902e-08 0 4.87052845528e-08 0 4.87252845528e-08 1.2 4.92134145528e-08 1.2 4.92334145528e-08 0 4.97215447154e-08 0 4.97415447154e-08 1.2 5.02296747154e-08 1.2 5.02496747154e-08 0 5.0737804878e-08 0 5.0757804878e-08 1.2 5.1245934878e-08 1.2 5.1265934878e-08 0 5.17540650406e-08 0 5.17740650406e-08 1.2 5.22621950406e-08 1.2 5.22821950406e-08 0 5.27703252032e-08 0 5.27903252032e-08 1.2 5.32784552032e-08 1.2 5.32984552032e-08 0 5.37865853658e-08 0 5.38065853658e-08 1.2 5.42947153658e-08 1.2 5.43147153658e-08 0 5.48028455284e-08 0 5.48228455284e-08 1.2 5.53109755284e-08 1.2 5.53309755284e-08 0 5.5819105691e-08 0 5.5839105691e-08 1.2 5.6327235691e-08 1.2 5.6347235691e-08 0 5.68353658536e-08 0 5.68553658536e-08 1.2 5.73434958536e-08 1.2 5.73634958536e-08 0 5.78516260162e-08 0 5.78716260162e-08 1.2 5.83597560162e-08 1.2 5.83797560162e-08 0 5.88678861788e-08 0 5.88878861788e-08 1.2 5.93760161788e-08 1.2 5.93960161788e-08 0 5.98841463414e-08 0 5.99041463414e-08 1.2 6.03922763414e-08 1.2 6.04122763414e-08 0 6.0900406504e-08 0 6.0920406504e-08 1.2 6.1408536504e-08 1.2 6.1428536504e-08 0 6.19166666666e-08 0 6.19366666666e-08 1.2 6.24247966666e-08 1.2 6.24447966666e-08 0 6.29329268292e-08 0 6.29529268292e-08 1.2 6.34410568292e-08 1.2 6.34610568292e-08 0 6.39491869918e-08 0 6.39691869918e-08 1.2 6.44573169918e-08 1.2 6.44773169918e-08 0 6.49654471544e-08 0 6.49854471544e-08 1.2 6.54735771544e-08 1.2 6.54935771544e-08 0 6.5981707317e-08 0 6.6001707317e-08 1.2 6.6489837317e-08 1.2 6.6509837317e-08 0 6.69979674796e-08 0 6.70179674796e-08 1.2 6.75060974796e-08 1.2 6.75260974796e-08 0 6.80142276422e-08 0 6.80342276422e-08 1.2 6.85223576422e-08 1.2 6.85423576422e-08 0 6.90304878048e-08 0 6.90504878048e-08 1.2 6.95386178048e-08 1.2 6.95586178048e-08 0 7.00467479674e-08 0 7.00667479674e-08 1.2 7.05548779674e-08 1.2 7.05748779674e-08 0 7.106300813e-08 0 7.108300813e-08 1.2 7.157113813e-08 1.2 7.159113813e-08 0 7.20792682926e-08 0 7.20992682926e-08 1.2 7.25873982926e-08 1.2 7.26073982926e-08 0 7.30955284552e-08 0 7.31155284552e-08 1.2 7.36036584552e-08 1.2 7.36236584552e-08 0 7.41117886178e-08 0 7.41317886178e-08 1.2 7.46199186178e-08 1.2 7.46399186178e-08 0 7.51280487804e-08 0 7.51480487804e-08 1.2 7.56361787804e-08 1.2 7.56561787804e-08 0 7.6144308943e-08 0 7.6164308943e-08 1.2 7.6652438943e-08 1.2 7.6672438943e-08 0 7.71605691056e-08 0 7.71805691056e-08 1.2 7.76686991056e-08 1.2 7.76886991056e-08 0 7.81768292682e-08 0 7.81968292682e-08 1.2 7.86849592682e-08 1.2 7.87049592682e-08 0 7.91930894308e-08 0 7.92130894308e-08 1.2 7.97012194308e-08 1.2 7.97212194308e-08 0 8.02093495934e-08 0 8.02293495934e-08 1.2 8.07174795934e-08 1.2 8.07374795934e-08 0 8.1225609756e-08 0 8.1245609756e-08 1.2 8.1733739756e-08 1.2 8.1753739756e-08 0 8.22418699186e-08 0 8.22618699186e-08 1.2 8.27499999186e-08 1.2 8.27699999186e-08 0 8.32581300812e-08 0 8.32781300812e-08 1.2 8.37662600812e-08 1.2 8.37862600812e-08 0 8.42743902438e-08 0 8.42943902438e-08 1.2 8.47825202438e-08 1.2 8.48025202438e-08 0 8.52906504064e-08 0 8.53106504064e-08 1.2 8.57987804064e-08 1.2 8.58187804064e-08 0 8.6306910569e-08 0 8.6326910569e-08 1.2 8.6815040569e-08 1.2 8.6835040569e-08 0 8.73231707316e-08 0 8.73431707316e-08 1.2 8.78313007316e-08 1.2 8.78513007316e-08 0 8.83394308942e-08 0 8.83594308942e-08 1.2 8.88475608942e-08 1.2 8.88675608942e-08 0 8.93556910568e-08 0 8.93756910568e-08 1.2 8.98638210568e-08 1.2 8.98838210568e-08 0 9.03719512194e-08 0 9.03919512194e-08 1.2 9.08800812194e-08 1.2 9.09000812194e-08 0 9.1388211382e-08 0 9.1408211382e-08 1.2 9.1896341382e-08 1.2 9.1916341382e-08 0 9.24044715446e-08 0 9.24244715446e-08 1.2 9.29126015446e-08 1.2 9.29326015446e-08 0 9.34207317072e-08 0 9.34407317072e-08 1.2 9.39288617072e-08 1.2 9.39488617072e-08 0 9.44369918698e-08 0 9.44569918698e-08 1.2 9.49451218698e-08 1.2 9.49651218698e-08 0 9.54532520324e-08 0 9.54732520324e-08 1.2 9.59613820324e-08 1.2 9.59813820324e-08 0 9.6469512195e-08 0 9.6489512195e-08 1.2 9.6977642195e-08 1.2 9.6997642195e-08 0 9.74857723576e-08 0 9.75057723576e-08 1.2 9.79939023576e-08 1.2 9.80139023576e-08 0 9.85020325202e-08 0 9.85220325202e-08 1.2 9.90101625202e-08 1.2 9.90301625202e-08 0 9.95182926828e-08 0 9.95382926828e-08 1.2 1.000264226828e-07 1.2 1.000464226828e-07 0 1.005345528454e-07 0 1.005545528454e-07 1.2 1.010426828454e-07 1.2 1.010626828454e-07 0 1.01550813008e-07 0 1.01570813008e-07 1.2 1.02058943008e-07 1.2 1.02078943008e-07 0 1.025670731706e-07 0 1.025870731706e-07 1.2 1.030752031706e-07 1.2 1.030952031706e-07 0 1.035833333332e-07 0 1.036033333332e-07 1.2 1.040914633332e-07 1.2 1.041114633332e-07 0 1.045995934958e-07 0 1.046195934958e-07 1.2 1.051077234958e-07 1.2 1.051277234958e-07 0 1.056158536584e-07 0 1.056358536584e-07 1.2 1.061239836584e-07 1.2 1.061439836584e-07 0 1.06632113821e-07 0 1.06652113821e-07 1.2 1.07140243821e-07 1.2 1.07160243821e-07 0 1.076483739836e-07 0 1.076683739836e-07 1.2 1.081565039836e-07 1.2 1.081765039836e-07 0 1.086646341462e-07 0 1.086846341462e-07 1.2 1.091727641462e-07 1.2 1.091927641462e-07 0 1.096808943088e-07 0 1.097008943088e-07 1.2 1.101890243088e-07 1.2 1.102090243088e-07 0 1.106971544714e-07 0 1.107171544714e-07 1.2 1.112052844714e-07 1.2 1.112252844714e-07 0 1.11713414634e-07 0 1.11733414634e-07 1.2 1.12221544634e-07 1.2 1.12241544634e-07 0 1.127296747966e-07 0 1.127496747966e-07 1.2 1.132378047966e-07 1.2 1.132578047966e-07 0 1.137459349592e-07 0 1.137659349592e-07 1.2 1.142540649592e-07 1.2 1.142740649592e-07 0 1.147621951218e-07 0 1.147821951218e-07 1.2 1.152703251218e-07 1.2 1.152903251218e-07 0 1.157784552844e-07 0 1.157984552844e-07 1.2 1.162865852844e-07 1.2 1.163065852844e-07 0 1.16794715447e-07 0 1.16814715447e-07 1.2 1.17302845447e-07 1.2 1.17322845447e-07 0 1.178109756096e-07 0 1.178309756096e-07 1.2 1.183191056096e-07 1.2 1.183391056096e-07 0 1.188272357722e-07 0 1.188472357722e-07 1.2 1.193353657722e-07 1.2 1.193553657722e-07 0 1.198434959348e-07 0 1.198634959348e-07 1.2 1.203516259348e-07 1.2 1.203716259348e-07 0 1.208597560974e-07 0 1.208797560974e-07 1.2 1.213678860974e-07 1.2 1.213878860974e-07 0 1.2187601626e-07 0 1.2189601626e-07 1.2 1.2238414626e-07 1.2 1.2240414626e-07 0 1.228922764226e-07 0 1.229122764226e-07 1.2 1.234004064226e-07 1.2 1.234204064226e-07 0 1.239085365852e-07 0 1.239285365852e-07 1.2 1.244166665852e-07 1.2 1.244366665852e-07 0 1.249247967478e-07 0 1.249447967478e-07 1.2 1.254329267478e-07 1.2 1.254529267478e-07 0 1.259410569104e-07 0 1.259610569104e-07 1.2 1.264491869104e-07 1.2 1.264691869104e-07 0 1.26957317073e-07 0 1.26977317073e-07 1.2 1.27465447073e-07 1.2 1.27485447073e-07 0 1.279735772356e-07 0 1.279935772356e-07 1.2 1.284817072356e-07 1.2 1.285017072356e-07 0 1.289898373982e-07 0 1.290098373982e-07 1.2 1.294979673982e-07 1.2 1.295179673982e-07 0 1.300060975608e-07 0 1.300260975608e-07 1.2 1.305142275608e-07 1.2 1.305342275608e-07 0 1.310223577234e-07 0 1.310423577234e-07 1.2 1.315304877234e-07 1.2 1.315504877234e-07 0 1.32038617886e-07 0 1.32058617886e-07 1.2 1.32546747886e-07 1.2 1.32566747886e-07 0 1.330548780486e-07 0 1.330748780486e-07 1.2 1.335630080486e-07 1.2 1.335830080486e-07 0 1.340711382112e-07 0 1.340911382112e-07 1.2 1.345792682112e-07 1.2 1.345992682112e-07 0 1.350873983738e-07 0 1.351073983738e-07 1.2 1.355955283738e-07 1.2 1.356155283738e-07 0 1.361036585364e-07 0 1.361236585364e-07 1.2 1.366117885364e-07 1.2 1.366317885364e-07 0 1.37119918699e-07 0 1.37139918699e-07 1.2 1.37628048699e-07 1.2 1.37648048699e-07 0 1.381361788616e-07 0 1.381561788616e-07 1.2 1.386443088616e-07 1.2 1.386643088616e-07 0 1.391524390242e-07 0 1.391724390242e-07 1.2 1.396605690242e-07 1.2 1.396805690242e-07 0 1.401686991868e-07 0 1.401886991868e-07 1.2 1.406768291868e-07 1.2 1.406968291868e-07 0 1.411849593494e-07 0 1.412049593494e-07 1.2 1.416930893494e-07 1.2 1.417130893494e-07 0 1.42201219512e-07 0 1.42221219512e-07 1.2 1.42709349512e-07 1.2 1.42729349512e-07 0 1.432174796746e-07 0 1.432374796746e-07 1.2 1.437256096746e-07 1.2 1.437456096746e-07 0 1.442337398372e-07 0 1.442537398372e-07 1.2 1.447418698372e-07 1.2 1.447618698372e-07 0 1.452499999998e-07 0 1.452699999998e-07 1.2 1.457581299998e-07 1.2 1.457781299998e-07 0 1.462662601624e-07 0 1.462862601624e-07 1.2 1.467743901624e-07 1.2 1.467943901624e-07 0 1.47282520325e-07 0 1.47302520325e-07 1.2 1.47790650325e-07 1.2 1.47810650325e-07 0 1.482987804876e-07 0 1.483187804876e-07 1.2 1.488069104876e-07 1.2 1.488269104876e-07 0 1.493150406502e-07 0 1.493350406502e-07 1.2 1.498231706502e-07 1.2 1.498431706502e-07 0 1.503313008128e-07 0 1.503513008128e-07 1.2 1.508394308128e-07 1.2 1.508594308128e-07 0 1.513475609754e-07 0 1.513675609754e-07 1.2 1.518556909754e-07 1.2 1.518756909754e-07 0 1.52363821138e-07 0 1.52383821138e-07 1.2 1.52871951138e-07 1.2 1.52891951138e-07 0 1.533800813006e-07 0 1.534000813006e-07 1.2 1.538882113006e-07 1.2 1.539082113006e-07 0 1.543963414632e-07 0 1.544163414632e-07 1.2 1.549044714632e-07 1.2 1.549244714632e-07 0 1.554126016258e-07 0 1.554326016258e-07 1.2 1.559207316258e-07 1.2 1.559407316258e-07 0 1.564288617884e-07 0 1.564488617884e-07 1.2 1.569369917884e-07 1.2 1.569569917884e-07 0 1.57445121951e-07 0 1.57465121951e-07 1.2 1.57953251951e-07 1.2 1.57973251951e-07 0 1.584613821136e-07 0 1.584813821136e-07 1.2 1.589695121136e-07 1.2 1.589895121136e-07 0 1.594776422762e-07 0 1.594976422762e-07 1.2 1.599857722762e-07 1.2 1.600057722762e-07 0 1.604939024388e-07 0 1.605139024388e-07 1.2 1.610020324388e-07 1.2 1.610220324388e-07 0 1.615101626014e-07 0 1.615301626014e-07 1.2 1.620182926014e-07 1.2 1.620382926014e-07 0 1.62526422764e-07 0 1.62546422764e-07 1.2 1.63034552764e-07 1.2 1.63054552764e-07 0 1.635426829266e-07 0 1.635626829266e-07 1.2 1.640508129266e-07 1.2 1.640708129266e-07 0 1.645589430892e-07 0 1.645789430892e-07 1.2 1.650670730892e-07 1.2 1.650870730892e-07 0 1.655752032518e-07 0 1.655952032518e-07 1.2 1.660833332518e-07 1.2 1.661033332518e-07 0 1.665914634144e-07 0 1.666114634144e-07 1.2 1.670995934144e-07 1.2 1.671195934144e-07 0 1.67607723577e-07 0 1.67627723577e-07 1.2 1.68115853577e-07 1.2 1.68135853577e-07 0 1.686239837396e-07 0 1.686439837396e-07 1.2 1.691321137396e-07 1.2 1.691521137396e-07 0 1.696402439022e-07 0 1.696602439022e-07 1.2 1.701483739022e-07 1.2 1.701683739022e-07 0 1.706565040648e-07 0 1.706765040648e-07 1.2 1.711646340648e-07 1.2 1.711846340648e-07 0 1.716727642274e-07 0 1.716927642274e-07 1.2 1.721808942274e-07 1.2 1.722008942274e-07 0 1.7268902439e-07 0 1.7270902439e-07 1.2 1.7319715439e-07 1.2 1.7321715439e-07 0 1.737052845526e-07 0 1.737252845526e-07 1.2 1.742134145526e-07 1.2 1.742334145526e-07 0 1.747215447152e-07 0 1.747415447152e-07 1.2 1.752296747152e-07 1.2 1.752496747152e-07 0 1.757378048778e-07 0 1.757578048778e-07 1.2 1.762459348778e-07 1.2 1.762659348778e-07 0 1.767540650404e-07 0 1.767740650404e-07 1.2 1.772621950404e-07 1.2 1.772821950404e-07 0 1.77770325203e-07 0 1.77790325203e-07 1.2 1.78278455203e-07 1.2 1.78298455203e-07 0 1.787865853656e-07 0 1.788065853656e-07 1.2 1.792947153656e-07 1.2 1.793147153656e-07 0 1.798028455282e-07 0 1.798228455282e-07 1.2 1.803109755282e-07 1.2 1.803309755282e-07 0 1.808191056908e-07 0 1.808391056908e-07 1.2 1.813272356908e-07 1.2 1.813472356908e-07 0 1.818353658534e-07 0 1.818553658534e-07 1.2 1.823434958534e-07 1.2 1.823634958534e-07 0 1.82851626016e-07 0 1.82871626016e-07 1.2 1.83359756016e-07 1.2 1.83379756016e-07 0 1.838678861786e-07 0 1.838878861786e-07 1.2 1.843760161786e-07 1.2 1.843960161786e-07 0 1.848841463412e-07 0 1.849041463412e-07 1.2 1.853922763412e-07 1.2 1.854122763412e-07 0 1.859004065038e-07 0 1.859204065038e-07 1.2 1.864085365038e-07 1.2 1.864285365038e-07 0 1.869166666664e-07 0 1.869366666664e-07 1.2 1.874247966664e-07 1.2 1.874447966664e-07 0 1.87932926829e-07 0 1.87952926829e-07 1.2 1.88441056829e-07 1.2 1.88461056829e-07 0 1.889491869916e-07 0 1.889691869916e-07 1.2 1.894573169916e-07 1.2 1.894773169916e-07 0 1.899654471542e-07 0 1.899854471542e-07 1.2 1.904735771542e-07 1.2 1.904935771542e-07 0 1.909817073168e-07 0 1.910017073168e-07 1.2 1.914898373168e-07 1.2 1.915098373168e-07 0 1.919979674794e-07 0 1.920179674794e-07 1.2 1.925060974794e-07 1.2 1.925260974794e-07 0 1.93014227642e-07 0 1.93034227642e-07 1.2 1.93522357642e-07 1.2 1.93542357642e-07 0 1.940304878046e-07 0 1.940504878046e-07 1.2 1.945386178046e-07 1.2 1.945586178046e-07 0 1.950467479672e-07 0 1.950667479672e-07 1.2 1.955548779672e-07 1.2 1.955748779672e-07 0 1.960630081298e-07 0 1.960830081298e-07 1.2 1.965711381298e-07 1.2 1.965911381298e-07 0 1.970792682924e-07 0 1.970992682924e-07 1.2 1.975873982924e-07 1.2 1.976073982924e-07 0 1.98095528455e-07 0 1.98115528455e-07 1.2 1.98603658455e-07 1.2 1.98623658455e-07 0 1.991117886176e-07 0 1.991317886176e-07 1.2 1.996199186176e-07 1.2 1.996399186176e-07 0 2.001280487802e-07 0 2.001480487802e-07 1.2 2.006361787802e-07 1.2 2.006561787802e-07 0 2.011443089428e-07 0 2.011643089428e-07 1.2 2.016524389428e-07 1.2 2.016724389428e-07 0 2.021605691054e-07 0 2.021805691054e-07 1.2 2.026686991054e-07 1.2 2.026886991054e-07 0 2.03176829268e-07 0 2.03196829268e-07 1.2 2.03684959268e-07 1.2 2.03704959268e-07 0 2.041930894306e-07 0 2.042130894306e-07 1.2 2.047012194306e-07 1.2 2.047212194306e-07 0 2.052093495932e-07 0 2.052293495932e-07 1.2 2.057174795932e-07 1.2 2.057374795932e-07 0 2.062256097558e-07 0 2.062456097558e-07 1.2 2.067337397558e-07 1.2 2.067537397558e-07 0 2.072418699184e-07 0 2.072618699184e-07 1.2 2.077499999184e-07 1.2 2.077699999184e-07 0 2.08258130081e-07 0 2.08278130081e-07 1.2 2.08766260081e-07 1.2 2.08786260081e-07 0 2.092743902436e-07 0 2.092943902436e-07 1.2 2.097825202436e-07 1.2 2.098025202436e-07 0 2.102906504062e-07 0 2.103106504062e-07 1.2 2.107987804062e-07 1.2 2.108187804062e-07 0 2.113069105688e-07 0 2.113269105688e-07 1.2 2.118150405688e-07 1.2 2.118350405688e-07 0 2.123231707314e-07 0 2.123431707314e-07 1.2 2.128313007314e-07 1.2 2.128513007314e-07 0 2.13339430894e-07 0 2.13359430894e-07 1.2 2.13847560894e-07 1.2 2.13867560894e-07 0 2.143556910566e-07 0 2.143756910566e-07 1.2 2.148638210566e-07 1.2 2.148838210566e-07 0 2.153719512192e-07 0 2.153919512192e-07 1.2 2.158800812192e-07 1.2 2.159000812192e-07 0 2.163882113818e-07 0 2.164082113818e-07 1.2 2.168963413818e-07 1.2 2.169163413818e-07 0 2.174044715444e-07 0 2.174244715444e-07 1.2 2.179126015444e-07 1.2 2.179326015444e-07 0 2.18420731707e-07 0 2.18440731707e-07 1.2 2.18928861707e-07 1.2 2.18948861707e-07 0 2.194369918696e-07 0 2.194569918696e-07 1.2 2.199451218696e-07 1.2 2.199651218696e-07 0 2.204532520322e-07 0 2.204732520322e-07 1.2 2.209613820322e-07 1.2 2.209813820322e-07 0 2.214695121948e-07 0 2.214895121948e-07 1.2 2.219776421948e-07 1.2 2.219976421948e-07 0 2.224857723574e-07 0 2.225057723574e-07 1.2 2.229939023574e-07 1.2 2.230139023574e-07 0 2.2350203252e-07 0 2.2352203252e-07 1.2 2.2401016252e-07 1.2 2.2403016252e-07 0 2.245182926826e-07 0 2.245382926826e-07 1.2 2.250264226826e-07 1.2 2.250464226826e-07 0 2.255345528452e-07 0 2.255545528452e-07 1.2 2.260426828452e-07 1.2 2.260626828452e-07 0 2.265508130078e-07 0 2.265708130078e-07 1.2 2.270589430078e-07 1.2 2.270789430078e-07 0 2.275670731704e-07 0 2.275870731704e-07 1.2 2.280752031704e-07 1.2 2.280952031704e-07 0 2.28583333333e-07 0 2.28603333333e-07 1.2 2.29091463333e-07 1.2 2.29111463333e-07 0 2.295995934956e-07 0 2.296195934956e-07 1.2 2.301077234956e-07 1.2 2.301277234956e-07 0 2.306158536582e-07 0 2.306358536582e-07 1.2 2.311239836582e-07 1.2 2.311439836582e-07 0 2.316321138208e-07 0 2.316521138208e-07 1.2 2.321402438208e-07 1.2 2.321602438208e-07 0 2.326483739834e-07 0 2.326683739834e-07 1.2 2.331565039834e-07 1.2 2.331765039834e-07 0 2.33664634146e-07 0 2.33684634146e-07 1.2 2.34172764146e-07 1.2 2.34192764146e-07 0 2.346808943086e-07 0 2.347008943086e-07 1.2 2.351890243086e-07 1.2 2.352090243086e-07 0 2.356971544712e-07 0 2.357171544712e-07 1.2 2.362052844712e-07 1.2 2.362252844712e-07 0 2.367134146338e-07 0 2.367334146338e-07 1.2 2.372215446338e-07 1.2 2.372415446338e-07 0 2.377296747964e-07 0 2.377496747964e-07 1.2 2.382378047964e-07 1.2 2.382578047964e-07 0 2.38745934959e-07 0 2.38765934959e-07 1.2 2.39254064959e-07 1.2 2.39274064959e-07 0 2.397621951216e-07 0 2.397821951216e-07 1.2 2.402703251216e-07 1.2 2.402903251216e-07 0 2.407784552842e-07 0 2.407984552842e-07 1.2 2.412865852842e-07 1.2 2.413065852842e-07 0 2.417947154468e-07 0 2.418147154468e-07 1.2 2.423028454468e-07 1.2 2.423228454468e-07 0 2.428109756094e-07 0 2.428309756094e-07 1.2 2.433191056094e-07 1.2 2.433391056094e-07 0 2.43827235772e-07 0 2.43847235772e-07 1.2 2.44335365772e-07 1.2 2.44355365772e-07 0 2.448434959346e-07 0 2.448634959346e-07 1.2 2.453516259346e-07 1.2 2.453716259346e-07 0 2.458597560972e-07 0 2.458797560972e-07 1.2 2.463678860972e-07 1.2 2.463878860972e-07 0 2.468760162598e-07 0 2.468960162598e-07 1.2 2.473841462598e-07 1.2 2.474041462598e-07 0 2.478922764224e-07 0 2.479122764224e-07 1.2 2.484004064224e-07 1.2 2.484204064224e-07 0 2.48908536585e-07 0 2.48928536585e-07 1.2 2.49416666585e-07 1.2 2.49436666585e-07 0 2.499247967476e-07 0 2.499447967476e-07 1.2 2.504329267476e-07 1.2 2.504529267476e-07 0 2.509410569102e-07 0 2.509610569102e-07 1.2 2.514491869102e-07 1.2 2.514691869102e-07 0 2.519573170728e-07 0 2.519773170728e-07 1.2 2.524654470728e-07 1.2 2.524854470728e-07 0 2.529735772354e-07 0 2.529935772354e-07 1.2 2.534817072354e-07 1.2 2.535017072354e-07 0 2.53989837398e-07 0 2.54009837398e-07 1.2 2.54497967398e-07 1.2 2.54517967398e-07 0 2.550060975606e-07 0 2.550260975606e-07 1.2 2.555142275606e-07 1.2 2.555342275606e-07 0 2.560223577232e-07 0 2.560423577232e-07 1.2 2.565304877232e-07 1.2 2.565504877232e-07 0 2.570386178858e-07 0 2.570586178858e-07 1.2 2.575467478858e-07 1.2 2.575667478858e-07 0 2.580548780484e-07 0 2.580748780484e-07 1.2 2.585630080484e-07 1.2 2.585830080484e-07 0 2.59071138211e-07 0 2.59091138211e-07 1.2 2.59579268211e-07 1.2 2.59599268211e-07 0 2.600873983736e-07 0 2.601073983736e-07 1.2 2.605955283736e-07 1.2 2.606155283736e-07 0 2.611036585362e-07 0 2.611236585362e-07 1.2 2.616117885362e-07 1.2 2.616317885362e-07 0 2.621199186988e-07 0 2.621399186988e-07 1.2 2.626280486988e-07 1.2 2.626480486988e-07 0 2.631361788614e-07 0 2.631561788614e-07 1.2 2.636443088614e-07 1.2 2.636643088614e-07 0 2.64152439024e-07 0 2.64172439024e-07 1.2 2.64660569024e-07 1.2 2.64680569024e-07 0 2.651686991866e-07 0 2.651886991866e-07 1.2 2.656768291866e-07 1.2 2.656968291866e-07 0 2.661849593492e-07 0 2.662049593492e-07 1.2 2.666930893492e-07 1.2 2.667130893492e-07 0 2.672012195118e-07 0 2.672212195118e-07 1.2 2.677093495118e-07 1.2 2.677293495118e-07 0 2.682174796744e-07 0 2.682374796744e-07 1.2 2.687256096744e-07 1.2 2.687456096744e-07 0 2.69233739837e-07 0 2.69253739837e-07 1.2 2.69741869837e-07 1.2 2.69761869837e-07 0 2.702499999996e-07 0 2.702699999996e-07 1.2 2.707581299996e-07 1.2 2.707781299996e-07 0 2.712662601622e-07 0 2.712862601622e-07 1.2 2.717743901622e-07 1.2 2.717943901622e-07 0 2.722825203248e-07 0 2.723025203248e-07 1.2 2.727906503248e-07 1.2 2.728106503248e-07 0 2.732987804874e-07 0 2.733187804874e-07 1.2 2.738069104874e-07 1.2 2.738269104874e-07 0 2.7431504065e-07 0 2.7433504065e-07 1.2 2.7482317065e-07 1.2 2.7484317065e-07 0 2.753313008126e-07 0 2.753513008126e-07 1.2 2.758394308126e-07 1.2 2.758594308126e-07 0 2.763475609752e-07 0 2.763675609752e-07 1.2 2.768556909752e-07 1.2 2.768756909752e-07 0 2.773638211378e-07 0 2.773838211378e-07 1.2 2.778719511378e-07 1.2 2.778919511378e-07 0 2.783800813004e-07 0 2.784000813004e-07 1.2 2.788882113004e-07 1.2 2.789082113004e-07 0 2.79396341463e-07 0 2.79416341463e-07 1.2 2.79904471463e-07 1.2 2.79924471463e-07 0 2.804126016256e-07 0 2.804326016256e-07 1.2 2.809207316256e-07 1.2 2.809407316256e-07 0 2.814288617882e-07 0 2.814488617882e-07 1.2 2.819369917882e-07 1.2 2.819569917882e-07 0 2.824451219508e-07 0 2.824651219508e-07 1.2 2.829532519508e-07 1.2 2.829732519508e-07 0 2.834613821134e-07 0 2.834813821134e-07 1.2 2.839695121134e-07 1.2 2.839895121134e-07 0 2.84477642276e-07 0 2.84497642276e-07 1.2 2.84985772276e-07 1.2 2.85005772276e-07 0 2.854939024386e-07 0 2.855139024386e-07 1.2 2.860020324386e-07 1.2 2.860220324386e-07 0 2.865101626012e-07 0 2.865301626012e-07 1.2 2.870182926012e-07 1.2 2.870382926012e-07 0 2.875264227638e-07 0 2.875464227638e-07 1.2 2.880345527638e-07 1.2 2.880545527638e-07 0 2.885426829264e-07 0 2.885626829264e-07 1.2 2.890508129264e-07 1.2 2.890708129264e-07 0 2.89558943089e-07 0 2.89578943089e-07 1.2 2.90067073089e-07 1.2 2.90087073089e-07 0 2.905752032516e-07 0 2.905952032516e-07 1.2 2.910833332516e-07 1.2 2.911033332516e-07 0 2.915914634142e-07 0 2.916114634142e-07 1.2 2.920995934142e-07 1.2 2.921195934142e-07 0 2.926077235768e-07 0 2.926277235768e-07 1.2 2.931158535768e-07 1.2 2.931358535768e-07 0 2.936239837394e-07 0 2.936439837394e-07 1.2 2.941321137394e-07 1.2 2.941521137394e-07 0 2.94640243902e-07 0 2.94660243902e-07 1.2 2.95148373902e-07 1.2 2.95168373902e-07 0 2.956565040646e-07 0 2.956765040646e-07 1.2 2.961646340646e-07 1.2 2.961846340646e-07 0 2.966727642272e-07 0 2.966927642272e-07 1.2 2.971808942272e-07 1.2 2.972008942272e-07 0 2.976890243898e-07 0 2.977090243898e-07 1.2 2.981971543898e-07 1.2 2.982171543898e-07 0 2.987052845524e-07 0 2.987252845524e-07 1.2 2.992134145524e-07 1.2 2.992334145524e-07 0 2.99721544715e-07 0 2.99741544715e-07 1.2 3.00229674715e-07 1.2 3.00249674715e-07 0 3.007378048776e-07 0 3.007578048776e-07 1.2 3.012459348776e-07 1.2 3.012659348776e-07 0 3.017540650402e-07 0 3.017740650402e-07 1.2 3.022621950402e-07 1.2 3.022821950402e-07 0 3.027703252028e-07 0 3.027903252028e-07 1.2 3.032784552028e-07 1.2 3.032984552028e-07 0 3.037865853654e-07 0 3.038065853654e-07 1.2 3.042947153654e-07 1.2 3.043147153654e-07 0 3.04802845528e-07 0 3.04822845528e-07 1.2 3.05310975528e-07 1.2 3.05330975528e-07 0 3.058191056906e-07 0 3.058391056906e-07 1.2 3.063272356906e-07 1.2 3.063472356906e-07 0 3.068353658532e-07 0 3.068553658532e-07 1.2 3.073434958532e-07 1.2 3.073634958532e-07 0 3.078516260158e-07 0 3.078716260158e-07 1.2 3.083597560158e-07 1.2 3.083797560158e-07 0 3.088678861784e-07 0 3.088878861784e-07 1.2 3.093760161784e-07 1.2 3.093960161784e-07 0 3.09884146341e-07 0 3.09904146341e-07 1.2 3.10392276341e-07 1.2 3.10412276341e-07 0 3.109004065036e-07 0 3.109204065036e-07 1.2 3.114085365036e-07 1.2 3.114285365036e-07 0 3.119166666662e-07 0 3.119366666662e-07 1.2 3.124247966662e-07 1.2 3.124447966662e-07 0 3.129329268288e-07 0 3.129529268288e-07 1.2 3.134410568288e-07 1.2 3.134610568288e-07 0 3.139491869914e-07 0 3.139691869914e-07 1.2 3.144573169914e-07 1.2 3.144773169914e-07 0 3.14965447154e-07 0 3.14985447154e-07 1.2 3.15473577154e-07 1.2 3.15493577154e-07 0 3.159817073166e-07 0 3.160017073166e-07 1.2 3.164898373166e-07 1.2 3.165098373166e-07 0 3.169979674792e-07 0 3.170179674792e-07 1.2 3.175060974792e-07 1.2 3.175260974792e-07 0 3.180142276418e-07 0 3.180342276418e-07 1.2 3.185223576418e-07 1.2 3.185423576418e-07 0 3.190304878044e-07 0 3.190504878044e-07 1.2 3.195386178044e-07 1.2 3.195586178044e-07 0 3.20046747967e-07 0 3.20066747967e-07 1.2 3.20554877967e-07 1.2 3.20574877967e-07 0 3.210630081296e-07 0 3.210830081296e-07 1.2 3.215711381296e-07 1.2 3.215911381296e-07 0 3.220792682922e-07 0 3.220992682922e-07 1.2 3.225873982922e-07 1.2 3.226073982922e-07 0 3.230955284548e-07 0 3.231155284548e-07 1.2 3.236036584548e-07 1.2 3.236236584548e-07 0 3.241117886174e-07 0 3.241317886174e-07 1.2 3.246199186174e-07 1.2 3.246399186174e-07 0 3.2512804878e-07 0 3.2514804878e-07 1.2 3.2563617878e-07 1.2 3.2565617878e-07 0 3.261443089426e-07 0 3.261643089426e-07 1.2 3.266524389426e-07 1.2 3.266724389426e-07 0 3.271605691052e-07 0 3.271805691052e-07 1.2 3.276686991052e-07 1.2 3.276886991052e-07 0 3.281768292678e-07 0 3.281968292678e-07 1.2 3.286849592678e-07 1.2 3.287049592678e-07 0 3.291930894304e-07 0 3.292130894304e-07 1.2 3.297012194304e-07 1.2 3.297212194304e-07 0 3.30209349593e-07 0 3.30229349593e-07 1.2 3.30717479593e-07 1.2 3.30737479593e-07 0 3.312256097556e-07 0 3.312456097556e-07 1.2 3.317337397556e-07 1.2 3.317537397556e-07 0 3.322418699182e-07 0 3.322618699182e-07 1.2 3.327499999182e-07 1.2 3.327699999182e-07 0 3.332581300808e-07 0 3.332781300808e-07 1.2 3.337662600808e-07 1.2 3.337862600808e-07 0 3.342743902434e-07 0 3.342943902434e-07 1.2 3.347825202434e-07 1.2 3.348025202434e-07 0 3.35290650406e-07 0 3.35310650406e-07 1.2 3.35798780406e-07 1.2 3.35818780406e-07 0 3.363069105686e-07 0 3.363269105686e-07 1.2 3.368150405686e-07 1.2 3.368350405686e-07 0 3.373231707312e-07 0 3.373431707312e-07 1.2 3.378313007312e-07 1.2 3.378513007312e-07 0 3.383394308938e-07 0 3.383594308938e-07 1.2 3.388475608938e-07 1.2 3.388675608938e-07 0 3.393556910564e-07 0 3.393756910564e-07 1.2 3.398638210564e-07 1.2 3.398838210564e-07 0 3.40371951219e-07 0 3.40391951219e-07 1.2 3.40880081219e-07 1.2 3.40900081219e-07 0 3.413882113816e-07 0 3.414082113816e-07 1.2 3.418963413816e-07 1.2 3.419163413816e-07 0 3.424044715442e-07 0 3.424244715442e-07 1.2 3.429126015442e-07 1.2 3.429326015442e-07 0 3.434207317068e-07 0 3.434407317068e-07 1.2 3.439288617068e-07 1.2 3.439488617068e-07 0 3.444369918694e-07 0 3.444569918694e-07 1.2 3.449451218694e-07 1.2 3.449651218694e-07 0 3.45453252032e-07 0 3.45473252032e-07 1.2 3.45961382032e-07 1.2 3.45981382032e-07 0 3.464695121946e-07 0 3.464895121946e-07 1.2 3.469776421946e-07 1.2 3.469976421946e-07 0 3.474857723572e-07 0 3.475057723572e-07 1.2 3.479939023572e-07 1.2 3.480139023572e-07 0 3.485020325198e-07 0 3.485220325198e-07 1.2 3.490101625198e-07 1.2 3.490301625198e-07 0 3.495182926824e-07 0 3.495382926824e-07 1.2 3.500264226824e-07 1.2 3.500464226824e-07 0 3.50534552845e-07 0 3.50554552845e-07 1.2 3.51042682845e-07 1.2 3.51062682845e-07 0 3.515508130076e-07 0 3.515708130076e-07 1.2 3.520589430076e-07 1.2 3.520789430076e-07 0 3.525670731702e-07 0 3.525870731702e-07 1.2 3.530752031702e-07 1.2 3.530952031702e-07 0 3.535833333328e-07 0 3.536033333328e-07 1.2 3.540914633328e-07 1.2 3.541114633328e-07 0 3.545995934954e-07 0 3.546195934954e-07 1.2 3.551077234954e-07 1.2 3.551277234954e-07 0 3.55615853658e-07 0 3.55635853658e-07 1.2 3.56123983658e-07 1.2 3.56143983658e-07 0 3.566321138206e-07 0 3.566521138206e-07 1.2 3.571402438206e-07 1.2 3.571602438206e-07 0 3.576483739832e-07 0 3.576683739832e-07 1.2 3.581565039832e-07 1.2 3.581765039832e-07 0 3.586646341458e-07 0 3.586846341458e-07 1.2 3.591727641458e-07 1.2 3.591927641458e-07 0 3.596808943084e-07 0 3.597008943084e-07 1.2 3.601890243084e-07 1.2 3.602090243084e-07 0 3.60697154471e-07 0 3.60717154471e-07 1.2 3.61205284471e-07 1.2 3.61225284471e-07 0 3.617134146336e-07 0 3.617334146336e-07 1.2 3.622215446336e-07 1.2 3.622415446336e-07 0 3.627296747962e-07 0 3.627496747962e-07 1.2 3.632378047962e-07 1.2 3.632578047962e-07 0 3.637459349588e-07 0 3.637659349588e-07 1.2 3.642540649588e-07 1.2 3.642740649588e-07 0 3.647621951214e-07 0 3.647821951214e-07 1.2 3.652703251214e-07 1.2 3.652903251214e-07 0 3.65778455284e-07 0 3.65798455284e-07 1.2 3.66286585284e-07 1.2 3.66306585284e-07 0 3.667947154466e-07 0 3.668147154466e-07 1.2 3.673028454466e-07 1.2 3.673228454466e-07 0 3.678109756092e-07 0 3.678309756092e-07 1.2 3.683191056092e-07 1.2 3.683391056092e-07 0 3.688272357718e-07 0 3.688472357718e-07 1.2 3.693353657718e-07 1.2 3.693553657718e-07 0 3.698434959344e-07 0 3.698634959344e-07 1.2 3.703516259344e-07 1.2 3.703716259344e-07 0 3.70859756097e-07 0 3.70879756097e-07 1.2 3.71367886097e-07 1.2 3.71387886097e-07 0 3.718760162596e-07 0 3.718960162596e-07 1.2 3.723841462596e-07 1.2 3.724041462596e-07 0 3.728922764222e-07 0 3.729122764222e-07 1.2 3.734004064222e-07 1.2 3.734204064222e-07 0 3.739085365848e-07 0 3.739285365848e-07 1.2 3.744166665848e-07 1.2 3.744366665848e-07 0 3.749247967474e-07 0 3.749447967474e-07 1.2 3.754329267474e-07 1.2 3.754529267474e-07 0 3.7594105691e-07 0 3.7596105691e-07 1.2 3.7644918691e-07 1.2 3.7646918691e-07 0 3.769573170726e-07 0 3.769773170726e-07 1.2 3.774654470726e-07 1.2 3.774854470726e-07 0 3.779735772352e-07 0 3.779935772352e-07 1.2 3.784817072352e-07 1.2 3.785017072352e-07 0 3.789898373978e-07 0 3.790098373978e-07 1.2 3.794979673978e-07 1.2 3.795179673978e-07 0 3.800060975604e-07 0 3.800260975604e-07 1.2 3.805142275604e-07 1.2 3.805342275604e-07 0 3.81022357723e-07 0 3.81042357723e-07 1.2 3.81530487723e-07 1.2 3.81550487723e-07 0 3.820386178856e-07 0 3.820586178856e-07 1.2 3.825467478856e-07 1.2 3.825667478856e-07 0 3.830548780482e-07 0 3.830748780482e-07 1.2 3.835630080482e-07 1.2 3.835830080482e-07 0 3.840711382108e-07 0 3.840911382108e-07 1.2 3.845792682108e-07 1.2 3.845992682108e-07 0 3.850873983734e-07 0 3.851073983734e-07 1.2 3.855955283734e-07 1.2 3.856155283734e-07 0 3.86103658536e-07 0 3.86123658536e-07 1.2 3.86611788536e-07 1.2 3.86631788536e-07 0 3.871199186986e-07 0 3.871399186986e-07 1.2 3.876280486986e-07 1.2 3.876480486986e-07 0 3.881361788612e-07 0 3.881561788612e-07 1.2 3.886443088612e-07 1.2 3.886643088612e-07 0 3.891524390238e-07 0 3.891724390238e-07 1.2 3.896605690238e-07 1.2 3.896805690238e-07 0 3.901686991864e-07 0 3.901886991864e-07 1.2 3.906768291864e-07 1.2 3.906968291864e-07 0 3.91184959349e-07 0 3.91204959349e-07 1.2 3.91693089349e-07 1.2 3.91713089349e-07 0 3.922012195116e-07 0 3.922212195116e-07 1.2 3.927093495116e-07 1.2 3.927293495116e-07 0 3.932174796742e-07 0 3.932374796742e-07 1.2 3.937256096742e-07 1.2 3.937456096742e-07 0 3.942337398368e-07 0 3.942537398368e-07 1.2 3.947418698368e-07 1.2 3.947618698368e-07 0 3.952499999994e-07 0 3.952699999994e-07 1.2 3.957581299994e-07 1.2 3.957781299994e-07 0 3.96266260162e-07 0 3.96286260162e-07 1.2 3.96774390162e-07 1.2 3.96794390162e-07 0 3.972825203246e-07 0 3.973025203246e-07 1.2 3.977906503246e-07 1.2 3.978106503246e-07 0 3.982987804872e-07 0 3.983187804872e-07 1.2 3.988069104872e-07 1.2 3.988269104872e-07 0 3.993150406498e-07 0 3.993350406498e-07 1.2 3.998231706498e-07 1.2 3.998431706498e-07 0 4.003313008124e-07 0 4.003513008124e-07 1.2 4.008394308124e-07 1.2 4.008594308124e-07 0 4.01347560975e-07 0 4.01367560975e-07 1.2 4.01855690975e-07 1.2 4.01875690975e-07 0 4.023638211376e-07 0 4.023838211376e-07 1.2 4.028719511376e-07 1.2 4.028919511376e-07 0 4.033800813002e-07 0 4.034000813002e-07 1.2 4.038882113002e-07 1.2 4.039082113002e-07 0 4.043963414628e-07 0 4.044163414628e-07 1.2 4.049044714628e-07 1.2 4.049244714628e-07 0 4.054126016254e-07 0 4.054326016254e-07 1.2 4.059207316254e-07 1.2 4.059407316254e-07 0 4.06428861788e-07 0 4.06448861788e-07 1.2 4.06936991788e-07 1.2 4.06956991788e-07 0 4.074451219506e-07 0 4.074651219506e-07 1.2 4.079532519506e-07 1.2 4.079732519506e-07 0 4.084613821132e-07 0 4.084813821132e-07 1.2 4.089695121132e-07 1.2 4.089895121132e-07 0 4.094776422758e-07 0 4.094976422758e-07 1.2 4.099857722758e-07 1.2 4.100057722758e-07 0 4.104939024384e-07 0 4.105139024384e-07 1.2 4.110020324384e-07 1.2 4.110220324384e-07 0 4.11510162601e-07 0 4.11530162601e-07 1.2 4.12018292601e-07 1.2 4.12038292601e-07 0 4.125264227636e-07 0 4.125464227636e-07 1.2 4.130345527636e-07 1.2 4.130545527636e-07 0 4.135426829262e-07 0 4.135626829262e-07 1.2 4.140508129262e-07 1.2 4.140708129262e-07 0 4.145589430888e-07 0 4.145789430888e-07 1.2 4.150670730888e-07 1.2 4.150870730888e-07 0 4.155752032514e-07 0 4.155952032514e-07 1.2 4.160833332514e-07 1.2 4.161033332514e-07 0 4.16591463414e-07 0 4.16611463414e-07 1.2 4.17099593414e-07 1.2 4.17119593414e-07 0 4.176077235766e-07 0 4.176277235766e-07 1.2 4.181158535766e-07 1.2 4.181358535766e-07 0 4.186239837392e-07 0 4.186439837392e-07 1.2 4.191321137392e-07 1.2 4.191521137392e-07 0 4.196402439018e-07 0 4.196602439018e-07 1.2 4.201483739018e-07 1.2 4.201683739018e-07 0 4.206565040644e-07 0 4.206765040644e-07 1.2 4.211646340644e-07 1.2 4.211846340644e-07 0 4.21672764227e-07 0 4.21692764227e-07 1.2 4.22180894227e-07 1.2 4.22200894227e-07 0 4.226890243896e-07 0 4.227090243896e-07 1.2 4.231971543896e-07 1.2 4.232171543896e-07 0 4.237052845522e-07 0 4.237252845522e-07 1.2 4.242134145522e-07 1.2 4.242334145522e-07 0 4.247215447148e-07 0 4.247415447148e-07 1.2 4.252296747148e-07 1.2 4.252496747148e-07 0 4.257378048774e-07 0 4.257578048774e-07 1.2 4.262459348774e-07 1.2 4.262659348774e-07 0 4.2675406504e-07 0 4.2677406504e-07 1.2 4.2726219504e-07 1.2 4.2728219504e-07 0 4.277703252026e-07 0 4.277903252026e-07 1.2 4.282784552026e-07 1.2 4.282984552026e-07 0 4.287865853652e-07 0 4.288065853652e-07 1.2 4.292947153652e-07 1.2 4.293147153652e-07 0 4.298028455278e-07 0 4.298228455278e-07 1.2 4.303109755278e-07 1.2 4.303309755278e-07 0 4.308191056904e-07 0 4.308391056904e-07 1.2 4.313272356904e-07 1.2 4.313472356904e-07 0 4.31835365853e-07 0 4.31855365853e-07 1.2 4.32343495853e-07 1.2 4.32363495853e-07 0 4.328516260156e-07 0 4.328716260156e-07 1.2 4.333597560156e-07 1.2 4.333797560156e-07 0 4.338678861782e-07 0 4.338878861782e-07 1.2 4.343760161782e-07 1.2 4.343960161782e-07 0 4.348841463408e-07 0 4.349041463408e-07 1.2 4.353922763408e-07 1.2 4.354122763408e-07 0 4.359004065034e-07 0 4.359204065034e-07 1.2 4.364085365034e-07 1.2 4.364285365034e-07 0 4.36916666666e-07 0 4.36936666666e-07 1.2 4.37424796666e-07 1.2 4.37444796666e-07 0 4.379329268286e-07 0 4.379529268286e-07 1.2 4.384410568286e-07 1.2 4.384610568286e-07 0 4.389491869912e-07 0 4.389691869912e-07 1.2 4.394573169912e-07 1.2 4.394773169912e-07 0 4.399654471538e-07 0 4.399854471538e-07 1.2 4.404735771538e-07 1.2 4.404935771538e-07 0 4.409817073164e-07 0 4.410017073164e-07 1.2 4.414898373164e-07 1.2 4.415098373164e-07 0 4.41997967479e-07 0 4.42017967479e-07 1.2 4.42506097479e-07 1.2 4.42526097479e-07 0 4.430142276416e-07 0 4.430342276416e-07 1.2 4.435223576416e-07 1.2 4.435423576416e-07 0 4.440304878042e-07 0 4.440504878042e-07 1.2 4.445386178042e-07 1.2 4.445586178042e-07 0 4.450467479668e-07 0 4.450667479668e-07 1.2 4.455548779668e-07 1.2 4.455748779668e-07 0 4.460630081294e-07 0 4.460830081294e-07 1.2 4.465711381294e-07 1.2 4.465911381294e-07 0 4.47079268292e-07 0 4.47099268292e-07 1.2 4.47587398292e-07 1.2 4.47607398292e-07 0 4.480955284546e-07 0 4.481155284546e-07 1.2 4.486036584546e-07 1.2 4.486236584546e-07 0 4.491117886172e-07 0 4.491317886172e-07 1.2 4.496199186172e-07 1.2 4.496399186172e-07 0 4.501280487798e-07 0 4.501480487798e-07 1.2 4.506361787798e-07 1.2 4.506561787798e-07 0 4.511443089424e-07 0 4.511643089424e-07 1.2 4.516524389424e-07 1.2 4.516724389424e-07 0 4.52160569105e-07 0 4.52180569105e-07 1.2 4.52668699105e-07 1.2 4.52688699105e-07 0 4.531768292676e-07 0 4.531968292676e-07 1.2 4.536849592676e-07 1.2 4.537049592676e-07 0 4.541930894302e-07 0 4.542130894302e-07 1.2 4.547012194302e-07 1.2 4.547212194302e-07 0 4.552093495928e-07 0 4.552293495928e-07 1.2 4.557174795928e-07 1.2 4.557374795928e-07 0 4.562256097554e-07 0 4.562456097554e-07 1.2 4.567337397554e-07 1.2 4.567537397554e-07 0 4.57241869918e-07 0 4.57261869918e-07 1.2 4.57749999918e-07 1.2 4.57769999918e-07 0 4.582581300806e-07 0 4.582781300806e-07 1.2 4.587662600806e-07 1.2 4.587862600806e-07 0 4.592743902432e-07 0 4.592943902432e-07 1.2 4.597825202432e-07 1.2 4.598025202432e-07 0 4.602906504058e-07 0 4.603106504058e-07 1.2 4.607987804058e-07 1.2 4.608187804058e-07 0 4.613069105684e-07 0 4.613269105684e-07 1.2 4.618150405684e-07 1.2 4.618350405684e-07 0 4.62323170731e-07 0 4.62343170731e-07 1.2 4.62831300731e-07 1.2 4.62851300731e-07 0 4.633394308936e-07 0 4.633594308936e-07 1.2 4.638475608936e-07 1.2 4.638675608936e-07 0 4.643556910562e-07 0 4.643756910562e-07 1.2 4.648638210562e-07 1.2 4.648838210562e-07 0 4.653719512188e-07 0 4.653919512188e-07 1.2 4.658800812188e-07 1.2 4.659000812188e-07 0 4.663882113814e-07 0 4.664082113814e-07 1.2 4.668963413814e-07 1.2 4.669163413814e-07 0 4.67404471544e-07 0 4.67424471544e-07 1.2 4.67912601544e-07 1.2 4.67932601544e-07 0 4.684207317066e-07 0 4.684407317066e-07 1.2 4.689288617066e-07 1.2 4.689488617066e-07 0 4.694369918692e-07 0 4.694569918692e-07 1.2 4.699451218692e-07 1.2 4.699651218692e-07 0 4.704532520318e-07 0 4.704732520318e-07 1.2 4.709613820318e-07 1.2 4.709813820318e-07 0 4.714695121944e-07 0 4.714895121944e-07 1.2 4.719776421944e-07 1.2 4.719976421944e-07 0 4.72485772357e-07 0 4.72505772357e-07 1.2 4.72993902357e-07 1.2 4.73013902357e-07 0 4.735020325196e-07 0 4.735220325196e-07 1.2 4.740101625196e-07 1.2 4.740301625196e-07 0 4.745182926822e-07 0 4.745382926822e-07 1.2 4.750264226822e-07 1.2 4.750464226822e-07 0 4.755345528448e-07 0 4.755545528448e-07 1.2 4.760426828448e-07 1.2 4.760626828448e-07 0 4.765508130074e-07 0 4.765708130074e-07 1.2 4.770589430074e-07 1.2 4.770789430074e-07 0 4.7756707317e-07 0 4.7758707317e-07 1.2 4.7807520317e-07 1.2 4.7809520317e-07 0 4.785833333326e-07 0 4.786033333326e-07 1.2 4.790914633326e-07 1.2 4.791114633326e-07 0 4.795995934952e-07 0 4.796195934952e-07 1.2 4.801077234952e-07 1.2 4.801277234952e-07 0 4.806158536578e-07 0 4.806358536578e-07 1.2 4.811239836578e-07 1.2 4.811439836578e-07 0 4.816321138204e-07 0 4.816521138204e-07 1.2 4.821402438204e-07 1.2 4.821602438204e-07 0 4.82648373983e-07 0 4.82668373983e-07 1.2 4.83156503983e-07 1.2 4.83176503983e-07 0 4.836646341456e-07 0 4.836846341456e-07 1.2 4.841727641456e-07 1.2 4.841927641456e-07 0 4.846808943082e-07 0 4.847008943082e-07 1.2 4.851890243082e-07 1.2 4.852090243082e-07 0 4.856971544708e-07 0 4.857171544708e-07 1.2 4.862052844708e-07 1.2 4.862252844708e-07 0 4.867134146334e-07 0 4.867334146334e-07 1.2 4.872215446334e-07 1.2 4.872415446334e-07 0 4.87729674796e-07 0 4.87749674796e-07 1.2 4.88237804796e-07 1.2 4.88257804796e-07 0 4.887459349586e-07 0 4.887659349586e-07 1.2 4.892540649586e-07 1.2 4.892740649586e-07 0 4.897621951212e-07 0 4.897821951212e-07 1.2 4.902703251212e-07 1.2 4.902903251212e-07 0 4.907784552838e-07 0 4.907984552838e-07 1.2 4.912865852838e-07 1.2 4.913065852838e-07 0 4.917947154464e-07 0 4.918147154464e-07 1.2 4.923028454464e-07 1.2 4.923228454464e-07 0 4.92810975609e-07 0 4.92830975609e-07 1.2 4.93319105609e-07 1.2 4.93339105609e-07 0 4.938272357716e-07 0 4.938472357716e-07 1.2 4.943353657716e-07 1.2 4.943553657716e-07 0 4.948434959342e-07 0 4.948634959342e-07 1.2 4.953516259342e-07 1.2 4.953716259342e-07 0 4.958597560968e-07 0 4.958797560968e-07 1.2 4.963678860968e-07 1.2 4.963878860968e-07 0 4.968760162594e-07 0 4.968960162594e-07 1.2 4.973841462594e-07 1.2 4.974041462594e-07 0 4.97892276422e-07 0 4.97912276422e-07 1.2 4.98400406422e-07 1.2 4.98420406422e-07 0 4.989085365846e-07 0 4.989285365846e-07 1.2 4.994166665846e-07 1.2 4.994366665846e-07 0 4.999247967472e-07 0 4.999447967472e-07 1.2 5.004329267472e-07 1.2 5.004529267472e-07 0 5.009410569098e-07 0 5.009610569098e-07 1.2 5.014491869098e-07 1.2 5.014691869098e-07 0 5.019573170724e-07 0 5.019773170724e-07 1.2 5.024654470724e-07 1.2 5.024854470724e-07 0 5.02973577235e-07 0 5.02993577235e-07 1.2 5.03481707235e-07 1.2 5.03501707235e-07 0 5.039898373976e-07 0 5.040098373976e-07 1.2 5.044979673976e-07 1.2 5.045179673976e-07 0 5.050060975602e-07 0 5.050260975602e-07 1.2 5.055142275602e-07 1.2 5.055342275602e-07 0 5.060223577228e-07 0 5.060423577228e-07 1.2 5.065304877228e-07 1.2 5.065504877228e-07 0 5.070386178854e-07 0 5.070586178854e-07 1.2 5.075467478854e-07 1.2 5.075667478854e-07 0 5.08054878048e-07 0 5.08074878048e-07 1.2 5.08563008048e-07 1.2 5.08583008048e-07 0 5.090711382106e-07 0 5.090911382106e-07 1.2 5.095792682106e-07 1.2 5.095992682106e-07 0 5.100873983732e-07 0 5.101073983732e-07 1.2 5.105955283732e-07 1.2 5.106155283732e-07 0 5.111036585358e-07 0 5.111236585358e-07 1.2 5.116117885358e-07 1.2 5.116317885358e-07 0 5.121199186984e-07 0 5.121399186984e-07 1.2 5.126280486984e-07 1.2 5.126480486984e-07 0 5.13136178861e-07 0 5.13156178861e-07 1.2 5.13644308861e-07 1.2 5.13664308861e-07 0 5.141524390236e-07 0 5.141724390236e-07 1.2 5.146605690236e-07 1.2 5.146805690236e-07 0 5.151686991862e-07 0 5.151886991862e-07 1.2 5.156768291862e-07 1.2 5.156968291862e-07 0 5.161849593488e-07 0 5.162049593488e-07 1.2 5.166930893488e-07 1.2 5.167130893488e-07 0 5.172012195114e-07 0 5.172212195114e-07 1.2 5.177093495114e-07 1.2 5.177293495114e-07 0 5.18217479674e-07 0 5.18237479674e-07 1.2 5.18725609674e-07 1.2 5.18745609674e-07 0 5.192337398366e-07 0 5.192537398366e-07 1.2 5.197418698366e-07 1.2 5.197618698366e-07 0 5.202499999992e-07 0 5.202699999992e-07 1.2 5.207581299992e-07 1.2 5.207781299992e-07 0 5.212662601618e-07 0 5.212862601618e-07 1.2 5.217743901618e-07 1.2 5.217943901618e-07 0 5.222825203244e-07 0 5.223025203244e-07 1.2 5.227906503244e-07 1.2 5.228106503244e-07 0 5.23298780487e-07 0 5.23318780487e-07 1.2 5.23806910487e-07 1.2 5.23826910487e-07 0 5.243150406496e-07 0 5.243350406496e-07 1.2 5.248231706496e-07 1.2 5.248431706496e-07 0 5.253313008122e-07 0 5.253513008122e-07 1.2 5.258394308122e-07 1.2 5.258594308122e-07 0 5.263475609748e-07 0 5.263675609748e-07 1.2 5.268556909748e-07 1.2 5.268756909748e-07 0 5.273638211374e-07 0 5.273838211374e-07 1.2 5.278719511374e-07 1.2 5.278919511374e-07 0 5.283800813e-07 0 5.284000813e-07 1.2 5.288882113e-07 1.2 5.289082113e-07 0 5.293963414626e-07 0 5.294163414626e-07 1.2 5.299044714626e-07 1.2 5.299244714626e-07 0 5.304126016252e-07 0 5.304326016252e-07 1.2 5.309207316252e-07 1.2 5.309407316252e-07 0 5.314288617878e-07 0 5.314488617878e-07 1.2 5.319369917878e-07 1.2 5.319569917878e-07 0 5.324451219504e-07 0 5.324651219504e-07 1.2 5.329532519504e-07 1.2 5.329732519504e-07 0 5.33461382113e-07 0 5.33481382113e-07 1.2 5.33969512113e-07 1.2 5.33989512113e-07 0 5.344776422756e-07 0 5.344976422756e-07 1.2 5.349857722756e-07 1.2 5.350057722756e-07 0 5.354939024382e-07 0 5.355139024382e-07 1.2 5.360020324382e-07 1.2 5.360220324382e-07 0 5.365101626008e-07 0 5.365301626008e-07 1.2 5.370182926008e-07 1.2 5.370382926008e-07 0 5.375264227634e-07 0 5.375464227634e-07 1.2 5.380345527634e-07 1.2 5.380545527634e-07 0 5.38542682926e-07 0 5.38562682926e-07 1.2 5.39050812926e-07 1.2 5.39070812926e-07 0 5.395589430886e-07 0 5.395789430886e-07 1.2 5.400670730886e-07 1.2 5.400870730886e-07 0 5.405752032512e-07 0 5.405952032512e-07 1.2 5.410833332512e-07 1.2 5.411033332512e-07 0 5.415914634138e-07 0 5.416114634138e-07 1.2 5.420995934138e-07 1.2 5.421195934138e-07 0 5.426077235764e-07 0 5.426277235764e-07 1.2 5.431158535764e-07 1.2 5.431358535764e-07 0 5.43623983739e-07 0 5.43643983739e-07 1.2 5.44132113739e-07 1.2 5.44152113739e-07 0 5.446402439016e-07 0 5.446602439016e-07 1.2 5.451483739016e-07 1.2 5.451683739016e-07 0 5.456565040642e-07 0 5.456765040642e-07 1.2 5.461646340642e-07 1.2 5.461846340642e-07 0 5.466727642268e-07 0 5.466927642268e-07 1.2 5.471808942268e-07 1.2 5.472008942268e-07 0 5.476890243894e-07 0 5.477090243894e-07 1.2 5.481971543894e-07 1.2 5.482171543894e-07 0 5.48705284552e-07 0 5.48725284552e-07 1.2 5.49213414552e-07 1.2 5.49233414552e-07 0 5.497215447146e-07 0 5.497415447146e-07 1.2 5.502296747146e-07 1.2 5.502496747146e-07 0 5.507378048772e-07 0 5.507578048772e-07 1.2 5.512459348772e-07 1.2 5.512659348772e-07 0 5.517540650398e-07 0 5.517740650398e-07 1.2 5.522621950398e-07 1.2 5.522821950398e-07 0 5.527703252024e-07 0 5.527903252024e-07 1.2 5.532784552024e-07 1.2 5.532984552024e-07 0 5.53786585365e-07 0 5.53806585365e-07 1.2 5.54294715365e-07 1.2 5.54314715365e-07 0 5.548028455276e-07 0 5.548228455276e-07 1.2 5.553109755276e-07 1.2 5.553309755276e-07 0 5.558191056902e-07 0 5.558391056902e-07 1.2 5.563272356902e-07 1.2 5.563472356902e-07 0 5.568353658528e-07 0 5.568553658528e-07 1.2 5.573434958528e-07 1.2 5.573634958528e-07 0 5.578516260154e-07 0 5.578716260154e-07 1.2 5.583597560154e-07 1.2 5.583797560154e-07 0 5.58867886178e-07 0 5.58887886178e-07 1.2 5.59376016178e-07 1.2 5.59396016178e-07 0 5.598841463406e-07 0 5.599041463406e-07 1.2 5.603922763406e-07 1.2 5.604122763406e-07 0 5.609004065032e-07 0 5.609204065032e-07 1.2 5.614085365032e-07 1.2 5.614285365032e-07 0 5.619166666658e-07 0 5.619366666658e-07 1.2 5.624247966658e-07 1.2 5.624447966658e-07 0 5.629329268284e-07 0 5.629529268284e-07 1.2 5.634410568284e-07 1.2 5.634610568284e-07 0 5.63949186991e-07 0 5.63969186991e-07 1.2 5.64457316991e-07 1.2 5.64477316991e-07 0 5.649654471536e-07 0 5.649854471536e-07 1.2 5.654735771536e-07 1.2 5.654935771536e-07 0 5.659817073162e-07 0 5.660017073162e-07 1.2 5.664898373162e-07 1.2 5.665098373162e-07 0 5.669979674788e-07 0 5.670179674788e-07 1.2 5.675060974788e-07 1.2 5.675260974788e-07 0 5.680142276414e-07 0 5.680342276414e-07 1.2 5.685223576414e-07 1.2 5.685423576414e-07 0 5.69030487804e-07 0 5.69050487804e-07 1.2 5.69538617804e-07 1.2 5.69558617804e-07 0 5.700467479666e-07 0 5.700667479666e-07 1.2 5.705548779666e-07 1.2 5.705748779666e-07 0 5.710630081292e-07 0 5.710830081292e-07 1.2 5.715711381292e-07 1.2 5.715911381292e-07 0 5.720792682918e-07 0 5.720992682918e-07 1.2 5.725873982918e-07 1.2 5.726073982918e-07 0 5.730955284544e-07 0 5.731155284544e-07 1.2 5.736036584544e-07 1.2 5.736236584544e-07 0 5.74111788617e-07 0 5.74131788617e-07 1.2 5.74619918617e-07 1.2 5.74639918617e-07 0 5.751280487796e-07 0 5.751480487796e-07 1.2 5.756361787796e-07 1.2 5.756561787796e-07 0 5.761443089422e-07 0 5.761643089422e-07 1.2 5.766524389422e-07 1.2 5.766724389422e-07 0 5.771605691048e-07 0 5.771805691048e-07 1.2 5.776686991048e-07 1.2 5.776886991048e-07 0 5.781768292674e-07 0 5.781968292674e-07 1.2 5.786849592674e-07 1.2 5.787049592674e-07 0 5.7919308943e-07 0 5.7921308943e-07 1.2 5.7970121943e-07 1.2 5.7972121943e-07 0 5.802093495926e-07 0 5.802293495926e-07 1.2 5.807174795926e-07 1.2 5.807374795926e-07 0 5.812256097552e-07 0 5.812456097552e-07 1.2 5.817337397552e-07 1.2 5.817537397552e-07 0 5.822418699178e-07 0 5.822618699178e-07 1.2 5.827499999178e-07 1.2 5.827699999178e-07 0 5.832581300804e-07 0 5.832781300804e-07 1.2 5.837662600804e-07 1.2 5.837862600804e-07 0 5.84274390243e-07 0 5.84294390243e-07 1.2 5.84782520243e-07 1.2 5.84802520243e-07 0 5.852906504056e-07 0 5.853106504056e-07 1.2 5.857987804056e-07 1.2 5.858187804056e-07 0 5.863069105682e-07 0 5.863269105682e-07 1.2 5.868150405682e-07 1.2 5.868350405682e-07 0 5.873231707308e-07 0 5.873431707308e-07 1.2 5.878313007308e-07 1.2 5.878513007308e-07 0 5.883394308934e-07 0 5.883594308934e-07 1.2 5.888475608934e-07 1.2 5.888675608934e-07 0 5.89355691056e-07 0 5.89375691056e-07 1.2 5.89863821056e-07 1.2 5.89883821056e-07 0 5.903719512186e-07 0 5.903919512186e-07 1.2 5.908800812186e-07 1.2 5.909000812186e-07 0 5.913882113812e-07 0 5.914082113812e-07 1.2 5.918963413812e-07 1.2 5.919163413812e-07 0 5.924044715438e-07 0 5.924244715438e-07 1.2 5.929126015438e-07 1.2 5.929326015438e-07 0 5.934207317064e-07 0 5.934407317064e-07 1.2 5.939288617064e-07 1.2 5.939488617064e-07 0 5.94436991869e-07 0 5.94456991869e-07 1.2 5.94945121869e-07 1.2 5.94965121869e-07 0 5.954532520316e-07 0 5.954732520316e-07 1.2 5.959613820316e-07 1.2 5.959813820316e-07 0 5.964695121942e-07 0 5.964895121942e-07 1.2 5.969776421942e-07 1.2 5.969976421942e-07 0 5.974857723568e-07 0 5.975057723568e-07 1.2 5.979939023568e-07 1.2 5.980139023568e-07 0 5.985020325194e-07 0 5.985220325194e-07 1.2 5.990101625194e-07 1.2 5.990301625194e-07 0 5.99518292682e-07 0 5.99538292682e-07 1.2 6.00026422682e-07 1.2 6.00046422682e-07 0 6.005345528446e-07 0 6.005545528446e-07 1.2 6.010426828446e-07 1.2 6.010626828446e-07 0 6.015508130072e-07 0 6.015708130072e-07 1.2 6.020589430072e-07 1.2 6.020789430072e-07 0 6.025670731698e-07 0 6.025870731698e-07 1.2 6.030752031698e-07 1.2 6.030952031698e-07 0 6.035833333324e-07 0 6.036033333324e-07 1.2 6.040914633324e-07 1.2 6.041114633324e-07 0 6.04599593495e-07 0 6.04619593495e-07 1.2 6.05107723495e-07 1.2 6.05127723495e-07 0 6.056158536576e-07 0 6.056358536576e-07 1.2 6.061239836576e-07 1.2 6.061439836576e-07 0 6.066321138202e-07 0 6.066521138202e-07 1.2 6.071402438202e-07 1.2 6.071602438202e-07 0 6.076483739828e-07 0 6.076683739828e-07 1.2 6.081565039828e-07 1.2 6.081765039828e-07 0 6.086646341454e-07 0 6.086846341454e-07 1.2 6.091727641454e-07 1.2 6.091927641454e-07 0 6.09680894308e-07 0 6.09700894308e-07 1.2 6.10189024308e-07 1.2 6.10209024308e-07 0 6.106971544706e-07 0 6.107171544706e-07 1.2 6.112052844706e-07 1.2 6.112252844706e-07 0 6.117134146332e-07 0 6.117334146332e-07 1.2 6.122215446332e-07 1.2 6.122415446332e-07 0 6.127296747958e-07 0 6.127496747958e-07 1.2 6.132378047958e-07 1.2 6.132578047958e-07 0 6.137459349584e-07 0 6.137659349584e-07 1.2 6.142540649584e-07 1.2 6.142740649584e-07 0 6.14762195121e-07 0 6.14782195121e-07 1.2 6.15270325121e-07 1.2 6.15290325121e-07 0 6.157784552836e-07 0 6.157984552836e-07 1.2 6.162865852836e-07 1.2 6.163065852836e-07 0 6.167947154462e-07 0 6.168147154462e-07 1.2 6.173028454462e-07 1.2 6.173228454462e-07 0 6.178109756088e-07 0 6.178309756088e-07 1.2 6.183191056088e-07 1.2 6.183391056088e-07 0 6.188272357714e-07 0 6.188472357714e-07 1.2 6.193353657714e-07 1.2 6.193553657714e-07 0 6.19843495934e-07 0 6.19863495934e-07 1.2 6.20351625934e-07 1.2 6.20371625934e-07 0 6.208597560966e-07 0 6.208797560966e-07 1.2 6.213678860966e-07 1.2 6.213878860966e-07 0 6.218760162592e-07 0 6.218960162592e-07 1.2 6.223841462592e-07 1.2 6.224041462592e-07 0 6.228922764218e-07 0 6.229122764218e-07 1.2 6.234004064218e-07 1.2 6.234204064218e-07 0 6.239085365844e-07 0 6.239285365844e-07 1.2 6.244166665844e-07 1.2 6.244366665844e-07 0 6.24924796747e-07 0 6.24944796747e-07 1.2 6.25432926747e-07 1.2 6.25452926747e-07 0 6.259410569096e-07 0 6.259610569096e-07 1.2 6.264491869096e-07 1.2 6.264691869096e-07 0 6.269573170722e-07 0 6.269773170722e-07 1.2 6.274654470722e-07 1.2 6.274854470722e-07 0 6.279735772348e-07 0 6.279935772348e-07 1.2 6.284817072348e-07 1.2 6.285017072348e-07 0 6.289898373974e-07 0 6.290098373974e-07 1.2 6.294979673974e-07 1.2 6.295179673974e-07 0 6.3000609756e-07 0 6.3002609756e-07 1.2 6.3051422756e-07 1.2 6.3053422756e-07 0 6.310223577226e-07 0 6.310423577226e-07 1.2 6.315304877226e-07 1.2 6.315504877226e-07 0 6.320386178852e-07 0 6.320586178852e-07 1.2 6.325467478852e-07 1.2 6.325667478852e-07 0 6.330548780478e-07 0 6.330748780478e-07 1.2 6.335630080478e-07 1.2 6.335830080478e-07 0 6.340711382104e-07 0 6.340911382104e-07 1.2 6.345792682104e-07 1.2 6.345992682104e-07 0 6.35087398373e-07 0 6.35107398373e-07 1.2 6.35595528373e-07 1.2 6.35615528373e-07 0 6.361036585356e-07 0 6.361236585356e-07 1.2 6.366117885356e-07 1.2 6.366317885356e-07 0 6.371199186982e-07 0 6.371399186982e-07 1.2 6.376280486982e-07 1.2 6.376480486982e-07 0 6.381361788608e-07 0 6.381561788608e-07 1.2 6.386443088608e-07 1.2 6.386643088608e-07 0 6.391524390234e-07 0 6.391724390234e-07 1.2 6.396605690234e-07 1.2 6.396805690234e-07 0 6.40168699186e-07 0 6.40188699186e-07 1.2 6.40676829186e-07 1.2 6.40696829186e-07 0 6.411849593486e-07 0 6.412049593486e-07 1.2 6.416930893486e-07 1.2 6.417130893486e-07 0 6.422012195112e-07 0 6.422212195112e-07 1.2 6.427093495112e-07 1.2 6.427293495112e-07 0 6.432174796738e-07 0 6.432374796738e-07 1.2 6.437256096738e-07 1.2 6.437456096738e-07 0 6.442337398364e-07 0 6.442537398364e-07 1.2 6.447418698364e-07 1.2 6.447618698364e-07 0 6.45249999999e-07 0 6.45269999999e-07 1.2 6.45758129999e-07 1.2 6.45778129999e-07 0 6.462662601616e-07 0 6.462862601616e-07 1.2 6.467743901616e-07 1.2 6.467943901616e-07 0 6.472825203242e-07 0 6.473025203242e-07 1.2 6.477906503242e-07 1.2 6.478106503242e-07 0 6.482987804868e-07 0 6.483187804868e-07 1.2 6.488069104868e-07 1.2 6.488269104868e-07 0 6.493150406494e-07 0 6.493350406494e-07 1.2 6.498231706494e-07 1.2 6.498431706494e-07 0 6.50331300812e-07 0 6.50351300812e-07 1.2 6.50839430812e-07 1.2 6.50859430812e-07 0 6.513475609746e-07 0 6.513675609746e-07 1.2 6.518556909746e-07 1.2 6.518756909746e-07 0 6.523638211372e-07 0 6.523838211372e-07 1.2 6.528719511372e-07 1.2 6.528919511372e-07 0 6.533800812998e-07 0 6.534000812998e-07 1.2 6.538882112998e-07 1.2 6.539082112998e-07 0 6.543963414624e-07 0 6.544163414624e-07 1.2 6.549044714624e-07 1.2 6.549244714624e-07 0 6.55412601625e-07 0 6.55432601625e-07 1.2 6.55920731625e-07 1.2 6.55940731625e-07 0 6.564288617876e-07 0 6.564488617876e-07 1.2 6.569369917876e-07 1.2 6.569569917876e-07 0 6.574451219502e-07 0 6.574651219502e-07 1.2 6.579532519502e-07 1.2 6.579732519502e-07 0 6.584613821128e-07 0 6.584813821128e-07 1.2 6.589695121128e-07 1.2 6.589895121128e-07 0 6.594776422754e-07 0 6.594976422754e-07 1.2 6.599857722754e-07 1.2 6.600057722754e-07 0 6.60493902438e-07 0 6.60513902438e-07 1.2 6.61002032438e-07 1.2 6.61022032438e-07 0 6.615101626006e-07 0 6.615301626006e-07 1.2 6.620182926006e-07 1.2 6.620382926006e-07 0 6.625264227632e-07 0 6.625464227632e-07 1.2 6.630345527632e-07 1.2 6.630545527632e-07 0 6.635426829258e-07 0 6.635626829258e-07 1.2 6.640508129258e-07 1.2 6.640708129258e-07 0 6.645589430884e-07 0 6.645789430884e-07 1.2 6.650670730884e-07 1.2 6.650870730884e-07 0 6.65575203251e-07 0 6.65595203251e-07 1.2 6.66083333251e-07 1.2 6.66103333251e-07 0 6.665914634136e-07 0 6.666114634136e-07 1.2 6.670995934136e-07 1.2 6.671195934136e-07 0 6.676077235762e-07 0 6.676277235762e-07 1.2 6.681158535762e-07 1.2 6.681358535762e-07 0 6.686239837388e-07 0 6.686439837388e-07 1.2 6.691321137388e-07 1.2 6.691521137388e-07 0 6.696402439014e-07 0 6.696602439014e-07 1.2 6.701483739014e-07 1.2 6.701683739014e-07 0 6.70656504064e-07 0 6.70676504064e-07 1.2 6.71164634064e-07 1.2 6.71184634064e-07 0 6.716727642266e-07 0 6.716927642266e-07 1.2 6.721808942266e-07 1.2 6.722008942266e-07 0 6.726890243892e-07 0 6.727090243892e-07 1.2 6.731971543892e-07 1.2 6.732171543892e-07 0 6.737052845518e-07 0 6.737252845518e-07 1.2 6.742134145518e-07 1.2 6.742334145518e-07 0 6.747215447144e-07 0 6.747415447144e-07 1.2 6.752296747144e-07 1.2 6.752496747144e-07 0 6.75737804877e-07 0 6.75757804877e-07 1.2 6.76245934877e-07 1.2 6.76265934877e-07 0 6.767540650396e-07 0 6.767740650396e-07 1.2 6.772621950396e-07 1.2 6.772821950396e-07 0 6.777703252022e-07 0 6.777903252022e-07 1.2 6.782784552022e-07 1.2 6.782984552022e-07 0 6.787865853648e-07 0 6.788065853648e-07 1.2 6.792947153648e-07 1.2 6.793147153648e-07 0 6.798028455274e-07 0 6.798228455274e-07 1.2 6.803109755274e-07 1.2 6.803309755274e-07 0 6.8081910569e-07 0 6.8083910569e-07 1.2 6.8132723569e-07 1.2 6.8134723569e-07 0 6.818353658526e-07 0 6.818553658526e-07 1.2 6.823434958526e-07 1.2 6.823634958526e-07 0 6.828516260152e-07 0 6.828716260152e-07 1.2 6.833597560152e-07 1.2 6.833797560152e-07 0 6.838678861778e-07 0 6.838878861778e-07 1.2 6.843760161778e-07 1.2 6.843960161778e-07 0 6.848841463404e-07 0 6.849041463404e-07 1.2 6.853922763404e-07 1.2 6.854122763404e-07 0 6.85900406503e-07 0 6.85920406503e-07 1.2 6.86408536503e-07 1.2 6.86428536503e-07 0 6.869166666656e-07 0 6.869366666656e-07 1.2 6.874247966656e-07 1.2 6.874447966656e-07 0 6.879329268282e-07 0 6.879529268282e-07 1.2 6.884410568282e-07 1.2 6.884610568282e-07 0 6.889491869908e-07 0 6.889691869908e-07 1.2 6.894573169908e-07 1.2 6.894773169908e-07 0 6.899654471534e-07 0 6.899854471534e-07 1.2 6.904735771534e-07 1.2 6.904935771534e-07 0 6.90981707316e-07 0 6.91001707316e-07 1.2 6.91489837316e-07 1.2 6.91509837316e-07 0 6.919979674786e-07 0 6.920179674786e-07 1.2 6.925060974786e-07 1.2 6.925260974786e-07 0 6.930142276412e-07 0 6.930342276412e-07 1.2 6.935223576412e-07 1.2 6.935423576412e-07 0 6.940304878038e-07 0 6.940504878038e-07 1.2 6.945386178038e-07 1.2 6.945586178038e-07 0 6.950467479664e-07 0 6.950667479664e-07 1.2 6.955548779664e-07 1.2 6.955748779664e-07 0 6.96063008129e-07 0 6.96083008129e-07 1.2 6.96571138129e-07 1.2 6.96591138129e-07 0 6.970792682916e-07 0 6.970992682916e-07 1.2 6.975873982916e-07 1.2 6.976073982916e-07 0 6.980955284542e-07 0 6.981155284542e-07 1.2 6.986036584542e-07 1.2 6.986236584542e-07 0 6.991117886168e-07 0 6.991317886168e-07 1.2 6.996199186168e-07 1.2 6.996399186168e-07 0 7.001280487794e-07 0 7.001480487794e-07 1.2 7.006361787794e-07 1.2 7.006561787794e-07 0 7.01144308942e-07 0 7.01164308942e-07 1.2 7.01652438942e-07 1.2 7.01672438942e-07 0 7.021605691046e-07 0 7.021805691046e-07 1.2 7.026686991046e-07 1.2 7.026886991046e-07 0 7.031768292672e-07 0 7.031968292672e-07 1.2 7.036849592672e-07 1.2 7.037049592672e-07 0 7.041930894298e-07 0 7.042130894298e-07 1.2 7.047012194298e-07 1.2 7.047212194298e-07 0 7.052093495924e-07 0 7.052293495924e-07 1.2 7.057174795924e-07 1.2 7.057374795924e-07 0 7.06225609755e-07 0 7.06245609755e-07 1.2 7.06733739755e-07 1.2 7.06753739755e-07 0 7.072418699176e-07 0 7.072618699176e-07 1.2 7.077499999176e-07 1.2 7.077699999176e-07 0 7.082581300802e-07 0 7.082781300802e-07 1.2 7.087662600802e-07 1.2 7.087862600802e-07 0 7.092743902428e-07 0 7.092943902428e-07 1.2 7.097825202428e-07 1.2 7.098025202428e-07 0 7.102906504054e-07 0 7.103106504054e-07 1.2 7.107987804054e-07 1.2 7.108187804054e-07 0 7.11306910568e-07 0 7.11326910568e-07 1.2 7.11815040568e-07 1.2 7.11835040568e-07 0 7.123231707306e-07 0 7.123431707306e-07 1.2 7.128313007306e-07 1.2 7.128513007306e-07 0 7.133394308932e-07 0 7.133594308932e-07 1.2 7.138475608932e-07 1.2 7.138675608932e-07 0 7.143556910558e-07 0 7.143756910558e-07 1.2 7.148638210558e-07 1.2 7.148838210558e-07 0 7.153719512184e-07 0 7.153919512184e-07 1.2 7.158800812184e-07 1.2 7.159000812184e-07 0 7.16388211381e-07 0 7.16408211381e-07 1.2 7.16896341381e-07 1.2 7.16916341381e-07 0 7.174044715436e-07 0 7.174244715436e-07 1.2 7.179126015436e-07 1.2 7.179326015436e-07 0 7.184207317062e-07 0 7.184407317062e-07 1.2 7.189288617062e-07 1.2 7.189488617062e-07 0 7.194369918688e-07 0 7.194569918688e-07 1.2 7.199451218688e-07 1.2 7.199651218688e-07 0 7.204532520314e-07 0 7.204732520314e-07 1.2 7.209613820314e-07 1.2 7.209813820314e-07 0 7.21469512194e-07 0 7.21489512194e-07 1.2 7.21977642194e-07 1.2 7.21997642194e-07 0 7.224857723566e-07 0 7.225057723566e-07 1.2 7.229939023566e-07 1.2 7.230139023566e-07 0 7.235020325192e-07 0 7.235220325192e-07 1.2 7.240101625192e-07 1.2 7.240301625192e-07 0 7.245182926818e-07 0 7.245382926818e-07 1.2 7.250264226818e-07 1.2 7.250464226818e-07 0 7.255345528444e-07 0 7.255545528444e-07 1.2 7.260426828444e-07 1.2 7.260626828444e-07 0 7.26550813007e-07 0 7.26570813007e-07 1.2 7.27058943007e-07 1.2 7.27078943007e-07 0 7.275670731696e-07 0 7.275870731696e-07 1.2 7.280752031696e-07 1.2 7.280952031696e-07 0 7.285833333322e-07 0 7.286033333322e-07 1.2 7.290914633322e-07 1.2 7.291114633322e-07 0 7.295995934948e-07 0 7.296195934948e-07 1.2 7.301077234948e-07 1.2 7.301277234948e-07 0 7.306158536574e-07 0 7.306358536574e-07 1.2 7.311239836574e-07 1.2 7.311439836574e-07 0 7.3163211382e-07 0 7.3165211382e-07 1.2 7.3214024382e-07 1.2 7.3216024382e-07 0 7.326483739826e-07 0 7.326683739826e-07 1.2 7.331565039826e-07 1.2 7.331765039826e-07 0 7.336646341452e-07 0 7.336846341452e-07 1.2 7.341727641452e-07 1.2 7.341927641452e-07 0 7.346808943078e-07 0 7.347008943078e-07 1.2 7.351890243078e-07 1.2 7.352090243078e-07 0 7.356971544704e-07 0 7.357171544704e-07 1.2 7.362052844704e-07 1.2 7.362252844704e-07 0 7.36713414633e-07 0 7.36733414633e-07 1.2 7.37221544633e-07 1.2 7.37241544633e-07 0 7.377296747956e-07 0 7.377496747956e-07 1.2 7.382378047956e-07 1.2 7.382578047956e-07 0 7.387459349582e-07 0 7.387659349582e-07 1.2 7.392540649582e-07 1.2 7.392740649582e-07 0 7.397621951208e-07 0 7.397821951208e-07 1.2 7.402703251208e-07 1.2 7.402903251208e-07 0 7.407784552834e-07 0 7.407984552834e-07 1.2 7.412865852834e-07 1.2 7.413065852834e-07 0 7.41794715446e-07 0 7.41814715446e-07 1.2 7.42302845446e-07 1.2 7.42322845446e-07 0 7.428109756086e-07 0 7.428309756086e-07 1.2 7.433191056086e-07 1.2 7.433391056086e-07 0 7.438272357712e-07 0 7.438472357712e-07 1.2 7.443353657712e-07 1.2 7.443553657712e-07 0 7.448434959338e-07 0 7.448634959338e-07 1.2 7.453516259338e-07 1.2 7.453716259338e-07 0 7.458597560964e-07 0 7.458797560964e-07 1.2 7.463678860964e-07 1.2 7.463878860964e-07 0 7.46876016259e-07 0 7.46896016259e-07 1.2 7.47384146259e-07 1.2 7.47404146259e-07 0 7.478922764216e-07 0 7.479122764216e-07 1.2 7.484004064216e-07 1.2 7.484204064216e-07 0 7.489085365842e-07 0 7.489285365842e-07 1.2 7.494166665842e-07 1.2 7.494366665842e-07 0 7.499247967468e-07 0 7.499447967468e-07 1.2 7.504329267468e-07 1.2 7.504529267468e-07 0 7.509410569094e-07 0 7.509610569094e-07 1.2 7.514491869094e-07 1.2 7.514691869094e-07 0 7.51957317072e-07 0 7.51977317072e-07 1.2 7.52465447072e-07 1.2 7.52485447072e-07 0 7.529735772346e-07 0 7.529935772346e-07 1.2 7.534817072346e-07 1.2 7.535017072346e-07 0 7.539898373972e-07 0 7.540098373972e-07 1.2 7.544979673972e-07 1.2 7.545179673972e-07 0 7.550060975598e-07 0 7.550260975598e-07 1.2 7.555142275598e-07 1.2 7.555342275598e-07 0 7.560223577224e-07 0 7.560423577224e-07 1.2 7.565304877224e-07 1.2 7.565504877224e-07 0 7.57038617885e-07 0 7.57058617885e-07 1.2 7.57546747885e-07 1.2 7.57566747885e-07 0 7.580548780476e-07 0 7.580748780476e-07 1.2 7.585630080476e-07 1.2 7.585830080476e-07 0 7.590711382102e-07 0 7.590911382102e-07 1.2 7.595792682102e-07 1.2 7.595992682102e-07 0 7.600873983728e-07 0 7.601073983728e-07 1.2 7.605955283728e-07 1.2 7.606155283728e-07 0 7.611036585354e-07 0 7.611236585354e-07 1.2 7.616117885354e-07 1.2 7.616317885354e-07 0 7.62119918698e-07 0 7.62139918698e-07 1.2 7.62628048698e-07 1.2 7.62648048698e-07 0 7.631361788606e-07 0 7.631561788606e-07 1.2 7.636443088606e-07 1.2 7.636643088606e-07 0 7.641524390232e-07 0 7.641724390232e-07 1.2 7.646605690232e-07 1.2 7.646805690232e-07 0 7.651686991858e-07 0 7.651886991858e-07 1.2 7.656768291858e-07 1.2 7.656968291858e-07 0 7.661849593484e-07 0 7.662049593484e-07 1.2 7.666930893484e-07 1.2 7.667130893484e-07 0 7.67201219511e-07 0 7.67221219511e-07 1.2 7.67709349511e-07 1.2 7.67729349511e-07 0 7.682174796736e-07 0 7.682374796736e-07 1.2 7.687256096736e-07 1.2 7.687456096736e-07 0 7.692337398362e-07 0 7.692537398362e-07 1.2 7.697418698362e-07 1.2 7.697618698362e-07 0 7.702499999988e-07 0 7.702699999988e-07 1.2 7.707581299988e-07 1.2 7.707781299988e-07 0 7.712662601614e-07 0 7.712862601614e-07 1.2 7.717743901614e-07 1.2 7.717943901614e-07 0 7.72282520324e-07 0 7.72302520324e-07 1.2 7.72790650324e-07 1.2 7.72810650324e-07 0 7.732987804866e-07 0 7.733187804866e-07 1.2 7.738069104866e-07 1.2 7.738269104866e-07 0 7.743150406492e-07 0 7.743350406492e-07 1.2 7.748231706492e-07 1.2 7.748431706492e-07 0 7.753313008118e-07 0 7.753513008118e-07 1.2 7.758394308118e-07 1.2 7.758594308118e-07 0 7.763475609744e-07 0 7.763675609744e-07 1.2 7.768556909744e-07 1.2 7.768756909744e-07 0 7.77363821137e-07 0 7.77383821137e-07 1.2 7.77871951137e-07 1.2 7.77891951137e-07 0 7.783800812996e-07 0 7.784000812996e-07 1.2 7.788882112996e-07 1.2 7.789082112996e-07 0 7.793963414622e-07 0 7.794163414622e-07 1.2 7.799044714622e-07 1.2 7.799244714622e-07 0 7.804126016248e-07 0 7.804326016248e-07 1.2 7.809207316248e-07 1.2 7.809407316248e-07 0 7.814288617874e-07 0 7.814488617874e-07 1.2 7.819369917874e-07 1.2 7.819569917874e-07 0 7.8244512195e-07 0 7.8246512195e-07 1.2 7.8295325195e-07 1.2 7.8297325195e-07 0 7.834613821126e-07 0 7.834813821126e-07 1.2 7.839695121126e-07 1.2 7.839895121126e-07 0 7.844776422752e-07 0 7.844976422752e-07 1.2 7.849857722752e-07 1.2 7.850057722752e-07 0 7.854939024378e-07 0 7.855139024378e-07 1.2 7.860020324378e-07 1.2 7.860220324378e-07 0 7.865101626004e-07 0 7.865301626004e-07 1.2 7.870182926004e-07 1.2 7.870382926004e-07 0 7.87526422763e-07 0 7.87546422763e-07 1.2 7.88034552763e-07 1.2 7.88054552763e-07 0 7.885426829256e-07 0 7.885626829256e-07 1.2 7.890508129256e-07 1.2 7.890708129256e-07 0 7.895589430882e-07 0 7.895789430882e-07 1.2 7.900670730882e-07 1.2 7.900870730882e-07 0 7.905752032508e-07 0 7.905952032508e-07 1.2 7.910833332508e-07 1.2 7.911033332508e-07 0 7.915914634134e-07 0 7.916114634134e-07 1.2 7.920995934134e-07 1.2 7.921195934134e-07 0 7.92607723576e-07 0 7.92627723576e-07 1.2 7.93115853576e-07 1.2 7.93135853576e-07 0 7.936239837386e-07 0 7.936439837386e-07 1.2 7.941321137386e-07 1.2 7.941521137386e-07 0 7.946402439012e-07 0 7.946602439012e-07 1.2 7.951483739012e-07 1.2 7.951683739012e-07 0 7.956565040638e-07 0 7.956765040638e-07 1.2 7.961646340638e-07 1.2 7.961846340638e-07 0 7.966727642264e-07 0 7.966927642264e-07 1.2 7.971808942264e-07 1.2 7.972008942264e-07 0 7.97689024389e-07 0 7.97709024389e-07 1.2 7.98197154389e-07 1.2 7.98217154389e-07 0 7.987052845516e-07 0 7.987252845516e-07 1.2 7.992134145516e-07 1.2 7.992334145516e-07 0 7.997215447142e-07 0 7.997415447142e-07 1.2 8.002296747142e-07 1.2 8.002496747142e-07 0 8.007378048768e-07 0 8.007578048768e-07 1.2 8.012459348768e-07 1.2 8.012659348768e-07 0 8.017540650394e-07 0 8.017740650394e-07 1.2 8.022621950394e-07 1.2 8.022821950394e-07 0 8.02770325202e-07 0 8.02790325202e-07 1.2 8.03278455202e-07 1.2 8.03298455202e-07 0 8.037865853646e-07 0 8.038065853646e-07 1.2 8.042947153646e-07 1.2 8.043147153646e-07 0 8.048028455272e-07 0 8.048228455272e-07 1.2 8.053109755272e-07 1.2 8.053309755272e-07 0 8.058191056898e-07 0 8.058391056898e-07 1.2 8.063272356898e-07 1.2 8.063472356898e-07 0 8.068353658524e-07 0 8.068553658524e-07 1.2 8.073434958524e-07 1.2 8.073634958524e-07 0 8.07851626015e-07 0 8.07871626015e-07 1.2 8.08359756015e-07 1.2 8.08379756015e-07 0 8.088678861776e-07 0 8.088878861776e-07 1.2 8.093760161776e-07 1.2 8.093960161776e-07 0 8.098841463402e-07 0 8.099041463402e-07 1.2 8.103922763402e-07 1.2 8.104122763402e-07 0 8.109004065028e-07 0 8.109204065028e-07 1.2 8.114085365028e-07 1.2 8.114285365028e-07 0 8.119166666654e-07 0 8.119366666654e-07 1.2 8.124247966654e-07 1.2 8.124447966654e-07 0 8.12932926828e-07 0 8.12952926828e-07 1.2 8.13441056828e-07 1.2 8.13461056828e-07 0 8.139491869906e-07 0 8.139691869906e-07 1.2 8.144573169906e-07 1.2 8.144773169906e-07 0 8.149654471532e-07 0 8.149854471532e-07 1.2 8.154735771532e-07 1.2 8.154935771532e-07 0 8.159817073158e-07 0 8.160017073158e-07 1.2 8.164898373158e-07 1.2 8.165098373158e-07 0 8.169979674784e-07 0 8.170179674784e-07 1.2 8.175060974784e-07 1.2 8.175260974784e-07 0 8.18014227641e-07 0 8.18034227641e-07 1.2 8.18522357641e-07 1.2 8.18542357641e-07 0 8.190304878036e-07 0 8.190504878036e-07 1.2 8.195386178036e-07 1.2 8.195586178036e-07 0 8.200467479662e-07 0 8.200667479662e-07 1.2 8.205548779662e-07 1.2 8.205748779662e-07 0 8.210630081288e-07 0 8.210830081288e-07 1.2 8.215711381288e-07 1.2 8.215911381288e-07 0 8.220792682914e-07 0 8.220992682914e-07 1.2 8.225873982914e-07 1.2 8.226073982914e-07 0 8.23095528454e-07 0 8.23115528454e-07 1.2 8.23603658454e-07 1.2 8.23623658454e-07 0 8.241117886166e-07 0 8.241317886166e-07 1.2 8.246199186166e-07 1.2 8.246399186166e-07 0 8.251280487792e-07 0 8.251480487792e-07 1.2 8.256361787792e-07 1.2 8.256561787792e-07 0 8.261443089418e-07 0 8.261643089418e-07 1.2 8.266524389418e-07 1.2 8.266724389418e-07 0 8.271605691044e-07 0 8.271805691044e-07 1.2 8.276686991044e-07 1.2 8.276886991044e-07 0 8.28176829267e-07 0 8.28196829267e-07 1.2 8.28684959267e-07 1.2 8.28704959267e-07 0 8.291930894296e-07 0 8.292130894296e-07 1.2 8.297012194296e-07 1.2 8.297212194296e-07 0 8.302093495922e-07 0 8.302293495922e-07 1.2 8.307174795922e-07 1.2 8.307374795922e-07 0 8.312256097548e-07 0 8.312456097548e-07 1.2 8.317337397548e-07 1.2 8.317537397548e-07 0 8.322418699174e-07 0 8.322618699174e-07 1.2 8.327499999174e-07 1.2 8.327699999174e-07 0 8.3325813008e-07 0 8.3327813008e-07 1.2 8.3376626008e-07 1.2 8.3378626008e-07 0 8.342743902426e-07 0 8.342943902426e-07 1.2 8.347825202426e-07 1.2 8.348025202426e-07 0 8.352906504052e-07 0 8.353106504052e-07 1.2 8.357987804052e-07 1.2 8.358187804052e-07 0 8.363069105678e-07 0 8.363269105678e-07 1.2 8.368150405678e-07 1.2 8.368350405678e-07 0 8.373231707304e-07 0 8.373431707304e-07 1.2 8.378313007304e-07 1.2 8.378513007304e-07 0 8.38339430893e-07 0 8.38359430893e-07 1.2 8.38847560893e-07 1.2 8.38867560893e-07 0 8.393556910556e-07 0 8.393756910556e-07 1.2 8.398638210556e-07 1.2 8.398838210556e-07 0 8.403719512182e-07 0 8.403919512182e-07 1.2 8.408800812182e-07 1.2 8.409000812182e-07 0 8.413882113808e-07 0 8.414082113808e-07 1.2 8.418963413808e-07 1.2 8.419163413808e-07 0 8.424044715434e-07 0 8.424244715434e-07 1.2 8.429126015434e-07 1.2 8.429326015434e-07 0 8.43420731706e-07 0 8.43440731706e-07 1.2 8.43928861706e-07 1.2 8.43948861706e-07 0 8.444369918686e-07 0 8.444569918686e-07 1.2 8.449451218686e-07 1.2 8.449651218686e-07 0 8.454532520312e-07 0 8.454732520312e-07 1.2 8.459613820312e-07 1.2 8.459813820312e-07 0 8.464695121938e-07 0 8.464895121938e-07 1.2 8.469776421938e-07 1.2 8.469976421938e-07 0 8.474857723564e-07 0 8.475057723564e-07 1.2 8.479939023564e-07 1.2 8.480139023564e-07 0 8.48502032519e-07 0 8.48522032519e-07 1.2 8.49010162519e-07 1.2 8.49030162519e-07 0 8.495182926816e-07 0 8.495382926816e-07 1.2 8.500264226816e-07 1.2 8.500464226816e-07 0 8.505345528442e-07 0 8.505545528442e-07 1.2 8.510426828442e-07 1.2 8.510626828442e-07 0 8.515508130068e-07 0 8.515708130068e-07 1.2 8.520589430068e-07 1.2 8.520789430068e-07 0 8.525670731694e-07 0 8.525870731694e-07 1.2 8.530752031694e-07 1.2 8.530952031694e-07 0 8.53583333332e-07 0 8.53603333332e-07 1.2 8.54091463332e-07 1.2 8.54111463332e-07 0 8.545995934946e-07 0 8.546195934946e-07 1.2 8.551077234946e-07 1.2 8.551277234946e-07 0 8.556158536572e-07 0 8.556358536572e-07 1.2 8.561239836572e-07 1.2 8.561439836572e-07 0 8.566321138198e-07 0 8.566521138198e-07 1.2 8.571402438198e-07 1.2 8.571602438198e-07 0 8.576483739824e-07 0 8.576683739824e-07 1.2 8.581565039824e-07 1.2 8.581765039824e-07 0 8.58664634145e-07 0 8.58684634145e-07 1.2 8.59172764145e-07 1.2 8.59192764145e-07 0 8.596808943076e-07 0 8.597008943076e-07 1.2 8.601890243076e-07 1.2 8.602090243076e-07 0 8.606971544702e-07 0 8.607171544702e-07 1.2 8.612052844702e-07 1.2 8.612252844702e-07 0 8.617134146328e-07 0 8.617334146328e-07 1.2 8.622215446328e-07 1.2 8.622415446328e-07 0 8.627296747954e-07 0 8.627496747954e-07 1.2 8.632378047954e-07 1.2 8.632578047954e-07 0 8.63745934958e-07 0 8.63765934958e-07 1.2 8.64254064958e-07 1.2 8.64274064958e-07 0 8.647621951206e-07 0 8.647821951206e-07 1.2 8.652703251206e-07 1.2 8.652903251206e-07 0 8.657784552832e-07 0 8.657984552832e-07 1.2 8.662865852832e-07 1.2 8.663065852832e-07 0 8.667947154458e-07 0 8.668147154458e-07 1.2 8.673028454458e-07 1.2 8.673228454458e-07 0 8.678109756084e-07 0 8.678309756084e-07 1.2 8.683191056084e-07 1.2 8.683391056084e-07 0 8.68827235771e-07 0 8.68847235771e-07 1.2 8.69335365771e-07 1.2 8.69355365771e-07 0 8.698434959336e-07 0 8.698634959336e-07 1.2 8.703516259336e-07 1.2 8.703716259336e-07 0 8.708597560962e-07 0 8.708797560962e-07 1.2 8.713678860962e-07 1.2 8.713878860962e-07 0 8.718760162588e-07 0 8.718960162588e-07 1.2 8.723841462588e-07 1.2 8.724041462588e-07 0 8.728922764214e-07 0 8.729122764214e-07 1.2 8.734004064214e-07 1.2 8.734204064214e-07 0 8.73908536584e-07 0 8.73928536584e-07 1.2 8.74416666584e-07 1.2 8.74436666584e-07 0 8.749247967466e-07 0 8.749447967466e-07 1.2 8.754329267466e-07 1.2 8.754529267466e-07 0 8.759410569092e-07 0 8.759610569092e-07 1.2 8.764491869092e-07 1.2 8.764691869092e-07 0 8.769573170718e-07 0 8.769773170718e-07 1.2 8.774654470718e-07 1.2 8.774854470718e-07 0 8.779735772344e-07 0 8.779935772344e-07 1.2 8.784817072344e-07 1.2 8.785017072344e-07 0 8.78989837397e-07 0 8.79009837397e-07 1.2 8.79497967397e-07 1.2 8.79517967397e-07 0 8.800060975596e-07 0 8.800260975596e-07 1.2 8.805142275596e-07 1.2 8.805342275596e-07 0 8.810223577222e-07 0 8.810423577222e-07 1.2 8.815304877222e-07 1.2 8.815504877222e-07 0 8.820386178848e-07 0 8.820586178848e-07 1.2 8.825467478848e-07 1.2 8.825667478848e-07 0 8.830548780474e-07 0 8.830748780474e-07 1.2 8.835630080474e-07 1.2 8.835830080474e-07 0 8.8407113821e-07 0 8.8409113821e-07 1.2 8.8457926821e-07 1.2 8.8459926821e-07 0 8.850873983726e-07 0 8.851073983726e-07 1.2 8.855955283726e-07 1.2 8.856155283726e-07 0 8.861036585352e-07 0 8.861236585352e-07 1.2 8.866117885352e-07 1.2 8.866317885352e-07 0 8.871199186978e-07 0 8.871399186978e-07 1.2 8.876280486978e-07 1.2 8.876480486978e-07 0 8.881361788604e-07 0 8.881561788604e-07 1.2 8.886443088604e-07 1.2 8.886643088604e-07 0 8.89152439023e-07 0 8.89172439023e-07 1.2 8.89660569023e-07 1.2 8.89680569023e-07 0 8.901686991856e-07 0 8.901886991856e-07 1.2 8.906768291856e-07 1.2 8.906968291856e-07 0 8.911849593482e-07 0 8.912049593482e-07 1.2 8.916930893482e-07 1.2 8.917130893482e-07 0 8.922012195108e-07 0 8.922212195108e-07 1.2 8.927093495108e-07 1.2 8.927293495108e-07 0 8.932174796734e-07 0 8.932374796734e-07 1.2 8.937256096734e-07 1.2 8.937456096734e-07 0 8.94233739836e-07 0 8.94253739836e-07 1.2 8.94741869836e-07 1.2 8.94761869836e-07 0 8.952499999986e-07 0 8.952699999986e-07 1.2 8.957581299986e-07 1.2 8.957781299986e-07 0 8.962662601612e-07 0 8.962862601612e-07 1.2 8.967743901612e-07 1.2 8.967943901612e-07 0 8.972825203238e-07 0 8.973025203238e-07 1.2 8.977906503238e-07 1.2 8.978106503238e-07 0 8.982987804864e-07 0 8.983187804864e-07 1.2 8.988069104864e-07 1.2 8.988269104864e-07 0 8.99315040649e-07 0 8.99335040649e-07 1.2 8.99823170649e-07 1.2 8.99843170649e-07 0 9.003313008116e-07 0 9.003513008116e-07 1.2 9.008394308116e-07 1.2 9.008594308116e-07 0 9.013475609742e-07 0 9.013675609742e-07 1.2 9.018556909742e-07 1.2 9.018756909742e-07 0 9.023638211368e-07 0 9.023838211368e-07 1.2 9.028719511368e-07 1.2 9.028919511368e-07 0 9.033800812994e-07 0 9.034000812994e-07 1.2 9.038882112994e-07 1.2 9.039082112994e-07 0 9.04396341462e-07 0 9.04416341462e-07 1.2 9.04904471462e-07 1.2 9.04924471462e-07 0 9.054126016246e-07 0 9.054326016246e-07 1.2 9.059207316246e-07 1.2 9.059407316246e-07 0 9.064288617872e-07 0 9.064488617872e-07 1.2 9.069369917872e-07 1.2 9.069569917872e-07 0 9.074451219498e-07 0 9.074651219498e-07 1.2 9.079532519498e-07 1.2 9.079732519498e-07 0 9.084613821124e-07 0 9.084813821124e-07 1.2 9.089695121124e-07 1.2 9.089895121124e-07 0 9.09477642275e-07 0 9.09497642275e-07 1.2 9.09985772275e-07 1.2 9.10005772275e-07 0 9.104939024376e-07 0 9.105139024376e-07 1.2 9.110020324376e-07 1.2 9.110220324376e-07 0 9.115101626002e-07 0 9.115301626002e-07 1.2 9.120182926002e-07 1.2 9.120382926002e-07 0 9.125264227628e-07 0 9.125464227628e-07 1.2 9.130345527628e-07 1.2 9.130545527628e-07 0 9.135426829254e-07 0 9.135626829254e-07 1.2 9.140508129254e-07 1.2 9.140708129254e-07 0 9.14558943088e-07 0 9.14578943088e-07 1.2 9.15067073088e-07 1.2 9.15087073088e-07 0 9.155752032506e-07 0 9.155952032506e-07 1.2 9.160833332506e-07 1.2 9.161033332506e-07 0 9.165914634132e-07 0 9.166114634132e-07 1.2 9.170995934132e-07 1.2 9.171195934132e-07 0 9.176077235758e-07 0 9.176277235758e-07 1.2 9.181158535758e-07 1.2 9.181358535758e-07 0 9.186239837384e-07 0 9.186439837384e-07 1.2 9.191321137384e-07 1.2 9.191521137384e-07 0 9.19640243901e-07 0 9.19660243901e-07 1.2 9.20148373901e-07 1.2 9.20168373901e-07 0 9.206565040636e-07 0 9.206765040636e-07 1.2 9.211646340636e-07 1.2 9.211846340636e-07 0 9.216727642262e-07 0 9.216927642262e-07 1.2 9.221808942262e-07 1.2 9.222008942262e-07 0 9.226890243888e-07 0 9.227090243888e-07 1.2 9.231971543888e-07 1.2 9.232171543888e-07 0 9.237052845514e-07 0 9.237252845514e-07 1.2 9.242134145514e-07 1.2 9.242334145514e-07 0 9.24721544714e-07 0 9.24741544714e-07 1.2 9.25229674714e-07 1.2 9.25249674714e-07 0 9.257378048766e-07 0 9.257578048766e-07 1.2 9.262459348766e-07 1.2 9.262659348766e-07 0 9.267540650392e-07 0 9.267740650392e-07 1.2 9.272621950392e-07 1.2 9.272821950392e-07 0 9.277703252018e-07 0 9.277903252018e-07 1.2 9.282784552018e-07 1.2 9.282984552018e-07 0 9.287865853644e-07 0 9.288065853644e-07 1.2 9.292947153644e-07 1.2 9.293147153644e-07 0 9.29802845527e-07 0 9.29822845527e-07 1.2 9.30310975527e-07 1.2 9.30330975527e-07 0 9.308191056896e-07 0 9.308391056896e-07 1.2 9.313272356896e-07 1.2 9.313472356896e-07 0 9.318353658522e-07 0 9.318553658522e-07 1.2 9.323434958522e-07 1.2 9.323634958522e-07 0 9.328516260148e-07 0 9.328716260148e-07 1.2 9.333597560148e-07 1.2 9.333797560148e-07 0 9.338678861774e-07 0 9.338878861774e-07 1.2 9.343760161774e-07 1.2 9.343960161774e-07 0 9.3488414634e-07 0 9.3490414634e-07 1.2 9.3539227634e-07 1.2 9.3541227634e-07 0 9.359004065026e-07 0 9.359204065026e-07 1.2 9.364085365026e-07 1.2 9.364285365026e-07 0 9.369166666652e-07 0 9.369366666652e-07 1.2 9.374247966652e-07 1.2 9.374447966652e-07 0 9.379329268278e-07 0 9.379529268278e-07 1.2 9.384410568278e-07 1.2 9.384610568278e-07 0 9.389491869904e-07 0 9.389691869904e-07 1.2 9.394573169904e-07 1.2 9.394773169904e-07 0 9.39965447153e-07 0 9.39985447153e-07 1.2 9.40473577153e-07 1.2 9.40493577153e-07 0 9.409817073156e-07 0 9.410017073156e-07 1.2 9.414898373156e-07 1.2 9.415098373156e-07 0 9.419979674782e-07 0 9.420179674782e-07 1.2 9.425060974782e-07 1.2 9.425260974782e-07 0 9.430142276408e-07 0 9.430342276408e-07 1.2 9.435223576408e-07 1.2 9.435423576408e-07 0 9.440304878034e-07 0 9.440504878034e-07 1.2 9.445386178034e-07 1.2 9.445586178034e-07 0 9.45046747966e-07 0 9.45066747966e-07 1.2 9.45554877966e-07 1.2 9.45574877966e-07 0 9.460630081286e-07 0 9.460830081286e-07 1.2 9.465711381286e-07 1.2 9.465911381286e-07 0 9.470792682912e-07 0 9.470992682912e-07 1.2 9.475873982912e-07 1.2 9.476073982912e-07 0 9.480955284538e-07 0 9.481155284538e-07 1.2 9.486036584538e-07 1.2 9.486236584538e-07 0 9.491117886164e-07 0 9.491317886164e-07 1.2 9.496199186164e-07 1.2 9.496399186164e-07 0 9.50128048779e-07 0 9.50148048779e-07 1.2 9.50636178779e-07 1.2 9.50656178779e-07 0 9.511443089416e-07 0 9.511643089416e-07 1.2 9.516524389416e-07 1.2 9.516724389416e-07 0 9.521605691042e-07 0 9.521805691042e-07 1.2 9.526686991042e-07 1.2 9.526886991042e-07 0 9.531768292668e-07 0 9.531968292668e-07 1.2 9.536849592668e-07 1.2 9.537049592668e-07 0 9.541930894294e-07 0 9.542130894294e-07 1.2 9.547012194294e-07 1.2 9.547212194294e-07 0 9.55209349592e-07 0 9.55229349592e-07 1.2 9.55717479592e-07 1.2 9.55737479592e-07 0 9.562256097546e-07 0 9.562456097546e-07 1.2 9.567337397546e-07 1.2 9.567537397546e-07 0 9.572418699172e-07 0 9.572618699172e-07 1.2 9.577499999172e-07 1.2 9.577699999172e-07 0 9.582581300798e-07 0 9.582781300798e-07 1.2 9.587662600798e-07 1.2 9.587862600798e-07 0 9.592743902424e-07 0 9.592943902424e-07 1.2 9.597825202424e-07 1.2 9.598025202424e-07 0 9.60290650405e-07 0 9.60310650405e-07 1.2 9.60798780405e-07 1.2 9.60818780405e-07 0 9.613069105676e-07 0 9.613269105676e-07 1.2 9.618150405676e-07 1.2 9.618350405676e-07 0 9.623231707302e-07 0 9.623431707302e-07 1.2 9.628313007302e-07 1.2 9.628513007302e-07 0 9.633394308928e-07 0 9.633594308928e-07 1.2 9.638475608928e-07 1.2 9.638675608928e-07 0 9.643556910554e-07 0 9.643756910554e-07 1.2 9.648638210554e-07 1.2 9.648838210554e-07 0 9.65371951218e-07 0 9.65391951218e-07 1.2 9.65880081218e-07 1.2 9.65900081218e-07 0 9.663882113806e-07 0 9.664082113806e-07 1.2 9.668963413806e-07 1.2 9.669163413806e-07 0 9.674044715432e-07 0 9.674244715432e-07 1.2 9.679126015432e-07 1.2 9.679326015432e-07 0 9.684207317058e-07 0 9.684407317058e-07 1.2 9.689288617058e-07 1.2 9.689488617058e-07 0 9.694369918684e-07 0 9.694569918684e-07 1.2 9.699451218684e-07 1.2 9.699651218684e-07 0 9.70453252031e-07 0 9.70473252031e-07 1.2 9.70961382031e-07 1.2 9.70981382031e-07 0 9.714695121936e-07 0 9.714895121936e-07 1.2 9.719776421936e-07 1.2 9.719976421936e-07 0 9.724857723562e-07 0 9.725057723562e-07 1.2 9.729939023562e-07 1.2 9.730139023562e-07 0 9.735020325188e-07 0 9.735220325188e-07 1.2 9.740101625188e-07 1.2 9.740301625188e-07 0 9.745182926814e-07 0 9.745382926814e-07 1.2 9.750264226814e-07 1.2 9.750464226814e-07 0 9.75534552844e-07 0 9.75554552844e-07 1.2 9.76042682844e-07 1.2 9.76062682844e-07 0 9.765508130066e-07 0 9.765708130066e-07 1.2 9.770589430066e-07 1.2 9.770789430066e-07 0 9.775670731692e-07 0 9.775870731692e-07 1.2 9.780752031692e-07 1.2 9.780952031692e-07 0 9.785833333318e-07 0 9.786033333318e-07 1.2 9.790914633318e-07 1.2 9.791114633318e-07 0 9.795995934944e-07 0 9.796195934944e-07 1.2 9.801077234944e-07 1.2 9.801277234944e-07 0 9.80615853657e-07 0 9.80635853657e-07 1.2 9.81123983657e-07 1.2 9.81143983657e-07 0 9.816321138196e-07 0 9.816521138196e-07 1.2 9.821402438196e-07 1.2 9.821602438196e-07 0 9.826483739822e-07 0 9.826683739822e-07 1.2 9.831565039822e-07 1.2 9.831765039822e-07 0 9.836646341448e-07 0 9.836846341448e-07 1.2 9.841727641448e-07 1.2 9.841927641448e-07 0 9.846808943074e-07 0 9.847008943074e-07 1.2 9.851890243074e-07 1.2 9.852090243074e-07 0 9.8569715447e-07 0 9.8571715447e-07 1.2 9.8620528447e-07 1.2 9.8622528447e-07 0 9.867134146326e-07 0 9.867334146326e-07 1.2 9.872215446326e-07 1.2 9.872415446326e-07 0 9.877296747952e-07 0 9.877496747952e-07 1.2 9.882378047952e-07 1.2 9.882578047952e-07 0 9.887459349578e-07 0 9.887659349578e-07 1.2 9.892540649578e-07 1.2 9.892740649578e-07 0 9.897621951204e-07 0 9.897821951204e-07 1.2 9.902703251204e-07 1.2 9.902903251204e-07 0 9.90778455283e-07 0 9.90798455283e-07 1.2 9.91286585283e-07 1.2 9.91306585283e-07 0 9.917947154456e-07 0 9.918147154456e-07 1.2 9.923028454456e-07 1.2 9.923228454456e-07 0 9.928109756082e-07 0 9.928309756082e-07 1.2 9.933191056082e-07 1.2 9.933391056082e-07 0 9.938272357708e-07 0 9.938472357708e-07 1.2 9.943353657708e-07 1.2 9.943553657708e-07 0 9.948434959334e-07 0 9.948634959334e-07 1.2 9.953516259334e-07 1.2 9.953716259334e-07 0 9.95859756096e-07 0 9.95879756096e-07 1.2 9.96367886096e-07 1.2 9.96387886096e-07 0 9.968760162586e-07 0 9.968960162586e-07 1.2 9.973841462586e-07 1.2 9.974041462586e-07 0 9.978922764212e-07 0 9.979122764212e-07 1.2 9.984004064212e-07 1.2 9.984204064212e-07 0 9.989085365838e-07 0 9.989285365838e-07 1.2 9.994166665838e-07 1.2 9.994366665838e-07 0 9.999247967464e-07 0 9.999447967464e-07 1.2 1.0004329267464e-06 1.2 1.0004529267464e-06 0 1.000941056909e-06 0 1.000961056909e-06 1.2 1.001449186909e-06 1.2 1.001469186909e-06 0 1.0019573170716e-06 0 1.0019773170716e-06 1.2 1.0024654470716e-06 1.2 1.0024854470716e-06 0 1.0029735772342e-06 0 1.0029935772342e-06 1.2 1.0034817072342e-06 1.2 1.0035017072342e-06 0 1.0039898373968e-06 0 1.0040098373968e-06 1.2 1.0044979673968e-06 1.2 1.0045179673968e-06 0 1.0050060975594e-06 0 1.0050260975594e-06 1.2 1.0055142275594e-06 1.2 1.0055342275594e-06 0 1.006022357722e-06 0 1.006042357722e-06 1.2 1.006530487722e-06 1.2 1.006550487722e-06 0 1.0070386178846e-06 0 1.0070586178846e-06 1.2 1.0075467478846e-06 1.2 1.0075667478846e-06 0 1.0080548780472e-06 0 1.0080748780472e-06 1.2 1.0085630080472e-06 1.2 1.0085830080472e-06 0 1.0090711382098e-06 0 1.0090911382098e-06 1.2 1.0095792682098e-06 1.2 1.0095992682098e-06 0 1.0100873983724e-06 0 1.0101073983724e-06 1.2 1.0105955283724e-06 1.2 1.0106155283724e-06 0 1.011103658535e-06 0 1.011123658535e-06 1.2 1.011611788535e-06 1.2 1.011631788535e-06 0 1.0121199186976e-06 0 1.0121399186976e-06 1.2 1.0126280486976e-06 1.2 1.0126480486976e-06 0 1.0131361788602e-06 0 1.0131561788602e-06 1.2 1.0136443088602e-06 1.2 1.0136643088602e-06 0 1.0141524390228e-06 0 1.0141724390228e-06 1.2 1.0146605690228e-06 1.2 1.0146805690228e-06 0 1.0151686991854e-06 0 1.0151886991854e-06 1.2 1.0156768291854e-06 1.2 1.0156968291854e-06 0 1.016184959348e-06 0 1.016204959348e-06 1.2 1.016693089348e-06 1.2 1.016713089348e-06 0 1.0172012195106e-06 0 1.0172212195106e-06 1.2 1.0177093495106e-06 1.2 1.0177293495106e-06 0 1.0182174796732e-06 0 1.0182374796732e-06 1.2 1.0187256096732e-06 1.2 1.0187456096732e-06 0 1.0192337398358e-06 0 1.0192537398358e-06 1.2 1.0197418698358e-06 1.2 1.0197618698358e-06 0 1.0202499999984e-06 0 1.0202699999984e-06 1.2 1.0207581299984e-06 1.2 1.0207781299984e-06 0 1.021266260161e-06 0 1.021286260161e-06 1.2 1.021774390161e-06 1.2 1.021794390161e-06 0 1.0222825203236e-06 0 1.0223025203236e-06 1.2 1.0227906503236e-06 1.2 1.0228106503236e-06 0 1.0232987804862e-06 0 1.0233187804862e-06 1.2 1.0238069104862e-06 1.2 1.0238269104862e-06 0 1.0243150406488e-06 0 1.0243350406488e-06 1.2 1.0248231706488e-06 1.2 1.0248431706488e-06 0 1.0253313008114e-06 0 1.0253513008114e-06 1.2 1.0258394308114e-06 1.2 1.0258594308114e-06 0 1.026347560974e-06 0 1.026367560974e-06 1.2 1.026855690974e-06 1.2 1.026875690974e-06 0 1.0273638211366e-06 0 1.0273838211366e-06 1.2 1.0278719511366e-06 1.2 1.0278919511366e-06 0 1.0283800812992e-06 0 1.0284000812992e-06 1.2 1.0288882112992e-06 1.2 1.0289082112992e-06 0 1.0293963414618e-06 0 1.0294163414618e-06 1.2 1.0299044714618e-06 1.2 1.0299244714618e-06 0 1.0304126016244e-06 0 1.0304326016244e-06 1.2 1.0309207316244e-06 1.2 1.0309407316244e-06 0 1.031428861787e-06 0 1.031448861787e-06 1.2 1.031936991787e-06 1.2 1.031956991787e-06 0 1.0324451219496e-06 0 1.0324651219496e-06 1.2 1.0329532519496e-06 1.2 1.0329732519496e-06 0 1.0334613821122e-06 0 1.0334813821122e-06 1.2 1.0339695121122e-06 1.2 1.0339895121122e-06 0 1.0344776422748e-06 0 1.0344976422748e-06 1.2 1.0349857722748e-06 1.2 1.0350057722748e-06 0 1.0354939024374e-06 0 1.0355139024374e-06 1.2 1.0360020324374e-06 1.2 1.0360220324374e-06 0 1.0365101626e-06 0 1.0365301626e-06 1.2 1.0370182926e-06 1.2 1.0370382926e-06 0 1.0375264227626e-06 0 1.0375464227626e-06 1.2 1.0380345527626e-06 1.2 1.0380545527626e-06 0 1.0385426829252e-06 0 1.0385626829252e-06 1.2 1.0390508129252e-06 1.2 1.0390708129252e-06 0 1.0395589430878e-06 0 1.0395789430878e-06 1.2 1.0400670730878e-06 1.2 1.0400870730878e-06 0 1.0405752032504e-06 0 1.0405952032504e-06 1.2 1.0410833332504e-06 1.2 1.0411033332504e-06 0 1.041591463413e-06 0 1.041611463413e-06 1.2 1.042099593413e-06 1.2 1.042119593413e-06 0 1.0426077235756e-06 0 1.0426277235756e-06 1.2 1.0431158535756e-06 1.2 1.0431358535756e-06 0 1.0436239837382e-06 0 1.0436439837382e-06 1.2 1.0441321137382e-06 1.2 1.0441521137382e-06 0 1.0446402439008e-06 0 1.0446602439008e-06 1.2 1.0451483739008e-06 1.2 1.0451683739008e-06 0 1.0456565040634e-06 0 1.0456765040634e-06 1.2 1.0461646340634e-06 1.2 1.0461846340634e-06 0 1.046672764226e-06 0 1.046692764226e-06 1.2 1.047180894226e-06 1.2 1.047200894226e-06 0 1.0476890243886e-06 0 1.0477090243886e-06 1.2 1.0481971543886e-06 1.2 1.0482171543886e-06 0 1.0487052845512e-06 0 1.0487252845512e-06 1.2 1.0492134145512e-06 1.2 1.0492334145512e-06 0 1.0497215447138e-06 0 1.0497415447138e-06 1.2 1.0502296747138e-06 1.2 1.0502496747138e-06 0 1.0507378048764e-06 0 1.0507578048764e-06 1.2 1.0512459348764e-06 1.2 1.0512659348764e-06 0 1.051754065039e-06 0 1.051774065039e-06 1.2 1.052262195039e-06 1.2 1.052282195039e-06 0 1.0527703252016e-06 0 1.0527903252016e-06 1.2 1.0532784552016e-06 1.2 1.0532984552016e-06 0 1.0537865853642e-06 0 1.0538065853642e-06 1.2 1.0542947153642e-06 1.2 1.0543147153642e-06 0 1.0548028455268e-06 0 1.0548228455268e-06 1.2 1.0553109755268e-06 1.2 1.0553309755268e-06 0 1.0558191056894e-06 0 1.0558391056894e-06 1.2 1.0563272356894e-06 1.2 1.0563472356894e-06 0 1.056835365852e-06 0 1.056855365852e-06 1.2 1.057343495852e-06 1.2 1.057363495852e-06 0 1.0578516260146e-06 0 1.0578716260146e-06 1.2 1.0583597560146e-06 1.2 1.0583797560146e-06 0 1.0588678861772e-06 0 1.0588878861772e-06 1.2 1.0593760161772e-06 1.2 1.0593960161772e-06 0 1.0598841463398e-06 0 1.0599041463398e-06 1.2 1.0603922763398e-06 1.2 1.0604122763398e-06 0 1.0609004065024e-06 0 1.0609204065024e-06 1.2 1.0614085365024e-06 1.2 1.0614285365024e-06 0 1.061916666665e-06 0 1.061936666665e-06 1.2 1.062424796665e-06 1.2 1.062444796665e-06 0 1.0629329268276e-06 0 1.0629529268276e-06 1.2 1.0634410568276e-06 1.2 1.0634610568276e-06 0 1.0639491869902e-06 0 1.0639691869902e-06 1.2 1.0644573169902e-06 1.2 1.0644773169902e-06 0 1.0649654471528e-06 0 1.0649854471528e-06 1.2 1.0654735771528e-06 1.2 1.0654935771528e-06 0 1.0659817073154e-06 0 1.0660017073154e-06 1.2 1.0664898373154e-06 1.2 1.0665098373154e-06 0 1.066997967478e-06 0 1.067017967478e-06 1.2 1.067506097478e-06 1.2 1.067526097478e-06 0 1.0680142276406e-06 0 1.0680342276406e-06 1.2 1.0685223576406e-06 1.2 1.0685423576406e-06 0 1.0690304878032e-06 0 1.0690504878032e-06 1.2 1.0695386178032e-06 1.2 1.0695586178032e-06 0 1.0700467479658e-06 0 1.0700667479658e-06 1.2 1.0705548779658e-06 1.2 1.0705748779658e-06 0 1.0710630081284e-06 0 1.0710830081284e-06 1.2 1.0715711381284e-06 1.2 1.0715911381284e-06 0 1.072079268291e-06 0 1.072099268291e-06 1.2 1.072587398291e-06 1.2 1.072607398291e-06 0 1.0730955284536e-06 0 1.0731155284536e-06 1.2 1.0736036584536e-06 1.2 1.0736236584536e-06 0 1.0741117886162e-06 0 1.0741317886162e-06 1.2 1.0746199186162e-06 1.2 1.0746399186162e-06 0 1.0751280487788e-06 0 1.0751480487788e-06 1.2 1.0756361787788e-06 1.2 1.0756561787788e-06 0 1.0761443089414e-06 0 1.0761643089414e-06 1.2 1.0766524389414e-06 1.2 1.0766724389414e-06 0 1.077160569104e-06 0 1.077180569104e-06 1.2 1.077668699104e-06 1.2 1.077688699104e-06 0 1.0781768292666e-06 0 1.0781968292666e-06 1.2 1.0786849592666e-06 1.2 1.0787049592666e-06 0 1.0791930894292e-06 0 1.0792130894292e-06 1.2 1.0797012194292e-06 1.2 1.0797212194292e-06 0 1.0802093495918e-06 0 1.0802293495918e-06 1.2 1.0807174795918e-06 1.2 1.0807374795918e-06 0 1.0812256097544e-06 0 1.0812456097544e-06 1.2 1.0817337397544e-06 1.2 1.0817537397544e-06 0 1.082241869917e-06 0 1.082261869917e-06 1.2 1.082749999917e-06 1.2 1.082769999917e-06 0 1.0832581300796e-06 0 1.0832781300796e-06 1.2 1.0837662600796e-06 1.2 1.0837862600796e-06 0 1.0842743902422e-06 0 1.0842943902422e-06 1.2 1.0847825202422e-06 1.2 1.0848025202422e-06 0 1.0852906504048e-06 0 1.0853106504048e-06 1.2 1.0857987804048e-06 1.2 1.0858187804048e-06 0 1.0863069105674e-06 0 1.0863269105674e-06 1.2 1.0868150405674e-06 1.2 1.0868350405674e-06 0 1.08732317073e-06 0 1.08734317073e-06 1.2 1.08783130073e-06 1.2 1.08785130073e-06 0 1.0883394308926e-06 0 1.0883594308926e-06 1.2 1.0888475608926e-06 1.2 1.0888675608926e-06 0 1.0893556910552e-06 0 1.0893756910552e-06 1.2 1.0898638210552e-06 1.2 1.0898838210552e-06 0 1.0903719512178e-06 0 1.0903919512178e-06 1.2 1.0908800812178e-06 1.2 1.0909000812178e-06 0 1.0913882113804e-06 0 1.0914082113804e-06 1.2 1.0918963413804e-06 1.2 1.0919163413804e-06 0 1.092404471543e-06 0 1.092424471543e-06 1.2 1.092912601543e-06 1.2 1.092932601543e-06 0 1.0934207317056e-06 0 1.0934407317056e-06 1.2 1.0939288617056e-06 1.2 1.0939488617056e-06 0 1.0944369918682e-06 0 1.0944569918682e-06 1.2 1.0949451218682e-06 1.2 1.0949651218682e-06 0 1.0954532520308e-06 0 1.0954732520308e-06 1.2 1.0959613820308e-06 1.2 1.0959813820308e-06 0 1.0964695121934e-06 0 1.0964895121934e-06 1.2 1.0969776421934e-06 1.2 1.0969976421934e-06 0 1.097485772356e-06 0 1.097505772356e-06 1.2 1.097993902356e-06 1.2 1.098013902356e-06 0 1.0985020325186e-06 0 1.0985220325186e-06 1.2 1.0990101625186e-06 1.2 1.0990301625186e-06 0 1.0995182926812e-06 0 1.0995382926812e-06 1.2 1.1000264226812e-06 1.2 1.1000464226812e-06 0 1.1005345528438e-06 0 1.1005545528438e-06 1.2 1.1010426828438e-06 1.2 1.1010626828438e-06 0 1.1015508130064e-06 0 1.1015708130064e-06 1.2 1.1020589430064e-06 1.2 1.1020789430064e-06 0 1.102567073169e-06 0 1.102587073169e-06 1.2 1.103075203169e-06 1.2 1.103095203169e-06 0 1.1035833333316e-06 0 1.1036033333316e-06 1.2 1.1040914633316e-06 1.2 1.1041114633316e-06 0 1.1045995934942e-06 0 1.1046195934942e-06 1.2 1.1051077234942e-06 1.2 1.1051277234942e-06 0 1.1056158536568e-06 0 1.1056358536568e-06 1.2 1.1061239836568e-06 1.2 1.1061439836568e-06 0 1.1066321138194e-06 0 1.1066521138194e-06 1.2 1.1071402438194e-06 1.2 1.1071602438194e-06 0 1.107648373982e-06 0 1.107668373982e-06 1.2 1.108156503982e-06 1.2 1.108176503982e-06 0 1.1086646341446e-06 0 1.1086846341446e-06 1.2 1.1091727641446e-06 1.2 1.1091927641446e-06 0 1.1096808943072e-06 0 1.1097008943072e-06 1.2 1.1101890243072e-06 1.2 1.1102090243072e-06 0 1.1106971544698e-06 0 1.1107171544698e-06 1.2 1.1112052844698e-06 1.2 1.1112252844698e-06 0 1.1117134146324e-06 0 1.1117334146324e-06 1.2 1.1122215446324e-06 1.2 1.1122415446324e-06 0 1.112729674795e-06 0 1.112749674795e-06 1.2 1.113237804795e-06 1.2 1.113257804795e-06 0 1.1137459349576e-06 0 1.1137659349576e-06 1.2 1.1142540649576e-06 1.2 1.1142740649576e-06 0 1.1147621951202e-06 0 1.1147821951202e-06 1.2 1.1152703251202e-06 1.2 1.1152903251202e-06 0 1.1157784552828e-06 0 1.1157984552828e-06 1.2 1.1162865852828e-06 1.2 1.1163065852828e-06 0 1.1167947154454e-06 0 1.1168147154454e-06 1.2 1.1173028454454e-06 1.2 1.1173228454454e-06 0 1.117810975608e-06 0 1.117830975608e-06 1.2 1.118319105608e-06 1.2 1.118339105608e-06 0 1.1188272357706e-06 0 1.1188472357706e-06 1.2 1.1193353657706e-06 1.2 1.1193553657706e-06 0 1.1198434959332e-06 0 1.1198634959332e-06 1.2 1.1203516259332e-06 1.2 1.1203716259332e-06 0 1.1208597560958e-06 0 1.1208797560958e-06 1.2 1.1213678860958e-06 1.2 1.1213878860958e-06 0 1.1218760162584e-06 0 1.1218960162584e-06 1.2 1.1223841462584e-06 1.2 1.1224041462584e-06 0 1.122892276421e-06 0 1.122912276421e-06 1.2 1.123400406421e-06 1.2 1.123420406421e-06 0 1.1239085365836e-06 0 1.1239285365836e-06 1.2 1.1244166665836e-06 1.2 1.1244366665836e-06 0 1.1249247967462e-06 0 1.1249447967462e-06 1.2 1.1254329267462e-06 1.2 1.1254529267462e-06 0 1.1259410569088e-06 0 1.1259610569088e-06 1.2 1.1264491869088e-06 1.2 1.1264691869088e-06 0 1.1269573170714e-06 0 1.1269773170714e-06 1.2 1.1274654470714e-06 1.2 1.1274854470714e-06 0 1.127973577234e-06 0 1.127993577234e-06 1.2 1.128481707234e-06 1.2 1.128501707234e-06 0 1.1289898373966e-06 0 1.1290098373966e-06 1.2 1.1294979673966e-06 1.2 1.1295179673966e-06 0 1.1300060975592e-06 0 1.1300260975592e-06 1.2 1.1305142275592e-06 1.2 1.1305342275592e-06 0 1.1310223577218e-06 0 1.1310423577218e-06 1.2 1.1315304877218e-06 1.2 1.1315504877218e-06 0 1.1320386178844e-06 0 1.1320586178844e-06 1.2 1.1325467478844e-06 1.2 1.1325667478844e-06 0 1.133054878047e-06 0 1.133074878047e-06 1.2 1.133563008047e-06 1.2 1.133583008047e-06 0 1.1340711382096e-06 0 1.1340911382096e-06 1.2 1.1345792682096e-06 1.2 1.1345992682096e-06 0 1.1350873983722e-06 0 1.1351073983722e-06 1.2 1.1355955283722e-06 1.2 1.1356155283722e-06 0 1.1361036585348e-06 0 1.1361236585348e-06 1.2 1.1366117885348e-06 1.2 1.1366317885348e-06 0 1.1371199186974e-06 0 1.1371399186974e-06 1.2 1.1376280486974e-06 1.2 1.1376480486974e-06 0 1.13813617886e-06 0 1.13815617886e-06 1.2 1.13864430886e-06 1.2 1.13866430886e-06 0 1.1391524390226e-06 0 1.1391724390226e-06 1.2 1.1396605690226e-06 1.2 1.1396805690226e-06 0 1.1401686991852e-06 0 1.1401886991852e-06 1.2 1.1406768291852e-06 1.2 1.1406968291852e-06 0 1.1411849593478e-06 0 1.1412049593478e-06 1.2 1.1416930893478e-06 1.2 1.1417130893478e-06 0 1.1422012195104e-06 0 1.1422212195104e-06 1.2 1.1427093495104e-06 1.2 1.1427293495104e-06 0 1.143217479673e-06 0 1.143237479673e-06 1.2 1.143725609673e-06 1.2 1.143745609673e-06 0 1.1442337398356e-06 0 1.1442537398356e-06 1.2 1.1447418698356e-06 1.2 1.1447618698356e-06 0 1.1452499999982e-06 0 1.1452699999982e-06 1.2 1.1457581299982e-06 1.2 1.1457781299982e-06 0 1.1462662601608e-06 0 1.1462862601608e-06 1.2 1.1467743901608e-06 1.2 1.1467943901608e-06 0 1.1472825203234e-06 0 1.1473025203234e-06 1.2 1.1477906503234e-06 1.2 1.1478106503234e-06 0 1.148298780486e-06 0 1.148318780486e-06 1.2 1.148806910486e-06 1.2 1.148826910486e-06 0 1.1493150406486e-06 0 1.1493350406486e-06 1.2 1.1498231706486e-06 1.2 1.1498431706486e-06 0 1.1503313008112e-06 0 1.1503513008112e-06 1.2 1.1508394308112e-06 1.2 1.1508594308112e-06 0 1.1513475609738e-06 0 1.1513675609738e-06 1.2 1.1518556909738e-06 1.2 1.1518756909738e-06 0 1.1523638211364e-06 0 1.1523838211364e-06 1.2 1.1528719511364e-06 1.2 1.1528919511364e-06 0 1.153380081299e-06 0 1.153400081299e-06 1.2 1.153888211299e-06 1.2 1.153908211299e-06 0 1.1543963414616e-06 0 1.1544163414616e-06 1.2 1.1549044714616e-06 1.2 1.1549244714616e-06 0 1.1554126016242e-06 0 1.1554326016242e-06 1.2 1.1559207316242e-06 1.2 1.1559407316242e-06 0 1.1564288617868e-06 0 1.1564488617868e-06 1.2 1.1569369917868e-06 1.2 1.1569569917868e-06 0 1.1574451219494e-06 0 1.1574651219494e-06 1.2 1.1579532519494e-06 1.2 1.1579732519494e-06 0 1.158461382112e-06 0 1.158481382112e-06 1.2 1.158969512112e-06 1.2 1.158989512112e-06 0 1.1594776422746e-06 0 1.1594976422746e-06 1.2 1.1599857722746e-06 1.2 1.1600057722746e-06 0 1.1604939024372e-06 0 1.1605139024372e-06 1.2 1.1610020324372e-06 1.2 1.1610220324372e-06 0 1.1615101625998e-06 0 1.1615301625998e-06 1.2 1.1620182925998e-06 1.2 1.1620382925998e-06 0 1.1625264227624e-06 0 1.1625464227624e-06 1.2 1.1630345527624e-06 1.2 1.1630545527624e-06 0 1.163542682925e-06 0 1.163562682925e-06 1.2 1.164050812925e-06 1.2 1.164070812925e-06 0 1.1645589430876e-06 0 1.1645789430876e-06 1.2 1.1650670730876e-06 1.2 1.1650870730876e-06 0 1.1655752032502e-06 0 1.1655952032502e-06 1.2 1.1660833332502e-06 1.2 1.1661033332502e-06 0 1.1665914634128e-06 0 1.1666114634128e-06 1.2 1.1670995934128e-06 1.2 1.1671195934128e-06 0 1.1676077235754e-06 0 1.1676277235754e-06 1.2 1.1681158535754e-06 1.2 1.1681358535754e-06 0 1.168623983738e-06 0 1.168643983738e-06 1.2 1.169132113738e-06 1.2 1.169152113738e-06 0 1.1696402439006e-06 0 1.1696602439006e-06 1.2 1.1701483739006e-06 1.2 1.1701683739006e-06 0 1.1706565040632e-06 0 1.1706765040632e-06 1.2 1.1711646340632e-06 1.2 1.1711846340632e-06 0 1.1716727642258e-06 0 1.1716927642258e-06 1.2 1.1721808942258e-06 1.2 1.1722008942258e-06 0 1.1726890243884e-06 0 1.1727090243884e-06 1.2 1.1731971543884e-06 1.2 1.1732171543884e-06 0 1.173705284551e-06 0 1.173725284551e-06 1.2 1.174213414551e-06 1.2 1.174233414551e-06 0 1.1747215447136e-06 0 1.1747415447136e-06 1.2 1.1752296747136e-06 1.2 1.1752496747136e-06 0 1.1757378048762e-06 0 1.1757578048762e-06 1.2 1.1762459348762e-06 1.2 1.1762659348762e-06 0 1.1767540650388e-06 0 1.1767740650388e-06 1.2 1.1772621950388e-06 1.2 1.1772821950388e-06 0 1.1777703252014e-06 0 1.1777903252014e-06 1.2 1.1782784552014e-06 1.2 1.1782984552014e-06 0 1.178786585364e-06 0 1.178806585364e-06 1.2 1.179294715364e-06 1.2 1.179314715364e-06 0 1.1798028455266e-06 0 1.1798228455266e-06 1.2 1.1803109755266e-06 1.2 1.1803309755266e-06 0 1.1808191056892e-06 0 1.1808391056892e-06 1.2 1.1813272356892e-06 1.2 1.1813472356892e-06 0 1.1818353658518e-06 0 1.1818553658518e-06 1.2 1.1823434958518e-06 1.2 1.1823634958518e-06 0 1.1828516260144e-06 0 1.1828716260144e-06 1.2 1.1833597560144e-06 1.2 1.1833797560144e-06 0 1.183867886177e-06 0 1.183887886177e-06 1.2 1.184376016177e-06 1.2 1.184396016177e-06 0 1.1848841463396e-06 0 1.1849041463396e-06 1.2 1.1853922763396e-06 1.2 1.1854122763396e-06 0 1.1859004065022e-06 0 1.1859204065022e-06 1.2 1.1864085365022e-06 1.2 1.1864285365022e-06 0 1.1869166666648e-06 0 1.1869366666648e-06 1.2 1.1874247966648e-06 1.2 1.1874447966648e-06 0 1.1879329268274e-06 0 1.1879529268274e-06 1.2 1.1884410568274e-06 1.2 1.1884610568274e-06 0 1.18894918699e-06 0 1.18896918699e-06 1.2 1.18945731699e-06 1.2 1.18947731699e-06 0 1.1899654471526e-06 0 1.1899854471526e-06 1.2 1.1904735771526e-06 1.2 1.1904935771526e-06 0 1.1909817073152e-06 0 1.1910017073152e-06 1.2 1.1914898373152e-06 1.2 1.1915098373152e-06 0 1.1919979674778e-06 0 1.1920179674778e-06 1.2 1.1925060974778e-06 1.2 1.1925260974778e-06 0 1.1930142276404e-06 0 1.1930342276404e-06 1.2 1.1935223576404e-06 1.2 1.1935423576404e-06 0 1.194030487803e-06 0 1.194050487803e-06 1.2 1.194538617803e-06 1.2 1.194558617803e-06 0 1.1950467479656e-06 0 1.1950667479656e-06 1.2 1.1955548779656e-06 1.2 1.1955748779656e-06 0 1.1960630081282e-06 0 1.1960830081282e-06 1.2 1.1965711381282e-06 1.2 1.1965911381282e-06 0 1.1970792682908e-06 0 1.1970992682908e-06 1.2 1.1975873982908e-06 1.2 1.1976073982908e-06 0 1.1980955284534e-06 0 1.1981155284534e-06 1.2 1.1986036584534e-06 1.2 1.1986236584534e-06 0 1.199111788616e-06 0 1.199131788616e-06 1.2 1.199619918616e-06 1.2 1.199639918616e-06 0 1.2001280487786e-06 0 1.2001480487786e-06 1.2 1.2006361787786e-06 1.2 1.2006561787786e-06 0 1.2011443089412e-06 0 1.2011643089412e-06 1.2 1.2016524389412e-06 1.2 1.2016724389412e-06 0 1.2021605691038e-06 0 1.2021805691038e-06 1.2 1.2026686991038e-06 1.2 1.2026886991038e-06 0 1.2031768292664e-06 0 1.2031968292664e-06 1.2 1.2036849592664e-06 1.2 1.2037049592664e-06 0 1.204193089429e-06 0 1.204213089429e-06 1.2 1.204701219429e-06 1.2 1.204721219429e-06 0 1.2052093495916e-06 0 1.2052293495916e-06 1.2 1.2057174795916e-06 1.2 1.2057374795916e-06 0 1.2062256097542e-06 0 1.2062456097542e-06 1.2 1.2067337397542e-06 1.2 1.2067537397542e-06 0 1.2072418699168e-06 0 1.2072618699168e-06 1.2 1.2077499999168e-06 1.2 1.2077699999168e-06 0 1.2082581300794e-06 0 1.2082781300794e-06 1.2 1.2087662600794e-06 1.2 1.2087862600794e-06 0 1.209274390242e-06 0 1.209294390242e-06 1.2 1.209782520242e-06 1.2 1.209802520242e-06 0 1.2102906504046e-06 0 1.2103106504046e-06 1.2 1.2107987804046e-06 1.2 1.2108187804046e-06 0 1.2113069105672e-06 0 1.2113269105672e-06 1.2 1.2118150405672e-06 1.2 1.2118350405672e-06 0 1.2123231707298e-06 0 1.2123431707298e-06 1.2 1.2128313007298e-06 1.2 1.2128513007298e-06 0 1.2133394308924e-06 0 1.2133594308924e-06 1.2 1.2138475608924e-06 1.2 1.2138675608924e-06 0 1.214355691055e-06 0 1.214375691055e-06 1.2 1.214863821055e-06 1.2 1.214883821055e-06 0 1.2153719512176e-06 0 1.2153919512176e-06 1.2 1.2158800812176e-06 1.2 1.2159000812176e-06 0 1.2163882113802e-06 0 1.2164082113802e-06 1.2 1.2168963413802e-06 1.2 1.2169163413802e-06 0 1.2174044715428e-06 0 1.2174244715428e-06 1.2 1.2179126015428e-06 1.2 1.2179326015428e-06 0 1.2184207317054e-06 0 1.2184407317054e-06 1.2 1.2189288617054e-06 1.2 1.2189488617054e-06 0 1.219436991868e-06 0 1.219456991868e-06 1.2 1.219945121868e-06 1.2 1.219965121868e-06 0 1.2204532520306e-06 0 1.2204732520306e-06 1.2 1.2209613820306e-06 1.2 1.2209813820306e-06 0 1.2214695121932e-06 0 1.2214895121932e-06 1.2 1.2219776421932e-06 1.2 1.2219976421932e-06 0 1.2224857723558e-06 0 1.2225057723558e-06 1.2 1.2229939023558e-06 1.2 1.2230139023558e-06 0 1.2235020325184e-06 0 1.2235220325184e-06 1.2 1.2240101625184e-06 1.2 1.2240301625184e-06 0 1.224518292681e-06 0 1.224538292681e-06 1.2 1.225026422681e-06 1.2 1.225046422681e-06 0 1.2255345528436e-06 0 1.2255545528436e-06 1.2 1.2260426828436e-06 1.2 1.2260626828436e-06 0 1.2265508130062e-06 0 1.2265708130062e-06 1.2 1.2270589430062e-06 1.2 1.2270789430062e-06 0 1.2275670731688e-06 0 1.2275870731688e-06 1.2 1.2280752031688e-06 1.2 1.2280952031688e-06 0 1.2285833333314e-06 0 1.2286033333314e-06 1.2 1.2290914633314e-06 1.2 1.2291114633314e-06 0 1.229599593494e-06 0 1.229619593494e-06 1.2 1.230107723494e-06 1.2 1.230127723494e-06 0 1.2306158536566e-06 0 1.2306358536566e-06 1.2 1.2311239836566e-06 1.2 1.2311439836566e-06 0 1.2316321138192e-06 0 1.2316521138192e-06 1.2 1.2321402438192e-06 1.2 1.2321602438192e-06 0 1.2326483739818e-06 0 1.2326683739818e-06 1.2 1.2331565039818e-06 1.2 1.2331765039818e-06 0 1.2336646341444e-06 0 1.2336846341444e-06 1.2 1.2341727641444e-06 1.2 1.2341927641444e-06 0 1.234680894307e-06 0 1.234700894307e-06 1.2 1.235189024307e-06 1.2 1.235209024307e-06 0 1.2356971544696e-06 0 1.2357171544696e-06 1.2 1.2362052844696e-06 1.2 1.2362252844696e-06 0 1.2367134146322e-06 0 1.2367334146322e-06 1.2 1.2372215446322e-06 1.2 1.2372415446322e-06 0 1.2377296747948e-06 0 1.2377496747948e-06 1.2 1.2382378047948e-06 1.2 1.2382578047948e-06 0 1.2387459349574e-06 0 1.2387659349574e-06 1.2 1.2392540649574e-06 1.2 1.2392740649574e-06 0 1.23976219512e-06 0 1.23978219512e-06 1.2 1.24027032512e-06 1.2 1.24029032512e-06 0 1.2407784552826e-06 0 1.2407984552826e-06 1.2 1.2412865852826e-06 1.2 1.2413065852826e-06 0 1.2417947154452e-06 0 1.2418147154452e-06 1.2 1.2423028454452e-06 1.2 1.2423228454452e-06 0 1.2428109756078e-06 0 1.2428309756078e-06 1.2 1.2433191056078e-06 1.2 1.2433391056078e-06 0 1.2438272357704e-06 0 1.2438472357704e-06 1.2 1.2443353657704e-06 1.2 1.2443553657704e-06 0 1.244843495933e-06 0 1.244863495933e-06 1.2 1.245351625933e-06 1.2 1.245371625933e-06 0 1.2458597560956e-06 0 1.2458797560956e-06 1.2 1.2463678860956e-06 1.2 1.2463878860956e-06 0 1.2468760162582e-06 0 1.2468960162582e-06 1.2 1.2473841462582e-06 1.2 1.2474041462582e-06 0 1.2478922764208e-06 0 1.2479122764208e-06 1.2 1.2484004064208e-06 1.2 1.2484204064208e-06 0 1.2489085365834e-06 0 1.2489285365834e-06 1.2 1.2494166665834e-06 1.2 1.2494366665834e-06 0 1.249924796746e-06 0 1.249944796746e-06 1.2 1.250432926746e-06 1.2 1.250452926746e-06 0]
VK0 (k0 0) vsource dc=1.2
VK1 (k1 0) vsource dc=0
VK2 (k2 0) vsource dc=0
VK3 (k3 0) vsource dc=1.2
VK4 (k4 0) vsource dc=0
VK5 (k5 0) vsource dc=1.2
XC (refclk reset apply k0 k1 k2 k3 k4 k5 outclk 0 frequency_good b0 b1 b2 b3 b4 b5 b6 b7 s0 s1 s2 s3 s4 s5 divider_reset enable pulse preset qualified range_error config_ready config_invalid restart count_gate count_reset vdd 0) tx_pll_control_monitored
XLF (ctrl vc1 enable preset vdd 0) tx_loop_filter rlf=100k
tran tran stop=1.4u maxstep=50p method=gear2only errpreset=moderate strobeperiod=20p strobeoutput=strobeonly
save frequency_good outclk XC.XCOUNT.gclk config_ready config_invalid divider_reset enable pulse qualified range_error restart count_gate count_reset preset ctrl VDD:p XC.q0 XC.q1 XC.q2 XC.q3 XC.q4 XC.q5 XC.q6 XC.q7 XC.q8 XC.q9 XC.q10 XC.q11 XC.q12 XC.q13 b0 b1 b2 b3 b4 b5 b6 b7 s0 s1 s2 s3 s4 s5
saveOptions options save=selected
