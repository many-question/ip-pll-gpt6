simulator lang=spectre
global 0
include "/home/process/tsmc180bcd_gen2_2022/PDK/TSMC180BCD/models/spectre/c018bcd_gen2_v1d6.scs" section=tt
include "/home/process/tsmc180bcd_gen2_2022/PDK/TSMC180BCD/models/spectre/c018bcd_gen2_v1d6.scs" section=stat_noise
simulator lang=spectre insensitive=no
include "/home/process/tsmc180bcd_gen2_2022/PDK/TSMC180BCD/models/spectre/c018bcd_gen2_v1d6.scs" section=tt_bbmvar
simulator lang=spectre insensitive=no
include "pll_noise_counterclear_core_v14.scs"
simulatorOptions options temp=27 reltol=1e-5 vabstol=1e-7 iabstol=1e-13
VDD (vdd 0) vsource dc=1.2
VR (ref 0) vsource type=pulse val0=0 val1=1.2 period=41.6666666666667n width=20.8233333333333n rise=10p fall=10p delay=1n
XP (ref out vdd 0) pll_noise_counterclear_core_v14 ref_load=1.9p
CL (out 0) capacitor c=10f
// lcm(24MHz reference, RF/8,RF/12) =>250ns;246 output edges.
save ref out XP.vp XP.vn XP.ctrl XP.vc1 XP.refb XP.hp XP.hn XP.pulse XP.clk XP.q1 XP.data XP.acqclk XP.XD.d8 XP.XD.d12 XP.preset VDD:p XP.VVCO:p XP.VRX:p XP.VRT:p
saveOptions options save=selected
save XP.b0 XP.b1 XP.b2 XP.b3 XP.b4 XP.b5 XP.b6 XP.b7
save XP.XD.XRL.a XP.XD.XRL.b XP.XD.load XP.XD.loadb XP.XD.XD12.X0.XM.fb XP.XD.ck

save XP.XD.ct0 XP.XD.ct1 XP.XD.cb XP.XD.d6 XP.XD.r0 XP.XD.r4 XP.XD.r6 XP.XD.fb

pss pss fund=4M harms=4095 tstart=3.5u tstab=2u skipdc=yes readic="core_counter_clear_noise_tt.ic" maxstep=1p method=gear2only tstabmethod=gear2only errpreset=conservative maxperiods=6 saveinit=yes writefinal="__FINAL_STATE__" writepss="__PERIODIC_STATE__" skipcount=2000 skipstop=5.25u savetime=[5.25u 5.75u] savefile="/home/jielu/TSMC180/MP/IP-PLL-GPT6/simulation/cmos_v14_full/corecounterclear01_core_counter_clear_noise_tt.srf"
pn pnoise values=[1M 10M 99.99M] pnoisemethod=fullspectrum noisetype=sampled measurement=[edge] sampleratio=246 maxsideband=4095
edge jitterevent trigger=[out] triggerthresh=0.6 triggernum=1 triggerdir=rise target=[out] jittercal=[Jee]

// Highest warm-state drift nodes and every physical branch-current state.
save XP.VFIX_acquired:p XP.VFIX_d1:p XP.VFIX_d2:p XP.VFIX_d5:p XP.VFIX_en:p XP.VFIX_s0:p XP.XCOUNT.XF0.XF.XS.XN.x XP.XCOUNT.XF1.XF.XS.XN.x XP.XCOUNT.XF2.XF.XS.XN.x XP.XCOUNT.XF3.XF.XS.XN.x
save XP.XCOUNT.XF4.XF.XS.XN.x XP.XCOUNT.XF5.XF.XS.XN.x XP.XD.XD6.clkb XP.XDAC.b0 XP.XDAC.b3 XP.XDAC.b4 XP.XDAC.vd XP.XR.ob XP.XV.XL.XN.LW:1 XP.XV.XL.XP.LW:1
save XP.XV.XL.nb XP.XV.XL.nfilt XP.XV.XL.tail XP.rt_vdd XP.rx_vdd XP.vco_vdd

// Observe every reset stack; initialization is not accepted PSS.
save XP.XCOUNT.XF0.XF.XM.XN.x XP.XCOUNT.XF1.XF.XM.XN.x XP.XCOUNT.XF2.XF.XM.XN.x XP.XCOUNT.XF3.XF.XM.XN.x XP.XCOUNT.XF4.XF.XM.XN.x XP.XCOUNT.XF5.XF.XM.XN.x XP.XCOUNT.XF6.XF.XM.XN.x XP.XCOUNT.XF6.XF.XS.XN.x XP.XCOUNT.XF7.XF.XM.XN.x XP.XCOUNT.XF7.XF.XS.XN.x XP.XCOUNT.XF8.XF.XM.XN.x XP.XCOUNT.XF8.XF.XS.XN.x XP.XCOUNT.XF9.XF.XM.XN.x XP.XCOUNT.XF9.XF.XS.XN.x XP.XCOUNT.XF10.XF.XM.XN.x XP.XCOUNT.XF10.XF.XS.XN.x XP.XCOUNT.XF11.XF.XM.XN.x XP.XCOUNT.XF11.XF.XS.XN.x XP.XCOUNT.XF12.XF.XM.XN.x XP.XCOUNT.XF12.XF.XS.XN.x XP.XCOUNT.XF13.XF.XM.XN.x XP.XCOUNT.XF13.XF.XS.XN.x
