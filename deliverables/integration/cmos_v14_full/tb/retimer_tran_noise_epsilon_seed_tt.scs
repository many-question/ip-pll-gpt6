simulator lang=spectre
global 0
include "/home/process/tsmc180bcd_gen2_2022/PDK/TSMC180BCD/models/spectre/c018bcd_gen2_v1d6.scs" section=tt
include "/home/process/tsmc180bcd_gen2_2022/PDK/TSMC180BCD/models/spectre/c018bcd_gen2_v1d6.scs" section=stat_noise
simulator lang=spectre insensitive=no
include "cells.scs"
include "rtcomb_v13.scs"
include "rt_noise_scale4_v14.scs"
simulatorOptions options temp=27 reltol=1e-6 vabstol=1e-9 iabstol=1e-15
VDD (vdd 0) vsource dc=1.2
VIN (in 0) vsource type=pulse val0=0 val1=1.2 period=1.016260162601626e-09 width=4.9813008130081302e-10 rise=10p fall=10p delay=30p
// Actual RT4 retimer and output stages; ideal data/RF clock isolate measurement.
VCLK (clk 0) vsource type=pulse val0=0 val1=1.2 period=2.5406504065040649e-10 width=1.1703252032520326e-10 rise=10p fall=10p
XR (in clk out vdd 0) rt_noise_scale4_v14
CL (out 0) capacitor c=10f
saveOptions options save=selected

save out
tran tran stop=1.1u maxstep=0.5p method=traponly errpreset=conservative noisefmax=80G noisescale=1e-6 noisefmin=1M noiseseed=11 savefile="/home/jielu/TSMC180/MP/IP-PLL-GPT6/simulation/cmos_v14_full/rtnoiseinitseed02_retimer_tran_noise_epsilon_seed_tt.srf" savetime=[1.1u] writefinal="__FINAL_STATE__"
