simulator lang=spectre
global 0
include "/home/process/tsmc180bcd_gen2_2022/PDK/TSMC180BCD/models/spectre/c018bcd_gen2_v1d6.scs" section=tt
include "/home/process/tsmc180bcd_gen2_2022/PDK/TSMC180BCD/models/spectre/c018bcd_gen2_v1d6.scs" section=stat_noise
simulator lang=spectre insensitive=no
include "cells.scs"
include "digital_cells_v2.scs"
include "sampler_bias_mid70_v14.scs"
include "cp_gate_probe_v14.scs"
include "cp_timing.scs"
include "validity_physical_v14.scs"
ahdl_include "tank_replay_phase_v14.va"
simulatorOptions options temp=27 reltol=1e-5 vabstol=1e-7 iabstol=1e-13
VDD (vdd 0) vsource dc=1.2
VR (ref 0) vsource type=pulse val0=0 val1=1.2 period=41.6666666666667n width=20.8233333333333n rise=10p fall=10p delay=1n
XRF (vp vn 0) tank_replay_phase_v14 phase_deg=196.74700280983583
XBM (vdd 0 vmid) sampler_bias_mid70_v14
CCP (vp sp) capacitor c=120f
CCN (vn sn) capacitor c=120f
RBP (sp vmid) resistor r=10k
RBN (sn vmid) resistor r=10k
XREF (ref refb vdd 0) tx_reference_buffer
CR (refb 0) capacitor c=60f
// Declared control-logic loading approximation, as in the core diagnostic.
CREFLOAD (refb 0) capacitor c=1.9p
XS (refb sp sn hp hn vdd 0) tx_sampler
XCP (hp hn pulse vdd out vdd 0) cp_gate_probe_v14 bias_r=24000
XT (refb vdd 0 pulse vdd 0) tx_cp_timing
XDET (vp hp hn amp_good phase_good vdd 0) validity_physical_v14
VO (out 0) vsource dc=0.66842892560065903
save ref refb vp vn sp sn hp hn vmid pulse out amp_good phase_good VO:p VDD:p
saveOptions options save=selected
pss pss fund=24M harms=4095 tstab=150n maxstep=1p maxacfreq=252G method=gear2only tstabmethod=gear2only errpreset=conservative maxperiods=30 saveinit=no writefinal="__FINAL_STATE__" writepss="__PERIODIC_STATE__"

// Instrumentation only: resistive currents and charge are distinct from terminal currents.
save XCP.nb XCP.ng XCP.tail XCP.mir XCP.gate XCP.gateb XCP.MT:d XCP.MIP:d XCP.MIN:d XCP.MPO:d XCP.MPD:d XCP.MB:id XCP.MB:ids XCP.MB:gm XCP.MB:vgs XCP.MB:vds XCP.MB:vth XCP.MB:vdsat XCP.MB:region XCP.MB:reversed XCP.MB:qd XCP.MB:qjd XCP.MT:id XCP.MT:ids XCP.MT:gm XCP.MT:vgs XCP.MT:vds XCP.MT:vth XCP.MT:vdsat XCP.MT:region XCP.MT:reversed XCP.MT:qd XCP.MT:qjd XCP.MIP:id XCP.MIP:ids XCP.MIP:gm XCP.MIP:vgs XCP.MIP:vds XCP.MIP:vth XCP.MIP:vdsat XCP.MIP:region XCP.MIP:reversed XCP.MIP:qd XCP.MIP:qjd XCP.MIN:id XCP.MIN:ids XCP.MIN:gm XCP.MIN:vgs XCP.MIN:vds XCP.MIN:vth XCP.MIN:vdsat XCP.MIN:region XCP.MIN:reversed XCP.MIN:qd XCP.MIN:qjd XCP.MPO:id XCP.MPO:ids XCP.MPO:gm XCP.MPO:vgs XCP.MPO:vds XCP.MPO:vth XCP.MPO:vdsat XCP.MPO:region XCP.MPO:reversed XCP.MPO:qd XCP.MPO:qjd XCP.MPD:id XCP.MPD:ids XCP.MPD:gm XCP.MPD:vgs XCP.MPD:vds XCP.MPD:vth XCP.MPD:vdsat XCP.MPD:region XCP.MPD:reversed XCP.MPD:qd XCP.MPD:qjd

// Observation-only terminal and charge balance probe.
save XCP.MIP:s XCP.MIN:s XCP.MT:g XCP.MPD:g XCP.MPO:g XCP.XT.MN:s XCP.XT.MP:s XCP.MOFF:d XCP.MIP:qs XCP.MIP:qg XCP.MIP:qb XCP.MIN:qs XCP.MIN:qg XCP.MIN:qb XCP.MT:qs XCP.MT:qg XCP.MT:qb XCP.MPD:qs XCP.MPD:qg XCP.MPD:qb XCP.MPO:qs XCP.MPO:qg XCP.MPO:qb

save XCP.VTG:p XCP.VOFF:p XCP.VMT:p XCP.ng_tg XCP.ng_off XCP.ng_mt
