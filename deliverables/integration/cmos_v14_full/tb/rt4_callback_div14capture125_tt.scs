// Independent K9/M14 full capture after verified autonomous prefix; frozen callback hardware.
simulator lang=spectre
global 0
include "/home/process/tsmc180bcd_gen2_2022/PDK/TSMC180BCD/models/spectre/c018bcd_gen2_v1d6.scs" section=tt
include "/home/process/tsmc180bcd_gen2_2022/PDK/TSMC180BCD/models/spectre/c018bcd_gen2_v1d6.scs" section=stat_noise
simulator lang=spectre insensitive=no
include "/home/process/tsmc180bcd_gen2_2022/PDK/TSMC180BCD/models/spectre/c018bcd_gen2_v1d6.scs" section=tt_bbmvar
simulator lang=spectre insensitive=no
include "rt4_callback110_after.scs"
simulatorOptions options temp=27 reltol=1e-3 vabstol=1e-6 iabstol=1e-12
VDD (vdd_source 0) vsource dc=1.2
ahdl_include "supply_energy_observer.va"
XE (vdd_source vdd 0 energy_nj power_mw) supply_energy_observer
VR (ref 0) vsource type=pulse val0=0 val1=1.2 period=41.6666666666667n width=20.8233333333333n rise=10p fall=10p delay=1n
VRST (reset 0) vsource type=pwl wave=[0 1.2 200n 1.2 200.01n 0]
VAP (apply 0) vsource type=pwl wave=[0 0 300n 0 300.01n 1.2 500n 1.2 500.01n 0]
VK0 (k0 0) vsource dc=1.2
VK1 (k1 0) vsource dc=0
VK2 (k2 0) vsource dc=0
VK3 (k3 0) vsource dc=1.2
VK4 (k4 0) vsource dc=0
VK5 (k5 0) vsource dc=0
XP (ref reset apply k0 k1 k2 k3 k4 k5 out qualified range_error cfg_ready frequency_good phase_good amp_good vdd 0) pll_capture_rt4_r48_recenter109_v14_pdk110_0
CL (out 0) capacitor c=10f
ahdl_include "lc_loop_observer.va"
XOBS (XP.vp XP.vn XP.refb XP.ctrl out 0 obsphase obscycles obsctrl obsdivcycles) lc_loop_observer
ic XP.vp=1.20001 XP.vn=1.2
tran tran stop=120u maxstep=8p strobeperiod=2n strobeoutput=strobeonly method=traponly errpreset=moderate writefinal="__FINAL_STATE__"
save energy_nj power_mw XP.XC.phase_held
save obsphase obscycles obsctrl obsdivcycles out ref qualified range_error cfg_ready frequency_good phase_good amp_good XP.ctrl XP.vc1 XP.preset XP.en XP.hp XP.hn XP.XV.XL.nb XP.XV.XL.nfilt XP.XV.XL.tail VDD:p XP.VVCO:p XP.VRX:p XP.VRT:p
save XP.count_gate XP.count_reset XP.restart XP.XC.acquired XP.XC.state0 XP.XC.state1 XP.XC.state2 XP.b0 XP.b1 XP.b2 XP.b3 XP.b4 XP.b5 XP.b6 XP.b7 XP.XC.d0 XP.XC.d1 XP.XC.d2 XP.XC.d3 XP.XC.d4 XP.XC.d5 XP.XC.m0 XP.XC.m1 XP.XC.m2 XP.XC.m3 XP.XC.m4 XP.XC.m5 XP.XC.m6 XP.XC.m7 XP.XC.m8 XP.XC.m9 XP.XC.m10 XP.XC.m11 XP.XC.m12 XP.XC.m13
save XP.s0 XP.s1 XP.s2 XP.s3 XP.s4 XP.s5 XP.XC.ak0 XP.XC.ak1 XP.XC.ak2 XP.XC.ak3 XP.XC.ak4 XP.XC.ak5 XP.cfg_invalid XP.divider_reset
saveOptions options save=selected
