simulator lang=spectre
global 0
include "/home/process/tsmc180bcd_gen2_2022/PDK/TSMC180BCD/models/spectre/c018bcd_gen2_v1d6.scs" section=tt
simulator lang=spectre insensitive=no
include "cells.scs"
include "digital_cells_v2.scs"
include "reset_clear_cells_v14.scs"
simulatorOptions options temp=27 reltol=1e-5 vabstol=1e-7 iabstol=1e-13
VDD (vdd 0) vsource dc=1.2
VC (clk 0) vsource type=pulse val0=0 val1=1.2 period=1.016260162601626e-09 width=4.9813008130081302e-10 rise=10p fall=10p delay=3.2n
VD (d 0) vsource type=pulse val0=0 val1=1.2 period=8.1300813008130078e-09 width=4.0550406504065041e-09 rise=10p fall=10p delay=4.7n
VR (reset 0) vsource type=pwl wave=[0 1.2 3n 1.2 3.01n 0 17.3n 0 17.31n 1.2 20.2n 1.2 20.21n 0 31.4n 0 31.41n 1.2 40n 1.2]
XOLD (d clk reset qo vdd 0) tx_dff_r0
XNEW (d clk reset qn vdd 0) dff_reset_clear_v14
CO (qo 0) capacitor c=2f
CN (qn 0) capacitor c=2f
ic XOLD.XM.XN.x=29.5m XOLD.XS.XN.x=29.5m XNEW.XM.XN.x=29.5m XNEW.XS.XN.x=29.5m
save clk d reset qo qn XOLD.XM.XN.x XOLD.XS.XN.x XNEW.XM.XN.x XNEW.XS.XN.x VDD:p
saveOptions options save=selected
tran tran stop=40n maxstep=1p method=traponly errpreset=conservative
