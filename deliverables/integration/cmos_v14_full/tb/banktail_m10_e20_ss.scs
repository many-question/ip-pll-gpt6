simulator lang=spectre
global 0
include "/home/process/tsmc180bcd_gen2_2022/PDK/TSMC180BCD/models/spectre/c018bcd_gen2_v1d6.scs" section=ss
include "/home/process/tsmc180bcd_gen2_2022/PDK/TSMC180BCD/models/spectre/c018bcd_gen2_v1d6.scs" section=stat_noise
simulator lang=spectre insensitive=no
include "cells.scs"
include "digital_cells_v2.scs"
include "bank_tail_window_v14.scs"
include "rtcomb_v13.scs"
include "rt_light24s12_out083_v14.scs"
simulatorOptions options temp=60 reltol=1e-5 vabstol=1e-7 iabstol=1e-13
VDD (vdd 0) vsource dc=1.2
VCLK (clk 0) vsource type=pulse val0=0 val1=1.2 period=3.205128205128205e-10 width=1.402564102564102e-10 rise=20p fall=20p
VRST (reset 0) vsource type=pwl wave=[0 1.2 8n 1.2 8.01n 0]
VS0 (s0 0) vsource dc=0
VS1 (s1 0) vsource dc=0
VS2 (s2 0) vsource dc=0
VS3 (s3 0) vsource dc=1.2
VS4 (s4 0) vsource dc=0
VS5 (s5 0) vsource dc=0
XD (clk reset s0 s1 s2 s3 s4 s5 q1 predata acqclk ck vdd 0) bank_tail_window_v14
XR (predata clk data vdd 0) rt_light24s12_out083_v14
CL (data 0) capacitor c=10f
tran tran stop=60n maxstep=1p method=traponly errpreset=conservative
saveOptions options save=selected
VCK (ck 0) vsource type=pulse val0=0 val1=1.2 period=6.4102564102564102e-10 rise=1.9999999999999999e-11 fall=1.9999999999999999e-11 width=3.0051282051282052e-10
save clk q1 ck predata data reset VDD:p XD.load XD.r0 XD.r1 XD.r2 XD.r3 XD.r4 XD.r5 XD.r6 XD.d6 XD.XD6.clkb XD.XD6.q0 XD.XD6.q1
save XD.XF4.XF.qb XD.XF4.XF.XF.a XD.XF4.XF.XF.b XD.XF0.din XD.XF5.din
