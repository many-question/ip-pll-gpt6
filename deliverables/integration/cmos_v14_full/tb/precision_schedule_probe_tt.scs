simulator lang=spectre
global 0
include "/home/process/tsmc180bcd_gen2_2022/PDK/TSMC180BCD/models/spectre/c018bcd_gen2_v1d6.scs" section=tt
include "/home/process/tsmc180bcd_gen2_2022/PDK/TSMC180BCD/models/spectre/c018bcd_gen2_v1d6.scs" section=stat_noise
simulator lang=spectre insensitive=no
include "/home/process/tsmc180bcd_gen2_2022/PDK/TSMC180BCD/models/spectre/c018bcd_gen2_v1d6.scs" section=tt_bbmvar
simulator lang=spectre insensitive=no
include "cells.scs"
simulatorOptions options temp=27 reltol=1e-4 vabstol=1e-6 iabstol=1e-12
VDD (vdd 0) vsource dc=1.2
VI (inp 0) vsource type=pulse val0=0 val1=1.2 period=1n width=480p rise=20p fall=20p delay=100p
XI (inp out vdd 0) pll_inv
CL (out 0) capacitor c=10f
precision_steps paramset {
time maxstep reltol vabstol iabstol isnoisy
0 4p 1e-4 1e-6 1e-12 0
2n 2p 1e-5 1e-7 1e-12 0
4n .5p 1e-6 1e-9 1e-12 0
6n .5p 1e-6 1e-9 1e-12 1
}
tran tran stop=8n maxstep=4p method=traponly errpreset=moderate noisefmax=160G noisefmin=1M noiseseed=11 paramset=precision_steps
saveOptions options save=selected
save inp out VDD:p
