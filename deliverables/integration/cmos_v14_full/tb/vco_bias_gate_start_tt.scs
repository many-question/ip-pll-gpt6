simulator lang=spectre
global 0
include "/home/process/tsmc180bcd_gen2_2022/PDK/TSMC180BCD/models/spectre/c018bcd_gen2_v1d6.scs" section=tt
simulator lang=spectre insensitive=no
include "vco_bias_gate_start_v14.scs"
simulatorOptions options temp=27 reltol=1e-5 vabstol=1e-7 iabstol=1e-13
VDD (vdd 0) vsource dc=0 type=pwl wave=[0 0 100n 0 110n 1.2]
VT (tail 0) vsource dc=0 type=pwl wave=[0 0 100n 0 110n 0.6378933201848205]
X10 (tail 0 vdd 0 0 0 vdd 0) vco_bias_gate_start_v14 filter_c=10p
X40 (tail 0 vdd 0 0 0 vdd 0) vco_bias_gate_start_v14 filter_c=40p
tran tran stop=400u maxstep=50n method=traponly errpreset=conservative writefinal="__FINAL_STATE__"
save vdd tail X10.nb X10.nfilt X40.nb X40.nfilt X10.MT:d X40.MT:d
saveOptions options save=selected
