simulator lang=spectre
global 0
include "/home/process/tsmc180bcd_gen2_2022/PDK/TSMC180BCD/models/spectre/c018bcd_gen2_v1d6.scs" section=tt
simulator lang=spectre insensitive=no
include "cells.scs"
include "digital_cells_v2.scs"
include "fll_circuit.scs"
include "fll_counter_reset_clear_v14.scs"
simulatorOptions options temp=27 reltol=1e-4 vabstol=1e-6 iabstol=1e-12
VDD (vdd 0) vsource dc=1.2
VC (clk 0) vsource type=pulse val0=0 val1=1.2 period=1.016260162601626e-09 width=4.9813008130081302e-10 rise=10p fall=10p delay=1.016260162601626e-10
VG (gate 0) vsource type=pwl wave=[0 0 2.1138211382113822e-08 0 2.1148211382113824e-08 1.2 2.2154471544715446e-08 1.2 2.2164471544715447e-08 0 3.4349593495934958e-08 0 3.4359593495934956e-08 1.2 3.5365853658536581e-08 1.2 3.5375853658536579e-08 0 4.7560975609756096e-08 0 4.7570975609756094e-08 1.2 4.857723577235772e-08 1.2 4.8587235772357718e-08 0 6.0772357723577228e-08 0 6.0782357723577226e-08 1.2 6.1788617886178851e-08 1.2 6.179861788617885e-08 0 7.3983739837398373e-08 0 7.3993739837398371e-08 1.2 7.7032520325203244e-08 1.2 7.7042520325203242e-08 0 8.9227642276422752e-08 0 8.923764227642275e-08 1.2 9.0243902439024389e-08 1.2 9.0253902439024387e-08 0 1.024390243902439e-07 0 1.024490243902439e-07 1.2 1.0955284552845527e-07 1.2 1.0956284552845527e-07 0 1.2174796747967478e-07 0 1.2175796747967479e-07 1.2 1.2276422764227642e-07 1.2 1.2277422764227643e-07 0 1.3495934959349593e-07 0 1.3496934959349594e-07 1.2 1.5020325203252032e-07 1.2 1.5021325203252033e-07 0 1.6239837398373986e-07 0 1.6240837398373987e-07 1.2 1.6341463414634147e-07 1.2 1.6342463414634148e-07 0 1.7560975609756097e-07 0 1.7561975609756099e-07 1.2 2.071138211382114e-07 1.2 2.0712382113821141e-07 0 2.193089430894309e-07 0 2.1931894308943091e-07 1.2 2.2032520325203251e-07 1.2 2.2033520325203253e-07 0 2.3252032520325202e-07 0 2.3253032520325203e-07 1.2 2.9654471544715445e-07 1.2 2.9655471544715446e-07 0 3.0873983739837398e-07 0 3.0874983739837399e-07 1.2 3.0975609756097559e-07 1.2 3.097660975609756e-07 0 3.2195121951219513e-07 0 3.2196121951219514e-07 1.2 4.5101626016260154e-07 1.2 4.5102626016260155e-07 0 4.6321138211382112e-07 0 4.6322138211382114e-07 1.2 4.6422764227642268e-07 1.2 4.6423764227642269e-07 0 4.7642276422764227e-07 0 4.7643276422764228e-07 1.2 7.3556910569105686e-07 1.2 7.3557910569105682e-07 0 7.4776422764227639e-07 0 7.4777422764227635e-07 1.2 7.48780487804878e-07 1.2 7.4879048780487796e-07 0 7.6097560975609754e-07 0 7.609856097560975e-07 1.2 1.2802845528455283e-06 1.2 1.2802945528455284e-06 0 1.2924796747967479e-06 0 1.2924896747967479e-06 1.2 1.2934959349593498e-06 1.2 1.2935059349593498e-06 0 1.3056910569105691e-06 0 1.3057010569105692e-06 1.2 2.3453252032520328e-06 1.2 2.3453352032520327e-06 0 2.3575203252032521e-06 0 2.357530325203252e-06 1.2 2.3585365853658539e-06 1.2 2.3585465853658537e-06 0 2.3707317073170732e-06 0 2.370741707317073e-06 1.2 4.4510162601626019e-06 1.2 4.4510262601626017e-06 0 4.4632113821138208e-06 0 4.4632213821138206e-06 1.2 4.4642276422764221e-06 1.2 4.4642376422764219e-06 0 4.4764227642276427e-06 0 4.4764327642276425e-06 1.2 8.6380081300813005e-06 1.2 8.6380181300813012e-06 0 8.6502032520325194e-06 0 8.6502132520325201e-06 1.2 8.6512195121951207e-06 1.2 8.6512295121951214e-06 0 8.6634146341463396e-06 0 8.6634246341463403e-06 1.2 1.698760162601626e-05 1.2 1.6987611626016261e-05 0 1.6999796747967479e-05 0 1.699980674796748e-05 1.2 1.7000813008130084e-05 1.2 1.7000823008130084e-05 0 1.7013008130081299e-05 0 1.70130181300813e-05 1.2 1.7018089430894312e-05 1.2 1.7018099430894313e-05 0]
VR (reset 0) vsource type=pwl wave=[0 1.2 1.016260162601626e-08 1.2 1.017260162601626e-08 0 1.703231707317073e-05 0 1.7032327073170731e-05 1.2 1.7050609756097561e-05 1.2]
XO (clk gate reset o0 o1 o2 o3 o4 o5 o6 o7 o8 o9 o10 o11 o12 o13 vdd 0) tx_fll_counter
XN (clk gate reset n0 n1 n2 n3 n4 n5 n6 n7 n8 n9 n10 n11 n12 n13 vdd 0) fll_counter_reset_clear_v14
Co0 (o0 0) capacitor c=2f
Co1 (o1 0) capacitor c=2f
Co2 (o2 0) capacitor c=2f
Co3 (o3 0) capacitor c=2f
Co4 (o4 0) capacitor c=2f
Co5 (o5 0) capacitor c=2f
Co6 (o6 0) capacitor c=2f
Co7 (o7 0) capacitor c=2f
Co8 (o8 0) capacitor c=2f
Co9 (o9 0) capacitor c=2f
Co10 (o10 0) capacitor c=2f
Co11 (o11 0) capacitor c=2f
Co12 (o12 0) capacitor c=2f
Co13 (o13 0) capacitor c=2f
Cn0 (n0 0) capacitor c=2f
Cn1 (n1 0) capacitor c=2f
Cn2 (n2 0) capacitor c=2f
Cn3 (n3 0) capacitor c=2f
Cn4 (n4 0) capacitor c=2f
Cn5 (n5 0) capacitor c=2f
Cn6 (n6 0) capacitor c=2f
Cn7 (n7 0) capacitor c=2f
Cn8 (n8 0) capacitor c=2f
Cn9 (n9 0) capacitor c=2f
Cn10 (n10 0) capacitor c=2f
Cn11 (n11 0) capacitor c=2f
Cn12 (n12 0) capacitor c=2f
Cn13 (n13 0) capacitor c=2f
ic XO.XF0.XF.XM.XN.x=29.5m XO.XF0.XF.XS.XN.x=29.5m XO.XF1.XF.XM.XN.x=29.5m XO.XF1.XF.XS.XN.x=29.5m XO.XF2.XF.XM.XN.x=29.5m XO.XF2.XF.XS.XN.x=29.5m XO.XF3.XF.XM.XN.x=29.5m XO.XF3.XF.XS.XN.x=29.5m XO.XF4.XF.XM.XN.x=29.5m XO.XF4.XF.XS.XN.x=29.5m XO.XF5.XF.XM.XN.x=29.5m XO.XF5.XF.XS.XN.x=29.5m XO.XF6.XF.XM.XN.x=29.5m XO.XF6.XF.XS.XN.x=29.5m XO.XF7.XF.XM.XN.x=29.5m XO.XF7.XF.XS.XN.x=29.5m XO.XF8.XF.XM.XN.x=29.5m XO.XF8.XF.XS.XN.x=29.5m XO.XF9.XF.XM.XN.x=29.5m XO.XF9.XF.XS.XN.x=29.5m XO.XF10.XF.XM.XN.x=29.5m XO.XF10.XF.XS.XN.x=29.5m XO.XF11.XF.XM.XN.x=29.5m XO.XF11.XF.XS.XN.x=29.5m XO.XF12.XF.XM.XN.x=29.5m XO.XF12.XF.XS.XN.x=29.5m XO.XF13.XF.XM.XN.x=29.5m XO.XF13.XF.XS.XN.x=29.5m XN.XF0.XF.XM.XN.x=29.5m XN.XF0.XF.XS.XN.x=29.5m XN.XF1.XF.XM.XN.x=29.5m XN.XF1.XF.XS.XN.x=29.5m XN.XF2.XF.XM.XN.x=29.5m XN.XF2.XF.XS.XN.x=29.5m XN.XF3.XF.XM.XN.x=29.5m XN.XF3.XF.XS.XN.x=29.5m XN.XF4.XF.XM.XN.x=29.5m XN.XF4.XF.XS.XN.x=29.5m XN.XF5.XF.XM.XN.x=29.5m XN.XF5.XF.XS.XN.x=29.5m XN.XF6.XF.XM.XN.x=29.5m XN.XF6.XF.XS.XN.x=29.5m XN.XF7.XF.XM.XN.x=29.5m XN.XF7.XF.XS.XN.x=29.5m XN.XF8.XF.XM.XN.x=29.5m XN.XF8.XF.XS.XN.x=29.5m XN.XF9.XF.XM.XN.x=29.5m XN.XF9.XF.XS.XN.x=29.5m XN.XF10.XF.XM.XN.x=29.5m XN.XF10.XF.XS.XN.x=29.5m XN.XF11.XF.XM.XN.x=29.5m XN.XF11.XF.XS.XN.x=29.5m XN.XF12.XF.XM.XN.x=29.5m XN.XF12.XF.XS.XN.x=29.5m XN.XF13.XF.XM.XN.x=29.5m XN.XF13.XF.XS.XN.x=29.5m
save clk gate reset o0 o1 o2 o3 o4 o5 o6 o7 o8 o9 o10 o11 o12 o13 n0 n1 n2 n3 n4 n5 n6 n7 n8 n9 n10 n11 n12 n13 XO.XF0.XF.XM.XN.x XO.XF0.XF.XS.XN.x XO.XF1.XF.XM.XN.x XO.XF1.XF.XS.XN.x XO.XF2.XF.XM.XN.x XO.XF2.XF.XS.XN.x XO.XF3.XF.XM.XN.x XO.XF3.XF.XS.XN.x XO.XF4.XF.XM.XN.x XO.XF4.XF.XS.XN.x XO.XF5.XF.XM.XN.x XO.XF5.XF.XS.XN.x XO.XF6.XF.XM.XN.x XO.XF6.XF.XS.XN.x XO.XF7.XF.XM.XN.x XO.XF7.XF.XS.XN.x XO.XF8.XF.XM.XN.x XO.XF8.XF.XS.XN.x XO.XF9.XF.XM.XN.x XO.XF9.XF.XS.XN.x XO.XF10.XF.XM.XN.x XO.XF10.XF.XS.XN.x XO.XF11.XF.XM.XN.x XO.XF11.XF.XS.XN.x XO.XF12.XF.XM.XN.x XO.XF12.XF.XS.XN.x XO.XF13.XF.XM.XN.x XO.XF13.XF.XS.XN.x XN.XF0.XF.XM.XN.x XN.XF0.XF.XS.XN.x XN.XF1.XF.XM.XN.x XN.XF1.XF.XS.XN.x XN.XF2.XF.XM.XN.x XN.XF2.XF.XS.XN.x XN.XF3.XF.XM.XN.x XN.XF3.XF.XS.XN.x XN.XF4.XF.XM.XN.x XN.XF4.XF.XS.XN.x XN.XF5.XF.XM.XN.x XN.XF5.XF.XS.XN.x XN.XF6.XF.XM.XN.x XN.XF6.XF.XS.XN.x XN.XF7.XF.XM.XN.x XN.XF7.XF.XS.XN.x XN.XF8.XF.XM.XN.x XN.XF8.XF.XS.XN.x XN.XF9.XF.XM.XN.x XN.XF9.XF.XS.XN.x XN.XF10.XF.XM.XN.x XN.XF10.XF.XS.XN.x XN.XF11.XF.XM.XN.x XN.XF11.XF.XS.XN.x XN.XF12.XF.XM.XN.x XN.XF12.XF.XS.XN.x XN.XF13.XF.XM.XN.x XN.XF13.XF.XS.XN.x VDD:p
saveOptions options save=selected
tran tran stop=1.7050609756097561e-05 maxstep=10p method=traponly errpreset=conservative strobeperiod=2n strobeoutput=strobeonly
