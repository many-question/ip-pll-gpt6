simulator lang=spectre
global 0
include "/home/process/tsmc180bcd_gen2_2022/PDK/TSMC180BCD/models/spectre/c018bcd_gen2_v1d6.scs" section=ss
include "/home/process/tsmc180bcd_gen2_2022/PDK/TSMC180BCD/models/spectre/c018bcd_gen2_v1d6.scs" section=stat_noise
simulator lang=spectre insensitive=no
include "cells.scs"
include "digital_cells_v2.scs"
simulatorOptions options temp=60 reltol=1e-4 vabstol=1e-6 iabstol=1e-12
VDD (vdd 0) vsource dc=1.2
VREF (refclk 0) vsource type=pulse val0=0 val1=1.2 delay=10n rise=50p fall=50p width=20.7833333333333n period=41.6666666666667n
VRST (reset 0) vsource type=pwl wave=[0 1.2 100n 1.2 100.05n 0]
include "fll_best128_v14.scs"
VK0 (k0 0) vsource dc=1.2
VK1 (k1 0) vsource dc=0
VK2 (k2 0) vsource dc=0
VK3 (k3 0) vsource dc=1.2
VK4 (k4 0) vsource dc=0
VK5 (k5 0) vsource dc=1.2
VM0 (m0 0) vsource type=pwl wave=[0 0 5.308333333333334e-07 0 5.308833333333334e-07 1.2 6.141666666666667e-07 1.2 6.142166666666667e-07 0 7.391666666666666e-07 0 7.392166666666667e-07 1.2 8.225000000000001e-07 1.2 8.225500000000001e-07 0 9.475e-07 0 9.4755e-07 1.2 1.030833333333333e-06 1.2 1.030883333333333e-06 0 1.114166666666667e-06 0 1.114216666666667e-06 1.2 1.239166666666667e-06 1.2 1.239216666666667e-06 0 1.3225e-06 0 1.32255e-06 1.2 1.4475e-06 1.2 1.44755e-06 0 1.530833333333334e-06 0 1.530883333333334e-06 1.2 1.655833333333334e-06 1.2 1.655883333333333e-06 0 1.739166666666667e-06 0 1.739216666666667e-06 1.2 1.9475e-06 1.2 1.94755e-06 0 2.364166666666667e-06 0 2.364216666666667e-06 1.2 2.4475e-06 1.2 2.44755e-06 0 2.5725e-06 0 2.57255e-06 1.2 2.655833333333333e-06 1.2 2.655883333333333e-06 0 2.780833333333333e-06 0 2.780883333333333e-06 1.2 2.905833333333333e-06 1.2 2.905883333333333e-06 0 2.989166666666667e-06 0 2.989216666666667e-06 1.2 3.114166666666667e-06 1.2 3.114216666666667e-06 0 3.1975e-06 0 3.19755e-06 1.2 3.3225e-06 1.2 3.32255e-06 0 3.4475e-06 0 3.44755e-06 1.2 3.530833333333333e-06 1.2 3.530883333333333e-06 0 6.030833333333334e-06 0 6.030883333333334e-06 1.2 6.239166666666668e-06 1.2 6.239216666666668e-06 0 6.447500000000001e-06 0 6.447550000000001e-06 1.2 6.614166666666668e-06 1.2 6.614216666666668e-06 0 6.8225e-06 0 6.82255e-06 1.2 7.030833333333335e-06 1.2 7.030883333333335e-06 0 7.1975e-06 0 7.19755e-06 1.2 7.4475e-06 1.2 7.44755e-06 0 7.864166666666667e-06 0 7.864216666666667e-06 1.2 7.905833333333335e-06 1.2 7.905883333333335e-06 0 7.989166666666668e-06 0 7.989216666666668e-06 1.2 8.030833333333335e-06 1.2 8.030883333333335e-06 0 8.114166666666668e-06 0 8.114216666666668e-06 1.2 8.155833333333334e-06 1.2 8.155883333333334e-06 0 8.239166666666667e-06 0 8.239216666666667e-06 1.2 8.280833333333334e-06 1.2 8.280883333333334e-06 0 8.364166666666667e-06 0 8.364216666666667e-06 1.2 8.405833333333333e-06 1.2 8.405883333333334e-06 0 8.489166666666667e-06 0 8.489216666666667e-06 1.2 8.530833333333333e-06 1.2 8.530883333333333e-06 0 8.572500000000001e-06 0 8.572550000000001e-06 1.2 8.655833333333333e-06 1.2 8.655883333333333e-06 0 8.697500000000001e-06 0 8.697550000000001e-06 1.2 8.780833333333332e-06 1.2 8.780883333333333e-06 0 8.822500000000001e-06 0 8.822550000000001e-06 1.2 8.905833333333332e-06 1.2 8.905883333333332e-06 0 8.9475e-06 0 8.94755e-06 1.2 9.030833333333333e-06 1.2 9.030883333333334e-06 0 9.0725e-06 0 9.07255e-06 1.2 9.280833333333333e-06 1.2 9.280883333333333e-06 0 9.655833333333333e-06 0 9.655883333333333e-06 1.2 9.6975e-06 1.2 9.69755e-06 0 9.739166666666666e-06 0 9.739216666666667e-06 1.2 9.780833333333333e-06 1.2 9.780883333333333e-06 0 9.822500000000001e-06 0 9.822550000000001e-06 1.2 9.905833333333333e-06 1.2 9.905883333333333e-06 0 9.947500000000001e-06 0 9.947550000000001e-06 1.2 9.989166666666667e-06 1.2 9.989216666666668e-06 0 1.003083333333333e-05 0 1.003088333333333e-05 1.2 1.00725e-05 1.2 1.007255e-05 0 1.011416666666667e-05 0 1.011421666666667e-05 1.2 1.015583333333333e-05 1.2 1.015588333333333e-05 0 1.023916666666667e-05 0 1.023921666666667e-05 1.2 1.028083333333333e-05 1.2 1.028088333333333e-05 0 1.03225e-05 0 1.032255e-05 1.2 1.036416666666667e-05 1.2 1.036421666666667e-05 0 1.040583333333333e-05 0 1.040588333333333e-05 1.2 1.04475e-05 1.2 1.044755e-05 0 1.053083333333333e-05 0 1.053088333333333e-05 1.2 1.05725e-05 1.2 1.057255e-05 0 1.061416666666667e-05 0 1.061421666666667e-05 1.2 1.065583333333333e-05 1.2 1.065588333333333e-05 0 1.06975e-05 0 1.069755e-05 1.2 1.073916666666667e-05 1.2 1.073921666666667e-05 0 1.078083333333333e-05 0 1.078088333333333e-05 1.2 1.086416666666667e-05 1.2 1.086421666666667e-05 0 1.090583333333333e-05 0 1.090588333333333e-05 1.2 1.09475e-05 1.2 1.094755e-05 0 1.148916666666667e-05 0 1.148921666666667e-05 1.2 1.15725e-05 1.2 1.157255e-05 0 1.161416666666667e-05 0 1.161421666666667e-05 1.2 1.165583333333333e-05 1.2 1.165588333333333e-05 0 1.16975e-05 0 1.169755e-05 1.2 1.173916666666667e-05 1.2 1.173921666666667e-05 0 1.178083333333333e-05 0 1.178088333333333e-05 1.2 1.18225e-05 1.2 1.182255e-05 0 1.186416666666667e-05 0 1.186421666666667e-05 1.2 1.190583333333333e-05 1.2 1.190588333333333e-05 0 1.19475e-05 0 1.194755e-05 1.2 1.203083333333333e-05 1.2 1.203088333333333e-05 0 1.20725e-05 0 1.207255e-05 1.2 1.211416666666667e-05 1.2 1.211421666666667e-05 0 1.215583333333333e-05 0 1.215588333333333e-05 1.2 1.21975e-05 1.2 1.219755e-05 0 1.223916666666667e-05 0 1.223921666666667e-05 1.2 1.228083333333333e-05 1.2 1.228088333333333e-05 0 1.23225e-05 0 1.232255e-05 1.2 1.236416666666667e-05 1.2 1.236421666666667e-05 0 1.240583333333333e-05 0 1.240588333333333e-05 1.2 1.248916666666667e-05 1.2 1.248921666666667e-05 0 1.253083333333333e-05 0 1.253088333333333e-05 1.2 1.25725e-05 1.2 1.257255e-05 0 1.261416666666667e-05 0 1.261421666666667e-05 1.2 1.265583333333333e-05 1.2 1.265588333333333e-05 0 1.26975e-05 0 1.269755e-05 1.2 1.273916666666667e-05 1.2 1.273921666666667e-05 0 1.278083333333333e-05 0 1.278088333333333e-05 1.2 1.29475e-05 1.2 1.294755e-05 0 1.33225e-05 0 1.332255e-05 1.2 1.336416666666667e-05 1.2 1.336421666666667e-05 0 1.340583333333333e-05 0 1.340588333333333e-05 1.2 1.34475e-05 1.2 1.344755e-05 0 1.348916666666667e-05 0 1.348921666666667e-05 1.2 1.353083333333333e-05 1.2 1.353088333333333e-05 0 1.35725e-05 0 1.357255e-05 1.2 1.361416666666667e-05 1.2 1.361421666666667e-05 0 1.365583333333333e-05 0 1.365588333333333e-05 1.2 1.36975e-05 1.2 1.369755e-05 0 1.373916666666667e-05 0 1.373921666666667e-05 1.2 1.378083333333333e-05 1.2 1.378088333333333e-05 0 1.38225e-05 0 1.382255e-05 1.2 1.386416666666667e-05 1.2 1.386421666666667e-05 0 1.390583333333333e-05 0 1.390588333333333e-05 1.2 1.39475e-05 1.2 1.394755e-05 0 1.398916666666667e-05 0 1.398921666666667e-05 1.2 1.403083333333333e-05 1.2 1.403088333333333e-05 0 1.40725e-05 0 1.407255e-05 1.2 1.411416666666667e-05 1.2 1.411421666666667e-05 0 1.415583333333333e-05 0 1.415588333333333e-05 1.2 1.41975e-05 1.2 1.419755e-05 0 1.423916666666667e-05 0 1.423921666666667e-05 1.2 1.428083333333333e-05 1.2 1.428088333333333e-05 0 1.43225e-05 0 1.432255e-05 1.2 1.436416666666667e-05 1.2 1.436421666666667e-05 0 1.440583333333333e-05 0 1.440588333333333e-05 1.2 1.44475e-05 1.2 1.444755e-05 0 1.448916666666667e-05 0 1.448921666666667e-05 1.2 1.453083333333333e-05 1.2 1.453088333333333e-05 0 1.45725e-05 0 1.457255e-05 1.2 1.461416666666667e-05 1.2 1.461421666666667e-05 0 1.515583333333333e-05 0 1.515588333333333e-05 1.2 1.51975e-05 1.2 1.519755e-05 0 1.523916666666667e-05 0 1.523921666666667e-05 1.2 1.528083333333333e-05 1.2 1.528088333333333e-05 0 1.536416666666667e-05 0 1.536421666666667e-05 1.2 1.540583333333333e-05 1.2 1.540588333333333e-05 0 1.54475e-05 0 1.544755e-05 1.2 1.548916666666667e-05 1.2 1.548921666666667e-05 0 1.553083333333333e-05 0 1.553088333333333e-05 1.2 1.55725e-05 1.2 1.557255e-05 0 1.561416666666667e-05 0 1.561421666666667e-05 1.2 1.565583333333333e-05 1.2 1.565588333333333e-05 0 1.56975e-05 0 1.569755e-05 1.2 1.573916666666667e-05 1.2 1.573921666666667e-05 0 1.578083333333333e-05 0 1.578088333333333e-05 1.2 1.58225e-05 1.2 1.582255e-05 0 1.590583333333333e-05 0 1.590588333333333e-05 1.2 1.59475e-05 1.2 1.594755e-05 0 1.598916666666667e-05 0 1.598921666666667e-05 1.2 1.603083333333333e-05 1.2 1.603088333333333e-05 0 1.60725e-05 0 1.607255e-05 1.2 1.611416666666667e-05 1.2 1.611421666666667e-05 0 1.615583333333333e-05 0 1.615588333333333e-05 1.2 1.61975e-05 1.2 1.619755e-05 0 1.623916666666667e-05 0 1.623921666666667e-05 1.2 1.628083333333333e-05 1.2 1.628088333333333e-05 0 1.63225e-05 0 1.632255e-05 1.2 1.636416666666667e-05 1.2 1.636421666666667e-05 0 1.64475e-05 0 1.644755e-05 1.2 1.661416666666667e-05 1.2 1.661421666666667e-05 0 1.698916666666667e-05 0 1.698921666666667e-05 1.2 1.703083333333334e-05 1.2 1.703088333333334e-05 0 1.70725e-05 0 1.707255e-05 1.2 1.711416666666667e-05 1.2 1.711421666666667e-05 0 1.71975e-05 0 1.719755e-05 1.2 1.723916666666667e-05 1.2 1.723921666666667e-05 0 1.728083333333334e-05 0 1.728088333333334e-05 1.2 1.73225e-05 1.2 1.732255e-05 0 1.736416666666667e-05 0 1.736421666666667e-05 1.2 1.740583333333334e-05 1.2 1.740588333333334e-05 0 1.74475e-05 0 1.744755e-05 1.2 1.748916666666667e-05 1.2 1.748921666666667e-05 0 1.753083333333334e-05 0 1.753088333333334e-05 1.2 1.75725e-05 1.2 1.757255e-05 0 1.761416666666667e-05 0 1.761421666666667e-05 1.2 1.765583333333334e-05 1.2 1.765588333333334e-05 0 1.76975e-05 0 1.769755e-05 1.2 1.773916666666667e-05 1.2 1.773921666666667e-05 0 1.778083333333334e-05 0 1.778088333333334e-05 1.2 1.78225e-05 1.2 1.782255e-05 0 1.786416666666667e-05 0 1.786421666666667e-05 1.2 1.790583333333334e-05 1.2 1.790588333333334e-05 0 1.79475e-05 0 1.794755e-05 1.2 1.798916666666667e-05 1.2 1.798921666666667e-05 0 1.80725e-05 0 1.807255e-05 1.2 1.811416666666667e-05 1.2 1.811421666666667e-05 0 1.815583333333334e-05 0 1.815588333333334e-05 1.2 1.81975e-05 1.2 1.819755e-05 0 1.823916666666667e-05 0 1.823921666666667e-05 1.2 1.828083333333334e-05 1.2 1.828088333333334e-05 0 1.83225e-05 0 1.832255e-05 1.2 1.836416666666667e-05 1.2 1.836421666666667e-05 0 1.840583333333334e-05 0 1.840588333333334e-05 1.2 1.84475e-05 1.2 1.844755e-05 0 1.848916666666667e-05 0 1.848921666666667e-05 1.2 1.853083333333334e-05 1.2 1.853088333333334e-05 0 1.85725e-05 0 1.857255e-05 1.2 1.861416666666667e-05 1.2 1.861421666666667e-05 0 1.865583333333334e-05 0 1.865588333333334e-05 1.2 1.86975e-05 1.2 1.869755e-05 0 1.873916666666667e-05 0 1.873921666666667e-05 1.2 1.878083333333334e-05 1.2 1.878088333333334e-05 0 1.88225e-05 0 1.882255e-05 1.2 1.890583333333334e-05 1.2 1.890588333333334e-05 0 1.89475e-05 0 1.894755e-05 1.2 1.898916666666667e-05 1.2 1.898921666666667e-05 0 1.903083333333334e-05 0 1.903088333333334e-05 1.2 1.90725e-05 1.2 1.907255e-05 0 1.911416666666667e-05 0 1.911421666666667e-05 1.2 1.915583333333334e-05 1.2 1.915588333333334e-05 0 1.91975e-05 0 1.919755e-05 1.2 1.923916666666667e-05 1.2 1.923921666666667e-05 0 1.928083333333334e-05 0 1.928088333333334e-05 1.2 1.93225e-05 1.2 1.932255e-05 0 1.936416666666667e-05 0 1.936421666666667e-05 1.2 1.940583333333334e-05 1.2 1.940588333333334e-05 0 1.94475e-05 0 1.944755e-05 1.2 1.948916666666667e-05 1.2 1.948921666666667e-05 0 1.953083333333334e-05 0 1.953088333333334e-05 1.2 1.95725e-05 1.2 1.957255e-05 0 1.961416666666667e-05 0 1.961421666666667e-05 1.2 1.965583333333334e-05 1.2 1.965588333333334e-05 0 1.96975e-05 0 1.969755e-05 1.2 1.978083333333334e-05 1.2 1.978088333333334e-05 0 1.98225e-05 0 1.982255e-05 1.2 1.986416666666667e-05 1.2 1.986421666666667e-05 0 1.990583333333334e-05 0 1.990588333333334e-05 1.2 1.99475e-05 1.2 1.994755e-05 0 1.998916666666667e-05 0 1.998921666666667e-05 1.2 2.003083333333334e-05 1.2 2.003088333333334e-05 0 2.00725e-05 0 2.007255e-05 1.2 2.011416666666667e-05 1.2 2.011421666666667e-05 0 2.015583333333334e-05 0 2.015588333333334e-05 1.2 2.01975e-05 1.2 2.019755e-05 0 2.023916666666667e-05 0 2.023921666666667e-05 1.2 2.028083333333334e-05 1.2 2.028088333333334e-05 0 2.03225e-05 0 2.032255e-05 1.2 2.036416666666667e-05 1.2 2.036421666666667e-05 0 2.040583333333334e-05 0 2.040588333333334e-05 1.2 2.04475e-05 1.2 2.044755e-05 0 2.048916666666667e-05 0 2.048921666666667e-05 1.2 2.053083333333334e-05 1.2 2.053088333333334e-05 0 2.05725e-05 0 2.057255e-05 1.2 2.065583333333334e-05 1.2 2.065588333333334e-05 0 2.06975e-05 0 2.069755e-05 1.2 2.073916666666667e-05 1.2 2.073921666666667e-05 0 2.078083333333334e-05 0 2.078088333333334e-05 1.2 2.08225e-05 1.2 2.082255e-05 0 2.086416666666667e-05 0 2.086421666666667e-05 1.2 2.090583333333334e-05 1.2 2.090588333333334e-05 0 2.09475e-05 0 2.094755e-05 1.2 2.098916666666667e-05 1.2 2.098921666666667e-05 0 2.103083333333334e-05 0 2.103088333333334e-05 1.2 2.10725e-05 1.2 2.107255e-05 0 2.111416666666667e-05 0 2.111421666666667e-05 1.2 2.115583333333334e-05 1.2 2.115588333333334e-05 0 2.11975e-05 0 2.119755e-05 1.2 2.123916666666667e-05 1.2 2.123921666666667e-05 0 2.128083333333334e-05 0 2.128088333333334e-05 1.2 2.13225e-05 1.2 2.132255e-05 0 2.136416666666667e-05 0 2.136421666666667e-05 1.2 2.140583333333334e-05 1.2 2.140588333333334e-05 0 2.14475e-05 0 2.144755e-05 1.2 2.153083333333334e-05 1.2 2.153088333333334e-05 0 2.15725e-05 0 2.157255e-05 1.2 2.161416666666667e-05 1.2 2.161421666666667e-05 0 2.165583333333334e-05 0 2.165588333333334e-05 1.2 2.16975e-05 1.2 2.169755e-05 0 2.173916666666667e-05 0 2.173921666666667e-05 1.2 2.178083333333334e-05 1.2 2.178088333333334e-05 0 2.18225e-05 0 2.182255e-05 1.2 2.186416666666667e-05 1.2 2.186421666666667e-05 0 2.190583333333334e-05 0 2.190588333333334e-05 1.2 2.19475e-05 1.2 2.194755e-05 0 2.198916666666667e-05 0 2.198921666666667e-05 1.2 2.203083333333334e-05 1.2 2.203088333333334e-05 0 2.20725e-05 0 2.207255e-05 1.2 2.211416666666667e-05 1.2 2.211421666666667e-05 0 2.215583333333334e-05 0 2.215588333333334e-05 1.2 2.21975e-05 1.2 2.219755e-05 0 2.223916666666667e-05 0 2.223921666666667e-05 1.2 2.228083333333334e-05 1.2 2.228088333333334e-05 0 2.28225e-05 0 2.282255e-05 1.2 2.286416666666667e-05 1.2 2.286421666666667e-05 0 2.290583333333334e-05 0 2.290588333333334e-05 1.2 2.29475e-05 1.2 2.294755e-05 0 2.298916666666667e-05 0 2.298921666666667e-05 1.2 2.303083333333334e-05 1.2 2.303088333333334e-05 0 2.30725e-05 0 2.307255e-05 1.2 2.311416666666667e-05 1.2 2.311421666666667e-05 0 2.315583333333334e-05 0 2.315588333333334e-05 1.2 2.31975e-05 1.2 2.319755e-05 0 2.323916666666667e-05 0 2.323921666666667e-05 1.2 2.328083333333334e-05 1.2 2.328088333333334e-05 0 2.33225e-05 0 2.332255e-05 1.2 2.336416666666667e-05 1.2 2.336421666666667e-05 0 2.340583333333334e-05 0 2.340588333333334e-05 1.2 2.34475e-05 1.2 2.344755e-05 0 2.348916666666667e-05 0 2.348921666666667e-05 1.2 2.353083333333334e-05 1.2 2.353088333333334e-05 0 2.35725e-05 0 2.357255e-05 1.2 2.361416666666667e-05 1.2 2.361421666666667e-05 0 2.365583333333334e-05 0 2.365588333333334e-05 1.2 2.36975e-05 1.2 2.369755e-05 0 2.373916666666667e-05 0 2.373921666666667e-05 1.2 2.378083333333334e-05 1.2 2.378088333333334e-05 0 2.38225e-05 0 2.382255e-05 1.2 2.386416666666667e-05 1.2 2.386421666666667e-05 0 2.390583333333334e-05 0 2.390588333333334e-05 1.2 2.39475e-05 1.2 2.394755e-05 0 2.398916666666667e-05 0 2.398921666666667e-05 1.2 2.403083333333334e-05 1.2 2.403088333333334e-05 0 2.40725e-05 0 2.407255e-05 1.2 2.411416666666667e-05 1.2 2.411421666666667e-05 0 2.415583333333334e-05 0 2.415588333333334e-05 1.2 2.41975e-05 1.2 2.419755e-05 0 2.423916666666667e-05 0 2.423921666666667e-05 1.2 2.428083333333334e-05 1.2 2.428088333333334e-05 0 2.43225e-05 0 2.432255e-05 1.2 2.436416666666667e-05 1.2 2.436421666666667e-05 0 2.440583333333334e-05 0 2.440588333333334e-05 1.2 2.44475e-05 1.2 2.444755e-05 0 2.448916666666667e-05 0 2.448921666666667e-05 1.2 2.453083333333334e-05 1.2 2.453088333333334e-05 0 2.45725e-05 0 2.457255e-05 1.2 2.461416666666667e-05 1.2 2.461421666666667e-05 0 2.465583333333334e-05 0 2.465588333333334e-05 1.2 2.46975e-05 1.2 2.469755e-05 0 2.473916666666667e-05 0 2.473921666666667e-05 1.2 2.478083333333334e-05 1.2 2.478088333333334e-05 0 2.48225e-05 0 2.482255e-05 1.2 2.486416666666667e-05 1.2 2.486421666666667e-05 0 2.490583333333334e-05 0 2.490588333333334e-05 1.2 2.49475e-05 1.2 2.494755e-05 0 2.498916666666667e-05 0 2.498921666666667e-05 1.2 2.503083333333334e-05 1.2 2.503088333333334e-05 0 2.50725e-05 0 2.507255e-05 1.2 2.511416666666667e-05 1.2 2.511421666666667e-05 0 2.515583333333334e-05 0 2.515588333333334e-05 1.2 2.51975e-05 1.2 2.519755e-05 0 2.523916666666667e-05 0 2.523921666666667e-05 1.2 2.528083333333334e-05 1.2 2.528088333333334e-05 0 2.53225e-05 0 2.532255e-05 1.2 2.536416666666667e-05 1.2 2.536421666666667e-05 0 2.540583333333334e-05 0 2.540588333333334e-05 1.2 2.54475e-05 1.2 2.544755e-05 0 2.553083333333334e-05 0 2.553088333333334e-05 1.2 2.55725e-05 1.2 2.557255e-05 0 2.561416666666667e-05 0 2.561421666666667e-05 1.2 2.565583333333334e-05 1.2 2.565588333333334e-05 0 2.56975e-05 0 2.569755e-05 1.2 2.573916666666667e-05 1.2 2.573921666666667e-05 0 2.578083333333334e-05 0 2.578088333333334e-05 1.2 2.58225e-05 1.2 2.582255e-05 0 2.586416666666667e-05 0 2.586421666666667e-05 1.2 2.590583333333334e-05 1.2 2.590588333333334e-05 0 2.59475e-05 0 2.594755e-05 1.2 2.598916666666667e-05 1.2 2.598921666666667e-05 0 2.603083333333334e-05 0 2.603088333333334e-05 1.2 2.60725e-05 1.2 2.607255e-05 0 2.611416666666667e-05 0 2.611421666666667e-05 1.2 2.615583333333334e-05 1.2 2.615588333333334e-05 0 2.61975e-05 0 2.619755e-05 1.2 2.623916666666667e-05 1.2 2.623921666666667e-05 0 2.628083333333334e-05 0 2.628088333333334e-05 1.2 2.63225e-05 1.2 2.632255e-05 0 2.636416666666667e-05 0 2.636421666666667e-05 1.2 2.640583333333334e-05 1.2 2.640588333333334e-05 0 2.64475e-05 0 2.644755e-05 1.2 2.648916666666667e-05 1.2 2.648921666666667e-05 0 2.653083333333334e-05 0 2.653088333333334e-05 1.2 2.65725e-05 1.2 2.657255e-05 0 2.661416666666667e-05 0 2.661421666666667e-05 1.2 2.665583333333334e-05 1.2 2.665588333333334e-05 0 2.66975e-05 0 2.669755e-05 1.2 2.673916666666667e-05 1.2 2.673921666666667e-05 0 2.678083333333334e-05 0 2.678088333333334e-05 1.2 2.68225e-05 1.2 2.682255e-05 0 2.686416666666667e-05 0 2.686421666666667e-05 1.2 2.690583333333334e-05 1.2 2.690588333333334e-05 0 2.69475e-05 0 2.694755e-05 1.2 2.698916666666667e-05 1.2 2.698921666666667e-05 0 2.703083333333334e-05 0 2.703088333333334e-05 1.2 2.70725e-05 1.2 2.707255e-05 0 2.711416666666667e-05 0 2.711421666666667e-05 1.2 2.715583333333334e-05 1.2 2.715588333333334e-05 0 2.71975e-05 0 2.719755e-05 1.2 2.723916666666667e-05 1.2 2.723921666666667e-05 0 2.728083333333334e-05 0 2.728088333333334e-05 1.2 2.73225e-05 1.2 2.732255e-05 0 2.736416666666667e-05 0 2.736421666666667e-05 1.2 2.740583333333334e-05 1.2 2.740588333333334e-05 0 2.74475e-05 0 2.744755e-05 1.2 2.748916666666667e-05 1.2 2.748921666666667e-05 0 2.753083333333334e-05 0 2.753088333333334e-05 1.2 2.75725e-05 1.2 2.757255e-05 0 2.761416666666667e-05 0 2.761421666666667e-05 1.2 2.765583333333334e-05 1.2 2.765588333333334e-05 0 2.76975e-05 0 2.769755e-05 1.2 2.773916666666667e-05 1.2 2.773921666666667e-05 0 2.778083333333334e-05 0 2.778088333333334e-05 1.2 2.78225e-05 1.2 2.782255e-05 0 2.786416666666667e-05 0 2.786421666666667e-05 1.2 2.790583333333334e-05 1.2 2.790588333333334e-05 0 2.79475e-05 0 2.794755e-05 1.2 2.798916666666667e-05 1.2 2.798921666666667e-05 0 2.803083333333334e-05 0 2.803088333333334e-05 1.2 2.80725e-05 1.2 2.807255e-05 0 2.811416666666667e-05 0 2.811421666666667e-05 1.2 2.828083333333334e-05 1.2 2.828088333333334e-05 0 2.865583333333334e-05 0 2.865588333333334e-05 1.2 2.86975e-05 1.2 2.869755e-05 0 2.873916666666667e-05 0 2.873921666666667e-05 1.2 2.878083333333334e-05 1.2 2.878088333333334e-05 0 2.88225e-05 0 2.882255e-05 1.2 2.886416666666667e-05 1.2 2.886421666666667e-05 0 2.890583333333334e-05 0 2.890588333333334e-05 1.2 2.89475e-05 1.2 2.894755e-05 0 2.898916666666667e-05 0 2.898921666666667e-05 1.2 2.903083333333334e-05 1.2 2.903088333333334e-05 0 2.90725e-05 0 2.907255e-05 1.2 2.911416666666667e-05 1.2 2.911421666666667e-05 0 2.915583333333334e-05 0 2.915588333333334e-05 1.2 2.91975e-05 1.2 2.919755e-05 0 2.923916666666667e-05 0 2.923921666666667e-05 1.2 2.928083333333334e-05 1.2 2.928088333333334e-05 0 2.93225e-05 0 2.932255e-05 1.2 2.936416666666667e-05 1.2 2.936421666666667e-05 0 2.940583333333334e-05 0 2.940588333333334e-05 1.2 2.94475e-05 1.2 2.944755e-05 0 2.948916666666667e-05 0 2.948921666666667e-05 1.2 2.953083333333334e-05 1.2 2.953088333333334e-05 0 2.95725e-05 0 2.957255e-05 1.2 2.961416666666667e-05 1.2 2.961421666666667e-05 0 2.965583333333334e-05 0 2.965588333333334e-05 1.2 2.96975e-05 1.2 2.969755e-05 0 2.973916666666667e-05 0 2.973921666666667e-05 1.2 2.978083333333334e-05 1.2 2.978088333333334e-05 0 2.98225e-05 0 2.982255e-05 1.2 2.986416666666667e-05 1.2 2.986421666666667e-05 0 2.990583333333334e-05 0 2.990588333333334e-05 1.2 2.99475e-05 1.2 2.994755e-05 0 2.998916666666667e-05 0 2.998921666666667e-05 1.2 3.003083333333334e-05 1.2 3.003088333333334e-05 0 3.00725e-05 0 3.007255e-05 1.2 3.011416666666667e-05 1.2 3.011421666666667e-05 0 3.015583333333334e-05 0 3.015588333333334e-05 1.2 3.01975e-05 1.2 3.019755e-05 0 3.023916666666667e-05 0 3.023921666666667e-05 1.2 3.028083333333334e-05 1.2 3.028088333333334e-05 0 3.03225e-05 0 3.032255e-05 1.2 3.036416666666667e-05 1.2 3.036421666666667e-05 0 3.040583333333334e-05 0 3.040588333333334e-05 1.2 3.04475e-05 1.2 3.044755e-05 0 3.048916666666667e-05 0 3.048921666666667e-05 1.2 3.053083333333334e-05 1.2 3.053088333333333e-05 0 3.05725e-05 0 3.057255e-05 1.2 3.061416666666667e-05 1.2 3.061421666666667e-05 0 3.065583333333334e-05 0 3.065588333333334e-05 1.2 3.073916666666667e-05 1.2 3.073921666666667e-05 0 3.078083333333334e-05 0 3.078088333333333e-05 1.2 3.082250000000001e-05 1.2 3.082255e-05 0 3.086416666666667e-05 0 3.086421666666667e-05 1.2 3.090583333333334e-05 1.2 3.090588333333333e-05 0 3.09475e-05 0 3.094755e-05 1.2 3.098916666666667e-05 1.2 3.098921666666667e-05 0 3.103083333333333e-05 0 3.103088333333333e-05 1.2 3.10725e-05 1.2 3.107255e-05 0 3.111416666666667e-05 0 3.111421666666666e-05 1.2 3.115583333333334e-05 1.2 3.115588333333333e-05 0 3.11975e-05 0 3.119755e-05 1.2 3.123916666666667e-05 1.2 3.123921666666667e-05 0 3.128083333333334e-05 0 3.128088333333334e-05 1.2 3.13225e-05 1.2 3.132255e-05 0 3.136416666666667e-05 0 3.136421666666666e-05 1.2 3.140583333333334e-05 1.2 3.140588333333333e-05 0 3.14475e-05 0 3.144755e-05 1.2 3.148916666666667e-05 1.2 3.148921666666667e-05 0 3.153083333333334e-05 0 3.153088333333334e-05 1.2 3.15725e-05 1.2 3.157255e-05 0 3.161416666666667e-05 0 3.161421666666667e-05 1.2 3.165583333333334e-05 1.2 3.165588333333333e-05 0 3.16975e-05 0 3.169755e-05 1.2 3.173916666666667e-05 1.2 3.173921666666667e-05 0 3.178083333333334e-05 0 3.178088333333334e-05 1.2 3.18225e-05 1.2 3.182255e-05 0 3.186416666666667e-05 0 3.186421666666667e-05 1.2 3.190583333333334e-05 1.2 3.190588333333333e-05 0 3.19475e-05 0 3.194755e-05 1.2 3.198916666666667e-05 1.2 3.198921666666667e-05 0 3.203083333333334e-05 0 3.203088333333334e-05 1.2 3.20725e-05 1.2 3.207255e-05 0 3.211416666666667e-05 0 3.211421666666667e-05 1.2 3.215583333333333e-05 1.2 3.215588333333333e-05 0 3.21975e-05 0 3.219755e-05 1.2 3.223916666666667e-05 1.2 3.223921666666666e-05 0 3.228083333333334e-05 0 3.228088333333333e-05 1.2 3.23225e-05 1.2 3.232255e-05 0 3.236416666666667e-05 0 3.236421666666667e-05 1.2 3.240583333333334e-05 1.2 3.240588333333334e-05 0 3.24475e-05 0 3.244755e-05 1.2 3.248916666666667e-05 1.2 3.248921666666666e-05 0 3.253083333333334e-05 0 3.253088333333333e-05 1.2 3.25725e-05 1.2 3.257255e-05 0 3.261416666666667e-05 0 3.261421666666667e-05 1.2 3.265583333333334e-05 1.2 3.265588333333334e-05 0 3.26975e-05 0 3.269755e-05 1.2 3.273916666666667e-05 1.2 3.273921666666667e-05 0 3.278083333333334e-05 0 3.278088333333333e-05 1.2 3.282249999999999e-05 1.2 3.282254999999999e-05 0 3.286416666666667e-05 0 3.286421666666667e-05 1.2 3.290583333333333e-05 1.2 3.290588333333333e-05 0 3.29475e-05 0 3.294755e-05 1.2 3.298916666666667e-05 1.2 3.298921666666666e-05 0 3.303083333333333e-05 0 3.303088333333333e-05 1.2 3.30725e-05 1.2 3.307255e-05 0 3.311416666666667e-05 0 3.311421666666667e-05 1.2 3.315583333333333e-05 1.2 3.315588333333333e-05 0 3.323916666666667e-05 0 3.323921666666666e-05 1.2 3.328083333333333e-05 1.2 3.328088333333332e-05 0 3.33225e-05 0 3.332255e-05 1.2 3.336416666666667e-05 1.2 3.336421666666666e-05 0 3.340583333333333e-05 0 3.340588333333333e-05 1.2 3.34475e-05 1.2 3.344755e-05 0 3.348916666666666e-05 0 3.348921666666666e-05 1.2 3.353083333333333e-05 1.2 3.353088333333332e-05 0 3.35725e-05 0 3.357255e-05 1.2 3.361416666666667e-05 1.2 3.361421666666666e-05 0 3.365583333333333e-05 0 3.365588333333333e-05 1.2 3.36975e-05 1.2 3.369755e-05 0 3.373916666666666e-05 0 3.373921666666666e-05 1.2 3.378083333333333e-05 1.2 3.378088333333333e-05 0 3.38225e-05 0 3.382255e-05 1.2 3.386416666666667e-05 1.2 3.386421666666666e-05 0 3.390583333333333e-05 0 3.390588333333333e-05 1.2 3.39475e-05 1.2 3.394755e-05 0 3.448916666666667e-05 0 3.448921666666667e-05 1.2 3.453083333333333e-05 1.2 3.453088333333333e-05 0 3.45725e-05 0 3.457255e-05 1.2 3.461416666666666e-05 1.2 3.461421666666666e-05 0 3.465583333333333e-05 0 3.465588333333332e-05 1.2 3.46975e-05 1.2 3.469755e-05 0 3.473916666666667e-05 0 3.473921666666666e-05 1.2 3.478083333333333e-05 1.2 3.478088333333333e-05 0 3.48225e-05 0 3.482255e-05 1.2 3.486416666666666e-05 1.2 3.486421666666666e-05 0 3.490583333333333e-05 0 3.490588333333333e-05 1.2 3.49475e-05 1.2 3.494755e-05 0 3.498916666666667e-05 0 3.498921666666666e-05 1.2 3.503083333333333e-05 1.2 3.503088333333333e-05 0 3.50725e-05 0 3.507255e-05 1.2 3.511416666666666e-05 1.2 3.511421666666666e-05 0 3.515583333333333e-05 0 3.515588333333333e-05 1.2 3.51975e-05 1.2 3.519755e-05 0 3.523916666666667e-05 0 3.523921666666666e-05 1.2 3.528083333333333e-05 1.2 3.528088333333333e-05 0 3.53225e-05 0 3.532255e-05 1.2 3.536416666666667e-05 1.2 3.536421666666667e-05 0 3.540583333333333e-05 0 3.540588333333333e-05 1.2 3.54475e-05 1.2 3.544755e-05 0 3.548916666666667e-05 0 3.548921666666666e-05 1.2 3.553083333333333e-05 1.2 3.553088333333333e-05 0 3.557250000000001e-05 0 3.557255e-05 1.2 3.561416666666667e-05 1.2 3.561421666666667e-05 0 3.565583333333333e-05 0 3.565588333333333e-05 1.2 3.56975e-05 1.2 3.569755e-05 0 3.573916666666666e-05 0 3.573921666666666e-05 1.2 3.578083333333333e-05 1.2 3.578088333333332e-05 0 3.58225e-05 0 3.582255e-05 1.2 3.586416666666667e-05 1.2 3.586421666666666e-05 0 3.590583333333333e-05 0 3.590588333333333e-05 1.2 3.59475e-05 1.2 3.594755e-05 0 3.598916666666666e-05 0 3.598921666666666e-05 1.2 3.603083333333333e-05 1.2 3.603088333333333e-05 0 3.60725e-05 0 3.607255e-05 1.2 3.611416666666667e-05 1.2 3.611421666666666e-05 0 3.615583333333333e-05 0 3.615588333333333e-05 1.2 3.61975e-05 1.2 3.619755e-05 0 3.623916666666666e-05 0 3.623921666666666e-05 1.2 3.628083333333333e-05 1.2 3.628088333333333e-05 0 3.63225e-05 0 3.632255e-05 1.2 3.636416666666667e-05 1.2 3.636421666666666e-05 0 3.640583333333333e-05 0 3.640588333333333e-05 1.2 3.64475e-05 1.2 3.644755e-05 0 3.648916666666667e-05 0 3.648921666666667e-05 1.2 3.653083333333333e-05 1.2 3.653088333333333e-05 0 3.65725e-05 0 3.657255e-05 1.2 3.661416666666667e-05 1.2 3.661421666666666e-05 0 3.665583333333333e-05 0 3.665588333333333e-05 1.2 3.669750000000001e-05 1.2 3.669755e-05 0 3.673916666666667e-05 0 3.673921666666667e-05 1.2 3.678083333333333e-05 1.2 3.678088333333333e-05 0 3.68225e-05 0 3.682255e-05 1.2 3.686416666666667e-05 1.2 3.686421666666666e-05 0 3.690583333333333e-05 0 3.690588333333332e-05 1.2 3.69475e-05 1.2 3.694755e-05 0 3.698916666666667e-05 0 3.698921666666666e-05 1.2 3.703083333333333e-05 1.2 3.703088333333333e-05 0 3.70725e-05 0 3.707255e-05 1.2 3.711416666666666e-05 1.2 3.711421666666666e-05 0 3.715583333333333e-05 0 3.715588333333332e-05 1.2 3.71975e-05 1.2 3.719755e-05 0 3.723916666666667e-05 0 3.723921666666666e-05 1.2 3.728083333333333e-05 1.2 3.728088333333333e-05 0 3.73225e-05 0 3.732255e-05 1.2 3.736416666666666e-05 1.2 3.736421666666666e-05 0 3.740583333333333e-05 0 3.740588333333333e-05 1.2 3.74475e-05 1.2 3.744755e-05 0 3.748916666666667e-05 0 3.748921666666666e-05 1.2 3.753083333333333e-05 1.2 3.753088333333333e-05 0 3.75725e-05 0 3.757255e-05 1.2 3.761416666666667e-05 1.2 3.761421666666667e-05 0 3.765583333333333e-05 0 3.765588333333333e-05 1.2 3.76975e-05 1.2 3.769755e-05 0 3.773916666666667e-05 0 3.773921666666666e-05 1.2 3.778083333333333e-05 1.2 3.778088333333333e-05 0 3.78225e-05 0 3.782255e-05 1.2 3.786416666666667e-05 1.2 3.786421666666667e-05 0 3.790583333333333e-05 0 3.790588333333333e-05 1.2 3.79475e-05 1.2 3.794755e-05 0 3.798916666666667e-05 0 3.798921666666666e-05 1.2 3.803083333333333e-05 1.2 3.803088333333333e-05 0 3.807250000000001e-05 0 3.807255e-05 1.2 3.811416666666667e-05 1.2 3.811421666666667e-05 0 3.815583333333333e-05 0 3.815588333333333e-05 1.2 3.81975e-05 1.2 3.819755e-05 0 3.823916666666666e-05 0 3.823921666666666e-05 1.2 3.828083333333333e-05 1.2 3.828088333333332e-05 0 3.83225e-05 0 3.832255e-05 1.2 3.836416666666667e-05 1.2 3.836421666666666e-05 0 3.840583333333333e-05 0 3.840588333333333e-05 1.2 3.84475e-05 1.2 3.844755e-05 0 3.848916666666666e-05 0 3.848921666666666e-05 1.2 3.853083333333333e-05 1.2 3.853088333333333e-05 0 3.85725e-05 0 3.857255e-05 1.2 3.861416666666667e-05 1.2 3.861421666666666e-05 0 3.865583333333333e-05 0 3.865588333333333e-05 1.2 3.86975e-05 1.2 3.869755e-05 0 3.873916666666667e-05 0 3.873921666666667e-05 1.2 3.878083333333333e-05 1.2 3.878088333333333e-05 0 3.88225e-05 0 3.882255e-05 1.2 3.886416666666667e-05 1.2 3.886421666666666e-05 0 3.890583333333333e-05 0 3.890588333333333e-05 1.2 3.89475e-05 1.2 3.894755e-05 0 3.898916666666667e-05 0 3.898921666666667e-05 1.2 3.903083333333333e-05 1.2 3.903088333333333e-05 0 3.90725e-05 0 3.907255e-05 1.2 3.911416666666667e-05 1.2 3.911421666666666e-05 0 3.915583333333333e-05 0 3.915588333333333e-05 1.2 3.919750000000001e-05 1.2 3.919755e-05 0 3.923916666666667e-05 0 3.923921666666667e-05 1.2 3.928083333333333e-05 1.2 3.928088333333333e-05 0 3.93225e-05 0 3.932255e-05 1.2 3.936416666666666e-05 1.2 3.936421666666666e-05 0 3.940583333333333e-05 0 3.940588333333332e-05 1.2 3.94475e-05 1.2 3.944755e-05 0 3.948916666666667e-05 0 3.948921666666666e-05 1.2 3.953083333333333e-05 1.2 3.953088333333333e-05 0 3.95725e-05 0 3.957255e-05 1.2 3.961416666666666e-05 1.2 3.961421666666666e-05 0 3.965583333333333e-05 0 3.965588333333333e-05 1.2 3.96975e-05 1.2 3.969755e-05 0 3.973916666666667e-05 0 3.973921666666666e-05 1.2 3.978083333333333e-05 1.2 3.978088333333333e-05 0 4.032250000000001e-05 0 4.032255e-05 1.2 4.036416666666667e-05 1.2 4.036421666666667e-05 0 4.040583333333333e-05 0 4.040588333333333e-05 1.2 4.04475e-05 1.2 4.044755e-05 0 4.048916666666667e-05 0 4.048921666666666e-05 1.2 4.053083333333333e-05 1.2 4.053088333333332e-05 0 4.05725e-05 0 4.057255e-05 1.2 4.061416666666667e-05 1.2 4.061421666666666e-05 0 4.065583333333333e-05 0 4.065588333333333e-05 1.2 4.06975e-05 1.2 4.069755e-05 0 4.073916666666666e-05 0 4.073921666666666e-05 1.2 4.078083333333333e-05 1.2 4.078088333333333e-05 0 4.08225e-05 0 4.082255e-05 1.2 4.086416666666667e-05 1.2 4.086421666666666e-05 0 4.090583333333333e-05 0 4.090588333333333e-05 1.2 4.09475e-05 1.2 4.094755e-05 0 4.098916666666666e-05 0 4.098921666666666e-05 1.2 4.103083333333333e-05 1.2 4.103088333333333e-05 0 4.10725e-05 0 4.107255e-05 1.2 4.111416666666667e-05 1.2 4.111421666666666e-05 0 4.115583333333333e-05 0 4.115588333333333e-05 1.2 4.11975e-05 1.2 4.119755e-05 0 4.123916666666667e-05 0 4.123921666666667e-05 1.2 4.128083333333333e-05 1.2 4.128088333333333e-05 0 4.13225e-05 0 4.132255e-05 1.2 4.136416666666667e-05 1.2 4.136421666666666e-05 0 4.140583333333333e-05 0 4.140588333333333e-05 1.2 4.144750000000001e-05 1.2 4.144755e-05 0 4.148916666666667e-05 0 4.148921666666667e-05 1.2 4.153083333333333e-05 1.2 4.153088333333333e-05 0 4.15725e-05 0 4.157255e-05 1.2 4.161416666666667e-05 1.2 4.161421666666666e-05 0 4.165583333333333e-05 0 4.165588333333333e-05 1.2 4.169750000000001e-05 1.2 4.169755e-05 0 4.173916666666667e-05 0 4.173921666666667e-05 1.2 4.178083333333333e-05 1.2 4.178088333333333e-05 0 4.18225e-05 0 4.182255e-05 1.2 4.186416666666666e-05 1.2 4.186421666666666e-05 0 4.190583333333333e-05 0 4.190588333333332e-05 1.2 4.19475e-05 1.2 4.194755e-05 0 4.198916666666667e-05 0 4.198921666666666e-05 1.2 4.203083333333333e-05 1.2 4.203088333333333e-05 0 4.20725e-05 0 4.207255e-05 1.2 4.211416666666666e-05 1.2 4.211421666666666e-05 0 4.215583333333333e-05 0 4.215588333333333e-05 1.2 4.21975e-05 1.2 4.219755e-05 0 4.223916666666667e-05 0 4.223921666666666e-05 1.2 4.228083333333333e-05 1.2 4.228088333333333e-05 0 4.23225e-05 0 4.232255e-05 1.2 4.236416666666667e-05 1.2 4.236421666666667e-05 0 4.240583333333333e-05 0 4.240588333333333e-05 1.2 4.24475e-05 1.2 4.244755e-05 0 4.248916666666667e-05 0 4.248921666666666e-05 1.2 4.253083333333333e-05 1.2 4.253088333333333e-05 0 4.25725e-05 0 4.257255e-05 1.2 4.261416666666667e-05 1.2 4.261421666666667e-05 0 4.265583333333333e-05 0 4.265588333333333e-05 1.2 4.26975e-05 1.2 4.269755e-05 0 4.273916666666667e-05 0 4.273921666666666e-05 1.2 4.278083333333333e-05 1.2 4.278088333333333e-05 0 4.282250000000001e-05 0 4.282255e-05 1.2 4.286416666666667e-05 1.2 4.286421666666667e-05 0 4.290583333333333e-05 0 4.290588333333333e-05 1.2 4.29475e-05 1.2 4.294755e-05 0 4.298916666666666e-05 0 4.298921666666666e-05 1.2 4.303083333333333e-05 1.2 4.303088333333332e-05 0 4.311416666666667e-05 0 4.311421666666666e-05 1.2 4.315583333333333e-05 1.2 4.315588333333333e-05 0 4.31975e-05 0 4.319755e-05 1.2 4.323916666666666e-05 1.2 4.323921666666666e-05 0 4.328083333333333e-05 0 4.328088333333333e-05 1.2 4.33225e-05 1.2 4.332255e-05 0 4.336416666666667e-05 0 4.336421666666666e-05 1.2 4.340583333333333e-05 1.2 4.340588333333333e-05 0 4.34475e-05 0 4.344755e-05 1.2 4.348916666666667e-05 1.2 4.348921666666667e-05 0 4.353083333333333e-05 0 4.353088333333333e-05 1.2 4.35725e-05 1.2 4.357255e-05 0 4.361416666666667e-05 0 4.361421666666666e-05 1.2 4.365583333333333e-05 1.2 4.365588333333333e-05 0 4.36975e-05 0 4.369755e-05 1.2 4.373916666666667e-05 1.2 4.373921666666667e-05 0 4.378083333333333e-05 0 4.378088333333333e-05 1.2 4.38225e-05 1.2 4.382255e-05 0 4.386416666666667e-05 0 4.386421666666666e-05 1.2 4.390583333333333e-05 1.2 4.390588333333333e-05 0 4.394750000000001e-05 0 4.394755e-05 1.2 4.398916666666667e-05 1.2 4.398921666666667e-05 0 4.403083333333333e-05 0 4.403088333333333e-05 1.2 4.40725e-05 1.2 4.407255e-05 0 4.411416666666667e-05 0 4.411421666666666e-05 1.2 4.415583333333333e-05 1.2 4.415588333333333e-05 0 4.419750000000001e-05 0 4.419755e-05 1.2 4.423916666666667e-05 1.2 4.423921666666666e-05 0 4.428083333333333e-05 0 4.428088333333333e-05 1.2 4.43225e-05 1.2 4.432255e-05 0 4.436416666666666e-05 0 4.436421666666666e-05 1.2 4.440583333333333e-05 1.2 4.440588333333333e-05 0 4.44475e-05 0 4.444755e-05 1.2 4.448916666666667e-05 1.2 4.448921666666666e-05 0 4.453083333333333e-05 0 4.453088333333333e-05 1.2 4.45725e-05 1.2 4.457255e-05 0 4.461416666666666e-05 0 4.461421666666666e-05 1.2 4.465583333333333e-05 1.2 4.465588333333333e-05 0 4.46975e-05 0 4.469755e-05 1.2 4.473916666666667e-05 1.2 4.473921666666666e-05 0 4.478083333333333e-05 0 4.478088333333333e-05 1.2 4.48225e-05 1.2 4.482255e-05 0 4.486416666666667e-05 0 4.486421666666667e-05 1.2 4.490583333333333e-05 1.2 4.490588333333333e-05 0 4.49475e-05 0 4.494755e-05 1.2 4.498916666666667e-05 1.2 4.498921666666666e-05 0 4.503083333333333e-05 0 4.503088333333333e-05 1.2 4.507250000000001e-05 1.2 4.507255e-05 0 4.511416666666667e-05 0 4.511421666666667e-05 1.2 4.515583333333333e-05 1.2 4.515588333333333e-05 0 4.51975e-05 0 4.519755e-05 1.2 4.523916666666667e-05 1.2 4.523921666666666e-05 0 4.528083333333333e-05 0 4.528088333333333e-05 1.2 4.532250000000001e-05 1.2 4.532255e-05 0 4.536416666666667e-05 0 4.536421666666667e-05 1.2 4.540583333333333e-05 1.2 4.540588333333333e-05 0 4.54475e-05 0 4.544755e-05 1.2 4.548916666666666e-05 1.2 4.548921666666666e-05 0 4.553083333333333e-05 0 4.553088333333333e-05 1.2 4.55725e-05 1.2 4.557255e-05 0 4.561416666666667e-05 0 4.561421666666666e-05 1.2 4.578083333333333e-05 1.2 4.578088333333333e-05 0 4.615583333333333e-05 0 4.615588333333333e-05 1.2 4.619750000000001e-05 1.2 4.619755e-05 0 4.623916666666667e-05 0 4.623921666666667e-05 1.2 4.628083333333333e-05 1.2 4.628088333333333e-05 0 4.63225e-05 0 4.632255e-05 1.2 4.636416666666667e-05 1.2 4.636421666666666e-05 0 4.640583333333333e-05 0 4.640588333333333e-05 1.2 4.644750000000001e-05 1.2 4.644755e-05 0 4.648916666666667e-05 0 4.648921666666667e-05 1.2 4.653083333333333e-05 1.2 4.653088333333333e-05 0 4.65725e-05 0 4.657255e-05 1.2 4.661416666666666e-05 1.2 4.661421666666666e-05 0 4.665583333333333e-05 0 4.665588333333332e-05 1.2 4.66975e-05 1.2 4.669755e-05 0 4.673916666666667e-05 0 4.673921666666666e-05 1.2 4.678083333333333e-05 1.2 4.678088333333333e-05 0 4.68225e-05 0 4.682255e-05 1.2 4.686416666666666e-05 1.2 4.686421666666666e-05 0 4.690583333333333e-05 0 4.690588333333333e-05 1.2 4.69475e-05 1.2 4.694755e-05 0 4.698916666666667e-05 0 4.698921666666666e-05 1.2 4.703083333333333e-05 1.2 4.703088333333333e-05 0 4.70725e-05 0 4.707255e-05 1.2 4.711416666666667e-05 1.2 4.711421666666667e-05 0 4.715583333333333e-05 0 4.715588333333333e-05 1.2 4.71975e-05 1.2 4.719755e-05 0 4.723916666666667e-05 0 4.723921666666666e-05 1.2 4.728083333333333e-05 1.2 4.728088333333333e-05 0 4.73225e-05 0 4.732255e-05 1.2 4.736416666666667e-05 1.2 4.736421666666667e-05 0 4.740583333333333e-05 0 4.740588333333333e-05 1.2 4.74475e-05 1.2 4.744755e-05 0 4.748916666666667e-05 0 4.748921666666666e-05 1.2 4.753083333333333e-05 1.2 4.753088333333333e-05 0 4.757250000000001e-05 0 4.757255e-05 1.2 4.761416666666667e-05 1.2 4.761421666666667e-05 0 4.765583333333333e-05 0 4.765588333333333e-05 1.2 4.76975e-05 1.2 4.769755e-05 0 4.773916666666667e-05 0 4.773921666666666e-05 1.2 4.778083333333333e-05 1.2 4.778088333333333e-05 0 4.782250000000001e-05 0 4.782255e-05 1.2 4.786416666666667e-05 1.2 4.786421666666666e-05 0 4.790583333333333e-05 0 4.790588333333333e-05 1.2 4.79475e-05 1.2 4.794755e-05 0 4.798916666666666e-05 0 4.798921666666666e-05 1.2 4.803083333333333e-05 1.2 4.803088333333333e-05 0 4.80725e-05 0 4.807255e-05 1.2 4.811416666666667e-05 1.2 4.811421666666666e-05 0 4.815583333333333e-05 0 4.815588333333333e-05 1.2 4.81975e-05 1.2 4.819755e-05 0 4.823916666666667e-05 0 4.823921666666667e-05 1.2 4.828083333333333e-05 1.2 4.828088333333333e-05 0 4.83225e-05 0 4.832255e-05 1.2 4.836416666666667e-05 1.2 4.836421666666666e-05 0 4.840583333333333e-05 0 4.840588333333333e-05 1.2 4.84475e-05 1.2 4.844755e-05 0 4.848916666666667e-05 0 4.848921666666667e-05 1.2 4.853083333333333e-05 1.2 4.853088333333333e-05 0 4.85725e-05 0 4.857255e-05 1.2 4.861416666666667e-05 1.2 4.861421666666666e-05 0 4.865583333333333e-05 0 4.865588333333333e-05 1.2 4.869750000000001e-05 1.2 4.869755e-05 0 4.873916666666667e-05 0 4.873921666666667e-05 1.2 4.878083333333333e-05 1.2 4.878088333333333e-05 0 4.88225e-05 0 4.882255e-05 1.2 4.886416666666667e-05 1.2 4.886421666666666e-05 0 4.890583333333333e-05 0 4.890588333333333e-05 1.2 4.894750000000001e-05 1.2 4.894755e-05 0 4.898916666666667e-05 0 4.898921666666667e-05 1.2 4.903083333333333e-05 1.2 4.903088333333333e-05 0 4.90725e-05 0 4.907255e-05 1.2 4.911416666666666e-05 1.2 4.911421666666666e-05 0 4.915583333333333e-05 0 4.915588333333333e-05 1.2 4.91975e-05 1.2 4.919755e-05 0 4.923916666666667e-05 0 4.923921666666666e-05 1.2 4.928083333333333e-05 1.2 4.928088333333333e-05 0 4.93225e-05 0 4.932255e-05 1.2 4.936416666666666e-05 1.2 4.936421666666666e-05 0 4.940583333333333e-05 0 4.940588333333333e-05 1.2 4.94475e-05 1.2 4.944755e-05 0 4.948916666666667e-05 0 4.948921666666666e-05 1.2 4.953083333333333e-05 1.2 4.953088333333333e-05 0 4.95725e-05 0 4.957255e-05 1.2 4.961416666666667e-05 1.2 4.961421666666667e-05 0 4.965583333333333e-05 0 4.965588333333333e-05 1.2 4.96975e-05 1.2 4.969755e-05 0 4.973916666666667e-05 0 4.973921666666666e-05 1.2 4.978083333333333e-05 1.2 4.978088333333333e-05 0 4.982250000000001e-05 0 4.982255e-05 1.2 4.986416666666667e-05 1.2 4.986421666666667e-05 0 4.990583333333333e-05 0 4.990588333333333e-05 1.2 4.99475e-05 1.2 4.994755e-05 0 4.998916666666667e-05 0 4.998921666666666e-05 1.2 5.003083333333333e-05 1.2 5.003088333333333e-05 0 5.007250000000001e-05 0 5.007255e-05 1.2 5.011416666666667e-05 1.2 5.011421666666667e-05 0 5.015583333333333e-05 0 5.015588333333333e-05 1.2 5.01975e-05 1.2 5.019755e-05 0 5.023916666666666e-05 0 5.023921666666666e-05 1.2 5.028083333333333e-05 1.2 5.028088333333333e-05 0 5.03225e-05 0 5.032255e-05 1.2 5.036416666666667e-05 1.2 5.036421666666666e-05 0 5.040583333333333e-05 0 5.040588333333333e-05 1.2 5.04475e-05 1.2 5.044755e-05 0 5.048916666666666e-05 0 5.048921666666666e-05 1.2 5.053083333333333e-05 1.2 5.053088333333333e-05 0 5.05725e-05 0 5.057255e-05 1.2 5.061416666666667e-05 1.2 5.061421666666666e-05 0 5.065583333333333e-05 0 5.065588333333333e-05 1.2 5.06975e-05 1.2 5.069755e-05 0 5.073916666666667e-05 0 5.073921666666667e-05 1.2 5.078083333333333e-05 1.2 5.078088333333333e-05 0 5.08225e-05 0 5.082255e-05 1.2 5.086416666666667e-05 1.2 5.086421666666666e-05 0 5.090583333333333e-05 0 5.090588333333333e-05 1.2 5.094750000000001e-05 1.2 5.094755e-05 0 5.098916666666667e-05 0 5.098921666666667e-05 1.2 5.103083333333333e-05 1.2 5.103088333333333e-05 0 5.10725e-05 0 5.107255e-05 1.2 5.111416666666667e-05 1.2 5.111421666666666e-05 0 5.115583333333333e-05 0 5.115588333333333e-05 1.2 5.119750000000001e-05 1.2 5.119755e-05 0 5.123916666666667e-05 0 5.123921666666667e-05 1.2 5.128083333333333e-05 1.2 5.128088333333333e-05 0 5.13225e-05 0 5.132255e-05 1.2 5.136416666666667e-05 1.2 5.136421666666666e-05 0 5.140583333333333e-05 0 5.140588333333333e-05 1.2 5.144750000000001e-05 1.2 5.144755e-05 0]
VM1 (m1 0) vsource type=pwl wave=[0 0 4.891666666666667e-07 0 4.892166666666667e-07 1.2 5.724999999999999e-07 1.2 5.725499999999999e-07 0 6.141666666666667e-07 0 6.142166666666667e-07 1.2 6.558333333333333e-07 1.2 6.558833333333333e-07 0 6.975e-07 0 6.9755e-07 1.2 7.808333333333333e-07 1.2 7.808833333333333e-07 0 8.225000000000001e-07 0 8.225500000000001e-07 1.2 8.641666666666667e-07 1.2 8.642166666666667e-07 0 9.058333333333333e-07 0 9.058833333333333e-07 1.2 9.891666666666668e-07 1.2 9.892166666666667e-07 0 1.030833333333333e-06 0 1.030883333333333e-06 1.2 1.0725e-06 1.2 1.07255e-06 0 1.155833333333334e-06 0 1.155883333333334e-06 1.2 1.1975e-06 1.2 1.19755e-06 0 1.239166666666667e-06 0 1.239216666666667e-06 1.2 1.280833333333333e-06 1.2 1.280883333333333e-06 0 1.364166666666667e-06 0 1.364216666666667e-06 1.2 1.405833333333334e-06 1.2 1.405883333333333e-06 0 1.4475e-06 0 1.44755e-06 1.2 1.489166666666667e-06 1.2 1.489216666666667e-06 0 1.5725e-06 0 1.57255e-06 1.2 1.614166666666667e-06 1.2 1.614216666666667e-06 0 1.655833333333334e-06 0 1.655883333333333e-06 1.2 1.6975e-06 1.2 1.69755e-06 0 1.780833333333334e-06 0 1.780883333333333e-06 1.2 1.9475e-06 1.2 1.94755e-06 0 2.3225e-06 0 2.32255e-06 1.2 2.364166666666667e-06 1.2 2.364216666666667e-06 0 2.405833333333333e-06 0 2.405883333333333e-06 1.2 2.489166666666667e-06 1.2 2.489216666666667e-06 0 2.530833333333333e-06 0 2.530883333333333e-06 1.2 2.5725e-06 1.2 2.57255e-06 0 2.614166666666666e-06 0 2.614216666666667e-06 1.2 2.6975e-06 1.2 2.69755e-06 0 2.739166666666667e-06 0 2.739216666666667e-06 1.2 2.780833333333333e-06 1.2 2.780883333333333e-06 0 2.8225e-06 0 2.82255e-06 1.2 2.864166666666667e-06 1.2 2.864216666666667e-06 0 2.9475e-06 0 2.94755e-06 1.2 2.989166666666667e-06 1.2 2.989216666666667e-06 0 3.030833333333333e-06 0 3.030883333333333e-06 1.2 3.0725e-06 1.2 3.07255e-06 0 3.155833333333333e-06 0 3.155883333333333e-06 1.2 3.1975e-06 1.2 3.19755e-06 0 3.239166666666667e-06 0 3.239216666666667e-06 1.2 3.280833333333333e-06 1.2 3.280883333333334e-06 0 3.364166666666667e-06 0 3.364216666666667e-06 1.2 3.405833333333333e-06 1.2 3.405883333333333e-06 0 3.4475e-06 0 3.44755e-06 1.2 3.489166666666667e-06 1.2 3.489216666666667e-06 0 3.5725e-06 0 3.57255e-06 1.2 3.614166666666667e-06 1.2 3.614216666666667e-06 0 4.155833333333333e-06 0 4.155883333333334e-06 1.2 4.197500000000001e-06 1.2 4.197550000000001e-06 0 4.239166666666667e-06 0 4.239216666666668e-06 1.2 4.280833333333334e-06 1.2 4.280883333333334e-06 0 4.322500000000001e-06 0 4.322550000000001e-06 1.2 4.364166666666667e-06 1.2 4.364216666666667e-06 0 4.405833333333334e-06 0 4.405883333333335e-06 1.2 4.4475e-06 1.2 4.44755e-06 0 4.489166666666668e-06 0 4.489216666666668e-06 1.2 4.530833333333334e-06 1.2 4.530883333333334e-06 0 4.572500000000001e-06 0 4.572550000000001e-06 1.2 4.614166666666667e-06 1.2 4.614216666666667e-06 0 4.655833333333335e-06 0 4.655883333333335e-06 1.2 4.6975e-06 1.2 4.69755e-06 0 4.739166666666667e-06 0 4.739216666666667e-06 1.2 4.780833333333334e-06 1.2 4.780883333333334e-06 0 4.8225e-06 0 4.82255e-06 1.2 4.864166666666667e-06 1.2 4.864216666666667e-06 0 4.905833333333334e-06 0 4.905883333333334e-06 1.2 4.9475e-06 1.2 4.947550000000001e-06 0 4.989166666666667e-06 0 4.989216666666667e-06 1.2 5.030833333333334e-06 1.2 5.030883333333335e-06 0 5.0725e-06 0 5.07255e-06 1.2 5.114166666666668e-06 1.2 5.114216666666668e-06 0 5.155833333333334e-06 0 5.155883333333334e-06 1.2 5.197500000000001e-06 1.2 5.197550000000001e-06 0 5.239166666666667e-06 0 5.239216666666667e-06 1.2 5.280833333333335e-06 1.2 5.280883333333335e-06 0 5.3225e-06 0 5.32255e-06 1.2 5.364166666666668e-06 1.2 5.364216666666668e-06 0 5.405833333333334e-06 0 5.405883333333334e-06 1.2 5.4475e-06 1.2 5.44755e-06 0 6.030833333333334e-06 0 6.030883333333334e-06 1.2 6.447500000000001e-06 1.2 6.447550000000001e-06 0 6.8225e-06 0 6.82255e-06 1.2 7.1975e-06 1.2 7.19755e-06 0 7.905833333333335e-06 0 7.905883333333335e-06 1.2 8.030833333333335e-06 1.2 8.030883333333335e-06 0 8.155833333333334e-06 0 8.155883333333334e-06 1.2 8.280833333333334e-06 1.2 8.280883333333334e-06 0 8.405833333333333e-06 0 8.405883333333334e-06 1.2 8.530833333333333e-06 1.2 8.530883333333333e-06 0 8.655833333333333e-06 0 8.655883333333333e-06 1.2 8.780833333333332e-06 1.2 8.780883333333333e-06 0 8.905833333333332e-06 0 8.905883333333332e-06 1.2 9.030833333333333e-06 1.2 9.030883333333334e-06 0 9.6975e-06 0 9.69755e-06 1.2 9.780833333333333e-06 1.2 9.780883333333333e-06 0 9.864166666666666e-06 0 9.864216666666666e-06 1.2 9.905833333333333e-06 1.2 9.905883333333333e-06 0 9.989166666666667e-06 0 9.989216666666668e-06 1.2 1.00725e-05 1.2 1.007255e-05 0 1.015583333333333e-05 0 1.015588333333333e-05 1.2 1.01975e-05 1.2 1.019755e-05 0 1.028083333333333e-05 0 1.028088333333333e-05 1.2 1.036416666666667e-05 1.2 1.036421666666667e-05 0 1.04475e-05 0 1.044755e-05 1.2 1.048916666666667e-05 1.2 1.048921666666667e-05 0 1.05725e-05 0 1.057255e-05 1.2 1.065583333333333e-05 1.2 1.065588333333333e-05 0 1.073916666666667e-05 0 1.073921666666667e-05 1.2 1.08225e-05 1.2 1.082255e-05 0 1.086416666666667e-05 0 1.086421666666667e-05 1.2 1.09475e-05 1.2 1.094755e-05 0 1.15725e-05 0 1.157255e-05 1.2 1.165583333333333e-05 1.2 1.165588333333333e-05 0 1.173916666666667e-05 0 1.173921666666667e-05 1.2 1.18225e-05 1.2 1.182255e-05 0 1.190583333333333e-05 0 1.190588333333333e-05 1.2 1.203083333333333e-05 1.2 1.203088333333333e-05 0 1.211416666666667e-05 0 1.211421666666667e-05 1.2 1.21975e-05 1.2 1.219755e-05 0 1.228083333333333e-05 0 1.228088333333333e-05 1.2 1.236416666666667e-05 1.2 1.236421666666667e-05 0 1.248916666666667e-05 0 1.248921666666667e-05 1.2 1.25725e-05 1.2 1.257255e-05 0 1.265583333333333e-05 0 1.265588333333333e-05 1.2 1.273916666666667e-05 1.2 1.273921666666667e-05 0 1.336416666666667e-05 0 1.336421666666667e-05 1.2 1.34475e-05 1.2 1.344755e-05 0 1.353083333333333e-05 0 1.353088333333333e-05 1.2 1.361416666666667e-05 1.2 1.361421666666667e-05 0 1.36975e-05 0 1.369755e-05 1.2 1.378083333333333e-05 1.2 1.378088333333333e-05 0 1.386416666666667e-05 0 1.386421666666667e-05 1.2 1.39475e-05 1.2 1.394755e-05 0 1.403083333333333e-05 0 1.403088333333333e-05 1.2 1.411416666666667e-05 1.2 1.411421666666667e-05 0 1.41975e-05 0 1.419755e-05 1.2 1.428083333333333e-05 1.2 1.428088333333333e-05 0 1.436416666666667e-05 0 1.436421666666667e-05 1.2 1.44475e-05 1.2 1.444755e-05 0 1.453083333333333e-05 0 1.453088333333333e-05 1.2 1.461416666666667e-05 1.2 1.461421666666667e-05 0 1.51975e-05 0 1.519755e-05 1.2 1.528083333333333e-05 1.2 1.528088333333333e-05 0 1.53225e-05 0 1.532255e-05 1.2 1.540583333333333e-05 1.2 1.540588333333333e-05 0 1.548916666666667e-05 0 1.548921666666667e-05 1.2 1.55725e-05 1.2 1.557255e-05 0 1.565583333333333e-05 0 1.565588333333333e-05 1.2 1.573916666666667e-05 1.2 1.573921666666667e-05 0 1.58225e-05 0 1.582255e-05 1.2 1.586416666666667e-05 1.2 1.586421666666667e-05 0 1.59475e-05 0 1.594755e-05 1.2 1.603083333333333e-05 1.2 1.603088333333333e-05 0 1.611416666666667e-05 0 1.611421666666667e-05 1.2 1.61975e-05 1.2 1.619755e-05 0 1.628083333333333e-05 0 1.628088333333333e-05 1.2 1.636416666666667e-05 1.2 1.636421666666667e-05 0 1.640583333333333e-05 0 1.640588333333333e-05 1.2 1.661416666666667e-05 1.2 1.661421666666667e-05 0 1.703083333333334e-05 0 1.703088333333334e-05 1.2 1.711416666666667e-05 1.2 1.711421666666667e-05 0 1.715583333333334e-05 0 1.715588333333334e-05 1.2 1.723916666666667e-05 1.2 1.723921666666667e-05 0 1.73225e-05 0 1.732255e-05 1.2 1.740583333333334e-05 1.2 1.740588333333334e-05 0 1.748916666666667e-05 0 1.748921666666667e-05 1.2 1.75725e-05 1.2 1.757255e-05 0 1.765583333333334e-05 0 1.765588333333334e-05 1.2 1.773916666666667e-05 1.2 1.773921666666667e-05 0 1.78225e-05 0 1.782255e-05 1.2 1.790583333333334e-05 1.2 1.790588333333334e-05 0 1.798916666666667e-05 0 1.798921666666667e-05 1.2 1.803083333333334e-05 1.2 1.803088333333334e-05 0 1.811416666666667e-05 0 1.811421666666667e-05 1.2 1.81975e-05 1.2 1.819755e-05 0 1.828083333333334e-05 0 1.828088333333334e-05 1.2 1.836416666666667e-05 1.2 1.836421666666667e-05 0 1.84475e-05 0 1.844755e-05 1.2 1.853083333333334e-05 1.2 1.853088333333334e-05 0 1.861416666666667e-05 0 1.861421666666667e-05 1.2 1.86975e-05 1.2 1.869755e-05 0 1.878083333333334e-05 0 1.878088333333334e-05 1.2 1.886416666666667e-05 1.2 1.886421666666667e-05 0 1.890583333333334e-05 0 1.890588333333334e-05 1.2 1.898916666666667e-05 1.2 1.898921666666667e-05 0 1.90725e-05 0 1.907255e-05 1.2 1.915583333333334e-05 1.2 1.915588333333334e-05 0 1.923916666666667e-05 0 1.923921666666667e-05 1.2 1.93225e-05 1.2 1.932255e-05 0 1.940583333333334e-05 0 1.940588333333334e-05 1.2 1.948916666666667e-05 1.2 1.948921666666667e-05 0 1.95725e-05 0 1.957255e-05 1.2 1.965583333333334e-05 1.2 1.965588333333334e-05 0 1.973916666666667e-05 0 1.973921666666667e-05 1.2 1.978083333333334e-05 1.2 1.978088333333334e-05 0 1.986416666666667e-05 0 1.986421666666667e-05 1.2 1.99475e-05 1.2 1.994755e-05 0 2.003083333333334e-05 0 2.003088333333334e-05 1.2 2.011416666666667e-05 1.2 2.011421666666667e-05 0 2.01975e-05 0 2.019755e-05 1.2 2.028083333333334e-05 1.2 2.028088333333334e-05 0 2.036416666666667e-05 0 2.036421666666667e-05 1.2 2.04475e-05 1.2 2.044755e-05 0 2.053083333333334e-05 0 2.053088333333334e-05 1.2 2.061416666666667e-05 1.2 2.061421666666667e-05 0 2.065583333333334e-05 0 2.065588333333334e-05 1.2 2.073916666666667e-05 1.2 2.073921666666667e-05 0 2.08225e-05 0 2.082255e-05 1.2 2.090583333333334e-05 1.2 2.090588333333334e-05 0 2.098916666666667e-05 0 2.098921666666667e-05 1.2 2.10725e-05 1.2 2.107255e-05 0 2.115583333333334e-05 0 2.115588333333334e-05 1.2 2.123916666666667e-05 1.2 2.123921666666667e-05 0 2.13225e-05 0 2.132255e-05 1.2 2.140583333333334e-05 1.2 2.140588333333334e-05 0 2.148916666666667e-05 0 2.148921666666667e-05 1.2 2.153083333333334e-05 1.2 2.153088333333334e-05 0 2.161416666666667e-05 0 2.161421666666667e-05 1.2 2.16975e-05 1.2 2.169755e-05 0 2.178083333333334e-05 0 2.178088333333334e-05 1.2 2.186416666666667e-05 1.2 2.186421666666667e-05 0 2.19475e-05 0 2.194755e-05 1.2 2.203083333333334e-05 1.2 2.203088333333334e-05 0 2.211416666666667e-05 0 2.211421666666667e-05 1.2 2.21975e-05 1.2 2.219755e-05 0 2.228083333333334e-05 0 2.228088333333334e-05 1.2 2.24475e-05 1.2 2.244755e-05 0 2.286416666666667e-05 0 2.286421666666667e-05 1.2 2.29475e-05 1.2 2.294755e-05 0 2.303083333333334e-05 0 2.303088333333334e-05 1.2 2.311416666666667e-05 1.2 2.311421666666667e-05 0 2.31975e-05 0 2.319755e-05 1.2 2.328083333333334e-05 1.2 2.328088333333334e-05 0 2.336416666666667e-05 0 2.336421666666667e-05 1.2 2.34475e-05 1.2 2.344755e-05 0 2.353083333333334e-05 0 2.353088333333334e-05 1.2 2.361416666666667e-05 1.2 2.361421666666667e-05 0 2.36975e-05 0 2.369755e-05 1.2 2.378083333333334e-05 1.2 2.378088333333334e-05 0 2.386416666666667e-05 0 2.386421666666667e-05 1.2 2.39475e-05 1.2 2.394755e-05 0 2.403083333333334e-05 0 2.403088333333334e-05 1.2 2.411416666666667e-05 1.2 2.411421666666667e-05 0 2.41975e-05 0 2.419755e-05 1.2 2.428083333333334e-05 1.2 2.428088333333334e-05 0 2.436416666666667e-05 0 2.436421666666667e-05 1.2 2.44475e-05 1.2 2.444755e-05 0 2.453083333333334e-05 0 2.453088333333334e-05 1.2 2.461416666666667e-05 1.2 2.461421666666667e-05 0 2.46975e-05 0 2.469755e-05 1.2 2.478083333333334e-05 1.2 2.478088333333334e-05 0 2.486416666666667e-05 0 2.486421666666667e-05 1.2 2.49475e-05 1.2 2.494755e-05 0 2.503083333333334e-05 0 2.503088333333334e-05 1.2 2.511416666666667e-05 1.2 2.511421666666667e-05 0 2.51975e-05 0 2.519755e-05 1.2 2.528083333333334e-05 1.2 2.528088333333334e-05 0 2.536416666666667e-05 0 2.536421666666667e-05 1.2 2.54475e-05 1.2 2.544755e-05 0 2.55725e-05 0 2.557255e-05 1.2 2.565583333333334e-05 1.2 2.565588333333334e-05 0 2.573916666666667e-05 0 2.573921666666667e-05 1.2 2.58225e-05 1.2 2.582255e-05 0 2.590583333333334e-05 0 2.590588333333334e-05 1.2 2.598916666666667e-05 1.2 2.598921666666667e-05 0 2.60725e-05 0 2.607255e-05 1.2 2.615583333333334e-05 1.2 2.615588333333334e-05 0 2.623916666666667e-05 0 2.623921666666667e-05 1.2 2.63225e-05 1.2 2.632255e-05 0 2.640583333333334e-05 0 2.640588333333334e-05 1.2 2.648916666666667e-05 1.2 2.648921666666667e-05 0 2.65725e-05 0 2.657255e-05 1.2 2.665583333333334e-05 1.2 2.665588333333334e-05 0 2.673916666666667e-05 0 2.673921666666667e-05 1.2 2.68225e-05 1.2 2.682255e-05 0 2.690583333333334e-05 0 2.690588333333334e-05 1.2 2.698916666666667e-05 1.2 2.698921666666667e-05 0 2.70725e-05 0 2.707255e-05 1.2 2.715583333333334e-05 1.2 2.715588333333334e-05 0 2.723916666666667e-05 0 2.723921666666667e-05 1.2 2.73225e-05 1.2 2.732255e-05 0 2.740583333333334e-05 0 2.740588333333334e-05 1.2 2.748916666666667e-05 1.2 2.748921666666667e-05 0 2.75725e-05 0 2.757255e-05 1.2 2.765583333333334e-05 1.2 2.765588333333334e-05 0 2.773916666666667e-05 0 2.773921666666667e-05 1.2 2.78225e-05 1.2 2.782255e-05 0 2.790583333333334e-05 0 2.790588333333334e-05 1.2 2.798916666666667e-05 1.2 2.798921666666667e-05 0 2.80725e-05 0 2.807255e-05 1.2 2.828083333333334e-05 1.2 2.828088333333334e-05 0 2.86975e-05 0 2.869755e-05 1.2 2.878083333333334e-05 1.2 2.878088333333334e-05 0 2.886416666666667e-05 0 2.886421666666667e-05 1.2 2.89475e-05 1.2 2.894755e-05 0 2.903083333333334e-05 0 2.903088333333334e-05 1.2 2.911416666666667e-05 1.2 2.911421666666667e-05 0 2.91975e-05 0 2.919755e-05 1.2 2.928083333333334e-05 1.2 2.928088333333334e-05 0 2.936416666666667e-05 0 2.936421666666667e-05 1.2 2.94475e-05 1.2 2.944755e-05 0 2.953083333333334e-05 0 2.953088333333334e-05 1.2 2.961416666666667e-05 1.2 2.961421666666667e-05 0 2.96975e-05 0 2.969755e-05 1.2 2.978083333333334e-05 1.2 2.978088333333334e-05 0 2.986416666666667e-05 0 2.986421666666667e-05 1.2 2.99475e-05 1.2 2.994755e-05 0 3.003083333333334e-05 0 3.003088333333334e-05 1.2 3.011416666666667e-05 1.2 3.011421666666667e-05 0 3.01975e-05 0 3.019755e-05 1.2 3.028083333333334e-05 1.2 3.028088333333334e-05 0 3.036416666666667e-05 0 3.036421666666667e-05 1.2 3.04475e-05 1.2 3.044755e-05 0 3.053083333333334e-05 0 3.053088333333333e-05 1.2 3.061416666666667e-05 1.2 3.061421666666667e-05 0 3.06975e-05 0 3.069755e-05 1.2 3.073916666666667e-05 1.2 3.073921666666667e-05 0 3.082250000000001e-05 0 3.082255e-05 1.2 3.090583333333334e-05 1.2 3.090588333333333e-05 0 3.098916666666667e-05 0 3.098921666666667e-05 1.2 3.10725e-05 1.2 3.107255e-05 0 3.115583333333334e-05 0 3.115588333333333e-05 1.2 3.123916666666667e-05 1.2 3.123921666666667e-05 0 3.13225e-05 0 3.132255e-05 1.2 3.140583333333334e-05 1.2 3.140588333333333e-05 0 3.148916666666667e-05 0 3.148921666666667e-05 1.2 3.15725e-05 1.2 3.157255e-05 0 3.165583333333334e-05 0 3.165588333333333e-05 1.2 3.173916666666667e-05 1.2 3.173921666666667e-05 0 3.18225e-05 0 3.182255e-05 1.2 3.190583333333334e-05 1.2 3.190588333333333e-05 0 3.198916666666667e-05 0 3.198921666666667e-05 1.2 3.20725e-05 1.2 3.207255e-05 0 3.215583333333333e-05 0 3.215588333333333e-05 1.2 3.223916666666667e-05 1.2 3.223921666666666e-05 0 3.23225e-05 0 3.232255e-05 1.2 3.240583333333334e-05 1.2 3.240588333333334e-05 0 3.248916666666667e-05 0 3.248921666666666e-05 1.2 3.25725e-05 1.2 3.257255e-05 0 3.265583333333334e-05 0 3.265588333333334e-05 1.2 3.273916666666667e-05 1.2 3.273921666666667e-05 0 3.282249999999999e-05 0 3.282254999999999e-05 1.2 3.290583333333333e-05 1.2 3.290588333333333e-05 0 3.298916666666667e-05 0 3.298921666666666e-05 1.2 3.30725e-05 1.2 3.307255e-05 0 3.315583333333333e-05 0 3.315588333333333e-05 1.2 3.31975e-05 1.2 3.319755e-05 0 3.328083333333333e-05 0 3.328088333333332e-05 1.2 3.336416666666667e-05 1.2 3.336421666666666e-05 0 3.34475e-05 0 3.344755e-05 1.2 3.353083333333333e-05 1.2 3.353088333333332e-05 0 3.361416666666667e-05 0 3.361421666666666e-05 1.2 3.36975e-05 1.2 3.369755e-05 0 3.378083333333333e-05 0 3.378088333333333e-05 1.2 3.386416666666667e-05 1.2 3.386421666666666e-05 0 3.39475e-05 0 3.394755e-05 1.2 3.411416666666667e-05 1.2 3.411421666666666e-05 0 3.453083333333333e-05 0 3.453088333333333e-05 1.2 3.461416666666666e-05 1.2 3.461421666666666e-05 0 3.46975e-05 0 3.469755e-05 1.2 3.478083333333333e-05 1.2 3.478088333333333e-05 0 3.486416666666666e-05 0 3.486421666666666e-05 1.2 3.49475e-05 1.2 3.494755e-05 0 3.503083333333333e-05 0 3.503088333333333e-05 1.2 3.511416666666666e-05 1.2 3.511421666666666e-05 0 3.51975e-05 0 3.519755e-05 1.2 3.528083333333333e-05 1.2 3.528088333333333e-05 0 3.536416666666667e-05 0 3.536421666666667e-05 1.2 3.54475e-05 1.2 3.544755e-05 0 3.553083333333333e-05 0 3.553088333333333e-05 1.2 3.561416666666667e-05 1.2 3.561421666666667e-05 0 3.56975e-05 0 3.569755e-05 1.2 3.578083333333333e-05 1.2 3.578088333333332e-05 0 3.586416666666667e-05 0 3.586421666666666e-05 1.2 3.59475e-05 1.2 3.594755e-05 0 3.603083333333333e-05 0 3.603088333333333e-05 1.2 3.611416666666667e-05 1.2 3.611421666666666e-05 0 3.61975e-05 0 3.619755e-05 1.2 3.628083333333333e-05 1.2 3.628088333333333e-05 0 3.636416666666667e-05 0 3.636421666666666e-05 1.2 3.64475e-05 1.2 3.644755e-05 0 3.653083333333333e-05 0 3.653088333333333e-05 1.2 3.661416666666667e-05 1.2 3.661421666666666e-05 0 3.669750000000001e-05 0 3.669755e-05 1.2 3.678083333333333e-05 1.2 3.678088333333333e-05 0 3.686416666666667e-05 0 3.686421666666666e-05 1.2 3.69475e-05 1.2 3.694755e-05 0 3.703083333333333e-05 0 3.703088333333333e-05 1.2 3.711416666666666e-05 1.2 3.711421666666666e-05 0 3.71975e-05 0 3.719755e-05 1.2 3.728083333333333e-05 1.2 3.728088333333333e-05 0 3.736416666666666e-05 0 3.736421666666666e-05 1.2 3.74475e-05 1.2 3.744755e-05 0 3.753083333333333e-05 0 3.753088333333333e-05 1.2 3.761416666666667e-05 1.2 3.761421666666667e-05 0 3.76975e-05 0 3.769755e-05 1.2 3.778083333333333e-05 1.2 3.778088333333333e-05 0 3.786416666666667e-05 0 3.786421666666667e-05 1.2 3.79475e-05 1.2 3.794755e-05 0 3.803083333333333e-05 0 3.803088333333333e-05 1.2 3.811416666666667e-05 1.2 3.811421666666667e-05 0 3.81975e-05 0 3.819755e-05 1.2 3.828083333333333e-05 1.2 3.828088333333332e-05 0 3.836416666666667e-05 0 3.836421666666666e-05 1.2 3.84475e-05 1.2 3.844755e-05 0 3.853083333333333e-05 0 3.853088333333333e-05 1.2 3.861416666666667e-05 1.2 3.861421666666666e-05 0 3.86975e-05 0 3.869755e-05 1.2 3.878083333333333e-05 1.2 3.878088333333333e-05 0 3.886416666666667e-05 0 3.886421666666666e-05 1.2 3.89475e-05 1.2 3.894755e-05 0 3.903083333333333e-05 0 3.903088333333333e-05 1.2 3.911416666666667e-05 1.2 3.911421666666666e-05 0 3.919750000000001e-05 0 3.919755e-05 1.2 3.928083333333333e-05 1.2 3.928088333333333e-05 0 3.936416666666666e-05 0 3.936421666666666e-05 1.2 3.94475e-05 1.2 3.944755e-05 0 3.953083333333333e-05 0 3.953088333333333e-05 1.2 3.961416666666666e-05 1.2 3.961421666666666e-05 0 3.96975e-05 0 3.969755e-05 1.2 3.978083333333333e-05 1.2 3.978088333333333e-05 0 4.036416666666667e-05 0 4.036421666666667e-05 1.2 4.04475e-05 1.2 4.044755e-05 0 4.053083333333333e-05 0 4.053088333333332e-05 1.2 4.061416666666667e-05 1.2 4.061421666666666e-05 0 4.06975e-05 0 4.069755e-05 1.2 4.078083333333333e-05 1.2 4.078088333333333e-05 0 4.086416666666667e-05 0 4.086421666666666e-05 1.2 4.09475e-05 1.2 4.094755e-05 0 4.103083333333333e-05 0 4.103088333333333e-05 1.2 4.111416666666667e-05 1.2 4.111421666666666e-05 0 4.11975e-05 0 4.119755e-05 1.2 4.128083333333333e-05 1.2 4.128088333333333e-05 0 4.136416666666667e-05 0 4.136421666666666e-05 1.2 4.144750000000001e-05 1.2 4.144755e-05 0 4.153083333333333e-05 0 4.153088333333333e-05 1.2 4.161416666666667e-05 1.2 4.161421666666666e-05 0 4.169750000000001e-05 0 4.169755e-05 1.2 4.178083333333333e-05 1.2 4.178088333333333e-05 0 4.186416666666666e-05 0 4.186421666666666e-05 1.2 4.19475e-05 1.2 4.194755e-05 0 4.203083333333333e-05 0 4.203088333333333e-05 1.2 4.211416666666666e-05 1.2 4.211421666666666e-05 0 4.21975e-05 0 4.219755e-05 1.2 4.228083333333333e-05 1.2 4.228088333333333e-05 0 4.236416666666667e-05 0 4.236421666666667e-05 1.2 4.24475e-05 1.2 4.244755e-05 0 4.253083333333333e-05 0 4.253088333333333e-05 1.2 4.261416666666667e-05 1.2 4.261421666666667e-05 0 4.26975e-05 0 4.269755e-05 1.2 4.278083333333333e-05 1.2 4.278088333333333e-05 0 4.286416666666667e-05 0 4.286421666666667e-05 1.2 4.29475e-05 1.2 4.294755e-05 0 4.303083333333333e-05 0 4.303088333333332e-05 1.2 4.315583333333333e-05 1.2 4.315588333333333e-05 0 4.323916666666666e-05 0 4.323921666666666e-05 1.2 4.33225e-05 1.2 4.332255e-05 0 4.340583333333333e-05 0 4.340588333333333e-05 1.2 4.348916666666667e-05 1.2 4.348921666666667e-05 0 4.35725e-05 0 4.357255e-05 1.2 4.365583333333333e-05 1.2 4.365588333333333e-05 0 4.373916666666667e-05 0 4.373921666666667e-05 1.2 4.38225e-05 1.2 4.382255e-05 0 4.390583333333333e-05 0 4.390588333333333e-05 1.2 4.398916666666667e-05 1.2 4.398921666666667e-05 0 4.40725e-05 0 4.407255e-05 1.2 4.415583333333333e-05 1.2 4.415588333333333e-05 0 4.423916666666667e-05 0 4.423921666666666e-05 1.2 4.43225e-05 1.2 4.432255e-05 0 4.440583333333333e-05 0 4.440588333333333e-05 1.2 4.448916666666667e-05 1.2 4.448921666666666e-05 0 4.45725e-05 0 4.457255e-05 1.2 4.465583333333333e-05 1.2 4.465588333333333e-05 0 4.473916666666667e-05 0 4.473921666666666e-05 1.2 4.48225e-05 1.2 4.482255e-05 0 4.490583333333333e-05 0 4.490588333333333e-05 1.2 4.498916666666667e-05 1.2 4.498921666666666e-05 0 4.507250000000001e-05 0 4.507255e-05 1.2 4.515583333333333e-05 1.2 4.515588333333333e-05 0 4.523916666666667e-05 0 4.523921666666666e-05 1.2 4.532250000000001e-05 1.2 4.532255e-05 0 4.540583333333333e-05 0 4.540588333333333e-05 1.2 4.548916666666666e-05 1.2 4.548921666666666e-05 0 4.55725e-05 0 4.557255e-05 1.2 4.578083333333333e-05 1.2 4.578088333333333e-05 0 4.619750000000001e-05 0 4.619755e-05 1.2 4.628083333333333e-05 1.2 4.628088333333333e-05 0 4.636416666666667e-05 0 4.636421666666666e-05 1.2 4.644750000000001e-05 1.2 4.644755e-05 0 4.653083333333333e-05 0 4.653088333333333e-05 1.2 4.661416666666666e-05 1.2 4.661421666666666e-05 0 4.66975e-05 0 4.669755e-05 1.2 4.678083333333333e-05 1.2 4.678088333333333e-05 0 4.686416666666666e-05 0 4.686421666666666e-05 1.2 4.69475e-05 1.2 4.694755e-05 0 4.703083333333333e-05 0 4.703088333333333e-05 1.2 4.711416666666667e-05 1.2 4.711421666666667e-05 0 4.71975e-05 0 4.719755e-05 1.2 4.728083333333333e-05 1.2 4.728088333333333e-05 0 4.736416666666667e-05 0 4.736421666666667e-05 1.2 4.74475e-05 1.2 4.744755e-05 0 4.753083333333333e-05 0 4.753088333333333e-05 1.2 4.761416666666667e-05 1.2 4.761421666666667e-05 0 4.76975e-05 0 4.769755e-05 1.2 4.778083333333333e-05 1.2 4.778088333333333e-05 0 4.786416666666667e-05 0 4.786421666666666e-05 1.2 4.79475e-05 1.2 4.794755e-05 0 4.803083333333333e-05 0 4.803088333333333e-05 1.2 4.811416666666667e-05 1.2 4.811421666666666e-05 0 4.81975e-05 0 4.819755e-05 1.2 4.828083333333333e-05 1.2 4.828088333333333e-05 0 4.836416666666667e-05 0 4.836421666666666e-05 1.2 4.84475e-05 1.2 4.844755e-05 0 4.853083333333333e-05 0 4.853088333333333e-05 1.2 4.861416666666667e-05 1.2 4.861421666666666e-05 0 4.869750000000001e-05 0 4.869755e-05 1.2 4.878083333333333e-05 1.2 4.878088333333333e-05 0 4.886416666666667e-05 0 4.886421666666666e-05 1.2 4.894750000000001e-05 1.2 4.894755e-05 0 4.903083333333333e-05 0 4.903088333333333e-05 1.2 4.911416666666666e-05 1.2 4.911421666666666e-05 0 4.91975e-05 0 4.919755e-05 1.2 4.928083333333333e-05 1.2 4.928088333333333e-05 0 4.936416666666666e-05 0 4.936421666666666e-05 1.2 4.94475e-05 1.2 4.944755e-05 0 4.953083333333333e-05 0 4.953088333333333e-05 1.2 4.961416666666667e-05 1.2 4.961421666666667e-05 0 4.96975e-05 0 4.969755e-05 1.2 4.978083333333333e-05 1.2 4.978088333333333e-05 0 4.986416666666667e-05 0 4.986421666666667e-05 1.2 4.99475e-05 1.2 4.994755e-05 0 5.003083333333333e-05 0 5.003088333333333e-05 1.2 5.011416666666667e-05 1.2 5.011421666666667e-05 0 5.01975e-05 0 5.019755e-05 1.2 5.028083333333333e-05 1.2 5.028088333333333e-05 0 5.036416666666667e-05 0 5.036421666666666e-05 1.2 5.04475e-05 1.2 5.044755e-05 0 5.053083333333333e-05 0 5.053088333333333e-05 1.2 5.061416666666667e-05 1.2 5.061421666666666e-05 0 5.06975e-05 0 5.069755e-05 1.2 5.078083333333333e-05 1.2 5.078088333333333e-05 0 5.086416666666667e-05 0 5.086421666666666e-05 1.2 5.094750000000001e-05 1.2 5.094755e-05 0 5.103083333333333e-05 0 5.103088333333333e-05 1.2 5.111416666666667e-05 1.2 5.111421666666666e-05 0 5.119750000000001e-05 0 5.119755e-05 1.2 5.128083333333333e-05 1.2 5.128088333333333e-05 0 5.136416666666667e-05 0 5.136421666666666e-05 1.2 5.144750000000001e-05 1.2 5.144755e-05 0]
VM2 (m2 0) vsource type=pwl wave=[0 0 5.724999999999999e-07 0 5.725499999999999e-07 1.2 6.558333333333333e-07 1.2 6.558833333333333e-07 0 7.808333333333333e-07 0 7.808833333333333e-07 1.2 8.641666666666667e-07 1.2 8.642166666666667e-07 0 9.891666666666668e-07 0 9.892166666666667e-07 1.2 1.0725e-06 1.2 1.07255e-06 0 1.1975e-06 0 1.19755e-06 1.2 1.280833333333333e-06 1.2 1.280883333333333e-06 0 1.405833333333334e-06 0 1.405883333333333e-06 1.2 1.489166666666667e-06 1.2 1.489216666666667e-06 0 1.614166666666667e-06 0 1.614216666666667e-06 1.2 1.6975e-06 1.2 1.69755e-06 0 2.364166666666667e-06 0 2.364216666666667e-06 1.2 2.4475e-06 1.2 2.44755e-06 0 2.489166666666667e-06 0 2.489216666666667e-06 1.2 2.5725e-06 1.2 2.57255e-06 0 2.655833333333333e-06 0 2.655883333333333e-06 1.2 2.6975e-06 1.2 2.69755e-06 0 2.780833333333333e-06 0 2.780883333333333e-06 1.2 2.864166666666667e-06 1.2 2.864216666666667e-06 0 2.905833333333333e-06 0 2.905883333333333e-06 1.2 2.989166666666667e-06 1.2 2.989216666666667e-06 0 3.0725e-06 0 3.07255e-06 1.2 3.114166666666667e-06 1.2 3.114216666666667e-06 0 3.1975e-06 0 3.19755e-06 1.2 3.280833333333333e-06 1.2 3.280883333333334e-06 0 3.3225e-06 0 3.32255e-06 1.2 3.405833333333333e-06 1.2 3.405883333333333e-06 0 3.489166666666667e-06 0 3.489216666666667e-06 1.2 3.530833333333333e-06 1.2 3.530883333333333e-06 0 3.614166666666667e-06 0 3.614216666666667e-06 1.2 3.780833333333333e-06 1.2 3.780883333333333e-06 0 4.155833333333333e-06 0 4.155883333333334e-06 1.2 4.239166666666667e-06 1.2 4.239216666666668e-06 0 4.322500000000001e-06 0 4.322550000000001e-06 1.2 4.405833333333334e-06 1.2 4.405883333333335e-06 0 4.489166666666668e-06 0 4.489216666666668e-06 1.2 4.572500000000001e-06 1.2 4.572550000000001e-06 0 4.655833333333335e-06 0 4.655883333333335e-06 1.2 4.739166666666667e-06 1.2 4.739216666666667e-06 0 4.8225e-06 0 4.82255e-06 1.2 4.905833333333334e-06 1.2 4.905883333333334e-06 0 4.989166666666667e-06 0 4.989216666666667e-06 1.2 5.0725e-06 1.2 5.07255e-06 0 5.155833333333334e-06 0 5.155883333333334e-06 1.2 5.239166666666667e-06 1.2 5.239216666666667e-06 0 5.3225e-06 0 5.32255e-06 1.2 5.405833333333334e-06 1.2 5.405883333333334e-06 0 6.030833333333334e-06 0 6.030883333333334e-06 1.2 6.8225e-06 1.2 6.82255e-06 0 8.030833333333335e-06 0 8.030883333333335e-06 1.2 8.280833333333334e-06 1.2 8.280883333333334e-06 0 8.530833333333333e-06 0 8.530883333333333e-06 1.2 8.780833333333332e-06 1.2 8.780883333333333e-06 0 9.030833333333333e-06 0 9.030883333333334e-06 1.2 9.280833333333333e-06 1.2 9.280883333333333e-06 0 9.780833333333333e-06 0 9.780883333333333e-06 1.2 9.905833333333333e-06 1.2 9.905883333333333e-06 0 1.00725e-05 0 1.007255e-05 1.2 1.01975e-05 1.2 1.019755e-05 0 1.036416666666667e-05 0 1.036421666666667e-05 1.2 1.048916666666667e-05 1.2 1.048921666666667e-05 0 1.065583333333333e-05 0 1.065588333333333e-05 1.2 1.08225e-05 1.2 1.082255e-05 0 1.09475e-05 0 1.094755e-05 1.2 1.111416666666667e-05 1.2 1.111421666666667e-05 0 1.165583333333333e-05 0 1.165588333333333e-05 1.2 1.18225e-05 1.2 1.182255e-05 0 1.203083333333333e-05 0 1.203088333333333e-05 1.2 1.21975e-05 1.2 1.219755e-05 0 1.236416666666667e-05 0 1.236421666666667e-05 1.2 1.25725e-05 1.2 1.257255e-05 0 1.273916666666667e-05 0 1.273921666666667e-05 1.2 1.29475e-05 1.2 1.294755e-05 0 1.34475e-05 0 1.344755e-05 1.2 1.361416666666667e-05 1.2 1.361421666666667e-05 0 1.378083333333333e-05 0 1.378088333333333e-05 1.2 1.39475e-05 1.2 1.394755e-05 0 1.411416666666667e-05 0 1.411421666666667e-05 1.2 1.428083333333333e-05 1.2 1.428088333333333e-05 0 1.44475e-05 0 1.444755e-05 1.2 1.461416666666667e-05 1.2 1.461421666666667e-05 0 1.528083333333333e-05 0 1.528088333333333e-05 1.2 1.540583333333333e-05 1.2 1.540588333333333e-05 0 1.55725e-05 0 1.557255e-05 1.2 1.573916666666667e-05 1.2 1.573921666666667e-05 0 1.586416666666667e-05 0 1.586421666666667e-05 1.2 1.603083333333333e-05 1.2 1.603088333333333e-05 0 1.61975e-05 0 1.619755e-05 1.2 1.636416666666667e-05 1.2 1.636421666666667e-05 0 1.711416666666667e-05 0 1.711421666666667e-05 1.2 1.723916666666667e-05 1.2 1.723921666666667e-05 0 1.740583333333334e-05 0 1.740588333333334e-05 1.2 1.75725e-05 1.2 1.757255e-05 0 1.773916666666667e-05 0 1.773921666666667e-05 1.2 1.790583333333334e-05 1.2 1.790588333333334e-05 0 1.803083333333334e-05 0 1.803088333333334e-05 1.2 1.81975e-05 1.2 1.819755e-05 0 1.836416666666667e-05 0 1.836421666666667e-05 1.2 1.853083333333334e-05 1.2 1.853088333333334e-05 0 1.86975e-05 0 1.869755e-05 1.2 1.886416666666667e-05 1.2 1.886421666666667e-05 0 1.898916666666667e-05 0 1.898921666666667e-05 1.2 1.915583333333334e-05 1.2 1.915588333333334e-05 0 1.93225e-05 0 1.932255e-05 1.2 1.948916666666667e-05 1.2 1.948921666666667e-05 0 1.965583333333334e-05 0 1.965588333333334e-05 1.2 1.978083333333334e-05 1.2 1.978088333333334e-05 0 1.99475e-05 0 1.994755e-05 1.2 2.011416666666667e-05 1.2 2.011421666666667e-05 0 2.028083333333334e-05 0 2.028088333333334e-05 1.2 2.04475e-05 1.2 2.044755e-05 0 2.061416666666667e-05 0 2.061421666666667e-05 1.2 2.073916666666667e-05 1.2 2.073921666666667e-05 0 2.090583333333334e-05 0 2.090588333333334e-05 1.2 2.10725e-05 1.2 2.107255e-05 0 2.123916666666667e-05 0 2.123921666666667e-05 1.2 2.140583333333334e-05 1.2 2.140588333333334e-05 0 2.153083333333334e-05 0 2.153088333333334e-05 1.2 2.16975e-05 1.2 2.169755e-05 0 2.186416666666667e-05 0 2.186421666666667e-05 1.2 2.203083333333334e-05 1.2 2.203088333333334e-05 0 2.21975e-05 0 2.219755e-05 1.2 2.24475e-05 1.2 2.244755e-05 0 2.29475e-05 0 2.294755e-05 1.2 2.311416666666667e-05 1.2 2.311421666666667e-05 0 2.328083333333334e-05 0 2.328088333333334e-05 1.2 2.34475e-05 1.2 2.344755e-05 0 2.361416666666667e-05 0 2.361421666666667e-05 1.2 2.378083333333334e-05 1.2 2.378088333333334e-05 0 2.39475e-05 0 2.394755e-05 1.2 2.411416666666667e-05 1.2 2.411421666666667e-05 0 2.428083333333334e-05 0 2.428088333333334e-05 1.2 2.44475e-05 1.2 2.444755e-05 0 2.461416666666667e-05 0 2.461421666666667e-05 1.2 2.478083333333334e-05 1.2 2.478088333333334e-05 0 2.49475e-05 0 2.494755e-05 1.2 2.511416666666667e-05 1.2 2.511421666666667e-05 0 2.528083333333334e-05 0 2.528088333333334e-05 1.2 2.54475e-05 1.2 2.544755e-05 0 2.565583333333334e-05 0 2.565588333333334e-05 1.2 2.58225e-05 1.2 2.582255e-05 0 2.598916666666667e-05 0 2.598921666666667e-05 1.2 2.615583333333334e-05 1.2 2.615588333333334e-05 0 2.63225e-05 0 2.632255e-05 1.2 2.648916666666667e-05 1.2 2.648921666666667e-05 0 2.665583333333334e-05 0 2.665588333333334e-05 1.2 2.68225e-05 1.2 2.682255e-05 0 2.698916666666667e-05 0 2.698921666666667e-05 1.2 2.715583333333334e-05 1.2 2.715588333333334e-05 0 2.73225e-05 0 2.732255e-05 1.2 2.748916666666667e-05 1.2 2.748921666666667e-05 0 2.765583333333334e-05 0 2.765588333333334e-05 1.2 2.78225e-05 1.2 2.782255e-05 0 2.798916666666667e-05 0 2.798921666666667e-05 1.2 2.828083333333334e-05 1.2 2.828088333333334e-05 0 2.878083333333334e-05 0 2.878088333333334e-05 1.2 2.89475e-05 1.2 2.894755e-05 0 2.911416666666667e-05 0 2.911421666666667e-05 1.2 2.928083333333334e-05 1.2 2.928088333333334e-05 0 2.94475e-05 0 2.944755e-05 1.2 2.961416666666667e-05 1.2 2.961421666666667e-05 0 2.978083333333334e-05 0 2.978088333333334e-05 1.2 2.99475e-05 1.2 2.994755e-05 0 3.011416666666667e-05 0 3.011421666666667e-05 1.2 3.028083333333334e-05 1.2 3.028088333333334e-05 0 3.04475e-05 0 3.044755e-05 1.2 3.061416666666667e-05 1.2 3.061421666666667e-05 0 3.073916666666667e-05 0 3.073921666666667e-05 1.2 3.090583333333334e-05 1.2 3.090588333333333e-05 0 3.10725e-05 0 3.107255e-05 1.2 3.123916666666667e-05 1.2 3.123921666666667e-05 0 3.140583333333334e-05 0 3.140588333333333e-05 1.2 3.15725e-05 1.2 3.157255e-05 0 3.173916666666667e-05 0 3.173921666666667e-05 1.2 3.190583333333334e-05 1.2 3.190588333333333e-05 0 3.20725e-05 0 3.207255e-05 1.2 3.223916666666667e-05 1.2 3.223921666666666e-05 0 3.240583333333334e-05 0 3.240588333333334e-05 1.2 3.25725e-05 1.2 3.257255e-05 0 3.273916666666667e-05 0 3.273921666666667e-05 1.2 3.290583333333333e-05 1.2 3.290588333333333e-05 0 3.30725e-05 0 3.307255e-05 1.2 3.31975e-05 1.2 3.319755e-05 0 3.336416666666667e-05 0 3.336421666666666e-05 1.2 3.353083333333333e-05 1.2 3.353088333333332e-05 0 3.36975e-05 0 3.369755e-05 1.2 3.386416666666667e-05 1.2 3.386421666666666e-05 0 3.461416666666666e-05 0 3.461421666666666e-05 1.2 3.478083333333333e-05 1.2 3.478088333333333e-05 0 3.49475e-05 0 3.494755e-05 1.2 3.511416666666666e-05 1.2 3.511421666666666e-05 0 3.528083333333333e-05 0 3.528088333333333e-05 1.2 3.54475e-05 1.2 3.544755e-05 0 3.561416666666667e-05 0 3.561421666666667e-05 1.2 3.578083333333333e-05 1.2 3.578088333333332e-05 0 3.59475e-05 0 3.594755e-05 1.2 3.611416666666667e-05 1.2 3.611421666666666e-05 0 3.628083333333333e-05 0 3.628088333333333e-05 1.2 3.64475e-05 1.2 3.644755e-05 0 3.661416666666667e-05 0 3.661421666666666e-05 1.2 3.678083333333333e-05 1.2 3.678088333333333e-05 0 3.69475e-05 0 3.694755e-05 1.2 3.711416666666666e-05 1.2 3.711421666666666e-05 0 3.728083333333333e-05 0 3.728088333333333e-05 1.2 3.74475e-05 1.2 3.744755e-05 0 3.761416666666667e-05 0 3.761421666666667e-05 1.2 3.778083333333333e-05 1.2 3.778088333333333e-05 0 3.79475e-05 0 3.794755e-05 1.2 3.811416666666667e-05 1.2 3.811421666666667e-05 0 3.828083333333333e-05 0 3.828088333333332e-05 1.2 3.84475e-05 1.2 3.844755e-05 0 3.861416666666667e-05 0 3.861421666666666e-05 1.2 3.878083333333333e-05 1.2 3.878088333333333e-05 0 3.89475e-05 0 3.894755e-05 1.2 3.911416666666667e-05 1.2 3.911421666666666e-05 0 3.928083333333333e-05 0 3.928088333333333e-05 1.2 3.94475e-05 1.2 3.944755e-05 0 3.961416666666666e-05 0 3.961421666666666e-05 1.2 3.978083333333333e-05 1.2 3.978088333333333e-05 0 4.04475e-05 0 4.044755e-05 1.2 4.061416666666667e-05 1.2 4.061421666666666e-05 0 4.078083333333333e-05 0 4.078088333333333e-05 1.2 4.09475e-05 1.2 4.094755e-05 0 4.111416666666667e-05 0 4.111421666666666e-05 1.2 4.128083333333333e-05 1.2 4.128088333333333e-05 0 4.144750000000001e-05 0 4.144755e-05 1.2 4.161416666666667e-05 1.2 4.161421666666666e-05 0 4.178083333333333e-05 0 4.178088333333333e-05 1.2 4.19475e-05 1.2 4.194755e-05 0 4.211416666666666e-05 0 4.211421666666666e-05 1.2 4.228083333333333e-05 1.2 4.228088333333333e-05 0 4.24475e-05 0 4.244755e-05 1.2 4.261416666666667e-05 1.2 4.261421666666667e-05 0 4.278083333333333e-05 0 4.278088333333333e-05 1.2 4.29475e-05 1.2 4.294755e-05 0 4.315583333333333e-05 0 4.315588333333333e-05 1.2 4.33225e-05 1.2 4.332255e-05 0 4.348916666666667e-05 0 4.348921666666667e-05 1.2 4.365583333333333e-05 1.2 4.365588333333333e-05 0 4.38225e-05 0 4.382255e-05 1.2 4.398916666666667e-05 1.2 4.398921666666667e-05 0 4.415583333333333e-05 0 4.415588333333333e-05 1.2 4.43225e-05 1.2 4.432255e-05 0 4.448916666666667e-05 0 4.448921666666666e-05 1.2 4.465583333333333e-05 1.2 4.465588333333333e-05 0 4.48225e-05 0 4.482255e-05 1.2 4.498916666666667e-05 1.2 4.498921666666666e-05 0 4.515583333333333e-05 0 4.515588333333333e-05 1.2 4.532250000000001e-05 1.2 4.532255e-05 0 4.548916666666666e-05 0 4.548921666666666e-05 1.2 4.578083333333333e-05 1.2 4.578088333333333e-05 0 4.628083333333333e-05 0 4.628088333333333e-05 1.2 4.644750000000001e-05 1.2 4.644755e-05 0 4.661416666666666e-05 0 4.661421666666666e-05 1.2 4.678083333333333e-05 1.2 4.678088333333333e-05 0 4.69475e-05 0 4.694755e-05 1.2 4.711416666666667e-05 1.2 4.711421666666667e-05 0 4.728083333333333e-05 0 4.728088333333333e-05 1.2 4.74475e-05 1.2 4.744755e-05 0 4.761416666666667e-05 0 4.761421666666667e-05 1.2 4.778083333333333e-05 1.2 4.778088333333333e-05 0 4.79475e-05 0 4.794755e-05 1.2 4.811416666666667e-05 1.2 4.811421666666666e-05 0 4.828083333333333e-05 0 4.828088333333333e-05 1.2 4.84475e-05 1.2 4.844755e-05 0 4.861416666666667e-05 0 4.861421666666666e-05 1.2 4.878083333333333e-05 1.2 4.878088333333333e-05 0 4.894750000000001e-05 0 4.894755e-05 1.2 4.911416666666666e-05 1.2 4.911421666666666e-05 0 4.928083333333333e-05 0 4.928088333333333e-05 1.2 4.94475e-05 1.2 4.944755e-05 0 4.961416666666667e-05 0 4.961421666666667e-05 1.2 4.978083333333333e-05 1.2 4.978088333333333e-05 0 4.99475e-05 0 4.994755e-05 1.2 5.011416666666667e-05 1.2 5.011421666666667e-05 0 5.028083333333333e-05 0 5.028088333333333e-05 1.2 5.04475e-05 1.2 5.044755e-05 0 5.061416666666667e-05 0 5.061421666666666e-05 1.2 5.078083333333333e-05 1.2 5.078088333333333e-05 0 5.094750000000001e-05 0 5.094755e-05 1.2 5.111416666666667e-05 1.2 5.111421666666666e-05 0 5.128083333333333e-05 0 5.128088333333333e-05 1.2 5.144750000000001e-05 1.2 5.144755e-05 0]
VM3 (m3 0) vsource type=pwl wave=[0 0 4.891666666666667e-07 0 4.892166666666667e-07 1.2 5.308333333333334e-07 1.2 5.308833333333334e-07 0 5.724999999999999e-07 0 5.725499999999999e-07 1.2 6.141666666666667e-07 1.2 6.142166666666667e-07 0 6.975e-07 0 6.9755e-07 1.2 7.391666666666666e-07 1.2 7.392166666666667e-07 0 7.808333333333333e-07 0 7.808833333333333e-07 1.2 8.225000000000001e-07 1.2 8.225500000000001e-07 0 9.058333333333333e-07 0 9.058833333333333e-07 1.2 9.475e-07 1.2 9.4755e-07 0 9.891666666666668e-07 0 9.892166666666667e-07 1.2 1.030833333333333e-06 1.2 1.030883333333333e-06 0 1.114166666666667e-06 0 1.114216666666667e-06 1.2 1.155833333333334e-06 1.2 1.155883333333334e-06 0 1.1975e-06 0 1.19755e-06 1.2 1.239166666666667e-06 1.2 1.239216666666667e-06 0 1.3225e-06 0 1.32255e-06 1.2 1.364166666666667e-06 1.2 1.364216666666667e-06 0 1.405833333333334e-06 0 1.405883333333333e-06 1.2 1.4475e-06 1.2 1.44755e-06 0 1.530833333333334e-06 0 1.530883333333334e-06 1.2 1.5725e-06 1.2 1.57255e-06 0 1.614166666666667e-06 0 1.614216666666667e-06 1.2 1.655833333333334e-06 1.2 1.655883333333333e-06 0 1.739166666666667e-06 0 1.739216666666667e-06 1.2 1.780833333333334e-06 1.2 1.780883333333333e-06 0 2.4475e-06 0 2.44755e-06 1.2 2.5725e-06 1.2 2.57255e-06 0 2.6975e-06 0 2.69755e-06 1.2 2.864166666666667e-06 1.2 2.864216666666667e-06 0 2.989166666666667e-06 0 2.989216666666667e-06 1.2 3.114166666666667e-06 1.2 3.114216666666667e-06 0 3.280833333333333e-06 0 3.280883333333334e-06 1.2 3.405833333333333e-06 1.2 3.405883333333333e-06 0 3.530833333333333e-06 0 3.530883333333333e-06 1.2 3.780833333333333e-06 1.2 3.780883333333333e-06 0 4.197500000000001e-06 0 4.197550000000001e-06 1.2 4.239166666666667e-06 1.2 4.239216666666668e-06 0 4.280833333333334e-06 0 4.280883333333334e-06 1.2 4.364166666666667e-06 1.2 4.364216666666667e-06 0 4.405833333333334e-06 0 4.405883333333335e-06 1.2 4.4475e-06 1.2 4.44755e-06 0 4.530833333333334e-06 0 4.530883333333334e-06 1.2 4.572500000000001e-06 1.2 4.572550000000001e-06 0 4.614166666666667e-06 0 4.614216666666667e-06 1.2 4.6975e-06 1.2 4.69755e-06 0 4.739166666666667e-06 0 4.739216666666667e-06 1.2 4.780833333333334e-06 1.2 4.780883333333334e-06 0 4.864166666666667e-06 0 4.864216666666667e-06 1.2 4.905833333333334e-06 1.2 4.905883333333334e-06 0 4.9475e-06 0 4.947550000000001e-06 1.2 5.030833333333334e-06 1.2 5.030883333333335e-06 0 5.0725e-06 0 5.07255e-06 1.2 5.114166666666668e-06 1.2 5.114216666666668e-06 0 5.197500000000001e-06 0 5.197550000000001e-06 1.2 5.239166666666667e-06 1.2 5.239216666666667e-06 0 5.280833333333335e-06 0 5.280883333333335e-06 1.2 5.364166666666668e-06 1.2 5.364216666666668e-06 0 5.405833333333334e-06 0 5.405883333333334e-06 1.2 5.4475e-06 1.2 5.44755e-06 0 5.989166666666668e-06 0 5.989216666666668e-06 1.2 6.072500000000001e-06 1.2 6.072550000000001e-06 0 6.114166666666667e-06 0 6.114216666666667e-06 1.2 6.155833333333335e-06 1.2 6.155883333333335e-06 0 6.1975e-06 0 6.19755e-06 1.2 6.239166666666668e-06 1.2 6.239216666666668e-06 0 6.280833333333334e-06 0 6.280883333333334e-06 1.2 6.3225e-06 1.2 6.32255e-06 0 6.364166666666667e-06 0 6.364216666666668e-06 1.2 6.405833333333334e-06 1.2 6.405883333333334e-06 0 6.447500000000001e-06 0 6.447550000000001e-06 1.2 6.489166666666667e-06 1.2 6.489216666666667e-06 0 6.530833333333334e-06 0 6.530883333333335e-06 1.2 6.5725e-06 1.2 6.57255e-06 0 6.614166666666668e-06 0 6.614216666666668e-06 1.2 6.655833333333334e-06 1.2 6.655883333333334e-06 0 6.697500000000001e-06 0 6.697550000000001e-06 1.2 6.739166666666667e-06 1.2 6.739216666666667e-06 0 6.780833333333335e-06 0 6.780883333333335e-06 1.2 6.8225e-06 1.2 6.82255e-06 0 6.864166666666668e-06 0 6.864216666666668e-06 1.2 6.905833333333334e-06 1.2 6.905883333333334e-06 0 6.947500000000001e-06 0 6.947550000000001e-06 1.2 6.989166666666667e-06 1.2 6.989216666666667e-06 0 7.030833333333335e-06 0 7.030883333333335e-06 1.2 7.0725e-06 1.2 7.072550000000001e-06 0 7.114166666666667e-06 0 7.114216666666667e-06 1.2 7.155833333333334e-06 1.2 7.155883333333335e-06 0 7.1975e-06 0 7.19755e-06 1.2 7.239166666666668e-06 1.2 7.239216666666668e-06 0 7.280833333333334e-06 0 7.280883333333334e-06 1.2 7.4475e-06 1.2 7.44755e-06 0 7.8225e-06 0 7.82255e-06 1.2 7.864166666666667e-06 1.2 7.864216666666667e-06 0 7.905833333333335e-06 0 7.905883333333335e-06 1.2 7.9475e-06 1.2 7.94755e-06 0 7.989166666666668e-06 0 7.989216666666668e-06 1.2 8.030833333333335e-06 1.2 8.030883333333335e-06 0 8.072500000000001e-06 0 8.072550000000001e-06 1.2 8.114166666666668e-06 1.2 8.114216666666668e-06 0 8.155833333333334e-06 0 8.155883333333334e-06 1.2 8.197499999999999e-06 1.2 8.197549999999999e-06 0 8.239166666666667e-06 0 8.239216666666667e-06 1.2 8.3225e-06 1.2 8.32255e-06 0 8.364166666666667e-06 0 8.364216666666667e-06 1.2 8.405833333333333e-06 1.2 8.405883333333334e-06 0 8.4475e-06 0 8.44755e-06 1.2 8.489166666666667e-06 1.2 8.489216666666667e-06 0 8.530833333333333e-06 0 8.530883333333333e-06 1.2 8.572500000000001e-06 1.2 8.572550000000001e-06 0 8.614166666666666e-06 0 8.614216666666666e-06 1.2 8.655833333333333e-06 1.2 8.655883333333333e-06 0 8.697500000000001e-06 0 8.697550000000001e-06 1.2 8.739166666666666e-06 1.2 8.739216666666666e-06 0 8.822500000000001e-06 0 8.822550000000001e-06 1.2 8.864166666666667e-06 1.2 8.864216666666667e-06 0 8.905833333333332e-06 0 8.905883333333332e-06 1.2 8.9475e-06 1.2 8.94755e-06 0 8.989166666666667e-06 0 8.989216666666667e-06 1.2 9.030833333333333e-06 1.2 9.030883333333334e-06 0 9.0725e-06 0 9.07255e-06 1.2 9.114166666666667e-06 1.2 9.114216666666667e-06 0 9.655833333333333e-06 0 9.655883333333333e-06 1.2 9.6975e-06 1.2 9.69755e-06 0 9.739166666666666e-06 0 9.739216666666667e-06 1.2 9.780833333333333e-06 1.2 9.780883333333333e-06 0 9.822500000000001e-06 0 9.822550000000001e-06 1.2 9.864166666666666e-06 1.2 9.864216666666666e-06 0 9.947500000000001e-06 0 9.947550000000001e-06 1.2 9.989166666666667e-06 1.2 9.989216666666668e-06 0 1.003083333333333e-05 0 1.003088333333333e-05 1.2 1.00725e-05 1.2 1.007255e-05 0 1.011416666666667e-05 0 1.011421666666667e-05 1.2 1.015583333333333e-05 1.2 1.015588333333333e-05 0 1.023916666666667e-05 0 1.023921666666667e-05 1.2 1.028083333333333e-05 1.2 1.028088333333333e-05 0 1.03225e-05 0 1.032255e-05 1.2 1.036416666666667e-05 1.2 1.036421666666667e-05 0 1.040583333333333e-05 0 1.040588333333333e-05 1.2 1.04475e-05 1.2 1.044755e-05 0 1.053083333333333e-05 0 1.053088333333333e-05 1.2 1.05725e-05 1.2 1.057255e-05 0 1.061416666666667e-05 0 1.061421666666667e-05 1.2 1.065583333333333e-05 1.2 1.065588333333333e-05 0 1.06975e-05 0 1.069755e-05 1.2 1.073916666666667e-05 1.2 1.073921666666667e-05 0 1.078083333333333e-05 0 1.078088333333333e-05 1.2 1.086416666666667e-05 1.2 1.086421666666667e-05 0 1.090583333333333e-05 0 1.090588333333333e-05 1.2 1.09475e-05 1.2 1.094755e-05 0 1.148916666666667e-05 0 1.148921666666667e-05 1.2 1.153083333333333e-05 1.2 1.153088333333333e-05 0 1.15725e-05 0 1.157255e-05 1.2 1.161416666666667e-05 1.2 1.161421666666667e-05 0 1.165583333333333e-05 0 1.165588333333333e-05 1.2 1.16975e-05 1.2 1.169755e-05 0 1.173916666666667e-05 0 1.173921666666667e-05 1.2 1.178083333333333e-05 1.2 1.178088333333333e-05 0 1.186416666666667e-05 0 1.186421666666667e-05 1.2 1.190583333333333e-05 1.2 1.190588333333333e-05 0 1.19475e-05 0 1.194755e-05 1.2 1.198916666666667e-05 1.2 1.198921666666667e-05 0 1.203083333333333e-05 0 1.203088333333333e-05 1.2 1.20725e-05 1.2 1.207255e-05 0 1.211416666666667e-05 0 1.211421666666667e-05 1.2 1.215583333333333e-05 1.2 1.215588333333333e-05 0 1.223916666666667e-05 0 1.223921666666667e-05 1.2 1.228083333333333e-05 1.2 1.228088333333333e-05 0 1.23225e-05 0 1.232255e-05 1.2 1.236416666666667e-05 1.2 1.236421666666667e-05 0 1.240583333333333e-05 0 1.240588333333333e-05 1.2 1.24475e-05 1.2 1.244755e-05 0 1.248916666666667e-05 0 1.248921666666667e-05 1.2 1.253083333333333e-05 1.2 1.253088333333333e-05 0 1.261416666666667e-05 0 1.261421666666667e-05 1.2 1.265583333333333e-05 1.2 1.265588333333333e-05 0 1.26975e-05 0 1.269755e-05 1.2 1.273916666666667e-05 1.2 1.273921666666667e-05 0 1.278083333333333e-05 0 1.278088333333333e-05 1.2 1.29475e-05 1.2 1.294755e-05 0 1.33225e-05 0 1.332255e-05 1.2 1.336416666666667e-05 1.2 1.336421666666667e-05 0 1.340583333333333e-05 0 1.340588333333333e-05 1.2 1.34475e-05 1.2 1.344755e-05 0 1.348916666666667e-05 0 1.348921666666667e-05 1.2 1.353083333333333e-05 1.2 1.353088333333333e-05 0 1.35725e-05 0 1.357255e-05 1.2 1.365583333333333e-05 1.2 1.365588333333333e-05 0 1.36975e-05 0 1.369755e-05 1.2 1.373916666666667e-05 1.2 1.373921666666667e-05 0 1.378083333333333e-05 0 1.378088333333333e-05 1.2 1.38225e-05 1.2 1.382255e-05 0 1.386416666666667e-05 0 1.386421666666667e-05 1.2 1.390583333333333e-05 1.2 1.390588333333333e-05 0 1.398916666666667e-05 0 1.398921666666667e-05 1.2 1.403083333333333e-05 1.2 1.403088333333333e-05 0 1.40725e-05 0 1.407255e-05 1.2 1.411416666666667e-05 1.2 1.411421666666667e-05 0 1.415583333333333e-05 0 1.415588333333333e-05 1.2 1.41975e-05 1.2 1.419755e-05 0 1.423916666666667e-05 0 1.423921666666667e-05 1.2 1.43225e-05 1.2 1.432255e-05 0 1.436416666666667e-05 0 1.436421666666667e-05 1.2 1.440583333333333e-05 1.2 1.440588333333333e-05 0 1.44475e-05 0 1.444755e-05 1.2 1.448916666666667e-05 1.2 1.448921666666667e-05 0 1.453083333333333e-05 0 1.453088333333333e-05 1.2 1.45725e-05 1.2 1.457255e-05 0 1.515583333333333e-05 0 1.515588333333333e-05 1.2 1.51975e-05 1.2 1.519755e-05 0 1.523916666666667e-05 0 1.523921666666667e-05 1.2 1.528083333333333e-05 1.2 1.528088333333333e-05 0 1.53225e-05 0 1.532255e-05 1.2 1.536416666666667e-05 1.2 1.536421666666667e-05 0 1.54475e-05 0 1.544755e-05 1.2 1.548916666666667e-05 1.2 1.548921666666667e-05 0 1.553083333333333e-05 0 1.553088333333333e-05 1.2 1.55725e-05 1.2 1.557255e-05 0 1.561416666666667e-05 0 1.561421666666667e-05 1.2 1.565583333333333e-05 1.2 1.565588333333333e-05 0 1.56975e-05 0 1.569755e-05 1.2 1.578083333333333e-05 1.2 1.578088333333333e-05 0 1.58225e-05 0 1.582255e-05 1.2 1.586416666666667e-05 1.2 1.586421666666667e-05 0 1.590583333333333e-05 0 1.590588333333333e-05 1.2 1.59475e-05 1.2 1.594755e-05 0 1.598916666666667e-05 0 1.598921666666667e-05 1.2 1.60725e-05 1.2 1.607255e-05 0 1.611416666666667e-05 0 1.611421666666667e-05 1.2 1.615583333333333e-05 1.2 1.615588333333333e-05 0 1.61975e-05 0 1.619755e-05 1.2 1.623916666666667e-05 1.2 1.623921666666667e-05 0 1.628083333333333e-05 0 1.628088333333333e-05 1.2 1.63225e-05 1.2 1.632255e-05 0 1.640583333333333e-05 0 1.640588333333333e-05 1.2 1.64475e-05 1.2 1.644755e-05 0 1.698916666666667e-05 0 1.698921666666667e-05 1.2 1.703083333333334e-05 1.2 1.703088333333334e-05 0 1.70725e-05 0 1.707255e-05 1.2 1.711416666666667e-05 1.2 1.711421666666667e-05 0 1.715583333333334e-05 0 1.715588333333334e-05 1.2 1.71975e-05 1.2 1.719755e-05 0 1.728083333333334e-05 0 1.728088333333334e-05 1.2 1.73225e-05 1.2 1.732255e-05 0 1.736416666666667e-05 0 1.736421666666667e-05 1.2 1.740583333333334e-05 1.2 1.740588333333334e-05 0 1.74475e-05 0 1.744755e-05 1.2 1.748916666666667e-05 1.2 1.748921666666667e-05 0 1.753083333333334e-05 0 1.753088333333334e-05 1.2 1.761416666666667e-05 1.2 1.761421666666667e-05 0 1.765583333333334e-05 0 1.765588333333334e-05 1.2 1.76975e-05 1.2 1.769755e-05 0 1.773916666666667e-05 0 1.773921666666667e-05 1.2 1.778083333333334e-05 1.2 1.778088333333334e-05 0 1.78225e-05 0 1.782255e-05 1.2 1.786416666666667e-05 1.2 1.786421666666667e-05 0 1.79475e-05 0 1.794755e-05 1.2 1.798916666666667e-05 1.2 1.798921666666667e-05 0 1.803083333333334e-05 0 1.803088333333334e-05 1.2 1.80725e-05 1.2 1.807255e-05 0 1.811416666666667e-05 0 1.811421666666667e-05 1.2 1.815583333333334e-05 1.2 1.815588333333334e-05 0 1.823916666666667e-05 0 1.823921666666667e-05 1.2 1.828083333333334e-05 1.2 1.828088333333334e-05 0 1.83225e-05 0 1.832255e-05 1.2 1.836416666666667e-05 1.2 1.836421666666667e-05 0 1.840583333333334e-05 0 1.840588333333334e-05 1.2 1.84475e-05 1.2 1.844755e-05 0 1.848916666666667e-05 0 1.848921666666667e-05 1.2 1.85725e-05 1.2 1.857255e-05 0 1.861416666666667e-05 0 1.861421666666667e-05 1.2 1.865583333333334e-05 1.2 1.865588333333334e-05 0 1.86975e-05 0 1.869755e-05 1.2 1.873916666666667e-05 1.2 1.873921666666667e-05 0 1.878083333333334e-05 0 1.878088333333334e-05 1.2 1.88225e-05 1.2 1.882255e-05 0 1.890583333333334e-05 0 1.890588333333334e-05 1.2 1.89475e-05 1.2 1.894755e-05 0 1.898916666666667e-05 0 1.898921666666667e-05 1.2 1.903083333333334e-05 1.2 1.903088333333334e-05 0 1.90725e-05 0 1.907255e-05 1.2 1.911416666666667e-05 1.2 1.911421666666667e-05 0 1.91975e-05 0 1.919755e-05 1.2 1.923916666666667e-05 1.2 1.923921666666667e-05 0 1.928083333333334e-05 0 1.928088333333334e-05 1.2 1.93225e-05 1.2 1.932255e-05 0 1.936416666666667e-05 0 1.936421666666667e-05 1.2 1.940583333333334e-05 1.2 1.940588333333334e-05 0 1.94475e-05 0 1.944755e-05 1.2 1.953083333333334e-05 1.2 1.953088333333334e-05 0 1.95725e-05 0 1.957255e-05 1.2 1.961416666666667e-05 1.2 1.961421666666667e-05 0 1.965583333333334e-05 0 1.965588333333334e-05 1.2 1.96975e-05 1.2 1.969755e-05 0 1.973916666666667e-05 0 1.973921666666667e-05 1.2 1.98225e-05 1.2 1.982255e-05 0 1.986416666666667e-05 0 1.986421666666667e-05 1.2 1.990583333333334e-05 1.2 1.990588333333334e-05 0 1.99475e-05 0 1.994755e-05 1.2 1.998916666666667e-05 1.2 1.998921666666667e-05 0 2.003083333333334e-05 0 2.003088333333334e-05 1.2 2.00725e-05 1.2 2.007255e-05 0 2.015583333333334e-05 0 2.015588333333334e-05 1.2 2.01975e-05 1.2 2.019755e-05 0 2.023916666666667e-05 0 2.023921666666667e-05 1.2 2.028083333333334e-05 1.2 2.028088333333334e-05 0 2.03225e-05 0 2.032255e-05 1.2 2.036416666666667e-05 1.2 2.036421666666667e-05 0 2.040583333333334e-05 0 2.040588333333334e-05 1.2 2.048916666666667e-05 1.2 2.048921666666667e-05 0 2.053083333333334e-05 0 2.053088333333334e-05 1.2 2.05725e-05 1.2 2.057255e-05 0 2.061416666666667e-05 0 2.061421666666667e-05 1.2 2.065583333333334e-05 1.2 2.065588333333334e-05 0 2.06975e-05 0 2.069755e-05 1.2 2.078083333333334e-05 1.2 2.078088333333334e-05 0 2.08225e-05 0 2.082255e-05 1.2 2.086416666666667e-05 1.2 2.086421666666667e-05 0 2.090583333333334e-05 0 2.090588333333334e-05 1.2 2.09475e-05 1.2 2.094755e-05 0 2.098916666666667e-05 0 2.098921666666667e-05 1.2 2.103083333333334e-05 1.2 2.103088333333334e-05 0 2.111416666666667e-05 0 2.111421666666667e-05 1.2 2.115583333333334e-05 1.2 2.115588333333334e-05 0 2.11975e-05 0 2.119755e-05 1.2 2.123916666666667e-05 1.2 2.123921666666667e-05 0 2.128083333333334e-05 0 2.128088333333334e-05 1.2 2.13225e-05 1.2 2.132255e-05 0 2.136416666666667e-05 0 2.136421666666667e-05 1.2 2.14475e-05 1.2 2.144755e-05 0 2.148916666666667e-05 0 2.148921666666667e-05 1.2 2.153083333333334e-05 1.2 2.153088333333334e-05 0 2.15725e-05 0 2.157255e-05 1.2 2.161416666666667e-05 1.2 2.161421666666667e-05 0 2.165583333333334e-05 0 2.165588333333334e-05 1.2 2.173916666666667e-05 1.2 2.173921666666667e-05 0 2.178083333333334e-05 0 2.178088333333334e-05 1.2 2.18225e-05 1.2 2.182255e-05 0 2.186416666666667e-05 0 2.186421666666667e-05 1.2 2.190583333333334e-05 1.2 2.190588333333334e-05 0 2.19475e-05 0 2.194755e-05 1.2 2.198916666666667e-05 1.2 2.198921666666667e-05 0 2.20725e-05 0 2.207255e-05 1.2 2.211416666666667e-05 1.2 2.211421666666667e-05 0 2.215583333333334e-05 0 2.215588333333334e-05 1.2 2.21975e-05 1.2 2.219755e-05 0 2.223916666666667e-05 0 2.223921666666667e-05 1.2 2.228083333333334e-05 1.2 2.228088333333334e-05 0 2.28225e-05 0 2.282255e-05 1.2 2.286416666666667e-05 1.2 2.286421666666667e-05 0 2.290583333333334e-05 0 2.290588333333334e-05 1.2 2.29475e-05 1.2 2.294755e-05 0 2.298916666666667e-05 0 2.298921666666667e-05 1.2 2.303083333333334e-05 1.2 2.303088333333334e-05 0 2.30725e-05 0 2.307255e-05 1.2 2.315583333333334e-05 1.2 2.315588333333334e-05 0 2.31975e-05 0 2.319755e-05 1.2 2.323916666666667e-05 1.2 2.323921666666667e-05 0 2.328083333333334e-05 0 2.328088333333334e-05 1.2 2.33225e-05 1.2 2.332255e-05 0 2.336416666666667e-05 0 2.336421666666667e-05 1.2 2.340583333333334e-05 1.2 2.340588333333334e-05 0 2.348916666666667e-05 0 2.348921666666667e-05 1.2 2.353083333333334e-05 1.2 2.353088333333334e-05 0 2.35725e-05 0 2.357255e-05 1.2 2.361416666666667e-05 1.2 2.361421666666667e-05 0 2.365583333333334e-05 0 2.365588333333334e-05 1.2 2.36975e-05 1.2 2.369755e-05 0 2.373916666666667e-05 0 2.373921666666667e-05 1.2 2.38225e-05 1.2 2.382255e-05 0 2.386416666666667e-05 0 2.386421666666667e-05 1.2 2.390583333333334e-05 1.2 2.390588333333334e-05 0 2.39475e-05 0 2.394755e-05 1.2 2.398916666666667e-05 1.2 2.398921666666667e-05 0 2.403083333333334e-05 0 2.403088333333334e-05 1.2 2.40725e-05 1.2 2.407255e-05 0 2.415583333333334e-05 0 2.415588333333334e-05 1.2 2.41975e-05 1.2 2.419755e-05 0 2.423916666666667e-05 0 2.423921666666667e-05 1.2 2.428083333333334e-05 1.2 2.428088333333334e-05 0 2.43225e-05 0 2.432255e-05 1.2 2.436416666666667e-05 1.2 2.436421666666667e-05 0 2.440583333333334e-05 0 2.440588333333334e-05 1.2 2.448916666666667e-05 1.2 2.448921666666667e-05 0 2.453083333333334e-05 0 2.453088333333334e-05 1.2 2.45725e-05 1.2 2.457255e-05 0 2.461416666666667e-05 0 2.461421666666667e-05 1.2 2.465583333333334e-05 1.2 2.465588333333334e-05 0 2.46975e-05 0 2.469755e-05 1.2 2.473916666666667e-05 1.2 2.473921666666667e-05 0 2.48225e-05 0 2.482255e-05 1.2 2.486416666666667e-05 1.2 2.486421666666667e-05 0 2.490583333333334e-05 0 2.490588333333334e-05 1.2 2.49475e-05 1.2 2.494755e-05 0 2.498916666666667e-05 0 2.498921666666667e-05 1.2 2.503083333333334e-05 1.2 2.503088333333334e-05 0 2.50725e-05 0 2.507255e-05 1.2 2.515583333333334e-05 1.2 2.515588333333334e-05 0 2.51975e-05 0 2.519755e-05 1.2 2.523916666666667e-05 1.2 2.523921666666667e-05 0 2.528083333333334e-05 0 2.528088333333334e-05 1.2 2.53225e-05 1.2 2.532255e-05 0 2.536416666666667e-05 0 2.536421666666667e-05 1.2 2.540583333333334e-05 1.2 2.540588333333334e-05 0 2.548916666666667e-05 0 2.548921666666667e-05 1.2 2.553083333333334e-05 1.2 2.553088333333334e-05 0 2.55725e-05 0 2.557255e-05 1.2 2.561416666666667e-05 1.2 2.561421666666667e-05 0 2.565583333333334e-05 0 2.565588333333334e-05 1.2 2.56975e-05 1.2 2.569755e-05 0 2.573916666666667e-05 0 2.573921666666667e-05 1.2 2.578083333333334e-05 1.2 2.578088333333334e-05 0 2.586416666666667e-05 0 2.586421666666667e-05 1.2 2.590583333333334e-05 1.2 2.590588333333334e-05 0 2.59475e-05 0 2.594755e-05 1.2 2.598916666666667e-05 1.2 2.598921666666667e-05 0 2.603083333333334e-05 0 2.603088333333334e-05 1.2 2.60725e-05 1.2 2.607255e-05 0 2.611416666666667e-05 0 2.611421666666667e-05 1.2 2.61975e-05 1.2 2.619755e-05 0 2.623916666666667e-05 0 2.623921666666667e-05 1.2 2.628083333333334e-05 1.2 2.628088333333334e-05 0 2.63225e-05 0 2.632255e-05 1.2 2.636416666666667e-05 1.2 2.636421666666667e-05 0 2.640583333333334e-05 0 2.640588333333334e-05 1.2 2.64475e-05 1.2 2.644755e-05 0 2.653083333333334e-05 0 2.653088333333334e-05 1.2 2.65725e-05 1.2 2.657255e-05 0 2.661416666666667e-05 0 2.661421666666667e-05 1.2 2.665583333333334e-05 1.2 2.665588333333334e-05 0 2.66975e-05 0 2.669755e-05 1.2 2.673916666666667e-05 1.2 2.673921666666667e-05 0 2.678083333333334e-05 0 2.678088333333334e-05 1.2 2.686416666666667e-05 1.2 2.686421666666667e-05 0 2.690583333333334e-05 0 2.690588333333334e-05 1.2 2.69475e-05 1.2 2.694755e-05 0 2.698916666666667e-05 0 2.698921666666667e-05 1.2 2.703083333333334e-05 1.2 2.703088333333334e-05 0 2.70725e-05 0 2.707255e-05 1.2 2.711416666666667e-05 1.2 2.711421666666667e-05 0 2.71975e-05 0 2.719755e-05 1.2 2.723916666666667e-05 1.2 2.723921666666667e-05 0 2.728083333333334e-05 0 2.728088333333334e-05 1.2 2.73225e-05 1.2 2.732255e-05 0 2.736416666666667e-05 0 2.736421666666667e-05 1.2 2.740583333333334e-05 1.2 2.740588333333334e-05 0 2.74475e-05 0 2.744755e-05 1.2 2.753083333333334e-05 1.2 2.753088333333334e-05 0 2.75725e-05 0 2.757255e-05 1.2 2.761416666666667e-05 1.2 2.761421666666667e-05 0 2.765583333333334e-05 0 2.765588333333334e-05 1.2 2.76975e-05 1.2 2.769755e-05 0 2.773916666666667e-05 0 2.773921666666667e-05 1.2 2.778083333333334e-05 1.2 2.778088333333334e-05 0 2.786416666666667e-05 0 2.786421666666667e-05 1.2 2.790583333333334e-05 1.2 2.790588333333334e-05 0 2.79475e-05 0 2.794755e-05 1.2 2.798916666666667e-05 1.2 2.798921666666667e-05 0 2.803083333333334e-05 0 2.803088333333334e-05 1.2 2.80725e-05 1.2 2.807255e-05 0 2.811416666666667e-05 0 2.811421666666667e-05 1.2 2.828083333333334e-05 1.2 2.828088333333334e-05 0 2.865583333333334e-05 0 2.865588333333334e-05 1.2 2.86975e-05 1.2 2.869755e-05 0 2.873916666666667e-05 0 2.873921666666667e-05 1.2 2.878083333333334e-05 1.2 2.878088333333334e-05 0 2.88225e-05 0 2.882255e-05 1.2 2.886416666666667e-05 1.2 2.886421666666667e-05 0 2.890583333333334e-05 0 2.890588333333334e-05 1.2 2.898916666666667e-05 1.2 2.898921666666667e-05 0 2.903083333333334e-05 0 2.903088333333334e-05 1.2 2.90725e-05 1.2 2.907255e-05 0 2.911416666666667e-05 0 2.911421666666667e-05 1.2 2.915583333333334e-05 1.2 2.915588333333334e-05 0 2.91975e-05 0 2.919755e-05 1.2 2.923916666666667e-05 1.2 2.923921666666667e-05 0 2.93225e-05 0 2.932255e-05 1.2 2.936416666666667e-05 1.2 2.936421666666667e-05 0 2.940583333333334e-05 0 2.940588333333334e-05 1.2 2.94475e-05 1.2 2.944755e-05 0 2.948916666666667e-05 0 2.948921666666667e-05 1.2 2.953083333333334e-05 1.2 2.953088333333334e-05 0 2.95725e-05 0 2.957255e-05 1.2 2.965583333333334e-05 1.2 2.965588333333334e-05 0 2.96975e-05 0 2.969755e-05 1.2 2.973916666666667e-05 1.2 2.973921666666667e-05 0 2.978083333333334e-05 0 2.978088333333334e-05 1.2 2.98225e-05 1.2 2.982255e-05 0 2.986416666666667e-05 0 2.986421666666667e-05 1.2 2.990583333333334e-05 1.2 2.990588333333334e-05 0 2.998916666666667e-05 0 2.998921666666667e-05 1.2 3.003083333333334e-05 1.2 3.003088333333334e-05 0 3.00725e-05 0 3.007255e-05 1.2 3.011416666666667e-05 1.2 3.011421666666667e-05 0 3.015583333333334e-05 0 3.015588333333334e-05 1.2 3.01975e-05 1.2 3.019755e-05 0 3.023916666666667e-05 0 3.023921666666667e-05 1.2 3.03225e-05 1.2 3.032255e-05 0 3.036416666666667e-05 0 3.036421666666667e-05 1.2 3.040583333333334e-05 1.2 3.040588333333334e-05 0 3.04475e-05 0 3.044755e-05 1.2 3.048916666666667e-05 1.2 3.048921666666667e-05 0 3.053083333333334e-05 0 3.053088333333333e-05 1.2 3.05725e-05 1.2 3.057255e-05 0 3.065583333333334e-05 0 3.065588333333334e-05 1.2 3.06975e-05 1.2 3.069755e-05 0 3.073916666666667e-05 0 3.073921666666667e-05 1.2 3.078083333333334e-05 1.2 3.078088333333333e-05 0 3.082250000000001e-05 0 3.082255e-05 1.2 3.086416666666667e-05 1.2 3.086421666666667e-05 0 3.09475e-05 0 3.094755e-05 1.2 3.098916666666667e-05 1.2 3.098921666666667e-05 0 3.103083333333333e-05 0 3.103088333333333e-05 1.2 3.10725e-05 1.2 3.107255e-05 0 3.111416666666667e-05 0 3.111421666666666e-05 1.2 3.115583333333334e-05 1.2 3.115588333333333e-05 0 3.11975e-05 0 3.119755e-05 1.2 3.128083333333334e-05 1.2 3.128088333333334e-05 0 3.13225e-05 0 3.132255e-05 1.2 3.136416666666667e-05 1.2 3.136421666666666e-05 0 3.140583333333334e-05 0 3.140588333333333e-05 1.2 3.14475e-05 1.2 3.144755e-05 0 3.148916666666667e-05 0 3.148921666666667e-05 1.2 3.153083333333334e-05 1.2 3.153088333333334e-05 0 3.161416666666667e-05 0 3.161421666666667e-05 1.2 3.165583333333334e-05 1.2 3.165588333333333e-05 0 3.16975e-05 0 3.169755e-05 1.2 3.173916666666667e-05 1.2 3.173921666666667e-05 0 3.178083333333334e-05 0 3.178088333333334e-05 1.2 3.18225e-05 1.2 3.182255e-05 0 3.186416666666667e-05 0 3.186421666666667e-05 1.2 3.19475e-05 1.2 3.194755e-05 0 3.198916666666667e-05 0 3.198921666666667e-05 1.2 3.203083333333334e-05 1.2 3.203088333333334e-05 0 3.20725e-05 0 3.207255e-05 1.2 3.211416666666667e-05 1.2 3.211421666666667e-05 0 3.215583333333333e-05 0 3.215588333333333e-05 1.2 3.21975e-05 1.2 3.219755e-05 0 3.228083333333334e-05 0 3.228088333333333e-05 1.2 3.23225e-05 1.2 3.232255e-05 0 3.236416666666667e-05 0 3.236421666666667e-05 1.2 3.240583333333334e-05 1.2 3.240588333333334e-05 0 3.24475e-05 0 3.244755e-05 1.2 3.248916666666667e-05 1.2 3.248921666666666e-05 0 3.253083333333334e-05 0 3.253088333333333e-05 1.2 3.261416666666667e-05 1.2 3.261421666666667e-05 0 3.265583333333334e-05 0 3.265588333333334e-05 1.2 3.26975e-05 1.2 3.269755e-05 0 3.273916666666667e-05 0 3.273921666666667e-05 1.2 3.278083333333334e-05 1.2 3.278088333333333e-05 0 3.282249999999999e-05 0 3.282254999999999e-05 1.2 3.286416666666667e-05 1.2 3.286421666666667e-05 0 3.29475e-05 0 3.294755e-05 1.2 3.298916666666667e-05 1.2 3.298921666666666e-05 0 3.303083333333333e-05 0 3.303088333333333e-05 1.2 3.30725e-05 1.2 3.307255e-05 0 3.311416666666667e-05 0 3.311421666666667e-05 1.2 3.315583333333333e-05 1.2 3.315588333333333e-05 0 3.323916666666667e-05 0 3.323921666666666e-05 1.2 3.328083333333333e-05 1.2 3.328088333333332e-05 0 3.33225e-05 0 3.332255e-05 1.2 3.336416666666667e-05 1.2 3.336421666666666e-05 0 3.340583333333333e-05 0 3.340588333333333e-05 1.2 3.34475e-05 1.2 3.344755e-05 0 3.348916666666666e-05 0 3.348921666666666e-05 1.2 3.35725e-05 1.2 3.357255e-05 0 3.361416666666667e-05 0 3.361421666666666e-05 1.2 3.365583333333333e-05 1.2 3.365588333333333e-05 0 3.36975e-05 0 3.369755e-05 1.2 3.373916666666666e-05 1.2 3.373921666666666e-05 0 3.378083333333333e-05 0 3.378088333333333e-05 1.2 3.38225e-05 1.2 3.382255e-05 0 3.390583333333333e-05 0 3.390588333333333e-05 1.2 3.39475e-05 1.2 3.394755e-05 0 3.448916666666667e-05 0 3.448921666666667e-05 1.2 3.453083333333333e-05 1.2 3.453088333333333e-05 0 3.45725e-05 0 3.457255e-05 1.2 3.461416666666666e-05 1.2 3.461421666666666e-05 0 3.465583333333333e-05 0 3.465588333333332e-05 1.2 3.46975e-05 1.2 3.469755e-05 0 3.473916666666667e-05 0 3.473921666666666e-05 1.2 3.48225e-05 1.2 3.482255e-05 0 3.486416666666666e-05 0 3.486421666666666e-05 1.2 3.490583333333333e-05 1.2 3.490588333333333e-05 0 3.49475e-05 0 3.494755e-05 1.2 3.498916666666667e-05 1.2 3.498921666666666e-05 0 3.503083333333333e-05 0 3.503088333333333e-05 1.2 3.50725e-05 1.2 3.507255e-05 0 3.515583333333333e-05 0 3.515588333333333e-05 1.2 3.51975e-05 1.2 3.519755e-05 0 3.523916666666667e-05 0 3.523921666666666e-05 1.2 3.528083333333333e-05 1.2 3.528088333333333e-05 0 3.53225e-05 0 3.532255e-05 1.2 3.536416666666667e-05 1.2 3.536421666666667e-05 0 3.540583333333333e-05 0 3.540588333333333e-05 1.2 3.548916666666667e-05 1.2 3.548921666666666e-05 0 3.553083333333333e-05 0 3.553088333333333e-05 1.2 3.557250000000001e-05 1.2 3.557255e-05 0 3.561416666666667e-05 0 3.561421666666667e-05 1.2 3.565583333333333e-05 1.2 3.565588333333333e-05 0 3.56975e-05 0 3.569755e-05 1.2 3.573916666666666e-05 1.2 3.573921666666666e-05 0 3.58225e-05 0 3.582255e-05 1.2 3.586416666666667e-05 1.2 3.586421666666666e-05 0 3.590583333333333e-05 0 3.590588333333333e-05 1.2 3.59475e-05 1.2 3.594755e-05 0 3.598916666666666e-05 0 3.598921666666666e-05 1.2 3.603083333333333e-05 1.2 3.603088333333333e-05 0 3.60725e-05 0 3.607255e-05 1.2 3.615583333333333e-05 1.2 3.615588333333333e-05 0 3.61975e-05 0 3.619755e-05 1.2 3.623916666666666e-05 1.2 3.623921666666666e-05 0 3.628083333333333e-05 0 3.628088333333333e-05 1.2 3.63225e-05 1.2 3.632255e-05 0 3.636416666666667e-05 0 3.636421666666666e-05 1.2 3.640583333333333e-05 1.2 3.640588333333333e-05 0 3.648916666666667e-05 0 3.648921666666667e-05 1.2 3.653083333333333e-05 1.2 3.653088333333333e-05 0 3.65725e-05 0 3.657255e-05 1.2 3.661416666666667e-05 1.2 3.661421666666666e-05 0 3.665583333333333e-05 0 3.665588333333333e-05 1.2 3.669750000000001e-05 1.2 3.669755e-05 0 3.673916666666667e-05 0 3.673921666666667e-05 1.2 3.68225e-05 1.2 3.682255e-05 0 3.686416666666667e-05 0 3.686421666666666e-05 1.2 3.690583333333333e-05 1.2 3.690588333333332e-05 0 3.69475e-05 0 3.694755e-05 1.2 3.698916666666667e-05 1.2 3.698921666666666e-05 0 3.703083333333333e-05 0 3.703088333333333e-05 1.2 3.70725e-05 1.2 3.707255e-05 0 3.715583333333333e-05 0 3.715588333333332e-05 1.2 3.71975e-05 1.2 3.719755e-05 0 3.723916666666667e-05 0 3.723921666666666e-05 1.2 3.728083333333333e-05 1.2 3.728088333333333e-05 0 3.73225e-05 0 3.732255e-05 1.2 3.736416666666666e-05 1.2 3.736421666666666e-05 0 3.740583333333333e-05 0 3.740588333333333e-05 1.2 3.748916666666667e-05 1.2 3.748921666666666e-05 0 3.753083333333333e-05 0 3.753088333333333e-05 1.2 3.75725e-05 1.2 3.757255e-05 0 3.761416666666667e-05 0 3.761421666666667e-05 1.2 3.765583333333333e-05 1.2 3.765588333333333e-05 0 3.76975e-05 0 3.769755e-05 1.2 3.773916666666667e-05 1.2 3.773921666666666e-05 0 3.78225e-05 0 3.782255e-05 1.2 3.786416666666667e-05 1.2 3.786421666666667e-05 0 3.790583333333333e-05 0 3.790588333333333e-05 1.2 3.79475e-05 1.2 3.794755e-05 0 3.798916666666667e-05 0 3.798921666666666e-05 1.2 3.803083333333333e-05 1.2 3.803088333333333e-05 0 3.807250000000001e-05 0 3.807255e-05 1.2 3.815583333333333e-05 1.2 3.815588333333333e-05 0 3.81975e-05 0 3.819755e-05 1.2 3.823916666666666e-05 1.2 3.823921666666666e-05 0 3.828083333333333e-05 0 3.828088333333332e-05 1.2 3.83225e-05 1.2 3.832255e-05 0 3.836416666666667e-05 0 3.836421666666666e-05 1.2 3.840583333333333e-05 1.2 3.840588333333333e-05 0 3.848916666666666e-05 0 3.848921666666666e-05 1.2 3.853083333333333e-05 1.2 3.853088333333333e-05 0 3.85725e-05 0 3.857255e-05 1.2 3.861416666666667e-05 1.2 3.861421666666666e-05 0 3.865583333333333e-05 0 3.865588333333333e-05 1.2 3.86975e-05 1.2 3.869755e-05 0 3.873916666666667e-05 0 3.873921666666667e-05 1.2 3.88225e-05 1.2 3.882255e-05 0 3.886416666666667e-05 0 3.886421666666666e-05 1.2 3.890583333333333e-05 1.2 3.890588333333333e-05 0 3.89475e-05 0 3.894755e-05 1.2 3.898916666666667e-05 1.2 3.898921666666667e-05 0 3.903083333333333e-05 0 3.903088333333333e-05 1.2 3.90725e-05 1.2 3.907255e-05 0 3.915583333333333e-05 0 3.915588333333333e-05 1.2 3.919750000000001e-05 1.2 3.919755e-05 0 3.923916666666667e-05 0 3.923921666666667e-05 1.2 3.928083333333333e-05 1.2 3.928088333333333e-05 0 3.93225e-05 0 3.932255e-05 1.2 3.936416666666666e-05 1.2 3.936421666666666e-05 0 3.940583333333333e-05 0 3.940588333333332e-05 1.2 3.948916666666667e-05 1.2 3.948921666666666e-05 0 3.953083333333333e-05 0 3.953088333333333e-05 1.2 3.95725e-05 1.2 3.957255e-05 0 3.961416666666666e-05 0 3.961421666666666e-05 1.2 3.965583333333333e-05 1.2 3.965588333333333e-05 0 3.96975e-05 0 3.969755e-05 1.2 3.973916666666667e-05 1.2 3.973921666666666e-05 0 4.032250000000001e-05 0 4.032255e-05 1.2 4.036416666666667e-05 1.2 4.036421666666667e-05 0 4.040583333333333e-05 0 4.040588333333333e-05 1.2 4.04475e-05 1.2 4.044755e-05 0 4.048916666666667e-05 0 4.048921666666666e-05 1.2 4.053083333333333e-05 1.2 4.053088333333332e-05 0 4.05725e-05 0 4.057255e-05 1.2 4.065583333333333e-05 1.2 4.065588333333333e-05 0 4.06975e-05 0 4.069755e-05 1.2 4.073916666666666e-05 1.2 4.073921666666666e-05 0 4.078083333333333e-05 0 4.078088333333333e-05 1.2 4.08225e-05 1.2 4.082255e-05 0 4.086416666666667e-05 0 4.086421666666666e-05 1.2 4.090583333333333e-05 1.2 4.090588333333333e-05 0 4.098916666666666e-05 0 4.098921666666666e-05 1.2 4.103083333333333e-05 1.2 4.103088333333333e-05 0 4.10725e-05 0 4.107255e-05 1.2 4.111416666666667e-05 1.2 4.111421666666666e-05 0 4.115583333333333e-05 0 4.115588333333333e-05 1.2 4.11975e-05 1.2 4.119755e-05 0 4.123916666666667e-05 0 4.123921666666667e-05 1.2 4.13225e-05 1.2 4.132255e-05 0 4.136416666666667e-05 0 4.136421666666666e-05 1.2 4.140583333333333e-05 1.2 4.140588333333333e-05 0 4.144750000000001e-05 0 4.144755e-05 1.2 4.148916666666667e-05 1.2 4.148921666666667e-05 0 4.153083333333333e-05 0 4.153088333333333e-05 1.2 4.15725e-05 1.2 4.157255e-05 0 4.165583333333333e-05 0 4.165588333333333e-05 1.2 4.169750000000001e-05 1.2 4.169755e-05 0 4.173916666666667e-05 0 4.173921666666667e-05 1.2 4.178083333333333e-05 1.2 4.178088333333333e-05 0 4.18225e-05 0 4.182255e-05 1.2 4.186416666666666e-05 1.2 4.186421666666666e-05 0 4.190583333333333e-05 0 4.190588333333332e-05 1.2 4.198916666666667e-05 1.2 4.198921666666666e-05 0 4.203083333333333e-05 0 4.203088333333333e-05 1.2 4.20725e-05 1.2 4.207255e-05 0 4.211416666666666e-05 0 4.211421666666666e-05 1.2 4.215583333333333e-05 1.2 4.215588333333333e-05 0 4.21975e-05 0 4.219755e-05 1.2 4.223916666666667e-05 1.2 4.223921666666666e-05 0 4.23225e-05 0 4.232255e-05 1.2 4.236416666666667e-05 1.2 4.236421666666667e-05 0 4.240583333333333e-05 0 4.240588333333333e-05 1.2 4.24475e-05 1.2 4.244755e-05 0 4.248916666666667e-05 0 4.248921666666666e-05 1.2 4.253083333333333e-05 1.2 4.253088333333333e-05 0 4.25725e-05 0 4.257255e-05 1.2 4.265583333333333e-05 1.2 4.265588333333333e-05 0 4.26975e-05 0 4.269755e-05 1.2 4.273916666666667e-05 1.2 4.273921666666666e-05 0 4.278083333333333e-05 0 4.278088333333333e-05 1.2 4.282250000000001e-05 1.2 4.282255e-05 0 4.286416666666667e-05 0 4.286421666666667e-05 1.2 4.290583333333333e-05 1.2 4.290588333333333e-05 0 4.298916666666666e-05 0 4.298921666666666e-05 1.2 4.303083333333333e-05 1.2 4.303088333333332e-05 0 4.30725e-05 0 4.307255e-05 1.2 4.311416666666667e-05 1.2 4.311421666666666e-05 0 4.315583333333333e-05 0 4.315588333333333e-05 1.2 4.31975e-05 1.2 4.319755e-05 0 4.323916666666666e-05 0 4.323921666666666e-05 1.2 4.328083333333333e-05 1.2 4.328088333333333e-05 0 4.336416666666667e-05 0 4.336421666666666e-05 1.2 4.340583333333333e-05 1.2 4.340588333333333e-05 0 4.34475e-05 0 4.344755e-05 1.2 4.348916666666667e-05 1.2 4.348921666666667e-05 0 4.353083333333333e-05 0 4.353088333333333e-05 1.2 4.35725e-05 1.2 4.357255e-05 0 4.361416666666667e-05 0 4.361421666666666e-05 1.2 4.36975e-05 1.2 4.369755e-05 0 4.373916666666667e-05 0 4.373921666666667e-05 1.2 4.378083333333333e-05 1.2 4.378088333333333e-05 0 4.38225e-05 0 4.382255e-05 1.2 4.386416666666667e-05 1.2 4.386421666666666e-05 0 4.390583333333333e-05 0 4.390588333333333e-05 1.2 4.394750000000001e-05 1.2 4.394755e-05 0 4.403083333333333e-05 0 4.403088333333333e-05 1.2 4.40725e-05 1.2 4.407255e-05 0 4.411416666666667e-05 0 4.411421666666666e-05 1.2 4.415583333333333e-05 1.2 4.415588333333333e-05 0 4.419750000000001e-05 0 4.419755e-05 1.2 4.423916666666667e-05 1.2 4.423921666666666e-05 0 4.428083333333333e-05 0 4.428088333333333e-05 1.2 4.436416666666666e-05 1.2 4.436421666666666e-05 0 4.440583333333333e-05 0 4.440588333333333e-05 1.2 4.44475e-05 1.2 4.444755e-05 0 4.448916666666667e-05 0 4.448921666666666e-05 1.2 4.453083333333333e-05 1.2 4.453088333333333e-05 0 4.45725e-05 0 4.457255e-05 1.2 4.461416666666666e-05 1.2 4.461421666666666e-05 0 4.46975e-05 0 4.469755e-05 1.2 4.473916666666667e-05 1.2 4.473921666666666e-05 0 4.478083333333333e-05 0 4.478088333333333e-05 1.2 4.48225e-05 1.2 4.482255e-05 0 4.486416666666667e-05 0 4.486421666666667e-05 1.2 4.490583333333333e-05 1.2 4.490588333333333e-05 0 4.49475e-05 0 4.494755e-05 1.2 4.503083333333333e-05 1.2 4.503088333333333e-05 0 4.507250000000001e-05 0 4.507255e-05 1.2 4.511416666666667e-05 1.2 4.511421666666667e-05 0 4.515583333333333e-05 0 4.515588333333333e-05 1.2 4.51975e-05 1.2 4.519755e-05 0 4.523916666666667e-05 0 4.523921666666666e-05 1.2 4.528083333333333e-05 1.2 4.528088333333333e-05 0 4.536416666666667e-05 0 4.536421666666667e-05 1.2 4.540583333333333e-05 1.2 4.540588333333333e-05 0 4.54475e-05 0 4.544755e-05 1.2 4.548916666666666e-05 1.2 4.548921666666666e-05 0 4.553083333333333e-05 0 4.553088333333333e-05 1.2 4.55725e-05 1.2 4.557255e-05 0 4.561416666666667e-05 0 4.561421666666666e-05 1.2 4.578083333333333e-05 1.2 4.578088333333333e-05 0 4.615583333333333e-05 0 4.615588333333333e-05 1.2 4.619750000000001e-05 1.2 4.619755e-05 0 4.623916666666667e-05 0 4.623921666666667e-05 1.2 4.628083333333333e-05 1.2 4.628088333333333e-05 0 4.63225e-05 0 4.632255e-05 1.2 4.636416666666667e-05 1.2 4.636421666666666e-05 0 4.640583333333333e-05 0 4.640588333333333e-05 1.2 4.648916666666667e-05 1.2 4.648921666666667e-05 0 4.653083333333333e-05 0 4.653088333333333e-05 1.2 4.65725e-05 1.2 4.657255e-05 0 4.661416666666666e-05 0 4.661421666666666e-05 1.2 4.665583333333333e-05 1.2 4.665588333333332e-05 0 4.66975e-05 0 4.669755e-05 1.2 4.673916666666667e-05 1.2 4.673921666666666e-05 0 4.68225e-05 0 4.682255e-05 1.2 4.686416666666666e-05 1.2 4.686421666666666e-05 0 4.690583333333333e-05 0 4.690588333333333e-05 1.2 4.69475e-05 1.2 4.694755e-05 0 4.698916666666667e-05 0 4.698921666666666e-05 1.2 4.703083333333333e-05 1.2 4.703088333333333e-05 0 4.70725e-05 0 4.707255e-05 1.2 4.715583333333333e-05 1.2 4.715588333333333e-05 0 4.71975e-05 0 4.719755e-05 1.2 4.723916666666667e-05 1.2 4.723921666666666e-05 0 4.728083333333333e-05 0 4.728088333333333e-05 1.2 4.73225e-05 1.2 4.732255e-05 0 4.736416666666667e-05 0 4.736421666666667e-05 1.2 4.740583333333333e-05 1.2 4.740588333333333e-05 0 4.748916666666667e-05 0 4.748921666666666e-05 1.2 4.753083333333333e-05 1.2 4.753088333333333e-05 0 4.757250000000001e-05 0 4.757255e-05 1.2 4.761416666666667e-05 1.2 4.761421666666667e-05 0 4.765583333333333e-05 0 4.765588333333333e-05 1.2 4.76975e-05 1.2 4.769755e-05 0 4.773916666666667e-05 0 4.773921666666666e-05 1.2 4.782250000000001e-05 1.2 4.782255e-05 0 4.786416666666667e-05 0 4.786421666666666e-05 1.2 4.790583333333333e-05 1.2 4.790588333333333e-05 0 4.79475e-05 0 4.794755e-05 1.2 4.798916666666666e-05 1.2 4.798921666666666e-05 0 4.803083333333333e-05 0 4.803088333333333e-05 1.2 4.80725e-05 1.2 4.807255e-05 0 4.815583333333333e-05 0 4.815588333333333e-05 1.2 4.81975e-05 1.2 4.819755e-05 0 4.823916666666667e-05 0 4.823921666666667e-05 1.2 4.828083333333333e-05 1.2 4.828088333333333e-05 0 4.83225e-05 0 4.832255e-05 1.2 4.836416666666667e-05 1.2 4.836421666666666e-05 0 4.840583333333333e-05 0 4.840588333333333e-05 1.2 4.848916666666667e-05 1.2 4.848921666666667e-05 0 4.853083333333333e-05 0 4.853088333333333e-05 1.2 4.85725e-05 1.2 4.857255e-05 0 4.861416666666667e-05 0 4.861421666666666e-05 1.2 4.865583333333333e-05 1.2 4.865588333333333e-05 0 4.869750000000001e-05 0 4.869755e-05 1.2 4.873916666666667e-05 1.2 4.873921666666667e-05 0 4.88225e-05 0 4.882255e-05 1.2 4.886416666666667e-05 1.2 4.886421666666666e-05 0 4.890583333333333e-05 0 4.890588333333333e-05 1.2 4.894750000000001e-05 1.2 4.894755e-05 0 4.898916666666667e-05 0 4.898921666666667e-05 1.2 4.903083333333333e-05 1.2 4.903088333333333e-05 0 4.90725e-05 0 4.907255e-05 1.2 4.915583333333333e-05 1.2 4.915588333333333e-05 0 4.91975e-05 0 4.919755e-05 1.2 4.923916666666667e-05 1.2 4.923921666666666e-05 0 4.928083333333333e-05 0 4.928088333333333e-05 1.2 4.93225e-05 1.2 4.932255e-05 0 4.936416666666666e-05 0 4.936421666666666e-05 1.2 4.940583333333333e-05 1.2 4.940588333333333e-05 0 4.948916666666667e-05 0 4.948921666666666e-05 1.2 4.953083333333333e-05 1.2 4.953088333333333e-05 0 4.95725e-05 0 4.957255e-05 1.2 4.961416666666667e-05 1.2 4.961421666666667e-05 0 4.965583333333333e-05 0 4.965588333333333e-05 1.2 4.96975e-05 1.2 4.969755e-05 0 4.973916666666667e-05 0 4.973921666666666e-05 1.2 4.982250000000001e-05 1.2 4.982255e-05 0 4.986416666666667e-05 0 4.986421666666667e-05 1.2 4.990583333333333e-05 1.2 4.990588333333333e-05 0 4.99475e-05 0 4.994755e-05 1.2 4.998916666666667e-05 1.2 4.998921666666666e-05 0 5.003083333333333e-05 0 5.003088333333333e-05 1.2 5.007250000000001e-05 1.2 5.007255e-05 0 5.015583333333333e-05 0 5.015588333333333e-05 1.2 5.01975e-05 1.2 5.019755e-05 0 5.023916666666666e-05 0 5.023921666666666e-05 1.2 5.028083333333333e-05 1.2 5.028088333333333e-05 0 5.03225e-05 0 5.032255e-05 1.2 5.036416666666667e-05 1.2 5.036421666666666e-05 0 5.040583333333333e-05 0 5.040588333333333e-05 1.2 5.048916666666666e-05 1.2 5.048921666666666e-05 0 5.053083333333333e-05 0 5.053088333333333e-05 1.2 5.05725e-05 1.2 5.057255e-05 0 5.061416666666667e-05 0 5.061421666666666e-05 1.2 5.065583333333333e-05 1.2 5.065588333333333e-05 0 5.06975e-05 0 5.069755e-05 1.2 5.073916666666667e-05 1.2 5.073921666666667e-05 0 5.08225e-05 0 5.082255e-05 1.2 5.086416666666667e-05 1.2 5.086421666666666e-05 0 5.090583333333333e-05 0 5.090588333333333e-05 1.2 5.094750000000001e-05 1.2 5.094755e-05 0 5.098916666666667e-05 0 5.098921666666667e-05 1.2 5.103083333333333e-05 1.2 5.103088333333333e-05 0 5.10725e-05 0 5.107255e-05 1.2 5.115583333333333e-05 1.2 5.115588333333333e-05 0 5.119750000000001e-05 0 5.119755e-05 1.2 5.123916666666667e-05 1.2 5.123921666666667e-05 0 5.128083333333333e-05 0 5.128088333333333e-05 1.2 5.13225e-05 1.2 5.132255e-05 0 5.136416666666667e-05 0 5.136421666666666e-05 1.2 5.140583333333333e-05 1.2 5.140588333333333e-05 0]
VM4 (m4 0) vsource type=pwl wave=[0 0 5.308333333333334e-07 0 5.308833333333334e-07 1.2 6.141666666666667e-07 1.2 6.142166666666667e-07 0 6.558333333333333e-07 0 6.558833333333333e-07 1.2 7.391666666666666e-07 1.2 7.392166666666667e-07 0 8.225000000000001e-07 0 8.225500000000001e-07 1.2 8.641666666666667e-07 1.2 8.642166666666667e-07 0 9.475e-07 0 9.4755e-07 1.2 1.030833333333333e-06 1.2 1.030883333333333e-06 0 1.0725e-06 0 1.07255e-06 1.2 1.155833333333334e-06 1.2 1.155883333333334e-06 0 1.239166666666667e-06 0 1.239216666666667e-06 1.2 1.280833333333333e-06 1.2 1.280883333333333e-06 0 1.364166666666667e-06 0 1.364216666666667e-06 1.2 1.4475e-06 1.2 1.44755e-06 0 1.489166666666667e-06 0 1.489216666666667e-06 1.2 1.5725e-06 1.2 1.57255e-06 0 1.655833333333334e-06 0 1.655883333333333e-06 1.2 1.6975e-06 1.2 1.69755e-06 0 1.780833333333334e-06 0 1.780883333333333e-06 1.2 1.9475e-06 1.2 1.94755e-06 0 2.5725e-06 0 2.57255e-06 1.2 2.864166666666667e-06 1.2 2.864216666666667e-06 0 3.114166666666667e-06 0 3.114216666666667e-06 1.2 3.405833333333333e-06 1.2 3.405883333333333e-06 0 4.239166666666667e-06 0 4.239216666666668e-06 1.2 4.364166666666667e-06 1.2 4.364216666666667e-06 0 4.4475e-06 0 4.44755e-06 1.2 4.572500000000001e-06 1.2 4.572550000000001e-06 0 4.6975e-06 0 4.69755e-06 1.2 4.780833333333334e-06 1.2 4.780883333333334e-06 0 4.905833333333334e-06 0 4.905883333333334e-06 1.2 5.030833333333334e-06 1.2 5.030883333333335e-06 0 5.114166666666668e-06 0 5.114216666666668e-06 1.2 5.239166666666667e-06 1.2 5.239216666666667e-06 0 5.364166666666668e-06 0 5.364216666666668e-06 1.2 5.4475e-06 1.2 5.44755e-06 0 6.072500000000001e-06 0 6.072550000000001e-06 1.2 6.155833333333335e-06 1.2 6.155883333333335e-06 0 6.239166666666668e-06 0 6.239216666666668e-06 1.2 6.3225e-06 1.2 6.32255e-06 0 6.405833333333334e-06 0 6.405883333333334e-06 1.2 6.489166666666667e-06 1.2 6.489216666666667e-06 0 6.5725e-06 0 6.57255e-06 1.2 6.655833333333334e-06 1.2 6.655883333333334e-06 0 6.739166666666667e-06 0 6.739216666666667e-06 1.2 6.8225e-06 1.2 6.82255e-06 0 6.905833333333334e-06 0 6.905883333333334e-06 1.2 6.989166666666667e-06 1.2 6.989216666666667e-06 0 7.0725e-06 0 7.072550000000001e-06 1.2 7.155833333333334e-06 1.2 7.155883333333335e-06 0 7.239166666666668e-06 0 7.239216666666668e-06 1.2 7.4475e-06 1.2 7.44755e-06 0 7.864166666666667e-06 0 7.864216666666667e-06 1.2 7.9475e-06 1.2 7.94755e-06 0 8.030833333333335e-06 0 8.030883333333335e-06 1.2 8.114166666666668e-06 1.2 8.114216666666668e-06 0 8.197499999999999e-06 0 8.197549999999999e-06 1.2 8.280833333333334e-06 1.2 8.280883333333334e-06 0 8.3225e-06 0 8.32255e-06 1.2 8.405833333333333e-06 1.2 8.405883333333334e-06 0 8.489166666666667e-06 0 8.489216666666667e-06 1.2 8.572500000000001e-06 1.2 8.572550000000001e-06 0 8.655833333333333e-06 0 8.655883333333333e-06 1.2 8.739166666666666e-06 1.2 8.739216666666666e-06 0 8.780833333333332e-06 0 8.780883333333333e-06 1.2 8.864166666666667e-06 1.2 8.864216666666667e-06 0 8.9475e-06 0 8.94755e-06 1.2 9.030833333333333e-06 1.2 9.030883333333334e-06 0 9.114166666666667e-06 0 9.114216666666667e-06 1.2 9.280833333333333e-06 1.2 9.280883333333333e-06 0 9.6975e-06 0 9.69755e-06 1.2 9.780833333333333e-06 1.2 9.780883333333333e-06 0 9.864166666666666e-06 0 9.864216666666666e-06 1.2 9.905833333333333e-06 1.2 9.905883333333333e-06 0 9.989166666666667e-06 0 9.989216666666668e-06 1.2 1.00725e-05 1.2 1.007255e-05 0 1.015583333333333e-05 0 1.015588333333333e-05 1.2 1.01975e-05 1.2 1.019755e-05 0 1.028083333333333e-05 0 1.028088333333333e-05 1.2 1.036416666666667e-05 1.2 1.036421666666667e-05 0 1.04475e-05 0 1.044755e-05 1.2 1.048916666666667e-05 1.2 1.048921666666667e-05 0 1.05725e-05 0 1.057255e-05 1.2 1.065583333333333e-05 1.2 1.065588333333333e-05 0 1.073916666666667e-05 0 1.073921666666667e-05 1.2 1.08225e-05 1.2 1.082255e-05 0 1.086416666666667e-05 0 1.086421666666667e-05 1.2 1.09475e-05 1.2 1.094755e-05 0 1.153083333333333e-05 0 1.153088333333333e-05 1.2 1.161416666666667e-05 1.2 1.161421666666667e-05 0 1.16975e-05 0 1.169755e-05 1.2 1.178083333333333e-05 1.2 1.178088333333333e-05 0 1.18225e-05 0 1.182255e-05 1.2 1.190583333333333e-05 1.2 1.190588333333333e-05 0 1.198916666666667e-05 0 1.198921666666667e-05 1.2 1.20725e-05 1.2 1.207255e-05 0 1.215583333333333e-05 0 1.215588333333333e-05 1.2 1.21975e-05 1.2 1.219755e-05 0 1.228083333333333e-05 0 1.228088333333333e-05 1.2 1.236416666666667e-05 1.2 1.236421666666667e-05 0 1.24475e-05 0 1.244755e-05 1.2 1.253083333333333e-05 1.2 1.253088333333333e-05 0 1.25725e-05 0 1.257255e-05 1.2 1.265583333333333e-05 1.2 1.265588333333333e-05 0 1.273916666666667e-05 0 1.273921666666667e-05 1.2 1.29475e-05 1.2 1.294755e-05 0 1.336416666666667e-05 0 1.336421666666667e-05 1.2 1.34475e-05 1.2 1.344755e-05 0 1.353083333333333e-05 0 1.353088333333333e-05 1.2 1.361416666666667e-05 1.2 1.361421666666667e-05 0 1.365583333333333e-05 0 1.365588333333333e-05 1.2 1.373916666666667e-05 1.2 1.373921666666667e-05 0 1.38225e-05 0 1.382255e-05 1.2 1.390583333333333e-05 1.2 1.390588333333333e-05 0 1.39475e-05 0 1.394755e-05 1.2 1.403083333333333e-05 1.2 1.403088333333333e-05 0 1.411416666666667e-05 0 1.411421666666667e-05 1.2 1.41975e-05 1.2 1.419755e-05 0 1.428083333333333e-05 0 1.428088333333333e-05 1.2 1.43225e-05 1.2 1.432255e-05 0 1.440583333333333e-05 0 1.440588333333333e-05 1.2 1.448916666666667e-05 1.2 1.448921666666667e-05 0 1.45725e-05 0 1.457255e-05 1.2 1.461416666666667e-05 1.2 1.461421666666667e-05 0 1.51975e-05 0 1.519755e-05 1.2 1.528083333333333e-05 1.2 1.528088333333333e-05 0 1.536416666666667e-05 0 1.536421666666667e-05 1.2 1.540583333333333e-05 1.2 1.540588333333333e-05 0 1.548916666666667e-05 0 1.548921666666667e-05 1.2 1.55725e-05 1.2 1.557255e-05 0 1.565583333333333e-05 0 1.565588333333333e-05 1.2 1.573916666666667e-05 1.2 1.573921666666667e-05 0 1.578083333333333e-05 0 1.578088333333333e-05 1.2 1.586416666666667e-05 1.2 1.586421666666667e-05 0 1.59475e-05 0 1.594755e-05 1.2 1.603083333333333e-05 1.2 1.603088333333333e-05 0 1.60725e-05 0 1.607255e-05 1.2 1.615583333333333e-05 1.2 1.615588333333333e-05 0 1.623916666666667e-05 0 1.623921666666667e-05 1.2 1.63225e-05 1.2 1.632255e-05 0 1.636416666666667e-05 0 1.636421666666667e-05 1.2 1.64475e-05 1.2 1.644755e-05 0 1.703083333333334e-05 0 1.703088333333334e-05 1.2 1.711416666666667e-05 1.2 1.711421666666667e-05 0 1.71975e-05 0 1.719755e-05 1.2 1.723916666666667e-05 1.2 1.723921666666667e-05 0 1.73225e-05 0 1.732255e-05 1.2 1.740583333333334e-05 1.2 1.740588333333334e-05 0 1.748916666666667e-05 0 1.748921666666667e-05 1.2 1.75725e-05 1.2 1.757255e-05 0 1.761416666666667e-05 0 1.761421666666667e-05 1.2 1.76975e-05 1.2 1.769755e-05 0 1.778083333333334e-05 0 1.778088333333334e-05 1.2 1.786416666666667e-05 1.2 1.786421666666667e-05 0 1.790583333333334e-05 0 1.790588333333334e-05 1.2 1.798916666666667e-05 1.2 1.798921666666667e-05 0 1.80725e-05 0 1.807255e-05 1.2 1.815583333333334e-05 1.2 1.815588333333334e-05 0 1.81975e-05 0 1.819755e-05 1.2 1.828083333333334e-05 1.2 1.828088333333334e-05 0 1.836416666666667e-05 0 1.836421666666667e-05 1.2 1.84475e-05 1.2 1.844755e-05 0 1.853083333333334e-05 0 1.853088333333334e-05 1.2 1.85725e-05 1.2 1.857255e-05 0 1.865583333333334e-05 0 1.865588333333334e-05 1.2 1.873916666666667e-05 1.2 1.873921666666667e-05 0 1.88225e-05 0 1.882255e-05 1.2 1.886416666666667e-05 1.2 1.886421666666667e-05 0 1.89475e-05 0 1.894755e-05 1.2 1.903083333333334e-05 1.2 1.903088333333334e-05 0 1.911416666666667e-05 0 1.911421666666667e-05 1.2 1.915583333333334e-05 1.2 1.915588333333334e-05 0 1.923916666666667e-05 0 1.923921666666667e-05 1.2 1.93225e-05 1.2 1.932255e-05 0 1.940583333333334e-05 0 1.940588333333334e-05 1.2 1.948916666666667e-05 1.2 1.948921666666667e-05 0 1.953083333333334e-05 0 1.953088333333334e-05 1.2 1.961416666666667e-05 1.2 1.961421666666667e-05 0 1.96975e-05 0 1.969755e-05 1.2 1.978083333333334e-05 1.2 1.978088333333334e-05 0 1.98225e-05 0 1.982255e-05 1.2 1.990583333333334e-05 1.2 1.990588333333334e-05 0 1.998916666666667e-05 0 1.998921666666667e-05 1.2 2.00725e-05 1.2 2.007255e-05 0 2.011416666666667e-05 0 2.011421666666667e-05 1.2 2.01975e-05 1.2 2.019755e-05 0 2.028083333333334e-05 0 2.028088333333334e-05 1.2 2.036416666666667e-05 1.2 2.036421666666667e-05 0 2.04475e-05 0 2.044755e-05 1.2 2.048916666666667e-05 1.2 2.048921666666667e-05 0 2.05725e-05 0 2.057255e-05 1.2 2.065583333333334e-05 1.2 2.065588333333334e-05 0 2.073916666666667e-05 0 2.073921666666667e-05 1.2 2.078083333333334e-05 1.2 2.078088333333334e-05 0 2.086416666666667e-05 0 2.086421666666667e-05 1.2 2.09475e-05 1.2 2.094755e-05 0 2.103083333333334e-05 0 2.103088333333334e-05 1.2 2.10725e-05 1.2 2.107255e-05 0 2.115583333333334e-05 0 2.115588333333334e-05 1.2 2.123916666666667e-05 1.2 2.123921666666667e-05 0 2.13225e-05 0 2.132255e-05 1.2 2.140583333333334e-05 1.2 2.140588333333334e-05 0 2.14475e-05 0 2.144755e-05 1.2 2.153083333333334e-05 1.2 2.153088333333334e-05 0 2.161416666666667e-05 0 2.161421666666667e-05 1.2 2.16975e-05 1.2 2.169755e-05 0 2.173916666666667e-05 0 2.173921666666667e-05 1.2 2.18225e-05 1.2 2.182255e-05 0 2.190583333333334e-05 0 2.190588333333334e-05 1.2 2.198916666666667e-05 1.2 2.198921666666667e-05 0 2.203083333333334e-05 0 2.203088333333334e-05 1.2 2.211416666666667e-05 1.2 2.211421666666667e-05 0 2.21975e-05 0 2.219755e-05 1.2 2.228083333333334e-05 1.2 2.228088333333334e-05 0 2.286416666666667e-05 0 2.286421666666667e-05 1.2 2.29475e-05 1.2 2.294755e-05 0 2.303083333333334e-05 0 2.303088333333334e-05 1.2 2.311416666666667e-05 1.2 2.311421666666667e-05 0 2.315583333333334e-05 0 2.315588333333334e-05 1.2 2.323916666666667e-05 1.2 2.323921666666667e-05 0 2.33225e-05 0 2.332255e-05 1.2 2.340583333333334e-05 1.2 2.340588333333334e-05 0 2.34475e-05 0 2.344755e-05 1.2 2.353083333333334e-05 1.2 2.353088333333334e-05 0 2.361416666666667e-05 0 2.361421666666667e-05 1.2 2.36975e-05 1.2 2.369755e-05 0 2.378083333333334e-05 0 2.378088333333334e-05 1.2 2.38225e-05 1.2 2.382255e-05 0 2.390583333333334e-05 0 2.390588333333334e-05 1.2 2.398916666666667e-05 1.2 2.398921666666667e-05 0 2.40725e-05 0 2.407255e-05 1.2 2.411416666666667e-05 1.2 2.411421666666667e-05 0 2.41975e-05 0 2.419755e-05 1.2 2.428083333333334e-05 1.2 2.428088333333334e-05 0 2.436416666666667e-05 0 2.436421666666667e-05 1.2 2.44475e-05 1.2 2.444755e-05 0 2.448916666666667e-05 0 2.448921666666667e-05 1.2 2.45725e-05 1.2 2.457255e-05 0 2.465583333333334e-05 0 2.465588333333334e-05 1.2 2.473916666666667e-05 1.2 2.473921666666667e-05 0 2.478083333333334e-05 0 2.478088333333334e-05 1.2 2.486416666666667e-05 1.2 2.486421666666667e-05 0 2.49475e-05 0 2.494755e-05 1.2 2.503083333333334e-05 1.2 2.503088333333334e-05 0 2.511416666666667e-05 0 2.511421666666667e-05 1.2 2.515583333333334e-05 1.2 2.515588333333334e-05 0 2.523916666666667e-05 0 2.523921666666667e-05 1.2 2.53225e-05 1.2 2.532255e-05 0 2.540583333333334e-05 0 2.540588333333334e-05 1.2 2.54475e-05 1.2 2.544755e-05 0 2.553083333333334e-05 0 2.553088333333334e-05 1.2 2.561416666666667e-05 1.2 2.561421666666667e-05 0 2.56975e-05 0 2.569755e-05 1.2 2.578083333333334e-05 1.2 2.578088333333334e-05 0 2.58225e-05 0 2.582255e-05 1.2 2.590583333333334e-05 1.2 2.590588333333334e-05 0 2.598916666666667e-05 0 2.598921666666667e-05 1.2 2.60725e-05 1.2 2.607255e-05 0 2.615583333333334e-05 0 2.615588333333334e-05 1.2 2.61975e-05 1.2 2.619755e-05 0 2.628083333333334e-05 0 2.628088333333334e-05 1.2 2.636416666666667e-05 1.2 2.636421666666667e-05 0 2.64475e-05 0 2.644755e-05 1.2 2.648916666666667e-05 1.2 2.648921666666667e-05 0 2.65725e-05 0 2.657255e-05 1.2 2.665583333333334e-05 1.2 2.665588333333334e-05 0 2.673916666666667e-05 0 2.673921666666667e-05 1.2 2.68225e-05 1.2 2.682255e-05 0 2.686416666666667e-05 0 2.686421666666667e-05 1.2 2.69475e-05 1.2 2.694755e-05 0 2.703083333333334e-05 0 2.703088333333334e-05 1.2 2.711416666666667e-05 1.2 2.711421666666667e-05 0 2.715583333333334e-05 0 2.715588333333334e-05 1.2 2.723916666666667e-05 1.2 2.723921666666667e-05 0 2.73225e-05 0 2.732255e-05 1.2 2.740583333333334e-05 1.2 2.740588333333334e-05 0 2.748916666666667e-05 0 2.748921666666667e-05 1.2 2.753083333333334e-05 1.2 2.753088333333334e-05 0 2.761416666666667e-05 0 2.761421666666667e-05 1.2 2.76975e-05 1.2 2.769755e-05 0 2.778083333333334e-05 0 2.778088333333334e-05 1.2 2.78225e-05 1.2 2.782255e-05 0 2.790583333333334e-05 0 2.790588333333334e-05 1.2 2.798916666666667e-05 1.2 2.798921666666667e-05 0 2.80725e-05 0 2.807255e-05 1.2 2.828083333333334e-05 1.2 2.828088333333334e-05 0 2.86975e-05 0 2.869755e-05 1.2 2.878083333333334e-05 1.2 2.878088333333334e-05 0 2.886416666666667e-05 0 2.886421666666667e-05 1.2 2.89475e-05 1.2 2.894755e-05 0 2.898916666666667e-05 0 2.898921666666667e-05 1.2 2.90725e-05 1.2 2.907255e-05 0 2.915583333333334e-05 0 2.915588333333334e-05 1.2 2.923916666666667e-05 1.2 2.923921666666667e-05 0 2.928083333333334e-05 0 2.928088333333334e-05 1.2 2.936416666666667e-05 1.2 2.936421666666667e-05 0 2.94475e-05 0 2.944755e-05 1.2 2.953083333333334e-05 1.2 2.953088333333334e-05 0 2.961416666666667e-05 0 2.961421666666667e-05 1.2 2.965583333333334e-05 1.2 2.965588333333334e-05 0 2.973916666666667e-05 0 2.973921666666667e-05 1.2 2.98225e-05 1.2 2.982255e-05 0 2.990583333333334e-05 0 2.990588333333334e-05 1.2 2.99475e-05 1.2 2.994755e-05 0 3.003083333333334e-05 0 3.003088333333334e-05 1.2 3.011416666666667e-05 1.2 3.011421666666667e-05 0 3.01975e-05 0 3.019755e-05 1.2 3.028083333333334e-05 1.2 3.028088333333334e-05 0 3.03225e-05 0 3.032255e-05 1.2 3.040583333333334e-05 1.2 3.040588333333334e-05 0 3.048916666666667e-05 0 3.048921666666667e-05 1.2 3.05725e-05 1.2 3.057255e-05 0 3.061416666666667e-05 0 3.061421666666667e-05 1.2 3.06975e-05 1.2 3.069755e-05 0 3.078083333333334e-05 0 3.078088333333333e-05 1.2 3.086416666666667e-05 1.2 3.086421666666667e-05 0 3.090583333333334e-05 0 3.090588333333333e-05 1.2 3.098916666666667e-05 1.2 3.098921666666667e-05 0 3.10725e-05 0 3.107255e-05 1.2 3.115583333333334e-05 1.2 3.115588333333333e-05 0 3.123916666666667e-05 0 3.123921666666667e-05 1.2 3.128083333333334e-05 1.2 3.128088333333334e-05 0 3.136416666666667e-05 0 3.136421666666666e-05 1.2 3.14475e-05 1.2 3.144755e-05 0 3.153083333333334e-05 0 3.153088333333334e-05 1.2 3.15725e-05 1.2 3.157255e-05 0 3.165583333333334e-05 0 3.165588333333333e-05 1.2 3.173916666666667e-05 1.2 3.173921666666667e-05 0 3.18225e-05 0 3.182255e-05 1.2 3.190583333333334e-05 1.2 3.190588333333333e-05 0 3.19475e-05 0 3.194755e-05 1.2 3.203083333333334e-05 1.2 3.203088333333334e-05 0 3.211416666666667e-05 0 3.211421666666667e-05 1.2 3.21975e-05 1.2 3.219755e-05 0 3.223916666666667e-05 0 3.223921666666666e-05 1.2 3.23225e-05 1.2 3.232255e-05 0 3.240583333333334e-05 0 3.240588333333334e-05 1.2 3.248916666666667e-05 1.2 3.248921666666666e-05 0 3.25725e-05 0 3.257255e-05 1.2 3.261416666666667e-05 1.2 3.261421666666667e-05 0 3.26975e-05 0 3.269755e-05 1.2 3.278083333333334e-05 1.2 3.278088333333333e-05 0 3.286416666666667e-05 0 3.286421666666667e-05 1.2 3.290583333333333e-05 1.2 3.290588333333333e-05 0 3.298916666666667e-05 0 3.298921666666666e-05 1.2 3.30725e-05 1.2 3.307255e-05 0 3.315583333333333e-05 0 3.315588333333333e-05 1.2 3.31975e-05 1.2 3.319755e-05 0 3.328083333333333e-05 0 3.328088333333332e-05 1.2 3.336416666666667e-05 1.2 3.336421666666666e-05 0 3.34475e-05 0 3.344755e-05 1.2 3.353083333333333e-05 1.2 3.353088333333332e-05 0 3.35725e-05 0 3.357255e-05 1.2 3.365583333333333e-05 1.2 3.365588333333333e-05 0 3.373916666666666e-05 0 3.373921666666666e-05 1.2 3.38225e-05 1.2 3.382255e-05 0 3.386416666666667e-05 0 3.386421666666666e-05 1.2 3.39475e-05 1.2 3.394755e-05 0 3.453083333333333e-05 0 3.453088333333333e-05 1.2 3.461416666666666e-05 1.2 3.461421666666666e-05 0 3.46975e-05 0 3.469755e-05 1.2 3.478083333333333e-05 1.2 3.478088333333333e-05 0 3.48225e-05 0 3.482255e-05 1.2 3.490583333333333e-05 1.2 3.490588333333333e-05 0 3.498916666666667e-05 0 3.498921666666666e-05 1.2 3.50725e-05 1.2 3.507255e-05 0 3.511416666666666e-05 0 3.511421666666666e-05 1.2 3.51975e-05 1.2 3.519755e-05 0 3.528083333333333e-05 0 3.528088333333333e-05 1.2 3.536416666666667e-05 1.2 3.536421666666667e-05 0 3.54475e-05 0 3.544755e-05 1.2 3.548916666666667e-05 1.2 3.548921666666666e-05 0 3.557250000000001e-05 0 3.557255e-05 1.2 3.565583333333333e-05 1.2 3.565588333333333e-05 0 3.573916666666666e-05 0 3.573921666666666e-05 1.2 3.578083333333333e-05 1.2 3.578088333333332e-05 0 3.586416666666667e-05 0 3.586421666666666e-05 1.2 3.59475e-05 1.2 3.594755e-05 0 3.603083333333333e-05 0 3.603088333333333e-05 1.2 3.611416666666667e-05 1.2 3.611421666666666e-05 0 3.615583333333333e-05 0 3.615588333333333e-05 1.2 3.623916666666666e-05 1.2 3.623921666666666e-05 0 3.63225e-05 0 3.632255e-05 1.2 3.640583333333333e-05 1.2 3.640588333333333e-05 0 3.64475e-05 0 3.644755e-05 1.2 3.653083333333333e-05 1.2 3.653088333333333e-05 0 3.661416666666667e-05 0 3.661421666666666e-05 1.2 3.669750000000001e-05 1.2 3.669755e-05 0 3.678083333333333e-05 0 3.678088333333333e-05 1.2 3.68225e-05 1.2 3.682255e-05 0 3.690583333333333e-05 0 3.690588333333332e-05 1.2 3.698916666666667e-05 1.2 3.698921666666666e-05 0 3.70725e-05 0 3.707255e-05 1.2 3.711416666666666e-05 1.2 3.711421666666666e-05 0 3.71975e-05 0 3.719755e-05 1.2 3.728083333333333e-05 1.2 3.728088333333333e-05 0 3.736416666666666e-05 0 3.736421666666666e-05 1.2 3.74475e-05 1.2 3.744755e-05 0 3.748916666666667e-05 0 3.748921666666666e-05 1.2 3.75725e-05 1.2 3.757255e-05 0 3.765583333333333e-05 0 3.765588333333333e-05 1.2 3.773916666666667e-05 1.2 3.773921666666666e-05 0 3.778083333333333e-05 0 3.778088333333333e-05 1.2 3.786416666666667e-05 1.2 3.786421666666667e-05 0 3.79475e-05 0 3.794755e-05 1.2 3.803083333333333e-05 1.2 3.803088333333333e-05 0 3.811416666666667e-05 0 3.811421666666667e-05 1.2 3.815583333333333e-05 1.2 3.815588333333333e-05 0 3.823916666666666e-05 0 3.823921666666666e-05 1.2 3.83225e-05 1.2 3.832255e-05 0 3.840583333333333e-05 0 3.840588333333333e-05 1.2 3.84475e-05 1.2 3.844755e-05 0 3.853083333333333e-05 0 3.853088333333333e-05 1.2 3.861416666666667e-05 1.2 3.861421666666666e-05 0 3.86975e-05 0 3.869755e-05 1.2 3.878083333333333e-05 1.2 3.878088333333333e-05 0 3.88225e-05 0 3.882255e-05 1.2 3.890583333333333e-05 1.2 3.890588333333333e-05 0 3.898916666666667e-05 0 3.898921666666667e-05 1.2 3.90725e-05 1.2 3.907255e-05 0 3.911416666666667e-05 0 3.911421666666666e-05 1.2 3.919750000000001e-05 1.2 3.919755e-05 0 3.928083333333333e-05 0 3.928088333333333e-05 1.2 3.936416666666666e-05 1.2 3.936421666666666e-05 0 3.94475e-05 0 3.944755e-05 1.2 3.948916666666667e-05 1.2 3.948921666666666e-05 0 3.95725e-05 0 3.957255e-05 1.2 3.965583333333333e-05 1.2 3.965588333333333e-05 0 3.973916666666667e-05 0 3.973921666666666e-05 1.2 3.978083333333333e-05 1.2 3.978088333333333e-05 0 4.036416666666667e-05 0 4.036421666666667e-05 1.2 4.04475e-05 1.2 4.044755e-05 0 4.053083333333333e-05 0 4.053088333333332e-05 1.2 4.061416666666667e-05 1.2 4.061421666666666e-05 0 4.065583333333333e-05 0 4.065588333333333e-05 1.2 4.073916666666666e-05 1.2 4.073921666666666e-05 0 4.08225e-05 0 4.082255e-05 1.2 4.090583333333333e-05 1.2 4.090588333333333e-05 0 4.09475e-05 0 4.094755e-05 1.2 4.103083333333333e-05 1.2 4.103088333333333e-05 0 4.111416666666667e-05 0 4.111421666666666e-05 1.2 4.11975e-05 1.2 4.119755e-05 0 4.128083333333333e-05 0 4.128088333333333e-05 1.2 4.13225e-05 1.2 4.132255e-05 0 4.140583333333333e-05 0 4.140588333333333e-05 1.2 4.148916666666667e-05 1.2 4.148921666666667e-05 0 4.15725e-05 0 4.157255e-05 1.2 4.161416666666667e-05 1.2 4.161421666666666e-05 0 4.169750000000001e-05 0 4.169755e-05 1.2 4.178083333333333e-05 1.2 4.178088333333333e-05 0 4.186416666666666e-05 0 4.186421666666666e-05 1.2 4.19475e-05 1.2 4.194755e-05 0 4.198916666666667e-05 0 4.198921666666666e-05 1.2 4.20725e-05 1.2 4.207255e-05 0 4.215583333333333e-05 0 4.215588333333333e-05 1.2 4.223916666666667e-05 1.2 4.223921666666666e-05 0 4.228083333333333e-05 0 4.228088333333333e-05 1.2 4.236416666666667e-05 1.2 4.236421666666667e-05 0 4.24475e-05 0 4.244755e-05 1.2 4.253083333333333e-05 1.2 4.253088333333333e-05 0 4.261416666666667e-05 0 4.261421666666667e-05 1.2 4.265583333333333e-05 1.2 4.265588333333333e-05 0 4.273916666666667e-05 0 4.273921666666666e-05 1.2 4.282250000000001e-05 1.2 4.282255e-05 0 4.290583333333333e-05 0 4.290588333333333e-05 1.2 4.29475e-05 1.2 4.294755e-05 0 4.303083333333333e-05 0 4.303088333333332e-05 1.2 4.311416666666667e-05 1.2 4.311421666666666e-05 0 4.31975e-05 0 4.319755e-05 1.2 4.328083333333333e-05 1.2 4.328088333333333e-05 0 4.33225e-05 0 4.332255e-05 1.2 4.340583333333333e-05 1.2 4.340588333333333e-05 0 4.348916666666667e-05 0 4.348921666666667e-05 1.2 4.35725e-05 1.2 4.357255e-05 0 4.365583333333333e-05 0 4.365588333333333e-05 1.2 4.36975e-05 1.2 4.369755e-05 0 4.378083333333333e-05 0 4.378088333333333e-05 1.2 4.386416666666667e-05 1.2 4.386421666666666e-05 0 4.394750000000001e-05 0 4.394755e-05 1.2 4.398916666666667e-05 1.2 4.398921666666667e-05 0 4.40725e-05 0 4.407255e-05 1.2 4.415583333333333e-05 1.2 4.415588333333333e-05 0 4.423916666666667e-05 0 4.423921666666666e-05 1.2 4.43225e-05 1.2 4.432255e-05 0 4.436416666666666e-05 0 4.436421666666666e-05 1.2 4.44475e-05 1.2 4.444755e-05 0 4.453083333333333e-05 0 4.453088333333333e-05 1.2 4.461416666666666e-05 1.2 4.461421666666666e-05 0 4.465583333333333e-05 0 4.465588333333333e-05 1.2 4.473916666666667e-05 1.2 4.473921666666666e-05 0 4.48225e-05 0 4.482255e-05 1.2 4.490583333333333e-05 1.2 4.490588333333333e-05 0 4.498916666666667e-05 0 4.498921666666666e-05 1.2 4.503083333333333e-05 1.2 4.503088333333333e-05 0 4.511416666666667e-05 0 4.511421666666667e-05 1.2 4.51975e-05 1.2 4.519755e-05 0 4.528083333333333e-05 0 4.528088333333333e-05 1.2 4.532250000000001e-05 1.2 4.532255e-05 0 4.540583333333333e-05 0 4.540588333333333e-05 1.2 4.548916666666666e-05 1.2 4.548921666666666e-05 0 4.55725e-05 0 4.557255e-05 1.2 4.578083333333333e-05 1.2 4.578088333333333e-05 0 4.619750000000001e-05 0 4.619755e-05 1.2 4.628083333333333e-05 1.2 4.628088333333333e-05 0 4.636416666666667e-05 0 4.636421666666666e-05 1.2 4.644750000000001e-05 1.2 4.644755e-05 0 4.648916666666667e-05 0 4.648921666666667e-05 1.2 4.65725e-05 1.2 4.657255e-05 0 4.665583333333333e-05 0 4.665588333333332e-05 1.2 4.673916666666667e-05 1.2 4.673921666666666e-05 0 4.678083333333333e-05 0 4.678088333333333e-05 1.2 4.686416666666666e-05 1.2 4.686421666666666e-05 0 4.69475e-05 0 4.694755e-05 1.2 4.703083333333333e-05 1.2 4.703088333333333e-05 0 4.711416666666667e-05 0 4.711421666666667e-05 1.2 4.715583333333333e-05 1.2 4.715588333333333e-05 0 4.723916666666667e-05 0 4.723921666666666e-05 1.2 4.73225e-05 1.2 4.732255e-05 0 4.740583333333333e-05 0 4.740588333333333e-05 1.2 4.74475e-05 1.2 4.744755e-05 0 4.753083333333333e-05 0 4.753088333333333e-05 1.2 4.761416666666667e-05 1.2 4.761421666666667e-05 0 4.76975e-05 0 4.769755e-05 1.2 4.778083333333333e-05 1.2 4.778088333333333e-05 0 4.782250000000001e-05 0 4.782255e-05 1.2 4.790583333333333e-05 1.2 4.790588333333333e-05 0 4.798916666666666e-05 0 4.798921666666666e-05 1.2 4.80725e-05 1.2 4.807255e-05 0 4.811416666666667e-05 0 4.811421666666666e-05 1.2 4.81975e-05 1.2 4.819755e-05 0 4.828083333333333e-05 0 4.828088333333333e-05 1.2 4.836416666666667e-05 1.2 4.836421666666666e-05 0 4.84475e-05 0 4.844755e-05 1.2 4.848916666666667e-05 1.2 4.848921666666667e-05 0 4.85725e-05 0 4.857255e-05 1.2 4.865583333333333e-05 1.2 4.865588333333333e-05 0 4.873916666666667e-05 0 4.873921666666667e-05 1.2 4.878083333333333e-05 1.2 4.878088333333333e-05 0 4.886416666666667e-05 0 4.886421666666666e-05 1.2 4.894750000000001e-05 1.2 4.894755e-05 0 4.903083333333333e-05 0 4.903088333333333e-05 1.2 4.911416666666666e-05 1.2 4.911421666666666e-05 0 4.915583333333333e-05 0 4.915588333333333e-05 1.2 4.923916666666667e-05 1.2 4.923921666666666e-05 0 4.93225e-05 0 4.932255e-05 1.2 4.940583333333333e-05 1.2 4.940588333333333e-05 0 4.94475e-05 0 4.944755e-05 1.2 4.953083333333333e-05 1.2 4.953088333333333e-05 0 4.961416666666667e-05 0 4.961421666666667e-05 1.2 4.96975e-05 1.2 4.969755e-05 0 4.978083333333333e-05 0 4.978088333333333e-05 1.2 4.982250000000001e-05 1.2 4.982255e-05 0 4.990583333333333e-05 0 4.990588333333333e-05 1.2 4.998916666666667e-05 1.2 4.998921666666666e-05 0 5.007250000000001e-05 0 5.007255e-05 1.2 5.011416666666667e-05 1.2 5.011421666666667e-05 0 5.01975e-05 0 5.019755e-05 1.2 5.028083333333333e-05 1.2 5.028088333333333e-05 0 5.036416666666667e-05 0 5.036421666666666e-05 1.2 5.04475e-05 1.2 5.044755e-05 0 5.048916666666666e-05 0 5.048921666666666e-05 1.2 5.05725e-05 1.2 5.057255e-05 0 5.065583333333333e-05 0 5.065588333333333e-05 1.2 5.073916666666667e-05 1.2 5.073921666666667e-05 0 5.078083333333333e-05 0 5.078088333333333e-05 1.2 5.086416666666667e-05 1.2 5.086421666666666e-05 0 5.094750000000001e-05 0 5.094755e-05 1.2 5.103083333333333e-05 1.2 5.103088333333333e-05 0 5.111416666666667e-05 0 5.111421666666666e-05 1.2 5.115583333333333e-05 1.2 5.115588333333333e-05 0 5.123916666666667e-05 0 5.123921666666667e-05 1.2 5.13225e-05 1.2 5.132255e-05 0 5.140583333333333e-05 0 5.140588333333333e-05 1.2 5.144750000000001e-05 1.2 5.144755e-05 0]
VM5 (m5 0) vsource type=pwl wave=[0 0 4.891666666666667e-07 0 4.892166666666667e-07 1.2 5.308333333333334e-07 1.2 5.308833333333334e-07 0 5.724999999999999e-07 0 5.725499999999999e-07 1.2 6.558333333333333e-07 1.2 6.558833333333333e-07 0 6.975e-07 0 6.9755e-07 1.2 7.808333333333333e-07 1.2 7.808833333333333e-07 0 8.225000000000001e-07 0 8.225500000000001e-07 1.2 9.058333333333333e-07 1.2 9.058833333333333e-07 0 9.475e-07 0 9.4755e-07 1.2 9.891666666666668e-07 1.2 9.892166666666667e-07 0 1.0725e-06 0 1.07255e-06 1.2 1.114166666666667e-06 1.2 1.114216666666667e-06 0 1.1975e-06 0 1.19755e-06 1.2 1.239166666666667e-06 1.2 1.239216666666667e-06 0 1.3225e-06 0 1.32255e-06 1.2 1.364166666666667e-06 1.2 1.364216666666667e-06 0 1.405833333333334e-06 0 1.405883333333333e-06 1.2 1.489166666666667e-06 1.2 1.489216666666667e-06 0 1.530833333333334e-06 0 1.530883333333334e-06 1.2 1.614166666666667e-06 1.2 1.614216666666667e-06 0 1.655833333333334e-06 0 1.655883333333333e-06 1.2 1.739166666666667e-06 1.2 1.739216666666667e-06 0 1.780833333333334e-06 0 1.780883333333333e-06 1.2 1.9475e-06 1.2 1.94755e-06 0 2.3225e-06 0 2.32255e-06 1.2 2.364166666666667e-06 1.2 2.364216666666667e-06 0 2.405833333333333e-06 0 2.405883333333333e-06 1.2 2.4475e-06 1.2 2.44755e-06 0 2.489166666666667e-06 0 2.489216666666667e-06 1.2 2.530833333333333e-06 1.2 2.530883333333333e-06 0 2.5725e-06 0 2.57255e-06 1.2 2.614166666666666e-06 1.2 2.614216666666667e-06 0 2.655833333333333e-06 0 2.655883333333333e-06 1.2 2.6975e-06 1.2 2.69755e-06 0 2.739166666666667e-06 0 2.739216666666667e-06 1.2 2.780833333333333e-06 1.2 2.780883333333333e-06 0 2.8225e-06 0 2.82255e-06 1.2 2.905833333333333e-06 1.2 2.905883333333333e-06 0 2.9475e-06 0 2.94755e-06 1.2 2.989166666666667e-06 1.2 2.989216666666667e-06 0 3.030833333333333e-06 0 3.030883333333333e-06 1.2 3.0725e-06 1.2 3.07255e-06 0 3.114166666666667e-06 0 3.114216666666667e-06 1.2 3.155833333333333e-06 1.2 3.155883333333333e-06 0 3.1975e-06 0 3.19755e-06 1.2 3.239166666666667e-06 1.2 3.239216666666667e-06 0 3.280833333333333e-06 0 3.280883333333334e-06 1.2 3.3225e-06 1.2 3.32255e-06 0 3.364166666666667e-06 0 3.364216666666667e-06 1.2 3.4475e-06 1.2 3.44755e-06 0 3.489166666666667e-06 0 3.489216666666667e-06 1.2 3.530833333333333e-06 1.2 3.530883333333333e-06 0 3.5725e-06 0 3.57255e-06 1.2 3.614166666666667e-06 1.2 3.614216666666667e-06 0 4.155833333333333e-06 0 4.155883333333334e-06 1.2 4.197500000000001e-06 1.2 4.197550000000001e-06 0 4.239166666666667e-06 0 4.239216666666668e-06 1.2 4.280833333333334e-06 1.2 4.280883333333334e-06 0 4.322500000000001e-06 0 4.322550000000001e-06 1.2 4.405833333333334e-06 1.2 4.405883333333335e-06 0 4.4475e-06 0 4.44755e-06 1.2 4.489166666666668e-06 1.2 4.489216666666668e-06 0 4.530833333333334e-06 0 4.530883333333334e-06 1.2 4.614166666666667e-06 1.2 4.614216666666667e-06 0 4.655833333333335e-06 0 4.655883333333335e-06 1.2 4.6975e-06 1.2 4.69755e-06 0 4.739166666666667e-06 0 4.739216666666667e-06 1.2 4.8225e-06 1.2 4.82255e-06 0 4.864166666666667e-06 0 4.864216666666667e-06 1.2 4.905833333333334e-06 1.2 4.905883333333334e-06 0 4.9475e-06 0 4.947550000000001e-06 1.2 4.989166666666667e-06 1.2 4.989216666666667e-06 0 5.0725e-06 0 5.07255e-06 1.2 5.114166666666668e-06 1.2 5.114216666666668e-06 0 5.155833333333334e-06 0 5.155883333333334e-06 1.2 5.197500000000001e-06 1.2 5.197550000000001e-06 0 5.280833333333335e-06 0 5.280883333333335e-06 1.2 5.3225e-06 1.2 5.32255e-06 0 5.364166666666668e-06 0 5.364216666666668e-06 1.2 5.405833333333334e-06 1.2 5.405883333333334e-06 0 5.989166666666668e-06 0 5.989216666666668e-06 1.2 6.030833333333334e-06 1.2 6.030883333333334e-06 0 6.072500000000001e-06 0 6.072550000000001e-06 1.2 6.114166666666667e-06 1.2 6.114216666666667e-06 0 6.1975e-06 0 6.19755e-06 1.2 6.239166666666668e-06 1.2 6.239216666666668e-06 0 6.280833333333334e-06 0 6.280883333333334e-06 1.2 6.364166666666667e-06 1.2 6.364216666666668e-06 0 6.405833333333334e-06 0 6.405883333333334e-06 1.2 6.447500000000001e-06 1.2 6.447550000000001e-06 0 6.530833333333334e-06 0 6.530883333333335e-06 1.2 6.5725e-06 1.2 6.57255e-06 0 6.614166666666668e-06 0 6.614216666666668e-06 1.2 6.697500000000001e-06 1.2 6.697550000000001e-06 0 6.739166666666667e-06 0 6.739216666666667e-06 1.2 6.780833333333335e-06 1.2 6.780883333333335e-06 0 6.864166666666668e-06 0 6.864216666666668e-06 1.2 6.905833333333334e-06 1.2 6.905883333333334e-06 0 6.947500000000001e-06 0 6.947550000000001e-06 1.2 7.030833333333335e-06 1.2 7.030883333333335e-06 0 7.0725e-06 0 7.072550000000001e-06 1.2 7.114166666666667e-06 1.2 7.114216666666667e-06 0 7.1975e-06 0 7.19755e-06 1.2 7.239166666666668e-06 1.2 7.239216666666668e-06 0 7.280833333333334e-06 0 7.280883333333334e-06 1.2 7.4475e-06 1.2 7.44755e-06 0 7.8225e-06 0 7.82255e-06 1.2 7.864166666666667e-06 1.2 7.864216666666667e-06 0 7.905833333333335e-06 0 7.905883333333335e-06 1.2 7.989166666666668e-06 1.2 7.989216666666668e-06 0 8.030833333333335e-06 0 8.030883333333335e-06 1.2 8.072500000000001e-06 1.2 8.072550000000001e-06 0 8.155833333333334e-06 0 8.155883333333334e-06 1.2 8.197499999999999e-06 1.2 8.197549999999999e-06 0 8.239166666666667e-06 0 8.239216666666667e-06 1.2 8.3225e-06 1.2 8.32255e-06 0 8.364166666666667e-06 0 8.364216666666667e-06 1.2 8.4475e-06 1.2 8.44755e-06 0 8.489166666666667e-06 0 8.489216666666667e-06 1.2 8.530833333333333e-06 1.2 8.530883333333333e-06 0 8.614166666666666e-06 0 8.614216666666666e-06 1.2 8.655833333333333e-06 1.2 8.655883333333333e-06 0 8.697500000000001e-06 0 8.697550000000001e-06 1.2 8.780833333333332e-06 1.2 8.780883333333333e-06 0 8.822500000000001e-06 0 8.822550000000001e-06 1.2 8.905833333333332e-06 1.2 8.905883333333332e-06 0 8.9475e-06 0 8.94755e-06 1.2 8.989166666666667e-06 1.2 8.989216666666667e-06 0 9.0725e-06 0 9.07255e-06 1.2 9.114166666666667e-06 1.2 9.114216666666667e-06 0 9.655833333333333e-06 0 9.655883333333333e-06 1.2 9.6975e-06 1.2 9.69755e-06 0 9.739166666666666e-06 0 9.739216666666667e-06 1.2 9.822500000000001e-06 1.2 9.822550000000001e-06 0 9.864166666666666e-06 0 9.864216666666666e-06 1.2 9.947500000000001e-06 1.2 9.947550000000001e-06 0 9.989166666666667e-06 0 9.989216666666668e-06 1.2 1.003083333333333e-05 1.2 1.003088333333333e-05 0 1.011416666666667e-05 0 1.011421666666667e-05 1.2 1.015583333333333e-05 1.2 1.015588333333333e-05 0 1.023916666666667e-05 0 1.023921666666667e-05 1.2 1.028083333333333e-05 1.2 1.028088333333333e-05 0 1.03225e-05 0 1.032255e-05 1.2 1.040583333333333e-05 1.2 1.040588333333333e-05 0 1.04475e-05 0 1.044755e-05 1.2 1.053083333333333e-05 1.2 1.053088333333333e-05 0 1.05725e-05 0 1.057255e-05 1.2 1.061416666666667e-05 1.2 1.061421666666667e-05 0 1.06975e-05 0 1.069755e-05 1.2 1.073916666666667e-05 1.2 1.073921666666667e-05 0 1.078083333333333e-05 0 1.078088333333333e-05 1.2 1.086416666666667e-05 1.2 1.086421666666667e-05 0 1.090583333333333e-05 0 1.090588333333333e-05 1.2 1.111416666666667e-05 1.2 1.111421666666667e-05 0 1.148916666666667e-05 0 1.148921666666667e-05 1.2 1.153083333333333e-05 1.2 1.153088333333333e-05 0 1.15725e-05 0 1.157255e-05 1.2 1.165583333333333e-05 1.2 1.165588333333333e-05 0 1.16975e-05 0 1.169755e-05 1.2 1.173916666666667e-05 1.2 1.173921666666667e-05 0 1.18225e-05 0 1.182255e-05 1.2 1.186416666666667e-05 1.2 1.186421666666667e-05 0 1.19475e-05 0 1.194755e-05 1.2 1.198916666666667e-05 1.2 1.198921666666667e-05 0 1.203083333333333e-05 0 1.203088333333333e-05 1.2 1.211416666666667e-05 1.2 1.211421666666667e-05 0 1.215583333333333e-05 0 1.215588333333333e-05 1.2 1.223916666666667e-05 1.2 1.223921666666667e-05 0 1.228083333333333e-05 0 1.228088333333333e-05 1.2 1.23225e-05 1.2 1.232255e-05 0 1.240583333333333e-05 0 1.240588333333333e-05 1.2 1.24475e-05 1.2 1.244755e-05 0 1.248916666666667e-05 0 1.248921666666667e-05 1.2 1.25725e-05 1.2 1.257255e-05 0 1.261416666666667e-05 0 1.261421666666667e-05 1.2 1.26975e-05 1.2 1.269755e-05 0 1.273916666666667e-05 0 1.273921666666667e-05 1.2 1.278083333333333e-05 1.2 1.278088333333333e-05 0 1.33225e-05 0 1.332255e-05 1.2 1.336416666666667e-05 1.2 1.336421666666667e-05 0 1.340583333333333e-05 0 1.340588333333333e-05 1.2 1.348916666666667e-05 1.2 1.348921666666667e-05 0 1.353083333333333e-05 0 1.353088333333333e-05 1.2 1.35725e-05 1.2 1.357255e-05 0 1.365583333333333e-05 0 1.365588333333333e-05 1.2 1.36975e-05 1.2 1.369755e-05 0 1.378083333333333e-05 0 1.378088333333333e-05 1.2 1.38225e-05 1.2 1.382255e-05 0 1.386416666666667e-05 0 1.386421666666667e-05 1.2 1.39475e-05 1.2 1.394755e-05 0 1.398916666666667e-05 0 1.398921666666667e-05 1.2 1.40725e-05 1.2 1.407255e-05 0 1.411416666666667e-05 0 1.411421666666667e-05 1.2 1.415583333333333e-05 1.2 1.415588333333333e-05 0 1.423916666666667e-05 0 1.423921666666667e-05 1.2 1.428083333333333e-05 1.2 1.428088333333333e-05 0 1.436416666666667e-05 0 1.436421666666667e-05 1.2 1.440583333333333e-05 1.2 1.440588333333333e-05 0 1.44475e-05 0 1.444755e-05 1.2 1.453083333333333e-05 1.2 1.453088333333333e-05 0 1.45725e-05 0 1.457255e-05 1.2 1.478083333333333e-05 1.2 1.478088333333333e-05 0 1.515583333333333e-05 0 1.515588333333333e-05 1.2 1.51975e-05 1.2 1.519755e-05 0 1.523916666666667e-05 0 1.523921666666667e-05 1.2 1.53225e-05 1.2 1.532255e-05 0 1.536416666666667e-05 0 1.536421666666667e-05 1.2 1.54475e-05 1.2 1.544755e-05 0 1.548916666666667e-05 0 1.548921666666667e-05 1.2 1.553083333333333e-05 1.2 1.553088333333333e-05 0 1.561416666666667e-05 0 1.561421666666667e-05 1.2 1.565583333333333e-05 1.2 1.565588333333333e-05 0 1.56975e-05 0 1.569755e-05 1.2 1.578083333333333e-05 1.2 1.578088333333333e-05 0 1.58225e-05 0 1.582255e-05 1.2 1.590583333333333e-05 1.2 1.590588333333333e-05 0 1.59475e-05 0 1.594755e-05 1.2 1.598916666666667e-05 1.2 1.598921666666667e-05 0 1.60725e-05 0 1.607255e-05 1.2 1.611416666666667e-05 1.2 1.611421666666667e-05 0 1.61975e-05 0 1.619755e-05 1.2 1.623916666666667e-05 1.2 1.623921666666667e-05 0 1.628083333333333e-05 0 1.628088333333333e-05 1.2 1.636416666666667e-05 1.2 1.636421666666667e-05 0 1.640583333333333e-05 0 1.640588333333333e-05 1.2 1.661416666666667e-05 1.2 1.661421666666667e-05 0 1.698916666666667e-05 0 1.698921666666667e-05 1.2 1.703083333333334e-05 1.2 1.703088333333334e-05 0 1.70725e-05 0 1.707255e-05 1.2 1.715583333333334e-05 1.2 1.715588333333334e-05 0 1.71975e-05 0 1.719755e-05 1.2 1.728083333333334e-05 1.2 1.728088333333334e-05 0 1.73225e-05 0 1.732255e-05 1.2 1.736416666666667e-05 1.2 1.736421666666667e-05 0 1.74475e-05 0 1.744755e-05 1.2 1.748916666666667e-05 1.2 1.748921666666667e-05 0 1.753083333333334e-05 0 1.753088333333334e-05 1.2 1.761416666666667e-05 1.2 1.761421666666667e-05 0 1.765583333333334e-05 0 1.765588333333334e-05 1.2 1.773916666666667e-05 1.2 1.773921666666667e-05 0 1.778083333333334e-05 0 1.778088333333334e-05 1.2 1.78225e-05 1.2 1.782255e-05 0 1.790583333333334e-05 0 1.790588333333334e-05 1.2 1.79475e-05 1.2 1.794755e-05 0 1.803083333333334e-05 0 1.803088333333334e-05 1.2 1.80725e-05 1.2 1.807255e-05 0 1.811416666666667e-05 0 1.811421666666667e-05 1.2 1.81975e-05 1.2 1.819755e-05 0 1.823916666666667e-05 0 1.823921666666667e-05 1.2 1.83225e-05 1.2 1.832255e-05 0 1.836416666666667e-05 0 1.836421666666667e-05 1.2 1.840583333333334e-05 1.2 1.840588333333334e-05 0 1.848916666666667e-05 0 1.848921666666667e-05 1.2 1.853083333333334e-05 1.2 1.853088333333334e-05 0 1.861416666666667e-05 0 1.861421666666667e-05 1.2 1.865583333333334e-05 1.2 1.865588333333334e-05 0 1.86975e-05 0 1.869755e-05 1.2 1.878083333333334e-05 1.2 1.878088333333334e-05 0 1.88225e-05 0 1.882255e-05 1.2 1.890583333333334e-05 1.2 1.890588333333334e-05 0 1.89475e-05 0 1.894755e-05 1.2 1.898916666666667e-05 1.2 1.898921666666667e-05 0 1.90725e-05 0 1.907255e-05 1.2 1.911416666666667e-05 1.2 1.911421666666667e-05 0 1.91975e-05 0 1.919755e-05 1.2 1.923916666666667e-05 1.2 1.923921666666667e-05 0 1.928083333333334e-05 0 1.928088333333334e-05 1.2 1.936416666666667e-05 1.2 1.936421666666667e-05 0 1.940583333333334e-05 0 1.940588333333334e-05 1.2 1.94475e-05 1.2 1.944755e-05 0 1.953083333333334e-05 0 1.953088333333334e-05 1.2 1.95725e-05 1.2 1.957255e-05 0 1.965583333333334e-05 0 1.965588333333334e-05 1.2 1.96975e-05 1.2 1.969755e-05 0 1.973916666666667e-05 0 1.973921666666667e-05 1.2 1.98225e-05 1.2 1.982255e-05 0 1.986416666666667e-05 0 1.986421666666667e-05 1.2 1.99475e-05 1.2 1.994755e-05 0 1.998916666666667e-05 0 1.998921666666667e-05 1.2 2.003083333333334e-05 1.2 2.003088333333334e-05 0 2.011416666666667e-05 0 2.011421666666667e-05 1.2 2.015583333333334e-05 1.2 2.015588333333334e-05 0 2.023916666666667e-05 0 2.023921666666667e-05 1.2 2.028083333333334e-05 1.2 2.028088333333334e-05 0 2.03225e-05 0 2.032255e-05 1.2 2.040583333333334e-05 1.2 2.040588333333334e-05 0 2.04475e-05 0 2.044755e-05 1.2 2.053083333333334e-05 1.2 2.053088333333334e-05 0 2.05725e-05 0 2.057255e-05 1.2 2.061416666666667e-05 1.2 2.061421666666667e-05 0 2.06975e-05 0 2.069755e-05 1.2 2.073916666666667e-05 1.2 2.073921666666667e-05 0 2.08225e-05 0 2.082255e-05 1.2 2.086416666666667e-05 1.2 2.086421666666667e-05 0 2.090583333333334e-05 0 2.090588333333334e-05 1.2 2.098916666666667e-05 1.2 2.098921666666667e-05 0 2.103083333333334e-05 0 2.103088333333334e-05 1.2 2.111416666666667e-05 1.2 2.111421666666667e-05 0 2.115583333333334e-05 0 2.115588333333334e-05 1.2 2.11975e-05 1.2 2.119755e-05 0 2.128083333333334e-05 0 2.128088333333334e-05 1.2 2.13225e-05 1.2 2.132255e-05 0 2.136416666666667e-05 0 2.136421666666667e-05 1.2 2.14475e-05 1.2 2.144755e-05 0 2.148916666666667e-05 0 2.148921666666667e-05 1.2 2.15725e-05 1.2 2.157255e-05 0 2.161416666666667e-05 0 2.161421666666667e-05 1.2 2.165583333333334e-05 1.2 2.165588333333334e-05 0 2.173916666666667e-05 0 2.173921666666667e-05 1.2 2.178083333333334e-05 1.2 2.178088333333334e-05 0 2.186416666666667e-05 0 2.186421666666667e-05 1.2 2.190583333333334e-05 1.2 2.190588333333334e-05 0 2.19475e-05 0 2.194755e-05 1.2 2.203083333333334e-05 1.2 2.203088333333334e-05 0 2.20725e-05 0 2.207255e-05 1.2 2.215583333333334e-05 1.2 2.215588333333334e-05 0 2.21975e-05 0 2.219755e-05 1.2 2.223916666666667e-05 1.2 2.223921666666667e-05 0 2.28225e-05 0 2.282255e-05 1.2 2.286416666666667e-05 1.2 2.286421666666667e-05 0 2.290583333333334e-05 0 2.290588333333334e-05 1.2 2.298916666666667e-05 1.2 2.298921666666667e-05 0 2.303083333333334e-05 0 2.303088333333334e-05 1.2 2.30725e-05 1.2 2.307255e-05 0 2.315583333333334e-05 0 2.315588333333334e-05 1.2 2.31975e-05 1.2 2.319755e-05 0 2.328083333333334e-05 0 2.328088333333334e-05 1.2 2.33225e-05 1.2 2.332255e-05 0 2.336416666666667e-05 0 2.336421666666667e-05 1.2 2.34475e-05 1.2 2.344755e-05 0 2.348916666666667e-05 0 2.348921666666667e-05 1.2 2.35725e-05 1.2 2.357255e-05 0 2.361416666666667e-05 0 2.361421666666667e-05 1.2 2.365583333333334e-05 1.2 2.365588333333334e-05 0 2.373916666666667e-05 0 2.373921666666667e-05 1.2 2.378083333333334e-05 1.2 2.378088333333334e-05 0 2.386416666666667e-05 0 2.386421666666667e-05 1.2 2.390583333333334e-05 1.2 2.390588333333334e-05 0 2.39475e-05 0 2.394755e-05 1.2 2.403083333333334e-05 1.2 2.403088333333334e-05 0 2.40725e-05 0 2.407255e-05 1.2 2.415583333333334e-05 1.2 2.415588333333334e-05 0 2.41975e-05 0 2.419755e-05 1.2 2.423916666666667e-05 1.2 2.423921666666667e-05 0 2.43225e-05 0 2.432255e-05 1.2 2.436416666666667e-05 1.2 2.436421666666667e-05 0 2.440583333333334e-05 0 2.440588333333334e-05 1.2 2.448916666666667e-05 1.2 2.448921666666667e-05 0 2.453083333333334e-05 0 2.453088333333334e-05 1.2 2.461416666666667e-05 1.2 2.461421666666667e-05 0 2.465583333333334e-05 0 2.465588333333334e-05 1.2 2.46975e-05 1.2 2.469755e-05 0 2.478083333333334e-05 0 2.478088333333334e-05 1.2 2.48225e-05 1.2 2.482255e-05 0 2.490583333333334e-05 0 2.490588333333334e-05 1.2 2.49475e-05 1.2 2.494755e-05 0 2.498916666666667e-05 0 2.498921666666667e-05 1.2 2.50725e-05 1.2 2.507255e-05 0 2.511416666666667e-05 0 2.511421666666667e-05 1.2 2.51975e-05 1.2 2.519755e-05 0 2.523916666666667e-05 0 2.523921666666667e-05 1.2 2.528083333333334e-05 1.2 2.528088333333334e-05 0 2.536416666666667e-05 0 2.536421666666667e-05 1.2 2.540583333333334e-05 1.2 2.540588333333334e-05 0 2.548916666666667e-05 0 2.548921666666667e-05 1.2 2.553083333333334e-05 1.2 2.553088333333334e-05 0 2.55725e-05 0 2.557255e-05 1.2 2.565583333333334e-05 1.2 2.565588333333334e-05 0 2.56975e-05 0 2.569755e-05 1.2 2.573916666666667e-05 1.2 2.573921666666667e-05 0 2.58225e-05 0 2.582255e-05 1.2 2.586416666666667e-05 1.2 2.586421666666667e-05 0 2.59475e-05 0 2.594755e-05 1.2 2.598916666666667e-05 1.2 2.598921666666667e-05 0 2.603083333333334e-05 0 2.603088333333334e-05 1.2 2.611416666666667e-05 1.2 2.611421666666667e-05 0 2.615583333333334e-05 0 2.615588333333334e-05 1.2 2.623916666666667e-05 1.2 2.623921666666667e-05 0 2.628083333333334e-05 0 2.628088333333334e-05 1.2 2.63225e-05 1.2 2.632255e-05 0 2.640583333333334e-05 0 2.640588333333334e-05 1.2 2.64475e-05 1.2 2.644755e-05 0 2.653083333333334e-05 0 2.653088333333334e-05 1.2 2.65725e-05 1.2 2.657255e-05 0 2.661416666666667e-05 0 2.661421666666667e-05 1.2 2.66975e-05 1.2 2.669755e-05 0 2.673916666666667e-05 0 2.673921666666667e-05 1.2 2.678083333333334e-05 1.2 2.678088333333334e-05 0 2.686416666666667e-05 0 2.686421666666667e-05 1.2 2.690583333333334e-05 1.2 2.690588333333334e-05 0 2.698916666666667e-05 0 2.698921666666667e-05 1.2 2.703083333333334e-05 1.2 2.703088333333334e-05 0 2.70725e-05 0 2.707255e-05 1.2 2.715583333333334e-05 1.2 2.715588333333334e-05 0 2.71975e-05 0 2.719755e-05 1.2 2.728083333333334e-05 1.2 2.728088333333334e-05 0 2.73225e-05 0 2.732255e-05 1.2 2.736416666666667e-05 1.2 2.736421666666667e-05 0 2.74475e-05 0 2.744755e-05 1.2 2.748916666666667e-05 1.2 2.748921666666667e-05 0 2.75725e-05 0 2.757255e-05 1.2 2.761416666666667e-05 1.2 2.761421666666667e-05 0 2.765583333333334e-05 0 2.765588333333334e-05 1.2 2.773916666666667e-05 1.2 2.773921666666667e-05 0 2.778083333333334e-05 0 2.778088333333334e-05 1.2 2.786416666666667e-05 1.2 2.786421666666667e-05 0 2.790583333333334e-05 0 2.790588333333334e-05 1.2 2.79475e-05 1.2 2.794755e-05 0 2.803083333333334e-05 0 2.803088333333334e-05 1.2 2.80725e-05 1.2 2.807255e-05 0 2.811416666666667e-05 0 2.811421666666667e-05 1.2 2.828083333333334e-05 1.2 2.828088333333334e-05 0 2.865583333333334e-05 0 2.865588333333334e-05 1.2 2.86975e-05 1.2 2.869755e-05 0 2.873916666666667e-05 0 2.873921666666667e-05 1.2 2.88225e-05 1.2 2.882255e-05 0 2.886416666666667e-05 0 2.886421666666667e-05 1.2 2.890583333333334e-05 1.2 2.890588333333334e-05 0 2.898916666666667e-05 0 2.898921666666667e-05 1.2 2.903083333333334e-05 1.2 2.903088333333334e-05 0 2.911416666666667e-05 0 2.911421666666667e-05 1.2 2.915583333333334e-05 1.2 2.915588333333334e-05 0 2.91975e-05 0 2.919755e-05 1.2 2.928083333333334e-05 1.2 2.928088333333334e-05 0 2.93225e-05 0 2.932255e-05 1.2 2.940583333333334e-05 1.2 2.940588333333334e-05 0 2.94475e-05 0 2.944755e-05 1.2 2.948916666666667e-05 1.2 2.948921666666667e-05 0 2.95725e-05 0 2.957255e-05 1.2 2.961416666666667e-05 1.2 2.961421666666667e-05 0 2.96975e-05 0 2.969755e-05 1.2 2.973916666666667e-05 1.2 2.973921666666667e-05 0 2.978083333333334e-05 0 2.978088333333334e-05 1.2 2.986416666666667e-05 1.2 2.986421666666667e-05 0 2.990583333333334e-05 0 2.990588333333334e-05 1.2 2.998916666666667e-05 1.2 2.998921666666667e-05 0 3.003083333333334e-05 0 3.003088333333334e-05 1.2 3.00725e-05 1.2 3.007255e-05 0 3.015583333333334e-05 0 3.015588333333334e-05 1.2 3.01975e-05 1.2 3.019755e-05 0 3.023916666666667e-05 0 3.023921666666667e-05 1.2 3.03225e-05 1.2 3.032255e-05 0 3.036416666666667e-05 0 3.036421666666667e-05 1.2 3.04475e-05 1.2 3.044755e-05 0 3.048916666666667e-05 0 3.048921666666667e-05 1.2 3.053083333333334e-05 1.2 3.053088333333333e-05 0 3.061416666666667e-05 0 3.061421666666667e-05 1.2 3.065583333333334e-05 1.2 3.065588333333334e-05 0 3.073916666666667e-05 0 3.073921666666667e-05 1.2 3.078083333333334e-05 1.2 3.078088333333333e-05 0 3.082250000000001e-05 0 3.082255e-05 1.2 3.090583333333334e-05 1.2 3.090588333333333e-05 0 3.09475e-05 0 3.094755e-05 1.2 3.103083333333333e-05 1.2 3.103088333333333e-05 0 3.10725e-05 0 3.107255e-05 1.2 3.111416666666667e-05 1.2 3.111421666666666e-05 0 3.11975e-05 0 3.119755e-05 1.2 3.123916666666667e-05 1.2 3.123921666666667e-05 0 3.13225e-05 0 3.132255e-05 1.2 3.136416666666667e-05 1.2 3.136421666666666e-05 0 3.140583333333334e-05 0 3.140588333333333e-05 1.2 3.148916666666667e-05 1.2 3.148921666666667e-05 0 3.153083333333334e-05 0 3.153088333333334e-05 1.2 3.161416666666667e-05 1.2 3.161421666666667e-05 0 3.165583333333334e-05 0 3.165588333333333e-05 1.2 3.16975e-05 1.2 3.169755e-05 0 3.178083333333334e-05 0 3.178088333333334e-05 1.2 3.18225e-05 1.2 3.182255e-05 0 3.186416666666667e-05 0 3.186421666666667e-05 1.2 3.19475e-05 1.2 3.194755e-05 0 3.198916666666667e-05 0 3.198921666666667e-05 1.2 3.20725e-05 1.2 3.207255e-05 0 3.211416666666667e-05 0 3.211421666666667e-05 1.2 3.215583333333333e-05 1.2 3.215588333333333e-05 0 3.223916666666667e-05 0 3.223921666666666e-05 1.2 3.228083333333334e-05 1.2 3.228088333333333e-05 0 3.236416666666667e-05 0 3.236421666666667e-05 1.2 3.240583333333334e-05 1.2 3.240588333333334e-05 0 3.24475e-05 0 3.244755e-05 1.2 3.253083333333334e-05 1.2 3.253088333333333e-05 0 3.25725e-05 0 3.257255e-05 1.2 3.265583333333334e-05 1.2 3.265588333333334e-05 0 3.26975e-05 0 3.269755e-05 1.2 3.273916666666667e-05 1.2 3.273921666666667e-05 0 3.282249999999999e-05 0 3.282254999999999e-05 1.2 3.286416666666667e-05 1.2 3.286421666666667e-05 0 3.29475e-05 0 3.294755e-05 1.2 3.298916666666667e-05 1.2 3.298921666666666e-05 0 3.303083333333333e-05 0 3.303088333333333e-05 1.2 3.311416666666667e-05 1.2 3.311421666666667e-05 0 3.315583333333333e-05 0 3.315588333333333e-05 1.2 3.323916666666667e-05 1.2 3.323921666666666e-05 0 3.328083333333333e-05 0 3.328088333333332e-05 1.2 3.33225e-05 1.2 3.332255e-05 0 3.340583333333333e-05 0 3.340588333333333e-05 1.2 3.34475e-05 1.2 3.344755e-05 0 3.348916666666666e-05 0 3.348921666666666e-05 1.2 3.35725e-05 1.2 3.357255e-05 0 3.361416666666667e-05 0 3.361421666666666e-05 1.2 3.36975e-05 1.2 3.369755e-05 0 3.373916666666666e-05 0 3.373921666666666e-05 1.2 3.378083333333333e-05 1.2 3.378088333333333e-05 0 3.386416666666667e-05 0 3.386421666666666e-05 1.2 3.390583333333333e-05 1.2 3.390588333333333e-05 0 3.448916666666667e-05 0 3.448921666666667e-05 1.2 3.453083333333333e-05 1.2 3.453088333333333e-05 0 3.45725e-05 0 3.457255e-05 1.2 3.465583333333333e-05 1.2 3.465588333333332e-05 0 3.46975e-05 0 3.469755e-05 1.2 3.473916666666667e-05 1.2 3.473921666666666e-05 0 3.48225e-05 0 3.482255e-05 1.2 3.486416666666666e-05 1.2 3.486421666666666e-05 0 3.49475e-05 0 3.494755e-05 1.2 3.498916666666667e-05 1.2 3.498921666666666e-05 0 3.503083333333333e-05 0 3.503088333333333e-05 1.2 3.511416666666666e-05 1.2 3.511421666666666e-05 0 3.515583333333333e-05 0 3.515588333333333e-05 1.2 3.523916666666667e-05 1.2 3.523921666666666e-05 0 3.528083333333333e-05 0 3.528088333333333e-05 1.2 3.53225e-05 1.2 3.532255e-05 0 3.540583333333333e-05 0 3.540588333333333e-05 1.2 3.54475e-05 1.2 3.544755e-05 0 3.553083333333333e-05 0 3.553088333333333e-05 1.2 3.557250000000001e-05 1.2 3.557255e-05 0 3.561416666666667e-05 0 3.561421666666667e-05 1.2 3.56975e-05 1.2 3.569755e-05 0 3.573916666666666e-05 0 3.573921666666666e-05 1.2 3.58225e-05 1.2 3.582255e-05 0 3.586416666666667e-05 0 3.586421666666666e-05 1.2 3.590583333333333e-05 1.2 3.590588333333333e-05 0 3.598916666666666e-05 0 3.598921666666666e-05 1.2 3.603083333333333e-05 1.2 3.603088333333333e-05 0 3.60725e-05 0 3.607255e-05 1.2 3.615583333333333e-05 1.2 3.615588333333333e-05 0 3.61975e-05 0 3.619755e-05 1.2 3.628083333333333e-05 1.2 3.628088333333333e-05 0 3.63225e-05 0 3.632255e-05 1.2 3.636416666666667e-05 1.2 3.636421666666666e-05 0 3.64475e-05 0 3.644755e-05 1.2 3.648916666666667e-05 1.2 3.648921666666667e-05 0 3.65725e-05 0 3.657255e-05 1.2 3.661416666666667e-05 1.2 3.661421666666666e-05 0 3.665583333333333e-05 0 3.665588333333333e-05 1.2 3.673916666666667e-05 1.2 3.673921666666667e-05 0 3.678083333333333e-05 0 3.678088333333333e-05 1.2 3.686416666666667e-05 1.2 3.686421666666666e-05 0 3.690583333333333e-05 0 3.690588333333332e-05 1.2 3.69475e-05 1.2 3.694755e-05 0 3.703083333333333e-05 0 3.703088333333333e-05 1.2 3.70725e-05 1.2 3.707255e-05 0 3.715583333333333e-05 0 3.715588333333332e-05 1.2 3.71975e-05 1.2 3.719755e-05 0 3.723916666666667e-05 0 3.723921666666666e-05 1.2 3.73225e-05 1.2 3.732255e-05 0 3.736416666666666e-05 0 3.736421666666666e-05 1.2 3.740583333333333e-05 1.2 3.740588333333333e-05 0 3.748916666666667e-05 0 3.748921666666666e-05 1.2 3.753083333333333e-05 1.2 3.753088333333333e-05 0 3.761416666666667e-05 0 3.761421666666667e-05 1.2 3.765583333333333e-05 1.2 3.765588333333333e-05 0 3.76975e-05 0 3.769755e-05 1.2 3.778083333333333e-05 1.2 3.778088333333333e-05 0 3.78225e-05 0 3.782255e-05 1.2 3.790583333333333e-05 1.2 3.790588333333333e-05 0 3.79475e-05 0 3.794755e-05 1.2 3.798916666666667e-05 1.2 3.798921666666666e-05 0 3.807250000000001e-05 0 3.807255e-05 1.2 3.811416666666667e-05 1.2 3.811421666666667e-05 0 3.81975e-05 0 3.819755e-05 1.2 3.823916666666666e-05 1.2 3.823921666666666e-05 0 3.828083333333333e-05 0 3.828088333333332e-05 1.2 3.836416666666667e-05 1.2 3.836421666666666e-05 0 3.840583333333333e-05 0 3.840588333333333e-05 1.2 3.848916666666666e-05 1.2 3.848921666666666e-05 0 3.853083333333333e-05 0 3.853088333333333e-05 1.2 3.85725e-05 1.2 3.857255e-05 0 3.865583333333333e-05 0 3.865588333333333e-05 1.2 3.86975e-05 1.2 3.869755e-05 0 3.873916666666667e-05 0 3.873921666666667e-05 1.2 3.88225e-05 1.2 3.882255e-05 0 3.886416666666667e-05 0 3.886421666666666e-05 1.2 3.89475e-05 1.2 3.894755e-05 0 3.898916666666667e-05 0 3.898921666666667e-05 1.2 3.903083333333333e-05 1.2 3.903088333333333e-05 0 3.911416666666667e-05 0 3.911421666666666e-05 1.2 3.915583333333333e-05 1.2 3.915588333333333e-05 0 3.923916666666667e-05 0 3.923921666666667e-05 1.2 3.928083333333333e-05 1.2 3.928088333333333e-05 0 3.93225e-05 0 3.932255e-05 1.2 3.940583333333333e-05 1.2 3.940588333333332e-05 0 3.94475e-05 0 3.944755e-05 1.2 3.953083333333333e-05 1.2 3.953088333333333e-05 0 3.95725e-05 0 3.957255e-05 1.2 3.961416666666666e-05 1.2 3.961421666666666e-05 0 3.96975e-05 0 3.969755e-05 1.2 3.973916666666667e-05 1.2 3.973921666666666e-05 0 4.032250000000001e-05 0 4.032255e-05 1.2 4.036416666666667e-05 1.2 4.036421666666667e-05 0 4.040583333333333e-05 0 4.040588333333333e-05 1.2 4.048916666666667e-05 1.2 4.048921666666666e-05 0 4.053083333333333e-05 0 4.053088333333332e-05 1.2 4.05725e-05 1.2 4.057255e-05 0 4.065583333333333e-05 0 4.065588333333333e-05 1.2 4.06975e-05 1.2 4.069755e-05 0 4.078083333333333e-05 0 4.078088333333333e-05 1.2 4.08225e-05 1.2 4.082255e-05 0 4.086416666666667e-05 0 4.086421666666666e-05 1.2 4.09475e-05 1.2 4.094755e-05 0 4.098916666666666e-05 0 4.098921666666666e-05 1.2 4.10725e-05 1.2 4.107255e-05 0 4.111416666666667e-05 0 4.111421666666666e-05 1.2 4.115583333333333e-05 1.2 4.115588333333333e-05 0 4.123916666666667e-05 0 4.123921666666667e-05 1.2 4.128083333333333e-05 1.2 4.128088333333333e-05 0 4.136416666666667e-05 0 4.136421666666666e-05 1.2 4.140583333333333e-05 1.2 4.140588333333333e-05 0 4.144750000000001e-05 0 4.144755e-05 1.2 4.153083333333333e-05 1.2 4.153088333333333e-05 0 4.15725e-05 0 4.157255e-05 1.2 4.165583333333333e-05 1.2 4.165588333333333e-05 0 4.169750000000001e-05 0 4.169755e-05 1.2 4.173916666666667e-05 1.2 4.173921666666667e-05 0 4.18225e-05 0 4.182255e-05 1.2 4.186416666666666e-05 1.2 4.186421666666666e-05 0 4.190583333333333e-05 0 4.190588333333332e-05 1.2 4.198916666666667e-05 1.2 4.198921666666666e-05 0 4.203083333333333e-05 0 4.203088333333333e-05 1.2 4.211416666666666e-05 1.2 4.211421666666666e-05 0 4.215583333333333e-05 0 4.215588333333333e-05 1.2 4.21975e-05 1.2 4.219755e-05 0 4.228083333333333e-05 0 4.228088333333333e-05 1.2 4.23225e-05 1.2 4.232255e-05 0 4.240583333333333e-05 0 4.240588333333333e-05 1.2 4.24475e-05 1.2 4.244755e-05 0 4.248916666666667e-05 0 4.248921666666666e-05 1.2 4.25725e-05 1.2 4.257255e-05 0 4.261416666666667e-05 0 4.261421666666667e-05 1.2 4.26975e-05 1.2 4.269755e-05 0 4.273916666666667e-05 0 4.273921666666666e-05 1.2 4.278083333333333e-05 1.2 4.278088333333333e-05 0 4.286416666666667e-05 0 4.286421666666667e-05 1.2 4.290583333333333e-05 1.2 4.290588333333333e-05 0 4.298916666666666e-05 0 4.298921666666666e-05 1.2 4.303083333333333e-05 1.2 4.303088333333332e-05 0 4.30725e-05 0 4.307255e-05 1.2 4.315583333333333e-05 1.2 4.315588333333333e-05 0 4.31975e-05 0 4.319755e-05 1.2 4.323916666666666e-05 1.2 4.323921666666666e-05 0 4.33225e-05 0 4.332255e-05 1.2 4.336416666666667e-05 1.2 4.336421666666666e-05 0 4.34475e-05 0 4.344755e-05 1.2 4.348916666666667e-05 1.2 4.348921666666667e-05 0 4.353083333333333e-05 0 4.353088333333333e-05 1.2 4.361416666666667e-05 1.2 4.361421666666666e-05 0 4.365583333333333e-05 0 4.365588333333333e-05 1.2 4.373916666666667e-05 1.2 4.373921666666667e-05 0 4.378083333333333e-05 0 4.378088333333333e-05 1.2 4.38225e-05 1.2 4.382255e-05 0 4.390583333333333e-05 0 4.390588333333333e-05 1.2 4.394750000000001e-05 1.2 4.394755e-05 0 4.403083333333333e-05 0 4.403088333333333e-05 1.2 4.40725e-05 1.2 4.407255e-05 0 4.411416666666667e-05 0 4.411421666666666e-05 1.2 4.419750000000001e-05 1.2 4.419755e-05 0 4.423916666666667e-05 0 4.423921666666666e-05 1.2 4.428083333333333e-05 1.2 4.428088333333333e-05 0 4.436416666666666e-05 0 4.436421666666666e-05 1.2 4.440583333333333e-05 1.2 4.440588333333333e-05 0 4.448916666666667e-05 0 4.448921666666666e-05 1.2 4.453083333333333e-05 1.2 4.453088333333333e-05 0 4.45725e-05 0 4.457255e-05 1.2 4.465583333333333e-05 1.2 4.465588333333333e-05 0 4.46975e-05 0 4.469755e-05 1.2 4.478083333333333e-05 1.2 4.478088333333333e-05 0 4.48225e-05 0 4.482255e-05 1.2 4.486416666666667e-05 1.2 4.486421666666667e-05 0 4.49475e-05 0 4.494755e-05 1.2 4.498916666666667e-05 1.2 4.498921666666666e-05 0 4.507250000000001e-05 0 4.507255e-05 1.2 4.511416666666667e-05 1.2 4.511421666666667e-05 0 4.515583333333333e-05 0 4.515588333333333e-05 1.2 4.523916666666667e-05 1.2 4.523921666666666e-05 0 4.528083333333333e-05 0 4.528088333333333e-05 1.2 4.536416666666667e-05 1.2 4.536421666666667e-05 0 4.540583333333333e-05 0 4.540588333333333e-05 1.2 4.54475e-05 1.2 4.544755e-05 0 4.553083333333333e-05 0 4.553088333333333e-05 1.2 4.55725e-05 1.2 4.557255e-05 0 4.561416666666667e-05 0 4.561421666666666e-05 1.2 4.578083333333333e-05 1.2 4.578088333333333e-05 0 4.615583333333333e-05 0 4.615588333333333e-05 1.2 4.619750000000001e-05 1.2 4.619755e-05 0 4.623916666666667e-05 0 4.623921666666667e-05 1.2 4.63225e-05 1.2 4.632255e-05 0 4.636416666666667e-05 0 4.636421666666666e-05 1.2 4.640583333333333e-05 1.2 4.640588333333333e-05 0 4.648916666666667e-05 0 4.648921666666667e-05 1.2 4.653083333333333e-05 1.2 4.653088333333333e-05 0 4.661416666666666e-05 0 4.661421666666666e-05 1.2 4.665583333333333e-05 1.2 4.665588333333332e-05 0 4.66975e-05 0 4.669755e-05 1.2 4.678083333333333e-05 1.2 4.678088333333333e-05 0 4.68225e-05 0 4.682255e-05 1.2 4.690583333333333e-05 1.2 4.690588333333333e-05 0 4.69475e-05 0 4.694755e-05 1.2 4.698916666666667e-05 1.2 4.698921666666666e-05 0 4.70725e-05 0 4.707255e-05 1.2 4.711416666666667e-05 1.2 4.711421666666667e-05 0 4.71975e-05 0 4.719755e-05 1.2 4.723916666666667e-05 1.2 4.723921666666666e-05 0 4.728083333333333e-05 0 4.728088333333333e-05 1.2 4.736416666666667e-05 1.2 4.736421666666667e-05 0 4.740583333333333e-05 0 4.740588333333333e-05 1.2 4.748916666666667e-05 1.2 4.748921666666666e-05 0 4.753083333333333e-05 0 4.753088333333333e-05 1.2 4.757250000000001e-05 1.2 4.757255e-05 0 4.765583333333333e-05 0 4.765588333333333e-05 1.2 4.76975e-05 1.2 4.769755e-05 0 4.773916666666667e-05 0 4.773921666666666e-05 1.2 4.782250000000001e-05 1.2 4.782255e-05 0 4.786416666666667e-05 0 4.786421666666666e-05 1.2 4.79475e-05 1.2 4.794755e-05 0 4.798916666666666e-05 0 4.798921666666666e-05 1.2 4.803083333333333e-05 1.2 4.803088333333333e-05 0 4.811416666666667e-05 0 4.811421666666666e-05 1.2 4.815583333333333e-05 1.2 4.815588333333333e-05 0 4.823916666666667e-05 0 4.823921666666667e-05 1.2 4.828083333333333e-05 1.2 4.828088333333333e-05 0 4.83225e-05 0 4.832255e-05 1.2 4.840583333333333e-05 1.2 4.840588333333333e-05 0 4.84475e-05 0 4.844755e-05 1.2 4.853083333333333e-05 1.2 4.853088333333333e-05 0 4.85725e-05 0 4.857255e-05 1.2 4.861416666666667e-05 1.2 4.861421666666666e-05 0 4.869750000000001e-05 0 4.869755e-05 1.2 4.873916666666667e-05 1.2 4.873921666666667e-05 0 4.88225e-05 0 4.882255e-05 1.2 4.886416666666667e-05 1.2 4.886421666666666e-05 0 4.890583333333333e-05 0 4.890588333333333e-05 1.2 4.898916666666667e-05 1.2 4.898921666666667e-05 0 4.903083333333333e-05 0 4.903088333333333e-05 1.2 4.90725e-05 1.2 4.907255e-05 0 4.915583333333333e-05 0 4.915588333333333e-05 1.2 4.91975e-05 1.2 4.919755e-05 0 4.928083333333333e-05 0 4.928088333333333e-05 1.2 4.93225e-05 1.2 4.932255e-05 0 4.936416666666666e-05 0 4.936421666666666e-05 1.2 4.94475e-05 1.2 4.944755e-05 0 4.948916666666667e-05 0 4.948921666666666e-05 1.2 4.95725e-05 1.2 4.957255e-05 0 4.961416666666667e-05 0 4.961421666666667e-05 1.2 4.965583333333333e-05 1.2 4.965588333333333e-05 0 4.973916666666667e-05 0 4.973921666666666e-05 1.2 4.978083333333333e-05 1.2 4.978088333333333e-05 0 4.986416666666667e-05 0 4.986421666666667e-05 1.2 4.990583333333333e-05 1.2 4.990588333333333e-05 0 4.99475e-05 0 4.994755e-05 1.2 5.003083333333333e-05 1.2 5.003088333333333e-05 0 5.007250000000001e-05 0 5.007255e-05 1.2 5.015583333333333e-05 1.2 5.015588333333333e-05 0 5.01975e-05 0 5.019755e-05 1.2 5.023916666666666e-05 1.2 5.023921666666666e-05 0 5.03225e-05 0 5.032255e-05 1.2 5.036416666666667e-05 1.2 5.036421666666666e-05 0 5.040583333333333e-05 0 5.040588333333333e-05 1.2 5.048916666666666e-05 1.2 5.048921666666666e-05 0 5.053083333333333e-05 0 5.053088333333333e-05 1.2 5.061416666666667e-05 1.2 5.061421666666666e-05 0 5.065583333333333e-05 0 5.065588333333333e-05 1.2 5.06975e-05 1.2 5.069755e-05 0 5.078083333333333e-05 0 5.078088333333333e-05 1.2 5.08225e-05 1.2 5.082255e-05 0 5.090583333333333e-05 0 5.090588333333333e-05 1.2 5.094750000000001e-05 1.2 5.094755e-05 0 5.098916666666667e-05 0 5.098921666666667e-05 1.2 5.10725e-05 1.2 5.107255e-05 0 5.111416666666667e-05 0 5.111421666666666e-05 1.2 5.119750000000001e-05 1.2 5.119755e-05 0 5.123916666666667e-05 0 5.123921666666667e-05 1.2 5.128083333333333e-05 1.2 5.128088333333333e-05 0 5.136416666666667e-05 0 5.136421666666666e-05 1.2 5.140583333333333e-05 1.2 5.140588333333333e-05 0]
VM6 (m6 0) vsource type=pwl wave=[0 0 5.308333333333334e-07 0 5.308833333333334e-07 1.2 6.141666666666667e-07 1.2 6.142166666666667e-07 0 6.558333333333333e-07 0 6.558833333333333e-07 1.2 7.391666666666666e-07 1.2 7.392166666666667e-07 0 7.808333333333333e-07 0 7.808833333333333e-07 1.2 8.641666666666667e-07 1.2 8.642166666666667e-07 0 9.058333333333333e-07 0 9.058833333333333e-07 1.2 9.891666666666668e-07 1.2 9.892166666666667e-07 0 1.030833333333333e-06 0 1.030883333333333e-06 1.2 1.114166666666667e-06 1.2 1.114216666666667e-06 0 1.155833333333334e-06 0 1.155883333333334e-06 1.2 1.239166666666667e-06 1.2 1.239216666666667e-06 0 1.280833333333333e-06 0 1.280883333333333e-06 1.2 1.364166666666667e-06 1.2 1.364216666666667e-06 0 1.4475e-06 0 1.44755e-06 1.2 1.489166666666667e-06 1.2 1.489216666666667e-06 0 1.5725e-06 0 1.57255e-06 1.2 1.614166666666667e-06 1.2 1.614216666666667e-06 0 1.6975e-06 0 1.69755e-06 1.2 1.739166666666667e-06 1.2 1.739216666666667e-06 0 2.364166666666667e-06 0 2.364216666666667e-06 1.2 2.4475e-06 1.2 2.44755e-06 0 2.530833333333333e-06 0 2.530883333333333e-06 1.2 2.614166666666666e-06 1.2 2.614216666666667e-06 0 2.6975e-06 0 2.69755e-06 1.2 2.780833333333333e-06 1.2 2.780883333333333e-06 0 2.864166666666667e-06 0 2.864216666666667e-06 1.2 2.905833333333333e-06 1.2 2.905883333333333e-06 0 2.989166666666667e-06 0 2.989216666666667e-06 1.2 3.0725e-06 1.2 3.07255e-06 0 3.155833333333333e-06 0 3.155883333333333e-06 1.2 3.239166666666667e-06 1.2 3.239216666666667e-06 0 3.3225e-06 0 3.32255e-06 1.2 3.405833333333333e-06 1.2 3.405883333333333e-06 0 3.4475e-06 0 3.44755e-06 1.2 3.530833333333333e-06 1.2 3.530883333333333e-06 0 3.614166666666667e-06 0 3.614216666666667e-06 1.2 3.780833333333333e-06 1.2 3.780883333333333e-06 0 4.197500000000001e-06 0 4.197550000000001e-06 1.2 4.280833333333334e-06 1.2 4.280883333333334e-06 0 4.364166666666667e-06 0 4.364216666666667e-06 1.2 4.405833333333334e-06 1.2 4.405883333333335e-06 0 4.489166666666668e-06 0 4.489216666666668e-06 1.2 4.572500000000001e-06 1.2 4.572550000000001e-06 0 4.614166666666667e-06 0 4.614216666666667e-06 1.2 4.6975e-06 1.2 4.69755e-06 0 4.780833333333334e-06 0 4.780883333333334e-06 1.2 4.8225e-06 1.2 4.82255e-06 0 4.905833333333334e-06 0 4.905883333333334e-06 1.2 4.989166666666667e-06 1.2 4.989216666666667e-06 0 5.030833333333334e-06 0 5.030883333333335e-06 1.2 5.114166666666668e-06 1.2 5.114216666666668e-06 0 5.197500000000001e-06 0 5.197550000000001e-06 1.2 5.239166666666667e-06 1.2 5.239216666666667e-06 0 5.3225e-06 0 5.32255e-06 1.2 5.405833333333334e-06 1.2 5.405883333333334e-06 0 5.4475e-06 0 5.44755e-06 1.2 5.614166666666667e-06 1.2 5.614216666666667e-06 0 6.030833333333334e-06 0 6.030883333333334e-06 1.2 6.114166666666667e-06 1.2 6.114216666666667e-06 0 6.155833333333335e-06 0 6.155883333333335e-06 1.2 6.239166666666668e-06 1.2 6.239216666666668e-06 0 6.3225e-06 0 6.32255e-06 1.2 6.364166666666667e-06 1.2 6.364216666666668e-06 0 6.447500000000001e-06 0 6.447550000000001e-06 1.2 6.489166666666667e-06 1.2 6.489216666666667e-06 0 6.5725e-06 0 6.57255e-06 1.2 6.655833333333334e-06 1.2 6.655883333333334e-06 0 6.697500000000001e-06 0 6.697550000000001e-06 1.2 6.780833333333335e-06 1.2 6.780883333333335e-06 0 6.8225e-06 0 6.82255e-06 1.2 6.905833333333334e-06 1.2 6.905883333333334e-06 0 6.989166666666667e-06 0 6.989216666666667e-06 1.2 7.030833333333335e-06 1.2 7.030883333333335e-06 0 7.114166666666667e-06 0 7.114216666666667e-06 1.2 7.155833333333334e-06 1.2 7.155883333333335e-06 0 7.239166666666668e-06 0 7.239216666666668e-06 1.2 7.4475e-06 1.2 7.44755e-06 0 7.864166666666667e-06 0 7.864216666666667e-06 1.2 7.9475e-06 1.2 7.94755e-06 0 7.989166666666668e-06 0 7.989216666666668e-06 1.2 8.072500000000001e-06 1.2 8.072550000000001e-06 0 8.114166666666668e-06 0 8.114216666666668e-06 1.2 8.197499999999999e-06 1.2 8.197549999999999e-06 0 8.280833333333334e-06 0 8.280883333333334e-06 1.2 8.3225e-06 1.2 8.32255e-06 0 8.405833333333333e-06 0 8.405883333333334e-06 1.2 8.4475e-06 1.2 8.44755e-06 0 8.530833333333333e-06 0 8.530883333333333e-06 1.2 8.572500000000001e-06 1.2 8.572550000000001e-06 0 8.655833333333333e-06 0 8.655883333333333e-06 1.2 8.739166666666666e-06 1.2 8.739216666666666e-06 0 8.780833333333332e-06 0 8.780883333333333e-06 1.2 8.864166666666667e-06 1.2 8.864216666666667e-06 0 8.905833333333332e-06 0 8.905883333333332e-06 1.2 8.989166666666667e-06 1.2 8.989216666666667e-06 0 9.030833333333333e-06 0 9.030883333333334e-06 1.2 9.114166666666667e-06 1.2 9.114216666666667e-06 0 9.6975e-06 0 9.69755e-06 1.2 9.780833333333333e-06 1.2 9.780883333333333e-06 0 9.822500000000001e-06 0 9.822550000000001e-06 1.2 9.905833333333333e-06 1.2 9.905883333333333e-06 0 9.947500000000001e-06 0 9.947550000000001e-06 1.2 1.003083333333333e-05 1.2 1.003088333333333e-05 0 1.00725e-05 0 1.007255e-05 1.2 1.015583333333333e-05 1.2 1.015588333333333e-05 0 1.01975e-05 0 1.019755e-05 1.2 1.028083333333333e-05 1.2 1.028088333333333e-05 0 1.036416666666667e-05 0 1.036421666666667e-05 1.2 1.040583333333333e-05 1.2 1.040588333333333e-05 0 1.048916666666667e-05 0 1.048921666666667e-05 1.2 1.053083333333333e-05 1.2 1.053088333333333e-05 0 1.061416666666667e-05 0 1.061421666666667e-05 1.2 1.065583333333333e-05 1.2 1.065588333333333e-05 0 1.073916666666667e-05 0 1.073921666666667e-05 1.2 1.08225e-05 1.2 1.082255e-05 0 1.086416666666667e-05 0 1.086421666666667e-05 1.2 1.09475e-05 1.2 1.094755e-05 0 1.153083333333333e-05 0 1.153088333333333e-05 1.2 1.161416666666667e-05 1.2 1.161421666666667e-05 0 1.165583333333333e-05 0 1.165588333333333e-05 1.2 1.173916666666667e-05 1.2 1.173921666666667e-05 0 1.178083333333333e-05 0 1.178088333333333e-05 1.2 1.186416666666667e-05 1.2 1.186421666666667e-05 0 1.190583333333333e-05 0 1.190588333333333e-05 1.2 1.198916666666667e-05 1.2 1.198921666666667e-05 0 1.20725e-05 0 1.207255e-05 1.2 1.211416666666667e-05 1.2 1.211421666666667e-05 0 1.21975e-05 0 1.219755e-05 1.2 1.223916666666667e-05 1.2 1.223921666666667e-05 0 1.23225e-05 0 1.232255e-05 1.2 1.236416666666667e-05 1.2 1.236421666666667e-05 0 1.24475e-05 0 1.244755e-05 1.2 1.253083333333333e-05 1.2 1.253088333333333e-05 0 1.25725e-05 0 1.257255e-05 1.2 1.265583333333333e-05 1.2 1.265588333333333e-05 0 1.26975e-05 0 1.269755e-05 1.2 1.278083333333333e-05 1.2 1.278088333333333e-05 0 1.336416666666667e-05 0 1.336421666666667e-05 1.2 1.34475e-05 1.2 1.344755e-05 0 1.348916666666667e-05 0 1.348921666666667e-05 1.2 1.35725e-05 1.2 1.357255e-05 0 1.361416666666667e-05 0 1.361421666666667e-05 1.2 1.36975e-05 1.2 1.369755e-05 0 1.373916666666667e-05 0 1.373921666666667e-05 1.2 1.38225e-05 1.2 1.382255e-05 0 1.390583333333333e-05 0 1.390588333333333e-05 1.2 1.39475e-05 1.2 1.394755e-05 0 1.403083333333333e-05 0 1.403088333333333e-05 1.2 1.40725e-05 1.2 1.407255e-05 0 1.415583333333333e-05 0 1.415588333333333e-05 1.2 1.41975e-05 1.2 1.419755e-05 0 1.428083333333333e-05 0 1.428088333333333e-05 1.2 1.43225e-05 1.2 1.432255e-05 0 1.440583333333333e-05 0 1.440588333333333e-05 1.2 1.448916666666667e-05 1.2 1.448921666666667e-05 0 1.453083333333333e-05 0 1.453088333333333e-05 1.2 1.461416666666667e-05 1.2 1.461421666666667e-05 0 1.51975e-05 0 1.519755e-05 1.2 1.528083333333333e-05 1.2 1.528088333333333e-05 0 1.53225e-05 0 1.532255e-05 1.2 1.540583333333333e-05 1.2 1.540588333333333e-05 0 1.54475e-05 0 1.544755e-05 1.2 1.553083333333333e-05 1.2 1.553088333333333e-05 0 1.55725e-05 0 1.557255e-05 1.2 1.565583333333333e-05 1.2 1.565588333333333e-05 0 1.573916666666667e-05 0 1.573921666666667e-05 1.2 1.578083333333333e-05 1.2 1.578088333333333e-05 0 1.586416666666667e-05 0 1.586421666666667e-05 1.2 1.590583333333333e-05 1.2 1.590588333333333e-05 0 1.598916666666667e-05 0 1.598921666666667e-05 1.2 1.603083333333333e-05 1.2 1.603088333333333e-05 0 1.611416666666667e-05 0 1.611421666666667e-05 1.2 1.615583333333333e-05 1.2 1.615588333333333e-05 0 1.623916666666667e-05 0 1.623921666666667e-05 1.2 1.63225e-05 1.2 1.632255e-05 0 1.636416666666667e-05 0 1.636421666666667e-05 1.2 1.64475e-05 1.2 1.644755e-05 0 1.703083333333334e-05 0 1.703088333333334e-05 1.2 1.711416666666667e-05 1.2 1.711421666666667e-05 0 1.715583333333334e-05 0 1.715588333333334e-05 1.2 1.723916666666667e-05 1.2 1.723921666666667e-05 0 1.728083333333334e-05 0 1.728088333333334e-05 1.2 1.736416666666667e-05 1.2 1.736421666666667e-05 0 1.740583333333334e-05 0 1.740588333333334e-05 1.2 1.748916666666667e-05 1.2 1.748921666666667e-05 0 1.75725e-05 0 1.757255e-05 1.2 1.761416666666667e-05 1.2 1.761421666666667e-05 0 1.76975e-05 0 1.769755e-05 1.2 1.773916666666667e-05 1.2 1.773921666666667e-05 0 1.78225e-05 0 1.782255e-05 1.2 1.786416666666667e-05 1.2 1.786421666666667e-05 0 1.79475e-05 0 1.794755e-05 1.2 1.798916666666667e-05 1.2 1.798921666666667e-05 0 1.80725e-05 0 1.807255e-05 1.2 1.815583333333334e-05 1.2 1.815588333333334e-05 0 1.81975e-05 0 1.819755e-05 1.2 1.828083333333334e-05 1.2 1.828088333333334e-05 0 1.83225e-05 0 1.832255e-05 1.2 1.840583333333334e-05 1.2 1.840588333333334e-05 0 1.84475e-05 0 1.844755e-05 1.2 1.853083333333334e-05 1.2 1.853088333333334e-05 0 1.85725e-05 0 1.857255e-05 1.2 1.865583333333334e-05 1.2 1.865588333333334e-05 0 1.873916666666667e-05 0 1.873921666666667e-05 1.2 1.878083333333334e-05 1.2 1.878088333333334e-05 0 1.886416666666667e-05 0 1.886421666666667e-05 1.2 1.890583333333334e-05 1.2 1.890588333333334e-05 0 1.898916666666667e-05 0 1.898921666666667e-05 1.2 1.903083333333334e-05 1.2 1.903088333333334e-05 0 1.911416666666667e-05 0 1.911421666666667e-05 1.2 1.915583333333334e-05 1.2 1.915588333333334e-05 0 1.923916666666667e-05 0 1.923921666666667e-05 1.2 1.93225e-05 1.2 1.932255e-05 0 1.936416666666667e-05 0 1.936421666666667e-05 1.2 1.94475e-05 1.2 1.944755e-05 0 1.948916666666667e-05 0 1.948921666666667e-05 1.2 1.95725e-05 1.2 1.957255e-05 0 1.961416666666667e-05 0 1.961421666666667e-05 1.2 1.96975e-05 1.2 1.969755e-05 0 1.978083333333334e-05 0 1.978088333333334e-05 1.2 1.98225e-05 1.2 1.982255e-05 0 1.990583333333334e-05 0 1.990588333333334e-05 1.2 1.99475e-05 1.2 1.994755e-05 0 2.003083333333334e-05 0 2.003088333333334e-05 1.2 2.00725e-05 1.2 2.007255e-05 0 2.015583333333334e-05 0 2.015588333333334e-05 1.2 2.01975e-05 1.2 2.019755e-05 0 2.028083333333334e-05 0 2.028088333333334e-05 1.2 2.036416666666667e-05 1.2 2.036421666666667e-05 0 2.040583333333334e-05 0 2.040588333333334e-05 1.2 2.048916666666667e-05 1.2 2.048921666666667e-05 0 2.053083333333334e-05 0 2.053088333333334e-05 1.2 2.061416666666667e-05 1.2 2.061421666666667e-05 0 2.065583333333334e-05 0 2.065588333333334e-05 1.2 2.073916666666667e-05 1.2 2.073921666666667e-05 0 2.078083333333334e-05 0 2.078088333333334e-05 1.2 2.086416666666667e-05 1.2 2.086421666666667e-05 0 2.09475e-05 0 2.094755e-05 1.2 2.098916666666667e-05 1.2 2.098921666666667e-05 0 2.10725e-05 0 2.107255e-05 1.2 2.111416666666667e-05 1.2 2.111421666666667e-05 0 2.11975e-05 0 2.119755e-05 1.2 2.123916666666667e-05 1.2 2.123921666666667e-05 0 2.13225e-05 0 2.132255e-05 1.2 2.140583333333334e-05 1.2 2.140588333333334e-05 0 2.14475e-05 0 2.144755e-05 1.2 2.153083333333334e-05 1.2 2.153088333333334e-05 0 2.15725e-05 0 2.157255e-05 1.2 2.165583333333334e-05 1.2 2.165588333333334e-05 0 2.16975e-05 0 2.169755e-05 1.2 2.178083333333334e-05 1.2 2.178088333333334e-05 0 2.18225e-05 0 2.182255e-05 1.2 2.190583333333334e-05 1.2 2.190588333333334e-05 0 2.198916666666667e-05 0 2.198921666666667e-05 1.2 2.203083333333334e-05 1.2 2.203088333333334e-05 0 2.211416666666667e-05 0 2.211421666666667e-05 1.2 2.215583333333334e-05 1.2 2.215588333333334e-05 0 2.223916666666667e-05 0 2.223921666666667e-05 1.2 2.228083333333334e-05 1.2 2.228088333333334e-05 0 2.286416666666667e-05 0 2.286421666666667e-05 1.2 2.29475e-05 1.2 2.294755e-05 0 2.298916666666667e-05 0 2.298921666666667e-05 1.2 2.30725e-05 1.2 2.307255e-05 0 2.311416666666667e-05 0 2.311421666666667e-05 1.2 2.31975e-05 1.2 2.319755e-05 0 2.323916666666667e-05 0 2.323921666666667e-05 1.2 2.33225e-05 1.2 2.332255e-05 0 2.340583333333334e-05 0 2.340588333333334e-05 1.2 2.34475e-05 1.2 2.344755e-05 0 2.353083333333334e-05 0 2.353088333333334e-05 1.2 2.35725e-05 1.2 2.357255e-05 0 2.365583333333334e-05 0 2.365588333333334e-05 1.2 2.36975e-05 1.2 2.369755e-05 0 2.378083333333334e-05 0 2.378088333333334e-05 1.2 2.38225e-05 1.2 2.382255e-05 0 2.390583333333334e-05 0 2.390588333333334e-05 1.2 2.398916666666667e-05 1.2 2.398921666666667e-05 0 2.403083333333334e-05 0 2.403088333333334e-05 1.2 2.411416666666667e-05 1.2 2.411421666666667e-05 0 2.415583333333334e-05 0 2.415588333333334e-05 1.2 2.423916666666667e-05 1.2 2.423921666666667e-05 0 2.428083333333334e-05 0 2.428088333333334e-05 1.2 2.436416666666667e-05 1.2 2.436421666666667e-05 0 2.44475e-05 0 2.444755e-05 1.2 2.448916666666667e-05 1.2 2.448921666666667e-05 0 2.45725e-05 0 2.457255e-05 1.2 2.461416666666667e-05 1.2 2.461421666666667e-05 0 2.46975e-05 0 2.469755e-05 1.2 2.473916666666667e-05 1.2 2.473921666666667e-05 0 2.48225e-05 0 2.482255e-05 1.2 2.486416666666667e-05 1.2 2.486421666666667e-05 0 2.49475e-05 0 2.494755e-05 1.2 2.503083333333334e-05 1.2 2.503088333333334e-05 0 2.50725e-05 0 2.507255e-05 1.2 2.515583333333334e-05 1.2 2.515588333333334e-05 0 2.51975e-05 0 2.519755e-05 1.2 2.528083333333334e-05 1.2 2.528088333333334e-05 0 2.53225e-05 0 2.532255e-05 1.2 2.540583333333334e-05 1.2 2.540588333333334e-05 0 2.54475e-05 0 2.544755e-05 1.2 2.553083333333334e-05 1.2 2.553088333333334e-05 0 2.561416666666667e-05 0 2.561421666666667e-05 1.2 2.565583333333334e-05 1.2 2.565588333333334e-05 0 2.573916666666667e-05 0 2.573921666666667e-05 1.2 2.578083333333334e-05 1.2 2.578088333333334e-05 0 2.586416666666667e-05 0 2.586421666666667e-05 1.2 2.590583333333334e-05 1.2 2.590588333333334e-05 0 2.598916666666667e-05 0 2.598921666666667e-05 1.2 2.60725e-05 1.2 2.607255e-05 0 2.611416666666667e-05 0 2.611421666666667e-05 1.2 2.61975e-05 1.2 2.619755e-05 0 2.623916666666667e-05 0 2.623921666666667e-05 1.2 2.63225e-05 1.2 2.632255e-05 0 2.636416666666667e-05 0 2.636421666666667e-05 1.2 2.64475e-05 1.2 2.644755e-05 0 2.648916666666667e-05 0 2.648921666666667e-05 1.2 2.65725e-05 1.2 2.657255e-05 0 2.665583333333334e-05 0 2.665588333333334e-05 1.2 2.66975e-05 1.2 2.669755e-05 0 2.678083333333334e-05 0 2.678088333333334e-05 1.2 2.68225e-05 1.2 2.682255e-05 0 2.690583333333334e-05 0 2.690588333333334e-05 1.2 2.69475e-05 1.2 2.694755e-05 0 2.703083333333334e-05 0 2.703088333333334e-05 1.2 2.711416666666667e-05 1.2 2.711421666666667e-05 0 2.715583333333334e-05 0 2.715588333333334e-05 1.2 2.723916666666667e-05 1.2 2.723921666666667e-05 0 2.728083333333334e-05 0 2.728088333333334e-05 1.2 2.736416666666667e-05 1.2 2.736421666666667e-05 0 2.740583333333334e-05 0 2.740588333333334e-05 1.2 2.748916666666667e-05 1.2 2.748921666666667e-05 0 2.753083333333334e-05 0 2.753088333333334e-05 1.2 2.761416666666667e-05 1.2 2.761421666666667e-05 0 2.76975e-05 0 2.769755e-05 1.2 2.773916666666667e-05 1.2 2.773921666666667e-05 0 2.78225e-05 0 2.782255e-05 1.2 2.786416666666667e-05 1.2 2.786421666666667e-05 0 2.79475e-05 0 2.794755e-05 1.2 2.798916666666667e-05 1.2 2.798921666666667e-05 0 2.80725e-05 0 2.807255e-05 1.2 2.828083333333334e-05 1.2 2.828088333333334e-05 0 2.86975e-05 0 2.869755e-05 1.2 2.878083333333334e-05 1.2 2.878088333333334e-05 0 2.88225e-05 0 2.882255e-05 1.2 2.890583333333334e-05 1.2 2.890588333333334e-05 0 2.89475e-05 0 2.894755e-05 1.2 2.903083333333334e-05 1.2 2.903088333333334e-05 0 2.90725e-05 0 2.907255e-05 1.2 2.915583333333334e-05 1.2 2.915588333333334e-05 0 2.923916666666667e-05 0 2.923921666666667e-05 1.2 2.928083333333334e-05 1.2 2.928088333333334e-05 0 2.936416666666667e-05 0 2.936421666666667e-05 1.2 2.940583333333334e-05 1.2 2.940588333333334e-05 0 2.948916666666667e-05 0 2.948921666666667e-05 1.2 2.953083333333334e-05 1.2 2.953088333333334e-05 0 2.961416666666667e-05 0 2.961421666666667e-05 1.2 2.965583333333334e-05 1.2 2.965588333333334e-05 0 2.973916666666667e-05 0 2.973921666666667e-05 1.2 2.98225e-05 1.2 2.982255e-05 0 2.986416666666667e-05 0 2.986421666666667e-05 1.2 2.99475e-05 1.2 2.994755e-05 0 2.998916666666667e-05 0 2.998921666666667e-05 1.2 3.00725e-05 1.2 3.007255e-05 0 3.011416666666667e-05 0 3.011421666666667e-05 1.2 3.01975e-05 1.2 3.019755e-05 0 3.028083333333334e-05 0 3.028088333333334e-05 1.2 3.03225e-05 1.2 3.032255e-05 0 3.040583333333334e-05 0 3.040588333333334e-05 1.2 3.04475e-05 1.2 3.044755e-05 0 3.053083333333334e-05 0 3.053088333333333e-05 1.2 3.05725e-05 1.2 3.057255e-05 0 3.065583333333334e-05 0 3.065588333333334e-05 1.2 3.06975e-05 1.2 3.069755e-05 0 3.078083333333334e-05 0 3.078088333333333e-05 1.2 3.086416666666667e-05 1.2 3.086421666666667e-05 0 3.090583333333334e-05 0 3.090588333333333e-05 1.2 3.098916666666667e-05 1.2 3.098921666666667e-05 0 3.103083333333333e-05 0 3.103088333333333e-05 1.2 3.111416666666667e-05 1.2 3.111421666666666e-05 0 3.115583333333334e-05 0 3.115588333333333e-05 1.2 3.123916666666667e-05 1.2 3.123921666666667e-05 0 3.128083333333334e-05 0 3.128088333333334e-05 1.2 3.136416666666667e-05 1.2 3.136421666666666e-05 0 3.14475e-05 0 3.144755e-05 1.2 3.148916666666667e-05 1.2 3.148921666666667e-05 0 3.15725e-05 0 3.157255e-05 1.2 3.161416666666667e-05 1.2 3.161421666666667e-05 0 3.16975e-05 0 3.169755e-05 1.2 3.173916666666667e-05 1.2 3.173921666666667e-05 0 3.18225e-05 0 3.182255e-05 1.2 3.190583333333334e-05 1.2 3.190588333333333e-05 0 3.19475e-05 0 3.194755e-05 1.2 3.203083333333334e-05 1.2 3.203088333333334e-05 0 3.20725e-05 0 3.207255e-05 1.2 3.215583333333333e-05 1.2 3.215588333333333e-05 0 3.21975e-05 0 3.219755e-05 1.2 3.228083333333334e-05 1.2 3.228088333333333e-05 0 3.23225e-05 0 3.232255e-05 1.2 3.240583333333334e-05 1.2 3.240588333333334e-05 0 3.248916666666667e-05 0 3.248921666666666e-05 1.2 3.253083333333334e-05 1.2 3.253088333333333e-05 0 3.261416666666667e-05 0 3.261421666666667e-05 1.2 3.265583333333334e-05 1.2 3.265588333333334e-05 0 3.273916666666667e-05 0 3.273921666666667e-05 1.2 3.278083333333334e-05 1.2 3.278088333333333e-05 0 3.286416666666667e-05 0 3.286421666666667e-05 1.2 3.290583333333333e-05 1.2 3.290588333333333e-05 0 3.298916666666667e-05 0 3.298921666666666e-05 1.2 3.30725e-05 1.2 3.307255e-05 0 3.311416666666667e-05 0 3.311421666666667e-05 1.2 3.31975e-05 1.2 3.319755e-05 0 3.323916666666667e-05 0 3.323921666666666e-05 1.2 3.33225e-05 1.2 3.332255e-05 0 3.336416666666667e-05 0 3.336421666666666e-05 1.2 3.34475e-05 1.2 3.344755e-05 0 3.353083333333333e-05 0 3.353088333333332e-05 1.2 3.35725e-05 1.2 3.357255e-05 0 3.365583333333333e-05 0 3.365588333333333e-05 1.2 3.36975e-05 1.2 3.369755e-05 0 3.378083333333333e-05 0 3.378088333333333e-05 1.2 3.38225e-05 1.2 3.382255e-05 0 3.390583333333333e-05 0 3.390588333333333e-05 1.2 3.39475e-05 1.2 3.394755e-05 0 3.453083333333333e-05 0 3.453088333333333e-05 1.2 3.461416666666666e-05 1.2 3.461421666666666e-05 0 3.465583333333333e-05 0 3.465588333333332e-05 1.2 3.473916666666667e-05 1.2 3.473921666666666e-05 0 3.478083333333333e-05 0 3.478088333333333e-05 1.2 3.486416666666666e-05 1.2 3.486421666666666e-05 0 3.490583333333333e-05 0 3.490588333333333e-05 1.2 3.498916666666667e-05 1.2 3.498921666666666e-05 0 3.50725e-05 0 3.507255e-05 1.2 3.511416666666666e-05 1.2 3.511421666666666e-05 0 3.51975e-05 0 3.519755e-05 1.2 3.523916666666667e-05 1.2 3.523921666666666e-05 0 3.53225e-05 0 3.532255e-05 1.2 3.536416666666667e-05 1.2 3.536421666666667e-05 0 3.54475e-05 0 3.544755e-05 1.2 3.548916666666667e-05 1.2 3.548921666666666e-05 0 3.557250000000001e-05 0 3.557255e-05 1.2 3.565583333333333e-05 1.2 3.565588333333333e-05 0 3.56975e-05 0 3.569755e-05 1.2 3.578083333333333e-05 1.2 3.578088333333332e-05 0 3.58225e-05 0 3.582255e-05 1.2 3.590583333333333e-05 1.2 3.590588333333333e-05 0 3.59475e-05 0 3.594755e-05 1.2 3.603083333333333e-05 1.2 3.603088333333333e-05 0 3.611416666666667e-05 0 3.611421666666666e-05 1.2 3.615583333333333e-05 1.2 3.615588333333333e-05 0 3.623916666666666e-05 0 3.623921666666666e-05 1.2 3.628083333333333e-05 1.2 3.628088333333333e-05 0 3.636416666666667e-05 0 3.636421666666666e-05 1.2 3.640583333333333e-05 1.2 3.640588333333333e-05 0 3.648916666666667e-05 0 3.648921666666667e-05 1.2 3.653083333333333e-05 1.2 3.653088333333333e-05 0 3.661416666666667e-05 0 3.661421666666666e-05 1.2 3.669750000000001e-05 1.2 3.669755e-05 0 3.673916666666667e-05 0 3.673921666666667e-05 1.2 3.68225e-05 1.2 3.682255e-05 0 3.686416666666667e-05 0 3.686421666666666e-05 1.2 3.69475e-05 1.2 3.694755e-05 0 3.698916666666667e-05 0 3.698921666666666e-05 1.2 3.70725e-05 1.2 3.707255e-05 0 3.711416666666666e-05 0 3.711421666666666e-05 1.2 3.71975e-05 1.2 3.719755e-05 0 3.728083333333333e-05 0 3.728088333333333e-05 1.2 3.73225e-05 1.2 3.732255e-05 0 3.740583333333333e-05 0 3.740588333333333e-05 1.2 3.74475e-05 1.2 3.744755e-05 0 3.753083333333333e-05 0 3.753088333333333e-05 1.2 3.75725e-05 1.2 3.757255e-05 0 3.765583333333333e-05 0 3.765588333333333e-05 1.2 3.773916666666667e-05 1.2 3.773921666666666e-05 0 3.778083333333333e-05 0 3.778088333333333e-05 1.2 3.786416666666667e-05 1.2 3.786421666666667e-05 0 3.790583333333333e-05 0 3.790588333333333e-05 1.2 3.798916666666667e-05 1.2 3.798921666666666e-05 0 3.803083333333333e-05 0 3.803088333333333e-05 1.2 3.811416666666667e-05 1.2 3.811421666666667e-05 0 3.815583333333333e-05 0 3.815588333333333e-05 1.2 3.823916666666666e-05 1.2 3.823921666666666e-05 0 3.83225e-05 0 3.832255e-05 1.2 3.836416666666667e-05 1.2 3.836421666666666e-05 0 3.84475e-05 0 3.844755e-05 1.2 3.848916666666666e-05 1.2 3.848921666666666e-05 0 3.85725e-05 0 3.857255e-05 1.2 3.861416666666667e-05 1.2 3.861421666666666e-05 0 3.86975e-05 0 3.869755e-05 1.2 3.878083333333333e-05 1.2 3.878088333333333e-05 0 3.88225e-05 0 3.882255e-05 1.2 3.890583333333333e-05 1.2 3.890588333333333e-05 0 3.89475e-05 0 3.894755e-05 1.2 3.903083333333333e-05 1.2 3.903088333333333e-05 0 3.90725e-05 0 3.907255e-05 1.2 3.915583333333333e-05 1.2 3.915588333333333e-05 0 3.919750000000001e-05 0 3.919755e-05 1.2 3.928083333333333e-05 1.2 3.928088333333333e-05 0 3.936416666666666e-05 0 3.936421666666666e-05 1.2 3.940583333333333e-05 1.2 3.940588333333332e-05 0 3.948916666666667e-05 0 3.948921666666666e-05 1.2 3.953083333333333e-05 1.2 3.953088333333333e-05 0 3.961416666666666e-05 0 3.961421666666666e-05 1.2 3.965583333333333e-05 1.2 3.965588333333333e-05 0 3.973916666666667e-05 0 3.973921666666666e-05 1.2 3.978083333333333e-05 1.2 3.978088333333333e-05 0 4.036416666666667e-05 0 4.036421666666667e-05 1.2 4.04475e-05 1.2 4.044755e-05 0 4.048916666666667e-05 0 4.048921666666666e-05 1.2 4.05725e-05 1.2 4.057255e-05 0 4.061416666666667e-05 0 4.061421666666666e-05 1.2 4.06975e-05 1.2 4.069755e-05 0 4.073916666666666e-05 0 4.073921666666666e-05 1.2 4.08225e-05 1.2 4.082255e-05 0 4.090583333333333e-05 0 4.090588333333333e-05 1.2 4.09475e-05 1.2 4.094755e-05 0 4.103083333333333e-05 0 4.103088333333333e-05 1.2 4.10725e-05 1.2 4.107255e-05 0 4.115583333333333e-05 0 4.115588333333333e-05 1.2 4.11975e-05 1.2 4.119755e-05 0 4.128083333333333e-05 0 4.128088333333333e-05 1.2 4.13225e-05 1.2 4.132255e-05 0 4.140583333333333e-05 0 4.140588333333333e-05 1.2 4.148916666666667e-05 1.2 4.148921666666667e-05 0 4.153083333333333e-05 0 4.153088333333333e-05 1.2 4.161416666666667e-05 1.2 4.161421666666666e-05 0 4.165583333333333e-05 0 4.165588333333333e-05 1.2 4.173916666666667e-05 1.2 4.173921666666667e-05 0 4.178083333333333e-05 0 4.178088333333333e-05 1.2 4.186416666666666e-05 1.2 4.186421666666666e-05 0 4.19475e-05 0 4.194755e-05 1.2 4.198916666666667e-05 1.2 4.198921666666666e-05 0 4.20725e-05 0 4.207255e-05 1.2 4.211416666666666e-05 1.2 4.211421666666666e-05 0 4.21975e-05 0 4.219755e-05 1.2 4.223916666666667e-05 1.2 4.223921666666666e-05 0 4.23225e-05 0 4.232255e-05 1.2 4.236416666666667e-05 1.2 4.236421666666667e-05 0 4.24475e-05 0 4.244755e-05 1.2 4.253083333333333e-05 1.2 4.253088333333333e-05 0 4.25725e-05 0 4.257255e-05 1.2 4.265583333333333e-05 1.2 4.265588333333333e-05 0 4.26975e-05 0 4.269755e-05 1.2 4.278083333333333e-05 1.2 4.278088333333333e-05 0 4.282250000000001e-05 0 4.282255e-05 1.2 4.290583333333333e-05 1.2 4.290588333333333e-05 0 4.29475e-05 0 4.294755e-05 1.2 4.303083333333333e-05 1.2 4.303088333333332e-05 0 4.311416666666667e-05 0 4.311421666666666e-05 1.2 4.315583333333333e-05 1.2 4.315588333333333e-05 0 4.323916666666666e-05 0 4.323921666666666e-05 1.2 4.328083333333333e-05 1.2 4.328088333333333e-05 0 4.336416666666667e-05 0 4.336421666666666e-05 1.2 4.340583333333333e-05 1.2 4.340588333333333e-05 0 4.348916666666667e-05 0 4.348921666666667e-05 1.2 4.35725e-05 1.2 4.357255e-05 0 4.361416666666667e-05 0 4.361421666666666e-05 1.2 4.36975e-05 1.2 4.369755e-05 0 4.373916666666667e-05 0 4.373921666666667e-05 1.2 4.38225e-05 1.2 4.382255e-05 0 4.386416666666667e-05 0 4.386421666666666e-05 1.2 4.394750000000001e-05 1.2 4.394755e-05 0 4.398916666666667e-05 0 4.398921666666667e-05 1.2 4.40725e-05 1.2 4.407255e-05 0 4.415583333333333e-05 0 4.415588333333333e-05 1.2 4.419750000000001e-05 1.2 4.419755e-05 0 4.428083333333333e-05 0 4.428088333333333e-05 1.2 4.43225e-05 1.2 4.432255e-05 0 4.440583333333333e-05 0 4.440588333333333e-05 1.2 4.44475e-05 1.2 4.444755e-05 0 4.453083333333333e-05 0 4.453088333333333e-05 1.2 4.461416666666666e-05 1.2 4.461421666666666e-05 0 4.465583333333333e-05 0 4.465588333333333e-05 1.2 4.473916666666667e-05 1.2 4.473921666666666e-05 0 4.478083333333333e-05 0 4.478088333333333e-05 1.2 4.486416666666667e-05 1.2 4.486421666666667e-05 0 4.490583333333333e-05 0 4.490588333333333e-05 1.2 4.498916666666667e-05 1.2 4.498921666666666e-05 0 4.503083333333333e-05 0 4.503088333333333e-05 1.2 4.511416666666667e-05 1.2 4.511421666666667e-05 0 4.51975e-05 0 4.519755e-05 1.2 4.523916666666667e-05 1.2 4.523921666666666e-05 0 4.532250000000001e-05 0 4.532255e-05 1.2 4.536416666666667e-05 1.2 4.536421666666667e-05 0 4.54475e-05 0 4.544755e-05 1.2 4.548916666666666e-05 1.2 4.548921666666666e-05 0 4.55725e-05 0 4.557255e-05 1.2 4.578083333333333e-05 1.2 4.578088333333333e-05 0 4.619750000000001e-05 0 4.619755e-05 1.2 4.628083333333333e-05 1.2 4.628088333333333e-05 0 4.63225e-05 0 4.632255e-05 1.2 4.640583333333333e-05 1.2 4.640588333333333e-05 0 4.644750000000001e-05 0 4.644755e-05 1.2 4.653083333333333e-05 1.2 4.653088333333333e-05 0 4.65725e-05 0 4.657255e-05 1.2 4.665583333333333e-05 1.2 4.665588333333332e-05 0 4.673916666666667e-05 0 4.673921666666666e-05 1.2 4.678083333333333e-05 1.2 4.678088333333333e-05 0 4.686416666666666e-05 0 4.686421666666666e-05 1.2 4.690583333333333e-05 1.2 4.690588333333333e-05 0 4.698916666666667e-05 0 4.698921666666666e-05 1.2 4.703083333333333e-05 1.2 4.703088333333333e-05 0 4.711416666666667e-05 0 4.711421666666667e-05 1.2 4.715583333333333e-05 1.2 4.715588333333333e-05 0 4.723916666666667e-05 0 4.723921666666666e-05 1.2 4.73225e-05 1.2 4.732255e-05 0 4.736416666666667e-05 0 4.736421666666667e-05 1.2 4.74475e-05 1.2 4.744755e-05 0 4.748916666666667e-05 0 4.748921666666666e-05 1.2 4.757250000000001e-05 1.2 4.757255e-05 0 4.761416666666667e-05 0 4.761421666666667e-05 1.2 4.76975e-05 1.2 4.769755e-05 0 4.778083333333333e-05 0 4.778088333333333e-05 1.2 4.782250000000001e-05 1.2 4.782255e-05 0 4.790583333333333e-05 0 4.790588333333333e-05 1.2 4.79475e-05 1.2 4.794755e-05 0 4.803083333333333e-05 0 4.803088333333333e-05 1.2 4.80725e-05 1.2 4.807255e-05 0 4.815583333333333e-05 0 4.815588333333333e-05 1.2 4.81975e-05 1.2 4.819755e-05 0 4.828083333333333e-05 0 4.828088333333333e-05 1.2 4.836416666666667e-05 1.2 4.836421666666666e-05 0 4.840583333333333e-05 0 4.840588333333333e-05 1.2 4.848916666666667e-05 1.2 4.848921666666667e-05 0 4.853083333333333e-05 0 4.853088333333333e-05 1.2 4.861416666666667e-05 1.2 4.861421666666666e-05 0 4.865583333333333e-05 0 4.865588333333333e-05 1.2 4.873916666666667e-05 1.2 4.873921666666667e-05 0 4.878083333333333e-05 0 4.878088333333333e-05 1.2 4.886416666666667e-05 1.2 4.886421666666666e-05 0 4.894750000000001e-05 0 4.894755e-05 1.2 4.898916666666667e-05 1.2 4.898921666666667e-05 0 4.90725e-05 0 4.907255e-05 1.2 4.911416666666666e-05 1.2 4.911421666666666e-05 0 4.91975e-05 0 4.919755e-05 1.2 4.923916666666667e-05 1.2 4.923921666666666e-05 0 4.93225e-05 0 4.932255e-05 1.2 4.940583333333333e-05 1.2 4.940588333333333e-05 0 4.94475e-05 0 4.944755e-05 1.2 4.953083333333333e-05 1.2 4.953088333333333e-05 0 4.95725e-05 0 4.957255e-05 1.2 4.965583333333333e-05 1.2 4.965588333333333e-05 0 4.96975e-05 0 4.969755e-05 1.2 4.978083333333333e-05 1.2 4.978088333333333e-05 0 4.982250000000001e-05 0 4.982255e-05 1.2 4.990583333333333e-05 1.2 4.990588333333333e-05 0 4.998916666666667e-05 0 4.998921666666666e-05 1.2 5.003083333333333e-05 1.2 5.003088333333333e-05 0 5.011416666666667e-05 0 5.011421666666667e-05 1.2 5.015583333333333e-05 1.2 5.015588333333333e-05 0 5.023916666666666e-05 0 5.023921666666666e-05 1.2 5.028083333333333e-05 1.2 5.028088333333333e-05 0 5.036416666666667e-05 0 5.036421666666666e-05 1.2 5.04475e-05 1.2 5.044755e-05 0 5.048916666666666e-05 0 5.048921666666666e-05 1.2 5.05725e-05 1.2 5.057255e-05 0 5.061416666666667e-05 0 5.061421666666666e-05 1.2 5.06975e-05 1.2 5.069755e-05 0 5.073916666666667e-05 0 5.073921666666667e-05 1.2 5.08225e-05 1.2 5.082255e-05 0 5.086416666666667e-05 0 5.086421666666666e-05 1.2 5.094750000000001e-05 1.2 5.094755e-05 0 5.103083333333333e-05 0 5.103088333333333e-05 1.2 5.10725e-05 1.2 5.107255e-05 0 5.115583333333333e-05 0 5.115588333333333e-05 1.2 5.119750000000001e-05 1.2 5.119755e-05 0 5.128083333333333e-05 0 5.128088333333333e-05 1.2 5.13225e-05 1.2 5.132255e-05 0 5.140583333333333e-05 0 5.140588333333333e-05 1.2 5.144750000000001e-05 1.2 5.144755e-05 0]
VM7 (m7 0) vsource type=pwl wave=[0 0 6.141666666666667e-07 0 6.142166666666667e-07 1.2 7.391666666666666e-07 1.2 7.392166666666667e-07 0 8.641666666666667e-07 0 8.642166666666667e-07 1.2 9.891666666666668e-07 1.2 9.892166666666667e-07 0 1.114166666666667e-06 0 1.114216666666667e-06 1.2 1.239166666666667e-06 1.2 1.239216666666667e-06 0 1.364166666666667e-06 0 1.364216666666667e-06 1.2 1.489166666666667e-06 1.2 1.489216666666667e-06 0 1.614166666666667e-06 0 1.614216666666667e-06 1.2 1.739166666666667e-06 1.2 1.739216666666667e-06 0 2.4475e-06 0 2.44755e-06 1.2 2.614166666666666e-06 1.2 2.614216666666667e-06 0 2.780833333333333e-06 0 2.780883333333333e-06 1.2 2.905833333333333e-06 1.2 2.905883333333333e-06 0 3.0725e-06 0 3.07255e-06 1.2 3.239166666666667e-06 1.2 3.239216666666667e-06 0 3.405833333333333e-06 0 3.405883333333333e-06 1.2 3.530833333333333e-06 1.2 3.530883333333333e-06 0 4.280833333333334e-06 0 4.280883333333334e-06 1.2 4.405833333333334e-06 1.2 4.405883333333335e-06 0 4.572500000000001e-06 0 4.572550000000001e-06 1.2 4.6975e-06 1.2 4.69755e-06 0 4.8225e-06 0 4.82255e-06 1.2 4.989166666666667e-06 1.2 4.989216666666667e-06 0 5.114166666666668e-06 0 5.114216666666668e-06 1.2 5.239166666666667e-06 1.2 5.239216666666667e-06 0 5.405833333333334e-06 0 5.405883333333334e-06 1.2 5.614166666666667e-06 1.2 5.614216666666667e-06 0 6.114166666666667e-06 0 6.114216666666667e-06 1.2 6.239166666666668e-06 1.2 6.239216666666668e-06 0 6.364166666666667e-06 0 6.364216666666668e-06 1.2 6.489166666666667e-06 1.2 6.489216666666667e-06 0 6.655833333333334e-06 0 6.655883333333334e-06 1.2 6.780833333333335e-06 1.2 6.780883333333335e-06 0 6.905833333333334e-06 0 6.905883333333334e-06 1.2 7.030833333333335e-06 1.2 7.030883333333335e-06 0 7.155833333333334e-06 0 7.155883333333335e-06 1.2 7.4475e-06 1.2 7.44755e-06 0 7.9475e-06 0 7.94755e-06 1.2 8.072500000000001e-06 1.2 8.072550000000001e-06 0 8.197499999999999e-06 0 8.197549999999999e-06 1.2 8.3225e-06 1.2 8.32255e-06 0 8.4475e-06 0 8.44755e-06 1.2 8.572500000000001e-06 1.2 8.572550000000001e-06 0 8.739166666666666e-06 0 8.739216666666666e-06 1.2 8.864166666666667e-06 1.2 8.864216666666667e-06 0 8.989166666666667e-06 0 8.989216666666667e-06 1.2 9.114166666666667e-06 1.2 9.114216666666667e-06 0 9.780833333333333e-06 0 9.780883333333333e-06 1.2 9.905833333333333e-06 1.2 9.905883333333333e-06 0 1.003083333333333e-05 0 1.003088333333333e-05 1.2 1.015583333333333e-05 1.2 1.015588333333333e-05 0 1.028083333333333e-05 0 1.028088333333333e-05 1.2 1.040583333333333e-05 1.2 1.040588333333333e-05 0 1.053083333333333e-05 0 1.053088333333333e-05 1.2 1.065583333333333e-05 1.2 1.065588333333333e-05 0 1.08225e-05 0 1.082255e-05 1.2 1.09475e-05 1.2 1.094755e-05 0 1.161416666666667e-05 0 1.161421666666667e-05 1.2 1.173916666666667e-05 1.2 1.173921666666667e-05 0 1.186416666666667e-05 0 1.186421666666667e-05 1.2 1.198916666666667e-05 1.2 1.198921666666667e-05 0 1.211416666666667e-05 0 1.211421666666667e-05 1.2 1.223916666666667e-05 1.2 1.223921666666667e-05 0 1.236416666666667e-05 0 1.236421666666667e-05 1.2 1.253083333333333e-05 1.2 1.253088333333333e-05 0 1.265583333333333e-05 0 1.265588333333333e-05 1.2 1.278083333333333e-05 1.2 1.278088333333333e-05 0 1.34475e-05 0 1.344755e-05 1.2 1.35725e-05 1.2 1.357255e-05 0 1.36975e-05 0 1.369755e-05 1.2 1.38225e-05 1.2 1.382255e-05 0 1.39475e-05 0 1.394755e-05 1.2 1.40725e-05 1.2 1.407255e-05 0 1.41975e-05 0 1.419755e-05 1.2 1.43225e-05 1.2 1.432255e-05 0 1.448916666666667e-05 0 1.448921666666667e-05 1.2 1.461416666666667e-05 1.2 1.461421666666667e-05 0 1.528083333333333e-05 0 1.528088333333333e-05 1.2 1.540583333333333e-05 1.2 1.540588333333333e-05 0 1.553083333333333e-05 0 1.553088333333333e-05 1.2 1.565583333333333e-05 1.2 1.565588333333333e-05 0 1.578083333333333e-05 0 1.578088333333333e-05 1.2 1.590583333333333e-05 1.2 1.590588333333333e-05 0 1.603083333333333e-05 0 1.603088333333333e-05 1.2 1.615583333333333e-05 1.2 1.615588333333333e-05 0 1.63225e-05 0 1.632255e-05 1.2 1.64475e-05 1.2 1.644755e-05 0 1.711416666666667e-05 0 1.711421666666667e-05 1.2 1.723916666666667e-05 1.2 1.723921666666667e-05 0 1.736416666666667e-05 0 1.736421666666667e-05 1.2 1.748916666666667e-05 1.2 1.748921666666667e-05 0 1.761416666666667e-05 0 1.761421666666667e-05 1.2 1.773916666666667e-05 1.2 1.773921666666667e-05 0 1.786416666666667e-05 0 1.786421666666667e-05 1.2 1.798916666666667e-05 1.2 1.798921666666667e-05 0 1.815583333333334e-05 0 1.815588333333334e-05 1.2 1.828083333333334e-05 1.2 1.828088333333334e-05 0 1.840583333333334e-05 0 1.840588333333334e-05 1.2 1.853083333333334e-05 1.2 1.853088333333334e-05 0 1.865583333333334e-05 0 1.865588333333334e-05 1.2 1.878083333333334e-05 1.2 1.878088333333334e-05 0 1.890583333333334e-05 0 1.890588333333334e-05 1.2 1.903083333333334e-05 1.2 1.903088333333334e-05 0 1.915583333333334e-05 0 1.915588333333334e-05 1.2 1.93225e-05 1.2 1.932255e-05 0 1.94475e-05 0 1.944755e-05 1.2 1.95725e-05 1.2 1.957255e-05 0 1.96975e-05 0 1.969755e-05 1.2 1.98225e-05 1.2 1.982255e-05 0 1.99475e-05 0 1.994755e-05 1.2 2.00725e-05 1.2 2.007255e-05 0 2.01975e-05 0 2.019755e-05 1.2 2.036416666666667e-05 1.2 2.036421666666667e-05 0 2.048916666666667e-05 0 2.048921666666667e-05 1.2 2.061416666666667e-05 1.2 2.061421666666667e-05 0 2.073916666666667e-05 0 2.073921666666667e-05 1.2 2.086416666666667e-05 1.2 2.086421666666667e-05 0 2.098916666666667e-05 0 2.098921666666667e-05 1.2 2.111416666666667e-05 1.2 2.111421666666667e-05 0 2.123916666666667e-05 0 2.123921666666667e-05 1.2 2.140583333333334e-05 1.2 2.140588333333334e-05 0 2.153083333333334e-05 0 2.153088333333334e-05 1.2 2.165583333333334e-05 1.2 2.165588333333334e-05 0 2.178083333333334e-05 0 2.178088333333334e-05 1.2 2.190583333333334e-05 1.2 2.190588333333334e-05 0 2.203083333333334e-05 0 2.203088333333334e-05 1.2 2.215583333333334e-05 1.2 2.215588333333334e-05 0 2.228083333333334e-05 0 2.228088333333334e-05 1.2 2.24475e-05 1.2 2.244755e-05 0 2.29475e-05 0 2.294755e-05 1.2 2.30725e-05 1.2 2.307255e-05 0 2.31975e-05 0 2.319755e-05 1.2 2.33225e-05 1.2 2.332255e-05 0 2.34475e-05 0 2.344755e-05 1.2 2.35725e-05 1.2 2.357255e-05 0 2.36975e-05 0 2.369755e-05 1.2 2.38225e-05 1.2 2.382255e-05 0 2.398916666666667e-05 0 2.398921666666667e-05 1.2 2.411416666666667e-05 1.2 2.411421666666667e-05 0 2.423916666666667e-05 0 2.423921666666667e-05 1.2 2.436416666666667e-05 1.2 2.436421666666667e-05 0 2.448916666666667e-05 0 2.448921666666667e-05 1.2 2.461416666666667e-05 1.2 2.461421666666667e-05 0 2.473916666666667e-05 0 2.473921666666667e-05 1.2 2.486416666666667e-05 1.2 2.486421666666667e-05 0 2.503083333333334e-05 0 2.503088333333334e-05 1.2 2.515583333333334e-05 1.2 2.515588333333334e-05 0 2.528083333333334e-05 0 2.528088333333334e-05 1.2 2.540583333333334e-05 1.2 2.540588333333334e-05 0 2.553083333333334e-05 0 2.553088333333334e-05 1.2 2.565583333333334e-05 1.2 2.565588333333334e-05 0 2.578083333333334e-05 0 2.578088333333334e-05 1.2 2.590583333333334e-05 1.2 2.590588333333334e-05 0 2.60725e-05 0 2.607255e-05 1.2 2.61975e-05 1.2 2.619755e-05 0 2.63225e-05 0 2.632255e-05 1.2 2.64475e-05 1.2 2.644755e-05 0 2.65725e-05 0 2.657255e-05 1.2 2.66975e-05 1.2 2.669755e-05 0 2.68225e-05 0 2.682255e-05 1.2 2.69475e-05 1.2 2.694755e-05 0 2.711416666666667e-05 0 2.711421666666667e-05 1.2 2.723916666666667e-05 1.2 2.723921666666667e-05 0 2.736416666666667e-05 0 2.736421666666667e-05 1.2 2.748916666666667e-05 1.2 2.748921666666667e-05 0 2.761416666666667e-05 0 2.761421666666667e-05 1.2 2.773916666666667e-05 1.2 2.773921666666667e-05 0 2.786416666666667e-05 0 2.786421666666667e-05 1.2 2.798916666666667e-05 1.2 2.798921666666667e-05 0 2.878083333333334e-05 0 2.878088333333334e-05 1.2 2.890583333333334e-05 1.2 2.890588333333334e-05 0 2.903083333333334e-05 0 2.903088333333334e-05 1.2 2.915583333333334e-05 1.2 2.915588333333334e-05 0 2.928083333333334e-05 0 2.928088333333334e-05 1.2 2.940583333333334e-05 1.2 2.940588333333334e-05 0 2.953083333333334e-05 0 2.953088333333334e-05 1.2 2.965583333333334e-05 1.2 2.965588333333334e-05 0 2.98225e-05 0 2.982255e-05 1.2 2.99475e-05 1.2 2.994755e-05 0 3.00725e-05 0 3.007255e-05 1.2 3.01975e-05 1.2 3.019755e-05 0 3.03225e-05 0 3.032255e-05 1.2 3.04475e-05 1.2 3.044755e-05 0 3.05725e-05 0 3.057255e-05 1.2 3.06975e-05 1.2 3.069755e-05 0 3.086416666666667e-05 0 3.086421666666667e-05 1.2 3.098916666666667e-05 1.2 3.098921666666667e-05 0 3.111416666666667e-05 0 3.111421666666666e-05 1.2 3.123916666666667e-05 1.2 3.123921666666667e-05 0 3.136416666666667e-05 0 3.136421666666666e-05 1.2 3.148916666666667e-05 1.2 3.148921666666667e-05 0 3.161416666666667e-05 0 3.161421666666667e-05 1.2 3.173916666666667e-05 1.2 3.173921666666667e-05 0 3.190583333333334e-05 0 3.190588333333333e-05 1.2 3.203083333333334e-05 1.2 3.203088333333334e-05 0 3.215583333333333e-05 0 3.215588333333333e-05 1.2 3.228083333333334e-05 1.2 3.228088333333333e-05 0 3.240583333333334e-05 0 3.240588333333334e-05 1.2 3.253083333333334e-05 1.2 3.253088333333333e-05 0 3.265583333333334e-05 0 3.265588333333334e-05 1.2 3.278083333333334e-05 1.2 3.278088333333333e-05 0 3.290583333333333e-05 0 3.290588333333333e-05 1.2 3.30725e-05 1.2 3.307255e-05 0 3.31975e-05 0 3.319755e-05 1.2 3.33225e-05 1.2 3.332255e-05 0 3.34475e-05 0 3.344755e-05 1.2 3.35725e-05 1.2 3.357255e-05 0 3.36975e-05 0 3.369755e-05 1.2 3.38225e-05 1.2 3.382255e-05 0 3.39475e-05 0 3.394755e-05 1.2 3.411416666666667e-05 1.2 3.411421666666666e-05 0 3.461416666666666e-05 0 3.461421666666666e-05 1.2 3.473916666666667e-05 1.2 3.473921666666666e-05 0 3.486416666666666e-05 0 3.486421666666666e-05 1.2 3.498916666666667e-05 1.2 3.498921666666666e-05 0 3.511416666666666e-05 0 3.511421666666666e-05 1.2 3.523916666666667e-05 1.2 3.523921666666666e-05 0 3.536416666666667e-05 0 3.536421666666667e-05 1.2 3.548916666666667e-05 1.2 3.548921666666666e-05 0 3.565583333333333e-05 0 3.565588333333333e-05 1.2 3.578083333333333e-05 1.2 3.578088333333332e-05 0 3.590583333333333e-05 0 3.590588333333333e-05 1.2 3.603083333333333e-05 1.2 3.603088333333333e-05 0 3.615583333333333e-05 0 3.615588333333333e-05 1.2 3.628083333333333e-05 1.2 3.628088333333333e-05 0 3.640583333333333e-05 0 3.640588333333333e-05 1.2 3.653083333333333e-05 1.2 3.653088333333333e-05 0 3.669750000000001e-05 0 3.669755e-05 1.2 3.68225e-05 1.2 3.682255e-05 0 3.69475e-05 0 3.694755e-05 1.2 3.70725e-05 1.2 3.707255e-05 0 3.71975e-05 0 3.719755e-05 1.2 3.73225e-05 1.2 3.732255e-05 0 3.74475e-05 0 3.744755e-05 1.2 3.75725e-05 1.2 3.757255e-05 0 3.773916666666667e-05 0 3.773921666666666e-05 1.2 3.786416666666667e-05 1.2 3.786421666666667e-05 0 3.798916666666667e-05 0 3.798921666666666e-05 1.2 3.811416666666667e-05 1.2 3.811421666666667e-05 0 3.823916666666666e-05 0 3.823921666666666e-05 1.2 3.836416666666667e-05 1.2 3.836421666666666e-05 0 3.848916666666666e-05 0 3.848921666666666e-05 1.2 3.861416666666667e-05 1.2 3.861421666666666e-05 0 3.878083333333333e-05 0 3.878088333333333e-05 1.2 3.890583333333333e-05 1.2 3.890588333333333e-05 0 3.903083333333333e-05 0 3.903088333333333e-05 1.2 3.915583333333333e-05 1.2 3.915588333333333e-05 0 3.928083333333333e-05 0 3.928088333333333e-05 1.2 3.940583333333333e-05 1.2 3.940588333333332e-05 0 3.953083333333333e-05 0 3.953088333333333e-05 1.2 3.965583333333333e-05 1.2 3.965588333333333e-05 0 3.978083333333333e-05 0 3.978088333333333e-05 1.2 3.99475e-05 1.2 3.994755e-05 0 4.04475e-05 0 4.044755e-05 1.2 4.05725e-05 1.2 4.057255e-05 0 4.06975e-05 0 4.069755e-05 1.2 4.08225e-05 1.2 4.082255e-05 0 4.09475e-05 0 4.094755e-05 1.2 4.10725e-05 1.2 4.107255e-05 0 4.11975e-05 0 4.119755e-05 1.2 4.13225e-05 1.2 4.132255e-05 0 4.148916666666667e-05 0 4.148921666666667e-05 1.2 4.161416666666667e-05 1.2 4.161421666666666e-05 0 4.173916666666667e-05 0 4.173921666666667e-05 1.2 4.186416666666666e-05 1.2 4.186421666666666e-05 0 4.198916666666667e-05 0 4.198921666666666e-05 1.2 4.211416666666666e-05 1.2 4.211421666666666e-05 0 4.223916666666667e-05 0 4.223921666666666e-05 1.2 4.236416666666667e-05 1.2 4.236421666666667e-05 0 4.253083333333333e-05 0 4.253088333333333e-05 1.2 4.265583333333333e-05 1.2 4.265588333333333e-05 0 4.278083333333333e-05 0 4.278088333333333e-05 1.2 4.290583333333333e-05 1.2 4.290588333333333e-05 0 4.303083333333333e-05 0 4.303088333333332e-05 1.2 4.315583333333333e-05 1.2 4.315588333333333e-05 0 4.328083333333333e-05 0 4.328088333333333e-05 1.2 4.340583333333333e-05 1.2 4.340588333333333e-05 0 4.35725e-05 0 4.357255e-05 1.2 4.36975e-05 1.2 4.369755e-05 0 4.38225e-05 0 4.382255e-05 1.2 4.394750000000001e-05 1.2 4.394755e-05 0 4.40725e-05 0 4.407255e-05 1.2 4.419750000000001e-05 1.2 4.419755e-05 0 4.43225e-05 0 4.432255e-05 1.2 4.44475e-05 1.2 4.444755e-05 0 4.461416666666666e-05 0 4.461421666666666e-05 1.2 4.473916666666667e-05 1.2 4.473921666666666e-05 0 4.486416666666667e-05 0 4.486421666666667e-05 1.2 4.498916666666667e-05 1.2 4.498921666666666e-05 0 4.511416666666667e-05 0 4.511421666666667e-05 1.2 4.523916666666667e-05 1.2 4.523921666666666e-05 0 4.536416666666667e-05 0 4.536421666666667e-05 1.2 4.548916666666666e-05 1.2 4.548921666666666e-05 0 4.628083333333333e-05 0 4.628088333333333e-05 1.2 4.640583333333333e-05 1.2 4.640588333333333e-05 0 4.653083333333333e-05 0 4.653088333333333e-05 1.2 4.665583333333333e-05 1.2 4.665588333333332e-05 0 4.678083333333333e-05 0 4.678088333333333e-05 1.2 4.690583333333333e-05 1.2 4.690588333333333e-05 0 4.703083333333333e-05 0 4.703088333333333e-05 1.2 4.715583333333333e-05 1.2 4.715588333333333e-05 0 4.73225e-05 0 4.732255e-05 1.2 4.74475e-05 1.2 4.744755e-05 0 4.757250000000001e-05 0 4.757255e-05 1.2 4.76975e-05 1.2 4.769755e-05 0 4.782250000000001e-05 0 4.782255e-05 1.2 4.79475e-05 1.2 4.794755e-05 0 4.80725e-05 0 4.807255e-05 1.2 4.81975e-05 1.2 4.819755e-05 0 4.836416666666667e-05 0 4.836421666666666e-05 1.2 4.848916666666667e-05 1.2 4.848921666666667e-05 0 4.861416666666667e-05 0 4.861421666666666e-05 1.2 4.873916666666667e-05 1.2 4.873921666666667e-05 0 4.886416666666667e-05 0 4.886421666666666e-05 1.2 4.898916666666667e-05 1.2 4.898921666666667e-05 0 4.911416666666666e-05 0 4.911421666666666e-05 1.2 4.923916666666667e-05 1.2 4.923921666666666e-05 0 4.940583333333333e-05 0 4.940588333333333e-05 1.2 4.953083333333333e-05 1.2 4.953088333333333e-05 0 4.965583333333333e-05 0 4.965588333333333e-05 1.2 4.978083333333333e-05 1.2 4.978088333333333e-05 0 4.990583333333333e-05 0 4.990588333333333e-05 1.2 5.003083333333333e-05 1.2 5.003088333333333e-05 0 5.015583333333333e-05 0 5.015588333333333e-05 1.2 5.028083333333333e-05 1.2 5.028088333333333e-05 0 5.04475e-05 0 5.044755e-05 1.2 5.05725e-05 1.2 5.057255e-05 0 5.06975e-05 0 5.069755e-05 1.2 5.08225e-05 1.2 5.082255e-05 0 5.094750000000001e-05 0 5.094755e-05 1.2 5.10725e-05 1.2 5.107255e-05 0 5.119750000000001e-05 0 5.119755e-05 1.2 5.13225e-05 1.2 5.132255e-05 0 5.144750000000001e-05 0 5.144755e-05 1.2 5.161416666666666e-05 1.2 5.161421666666666e-05 0]
VM8 (m8 0) vsource type=pwl wave=[0 0 7.391666666666666e-07 0 7.392166666666667e-07 1.2 9.891666666666668e-07 1.2 9.892166666666667e-07 0 1.239166666666667e-06 0 1.239216666666667e-06 1.2 1.489166666666667e-06 1.2 1.489216666666667e-06 0 1.739166666666667e-06 0 1.739216666666667e-06 1.2 1.9475e-06 1.2 1.94755e-06 0 2.614166666666666e-06 0 2.614216666666667e-06 1.2 2.905833333333333e-06 1.2 2.905883333333333e-06 0 3.239166666666667e-06 0 3.239216666666667e-06 1.2 3.530833333333333e-06 1.2 3.530883333333333e-06 0 4.405833333333334e-06 0 4.405883333333335e-06 1.2 4.6975e-06 1.2 4.69755e-06 0 4.989166666666667e-06 0 4.989216666666667e-06 1.2 5.239166666666667e-06 1.2 5.239216666666667e-06 0 6.239166666666668e-06 0 6.239216666666668e-06 1.2 6.489166666666667e-06 1.2 6.489216666666667e-06 0 6.780833333333335e-06 0 6.780883333333335e-06 1.2 7.030833333333335e-06 1.2 7.030883333333335e-06 0 8.072500000000001e-06 0 8.072550000000001e-06 1.2 8.3225e-06 1.2 8.32255e-06 0 8.572500000000001e-06 0 8.572550000000001e-06 1.2 8.864166666666667e-06 1.2 8.864216666666667e-06 0 9.114166666666667e-06 0 9.114216666666667e-06 1.2 9.280833333333333e-06 1.2 9.280883333333333e-06 0 9.905833333333333e-06 0 9.905883333333333e-06 1.2 1.015583333333333e-05 1.2 1.015588333333333e-05 0 1.040583333333333e-05 0 1.040588333333333e-05 1.2 1.065583333333333e-05 1.2 1.065588333333333e-05 0 1.09475e-05 0 1.094755e-05 1.2 1.111416666666667e-05 1.2 1.111421666666667e-05 0 1.173916666666667e-05 0 1.173921666666667e-05 1.2 1.198916666666667e-05 1.2 1.198921666666667e-05 0 1.223916666666667e-05 0 1.223921666666667e-05 1.2 1.253083333333333e-05 1.2 1.253088333333333e-05 0 1.278083333333333e-05 0 1.278088333333333e-05 1.2 1.29475e-05 1.2 1.294755e-05 0 1.35725e-05 0 1.357255e-05 1.2 1.38225e-05 1.2 1.382255e-05 0 1.40725e-05 0 1.407255e-05 1.2 1.43225e-05 1.2 1.432255e-05 0 1.461416666666667e-05 0 1.461421666666667e-05 1.2 1.478083333333333e-05 1.2 1.478088333333333e-05 0 1.540583333333333e-05 0 1.540588333333333e-05 1.2 1.565583333333333e-05 1.2 1.565588333333333e-05 0 1.590583333333333e-05 0 1.590588333333333e-05 1.2 1.615583333333333e-05 1.2 1.615588333333333e-05 0 1.64475e-05 0 1.644755e-05 1.2 1.661416666666667e-05 1.2 1.661421666666667e-05 0 1.723916666666667e-05 0 1.723921666666667e-05 1.2 1.748916666666667e-05 1.2 1.748921666666667e-05 0 1.773916666666667e-05 0 1.773921666666667e-05 1.2 1.798916666666667e-05 1.2 1.798921666666667e-05 0 1.828083333333334e-05 0 1.828088333333334e-05 1.2 1.853083333333334e-05 1.2 1.853088333333334e-05 0 1.878083333333334e-05 0 1.878088333333334e-05 1.2 1.903083333333334e-05 1.2 1.903088333333334e-05 0 1.93225e-05 0 1.932255e-05 1.2 1.95725e-05 1.2 1.957255e-05 0 1.98225e-05 0 1.982255e-05 1.2 2.00725e-05 1.2 2.007255e-05 0 2.036416666666667e-05 0 2.036421666666667e-05 1.2 2.061416666666667e-05 1.2 2.061421666666667e-05 0 2.086416666666667e-05 0 2.086421666666667e-05 1.2 2.111416666666667e-05 1.2 2.111421666666667e-05 0 2.140583333333334e-05 0 2.140588333333334e-05 1.2 2.165583333333334e-05 1.2 2.165588333333334e-05 0 2.190583333333334e-05 0 2.190588333333334e-05 1.2 2.215583333333334e-05 1.2 2.215588333333334e-05 0 2.30725e-05 0 2.307255e-05 1.2 2.33225e-05 1.2 2.332255e-05 0 2.35725e-05 0 2.357255e-05 1.2 2.38225e-05 1.2 2.382255e-05 0 2.411416666666667e-05 0 2.411421666666667e-05 1.2 2.436416666666667e-05 1.2 2.436421666666667e-05 0 2.461416666666667e-05 0 2.461421666666667e-05 1.2 2.486416666666667e-05 1.2 2.486421666666667e-05 0 2.515583333333334e-05 0 2.515588333333334e-05 1.2 2.540583333333334e-05 1.2 2.540588333333334e-05 0 2.565583333333334e-05 0 2.565588333333334e-05 1.2 2.590583333333334e-05 1.2 2.590588333333334e-05 0 2.61975e-05 0 2.619755e-05 1.2 2.64475e-05 1.2 2.644755e-05 0 2.66975e-05 0 2.669755e-05 1.2 2.69475e-05 1.2 2.694755e-05 0 2.723916666666667e-05 0 2.723921666666667e-05 1.2 2.748916666666667e-05 1.2 2.748921666666667e-05 0 2.773916666666667e-05 0 2.773921666666667e-05 1.2 2.798916666666667e-05 1.2 2.798921666666667e-05 0 2.890583333333334e-05 0 2.890588333333334e-05 1.2 2.915583333333334e-05 1.2 2.915588333333334e-05 0 2.940583333333334e-05 0 2.940588333333334e-05 1.2 2.965583333333334e-05 1.2 2.965588333333334e-05 0 2.99475e-05 0 2.994755e-05 1.2 3.01975e-05 1.2 3.019755e-05 0 3.04475e-05 0 3.044755e-05 1.2 3.06975e-05 1.2 3.069755e-05 0 3.098916666666667e-05 0 3.098921666666667e-05 1.2 3.123916666666667e-05 1.2 3.123921666666667e-05 0 3.148916666666667e-05 0 3.148921666666667e-05 1.2 3.173916666666667e-05 1.2 3.173921666666667e-05 0 3.203083333333334e-05 0 3.203088333333334e-05 1.2 3.228083333333334e-05 1.2 3.228088333333333e-05 0 3.253083333333334e-05 0 3.253088333333333e-05 1.2 3.278083333333334e-05 1.2 3.278088333333333e-05 0 3.30725e-05 0 3.307255e-05 1.2 3.33225e-05 1.2 3.332255e-05 0 3.35725e-05 0 3.357255e-05 1.2 3.38225e-05 1.2 3.382255e-05 0 3.473916666666667e-05 0 3.473921666666666e-05 1.2 3.498916666666667e-05 1.2 3.498921666666666e-05 0 3.523916666666667e-05 0 3.523921666666666e-05 1.2 3.548916666666667e-05 1.2 3.548921666666666e-05 0 3.578083333333333e-05 0 3.578088333333332e-05 1.2 3.603083333333333e-05 1.2 3.603088333333333e-05 0 3.628083333333333e-05 0 3.628088333333333e-05 1.2 3.653083333333333e-05 1.2 3.653088333333333e-05 0 3.68225e-05 0 3.682255e-05 1.2 3.70725e-05 1.2 3.707255e-05 0 3.73225e-05 0 3.732255e-05 1.2 3.75725e-05 1.2 3.757255e-05 0 3.786416666666667e-05 0 3.786421666666667e-05 1.2 3.811416666666667e-05 1.2 3.811421666666667e-05 0 3.836416666666667e-05 0 3.836421666666666e-05 1.2 3.861416666666667e-05 1.2 3.861421666666666e-05 0 3.890583333333333e-05 0 3.890588333333333e-05 1.2 3.915583333333333e-05 1.2 3.915588333333333e-05 0 3.940583333333333e-05 0 3.940588333333332e-05 1.2 3.965583333333333e-05 1.2 3.965588333333333e-05 0 4.05725e-05 0 4.057255e-05 1.2 4.08225e-05 1.2 4.082255e-05 0 4.10725e-05 0 4.107255e-05 1.2 4.13225e-05 1.2 4.132255e-05 0 4.161416666666667e-05 0 4.161421666666666e-05 1.2 4.186416666666666e-05 1.2 4.186421666666666e-05 0 4.211416666666666e-05 0 4.211421666666666e-05 1.2 4.236416666666667e-05 1.2 4.236421666666667e-05 0 4.265583333333333e-05 0 4.265588333333333e-05 1.2 4.290583333333333e-05 1.2 4.290588333333333e-05 0 4.315583333333333e-05 0 4.315588333333333e-05 1.2 4.340583333333333e-05 1.2 4.340588333333333e-05 0 4.36975e-05 0 4.369755e-05 1.2 4.394750000000001e-05 1.2 4.394755e-05 0 4.419750000000001e-05 0 4.419755e-05 1.2 4.44475e-05 1.2 4.444755e-05 0 4.473916666666667e-05 0 4.473921666666666e-05 1.2 4.498916666666667e-05 1.2 4.498921666666666e-05 0 4.523916666666667e-05 0 4.523921666666666e-05 1.2 4.548916666666666e-05 1.2 4.548921666666666e-05 0 4.640583333333333e-05 0 4.640588333333333e-05 1.2 4.665583333333333e-05 1.2 4.665588333333332e-05 0 4.690583333333333e-05 0 4.690588333333333e-05 1.2 4.715583333333333e-05 1.2 4.715588333333333e-05 0 4.74475e-05 0 4.744755e-05 1.2 4.76975e-05 1.2 4.769755e-05 0 4.79475e-05 0 4.794755e-05 1.2 4.81975e-05 1.2 4.819755e-05 0 4.848916666666667e-05 0 4.848921666666667e-05 1.2 4.873916666666667e-05 1.2 4.873921666666667e-05 0 4.898916666666667e-05 0 4.898921666666667e-05 1.2 4.923916666666667e-05 1.2 4.923921666666666e-05 0 4.953083333333333e-05 0 4.953088333333333e-05 1.2 4.978083333333333e-05 1.2 4.978088333333333e-05 0 5.003083333333333e-05 0 5.003088333333333e-05 1.2 5.028083333333333e-05 1.2 5.028088333333333e-05 0 5.05725e-05 0 5.057255e-05 1.2 5.08225e-05 1.2 5.082255e-05 0 5.10725e-05 0 5.107255e-05 1.2 5.13225e-05 1.2 5.132255e-05 0]
VM9 (m9 0) vsource type=pwl wave=[0 0 9.891666666666668e-07 0 9.892166666666667e-07 1.2 1.489166666666667e-06 1.2 1.489216666666667e-06 0 2.905833333333333e-06 0 2.905883333333333e-06 1.2 3.530833333333333e-06 1.2 3.530883333333333e-06 0 4.6975e-06 0 4.69755e-06 1.2 5.239166666666667e-06 1.2 5.239216666666667e-06 0 6.489166666666667e-06 0 6.489216666666667e-06 1.2 7.030833333333335e-06 1.2 7.030883333333335e-06 0 8.3225e-06 0 8.32255e-06 1.2 8.864166666666667e-06 1.2 8.864216666666667e-06 0 1.015583333333333e-05 0 1.015588333333333e-05 1.2 1.065583333333333e-05 1.2 1.065588333333333e-05 0 1.198916666666667e-05 0 1.198921666666667e-05 1.2 1.253083333333333e-05 1.2 1.253088333333333e-05 0 1.38225e-05 0 1.382255e-05 1.2 1.43225e-05 1.2 1.432255e-05 0 1.565583333333333e-05 0 1.565588333333333e-05 1.2 1.615583333333333e-05 1.2 1.615588333333333e-05 0 1.748916666666667e-05 0 1.748921666666667e-05 1.2 1.798916666666667e-05 1.2 1.798921666666667e-05 0 1.853083333333334e-05 0 1.853088333333334e-05 1.2 1.903083333333334e-05 1.2 1.903088333333334e-05 0 1.95725e-05 0 1.957255e-05 1.2 2.00725e-05 1.2 2.007255e-05 0 2.061416666666667e-05 0 2.061421666666667e-05 1.2 2.111416666666667e-05 1.2 2.111421666666667e-05 0 2.165583333333334e-05 0 2.165588333333334e-05 1.2 2.215583333333334e-05 1.2 2.215588333333334e-05 0 2.33225e-05 0 2.332255e-05 1.2 2.38225e-05 1.2 2.382255e-05 0 2.436416666666667e-05 0 2.436421666666667e-05 1.2 2.486416666666667e-05 1.2 2.486421666666667e-05 0 2.540583333333334e-05 0 2.540588333333334e-05 1.2 2.590583333333334e-05 1.2 2.590588333333334e-05 0 2.64475e-05 0 2.644755e-05 1.2 2.69475e-05 1.2 2.694755e-05 0 2.748916666666667e-05 0 2.748921666666667e-05 1.2 2.798916666666667e-05 1.2 2.798921666666667e-05 0 2.915583333333334e-05 0 2.915588333333334e-05 1.2 2.965583333333334e-05 1.2 2.965588333333334e-05 0 3.01975e-05 0 3.019755e-05 1.2 3.06975e-05 1.2 3.069755e-05 0 3.123916666666667e-05 0 3.123921666666667e-05 1.2 3.173916666666667e-05 1.2 3.173921666666667e-05 0 3.228083333333334e-05 0 3.228088333333333e-05 1.2 3.278083333333334e-05 1.2 3.278088333333333e-05 0 3.33225e-05 0 3.332255e-05 1.2 3.38225e-05 1.2 3.382255e-05 0 3.498916666666667e-05 0 3.498921666666666e-05 1.2 3.548916666666667e-05 1.2 3.548921666666666e-05 0 3.603083333333333e-05 0 3.603088333333333e-05 1.2 3.653083333333333e-05 1.2 3.653088333333333e-05 0 3.70725e-05 0 3.707255e-05 1.2 3.75725e-05 1.2 3.757255e-05 0 3.811416666666667e-05 0 3.811421666666667e-05 1.2 3.861416666666667e-05 1.2 3.861421666666666e-05 0 3.915583333333333e-05 0 3.915588333333333e-05 1.2 3.965583333333333e-05 1.2 3.965588333333333e-05 0 4.08225e-05 0 4.082255e-05 1.2 4.13225e-05 1.2 4.132255e-05 0 4.186416666666666e-05 0 4.186421666666666e-05 1.2 4.236416666666667e-05 1.2 4.236421666666667e-05 0 4.290583333333333e-05 0 4.290588333333333e-05 1.2 4.340583333333333e-05 1.2 4.340588333333333e-05 0 4.394750000000001e-05 0 4.394755e-05 1.2 4.44475e-05 1.2 4.444755e-05 0 4.498916666666667e-05 0 4.498921666666666e-05 1.2 4.548916666666666e-05 1.2 4.548921666666666e-05 0 4.665583333333333e-05 0 4.665588333333332e-05 1.2 4.715583333333333e-05 1.2 4.715588333333333e-05 0 4.76975e-05 0 4.769755e-05 1.2 4.81975e-05 1.2 4.819755e-05 0 4.873916666666667e-05 0 4.873921666666667e-05 1.2 4.923916666666667e-05 1.2 4.923921666666666e-05 0 4.978083333333333e-05 0 4.978088333333333e-05 1.2 5.028083333333333e-05 1.2 5.028088333333333e-05 0 5.08225e-05 0 5.082255e-05 1.2 5.13225e-05 1.2 5.132255e-05 0]
VM10 (m10 0) vsource type=pwl wave=[0 0 1.489166666666667e-06 0 1.489216666666667e-06 1.2 1.9475e-06 1.2 1.94755e-06 0 3.530833333333333e-06 0 3.530883333333333e-06 1.2 3.780833333333333e-06 1.2 3.780883333333333e-06 0 5.239166666666667e-06 0 5.239216666666667e-06 1.2 5.614166666666667e-06 1.2 5.614216666666667e-06 0 7.030833333333335e-06 0 7.030883333333335e-06 1.2 7.4475e-06 1.2 7.44755e-06 0 8.864166666666667e-06 0 8.864216666666667e-06 1.2 9.280833333333333e-06 1.2 9.280883333333333e-06 0 1.065583333333333e-05 0 1.065588333333333e-05 1.2 1.111416666666667e-05 1.2 1.111421666666667e-05 0 1.253083333333333e-05 0 1.253088333333333e-05 1.2 1.29475e-05 1.2 1.294755e-05 0 1.43225e-05 0 1.432255e-05 1.2 1.478083333333333e-05 1.2 1.478088333333333e-05 0 1.615583333333333e-05 0 1.615588333333333e-05 1.2 1.661416666666667e-05 1.2 1.661421666666667e-05 0 1.798916666666667e-05 0 1.798921666666667e-05 1.2 1.903083333333334e-05 1.2 1.903088333333334e-05 0 2.00725e-05 0 2.007255e-05 1.2 2.111416666666667e-05 1.2 2.111421666666667e-05 0 2.215583333333334e-05 0 2.215588333333334e-05 1.2 2.24475e-05 1.2 2.244755e-05 0 2.38225e-05 0 2.382255e-05 1.2 2.486416666666667e-05 1.2 2.486421666666667e-05 0 2.590583333333334e-05 0 2.590588333333334e-05 1.2 2.69475e-05 1.2 2.694755e-05 0 2.798916666666667e-05 0 2.798921666666667e-05 1.2 2.828083333333334e-05 1.2 2.828088333333334e-05 0 2.965583333333334e-05 0 2.965588333333334e-05 1.2 3.06975e-05 1.2 3.069755e-05 0 3.173916666666667e-05 0 3.173921666666667e-05 1.2 3.278083333333334e-05 1.2 3.278088333333333e-05 0 3.38225e-05 0 3.382255e-05 1.2 3.411416666666667e-05 1.2 3.411421666666666e-05 0 3.548916666666667e-05 0 3.548921666666666e-05 1.2 3.653083333333333e-05 1.2 3.653088333333333e-05 0 3.75725e-05 0 3.757255e-05 1.2 3.861416666666667e-05 1.2 3.861421666666666e-05 0 3.965583333333333e-05 0 3.965588333333333e-05 1.2 3.99475e-05 1.2 3.994755e-05 0 4.13225e-05 0 4.132255e-05 1.2 4.236416666666667e-05 1.2 4.236421666666667e-05 0 4.340583333333333e-05 0 4.340588333333333e-05 1.2 4.44475e-05 1.2 4.444755e-05 0 4.548916666666666e-05 0 4.548921666666666e-05 1.2 4.578083333333333e-05 1.2 4.578088333333333e-05 0 4.715583333333333e-05 0 4.715588333333333e-05 1.2 4.81975e-05 1.2 4.819755e-05 0 4.923916666666667e-05 0 4.923921666666666e-05 1.2 5.028083333333333e-05 1.2 5.028088333333333e-05 0 5.13225e-05 0 5.132255e-05 1.2 5.161416666666666e-05 1.2 5.161421666666666e-05 0]
VM11 (m11 0) vsource type=pwl wave=[0 0 1.903083333333334e-05 0 1.903088333333334e-05 1.2 2.111416666666667e-05 1.2 2.111421666666667e-05 0 2.486416666666667e-05 0 2.486421666666667e-05 1.2 2.69475e-05 1.2 2.694755e-05 0 3.06975e-05 0 3.069755e-05 1.2 3.278083333333334e-05 1.2 3.278088333333333e-05 0 3.653083333333333e-05 0 3.653088333333333e-05 1.2 3.861416666666667e-05 1.2 3.861421666666666e-05 0 4.236416666666667e-05 0 4.236421666666667e-05 1.2 4.44475e-05 1.2 4.444755e-05 0 4.81975e-05 0 4.819755e-05 1.2 5.028083333333333e-05 1.2 5.028088333333333e-05 0]
VM12 (m12 0) vsource type=pwl wave=[0 0 2.111416666666667e-05 0 2.111421666666667e-05 1.2 2.24475e-05 1.2 2.244755e-05 0 2.69475e-05 0 2.694755e-05 1.2 2.828083333333334e-05 1.2 2.828088333333334e-05 0 3.278083333333334e-05 0 3.278088333333333e-05 1.2 3.411416666666667e-05 1.2 3.411421666666666e-05 0 3.861416666666667e-05 0 3.861421666666666e-05 1.2 3.99475e-05 1.2 3.994755e-05 0 4.44475e-05 0 4.444755e-05 1.2 4.578083333333333e-05 1.2 4.578088333333333e-05 0 5.028083333333333e-05 0 5.028088333333333e-05 1.2 5.161416666666666e-05 1.2 5.161421666666666e-05 0]
VM13 (m13 0) vsource type=pwl wave=[0 0]
XF (refclk reset k0 k1 k2 k3 k4 k5 m0 m1 m2 m3 m4 m5 m6 m7 m8 m9 m10 m11 m12 m13 coarse0 coarse1 coarse2 coarse3 coarse4 coarse5 coarse6 coarse7 dac0 dac1 dac2 dac3 dac4 dac5 count_gate count_reset enable range_error state_out0 state_out1 state_out2 vdd 0) tx_fll_best128_v14
C0 (coarse0 0) capacitor c=20f
C1 (coarse1 0) capacitor c=20f
C2 (coarse2 0) capacitor c=20f
C3 (coarse3 0) capacitor c=20f
C4 (coarse4 0) capacitor c=20f
C5 (coarse5 0) capacitor c=20f
C6 (coarse6 0) capacitor c=20f
C7 (coarse7 0) capacitor c=20f
C8 (dac0 0) capacitor c=20f
C9 (dac1 0) capacitor c=20f
C10 (dac2 0) capacitor c=20f
C11 (dac3 0) capacitor c=20f
C12 (dac4 0) capacitor c=20f
C13 (dac5 0) capacitor c=20f
C14 (count_gate 0) capacitor c=20f
C15 (count_reset 0) capacitor c=20f
C16 (enable 0) capacitor c=20f
C17 (range_error 0) capacitor c=20f
C18 (state_out0 0) capacitor c=20f
C19 (state_out1 0) capacitor c=20f
C20 (state_out2 0) capacitor c=20f
tran tran stop=5.313500000000001e-05 maxstep=500p method=traponly errpreset=moderate strobeperiod=1n strobeoutput=strobeonly
save refclk reset coarse0 coarse1 coarse2 coarse3 coarse4 coarse5 coarse6 coarse7 dac0 dac1 dac2 dac3 dac4 dac5 count_gate count_reset enable range_error state_out0 state_out1 state_out2
saveOptions options save=selected
