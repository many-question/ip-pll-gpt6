simulator lang=spectre
global 0
include "/home/process/tsmc180bcd_gen2_2022/PDK/TSMC180BCD/models/spectre/c018bcd_gen2_v1d6.scs" section=tt
include "/home/process/tsmc180bcd_gen2_2022/PDK/TSMC180BCD/models/spectre/c018bcd_gen2_v1d6.scs" section=stat_noise
simulator lang=spectre insensitive=no
include "/home/process/tsmc180bcd_gen2_2022/PDK/TSMC180BCD/models/spectre/c018bcd_gen2_v1d6.scs" section=tt_bbmvar
simulator lang=spectre insensitive=no
include "pll_noise_pulsetrip_core_v14.scs"
simulatorOptions options temp=27 reltol=1e-5 vabstol=1e-7 iabstol=1e-13
VDD (vdd 0) vsource dc=1.2
VR (ref 0) vsource type=pulse val0=0 val1=1.2 period=41.6666666666667n width=20.8233333333333n rise=10p fall=10p delay=1n
XP (ref out vdd 0) pll_noise_pulsetrip_core_v14 ref_load=1.9p
CL (out 0) capacitor c=10f
ahdl_include "lc_loop_observer.va"
XOBS (XP.vp XP.vn XP.refb XP.ctrl out 0 obsphase obscycles obsctrl obsdivcycles) lc_loop_observer
tran tran stop=3u skipdc=yes readic="core_pulsetrip_analog_seed_tt.ic" maxstep=1p strobeperiod=2n strobeoutput=strobeonly method=traponly errpreset=conservative writefinal="__FINAL_STATE__"
save obsphase obscycles obsctrl obsdivcycles XP.ctrl XP.vc1 XP.preset XP.hp XP.hn XP.en out
save XP.b0 XP.b1 XP.b2 XP.b3 XP.b4 XP.b5 XP.b6 XP.b7
saveOptions options save=selected

save XP.XD.ck XP.XD.load XP.XD.loadb XP.q1 XP.data XP.acqclk
