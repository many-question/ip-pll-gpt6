simulator lang=spectre
global 0
include "/home/process/tsmc180bcd_gen2_2022/PDK/TSMC180BCD/models/spectre/c018bcd_gen2_v1d6.scs" section=tt
include "/home/process/tsmc180bcd_gen2_2022/PDK/TSMC180BCD/models/spectre/c018bcd_gen2_v1d6.scs" section=stat_noise
simulator lang=spectre insensitive=no
include "/home/process/tsmc180bcd_gen2_2022/PDK/TSMC180BCD/models/spectre/c018bcd_gen2_v1d6.scs" section=tt_bbmvar
simulator lang=spectre insensitive=no
include "cells.scs"
simulatorOptions options reltol=1e-5 vabstol=1e-7 iabstol=1e-13 temp=27
include "lc_vco_physical_v14.scs"
VDD (vdd 0) vsource dc=1.2
VVCO (vco_vdd vdd) vsource dc=0
VC (ctrl 0) vsource dc=0.2
VB0 (b0 0) vsource dc=1.2
VB1 (b1 0) vsource dc=1.2
VB2 (b2 0) vsource dc=1.2
VB3 (b3 0) vsource dc=1.2
VB4 (b4 0) vsource dc=1.2
VB5 (b5 0) vsource dc=1.2
VB6 (b6 0) vsource dc=1.2
VB7 (b7 0) vsource dc=1.2
XV (vp vn ctrl b0 b1 b2 b3 b4 b5 b6 b7 vco_vdd 0) lc_vco_physical_v14 bias_r=2500 unit_c=4.8f
include "cp_physical_v14.scs"
include "digital_cells_v2.scs"
include "cp_timing.scs"
include "sampler_bias_v5.scs"
XBM (vdd 0 vmid) tx_bias_mid_v5
CCP (vp sp) capacitor c=120f
CCN (vn sn) capacitor c=120f
RBP (sp vmid) resistor r=10k
RBN (sn vmid) resistor r=10k
VR (ref 0) vsource type=pulse val0=0 val1=1.2 period=41.6666666666667n width=20.8233333333333n rise=10p fall=10p delay=1n
XREF (ref refb vdd 0) tx_reference_buffer
CR (refb 0) capacitor c=60f
XS (refb sp sn hp hn vdd 0) tx_sampler
XA (refb en rst pulse vdd 0) tx_cp_timing
VE (en 0) vsource dc=1.2
XCP (hp hn pulse en cpout vdd 0) cp_physical_v14
VO (cpout 0) vsource dc=.6
VRST (rst 0) vsource dc=0
include "rf_light24s12_v14.scs"
include "cmos_even_bank_acq_v14.scs"
include "validity_physical_v14.scs"
include "rtcomb_v13.scs"
include "rt_light24s12_out083_v14.scs"
VRX (rx_vdd vdd) vsource dc=0
VRT (rt_vdd vdd) vsource dc=0
XRX (vp clk rx_vdd 0) rf_light24s12_v14
VDRESET (div_reset 0) vsource type=pwl wave=[0 1.2 20n 1.2 20.01n 0]
XD (clk div_reset 0 0 0 0 0 vdd q1 data acqclk vdd 0) cmos_even_bank_acq_v14
XDET (vp hp hn amp_good phase_good vdd 0) validity_physical_v14
XR (data clk out rt_vdd 0) rt_light24s12_out083_v14
CL (out 0) capacitor c=10f
ic vp=1.20001 vn=1.2
tran tran stop=400n start=0 outputstart=340n maxstep=1p method=traponly errpreset=conservative writefinal="__FINAL_STATE__"
save vp vn clk q1 data out ctrl sp sn hp hn refb XV.XL.nb XV.XL.nfilt XV.XL.tail VDD:p VVCO:p VRX:p VRT:p
saveOptions options save=selected

save XCP.nb

save amp_good phase_good acqclk

// TB-only isolated1.2V/1kohm fixture validates hierarchical-current integration.
subckt instrument_check (p n)
VP (p x) vsource dc=0
R (x n) resistor r=1k
ends instrument_check
VTST (vtst 0) vsource dc=1.2
XTST (vtst 0) instrument_check
ahdl_include "tb_power_integrator.va"
BTST (power_test_w 0) bsource v=v(vtst)*i("XTST.VP:1")
BTOTAL (power_total_w 0) bsource v=-v(vdd)*i("VDD:1")
BVCO (power_vco_w 0) bsource v=-v(vdd)*i("VVCO:1")
BRX (power_rx_w 0) bsource v=-v(vdd)*i("VRX:1")
BRT (power_rt_w 0) bsource v=-v(vdd)*i("VRT:1")
XETST (power_test_w 0 energy_test_nj) tb_power_integrator
XETOTAL (power_total_w 0 energy_total_nj) tb_power_integrator
XEVCO (power_vco_w 0 energy_vco_nj) tb_power_integrator
XERX (power_rx_w 0 energy_rx_nj) tb_power_integrator
XERT (power_rt_w 0 energy_rt_nj) tb_power_integrator
save energy_test_nj energy_total_nj energy_vco_nj energy_rx_nj energy_rt_nj
