simulator lang=spectre
global 0
include "/home/process/tsmc180bcd_gen2_2022/PDK/TSMC180BCD/models/spectre/c018bcd_gen2_v1d6.scs" section=tt
include "/home/process/tsmc180bcd_gen2_2022/PDK/TSMC180BCD/models/spectre/c018bcd_gen2_v1d6.scs" section=stat_noise
simulator lang=spectre insensitive=no
include "/home/process/tsmc180bcd_gen2_2022/PDK/TSMC180BCD/models/spectre/c018bcd_gen2_v1d6.scs" section=tt_bbmvar
simulator lang=spectre insensitive=no
include "pll_noise_pulsetrip_core_v14.scs"
simulatorOptions options temp=27 reltol=1e-5 vabstol=1e-7 iabstol=1e-13
VDD (vdd 0) vsource dc=1.2
VR (ref 0) vsource type=pulse val0=0 val1=1.2 period=41.6666666666667n width=20.8233333333333n rise=10p fall=10p delay=1n
XP (ref out vdd 0) pll_noise_pulsetrip_core_v14 ref_load=1.9p
CL (out 0) capacitor c=10f
// lcm(24MHz reference, RF/8,RF/12) =>250ns;246 output edges.
save ref out XP.vp XP.vn XP.ctrl XP.vc1 XP.refb XP.hp XP.hn XP.pulse XP.clk XP.q1 XP.data XP.acqclk XP.XD.d8 XP.XD.d12 XP.preset VDD:p XP.VVCO:p XP.VRX:p XP.VRT:p
saveOptions options save=selected
save XP.b0 XP.b1 XP.b2 XP.b3 XP.b4 XP.b5 XP.b6 XP.b7
save XP.XD.XRL.a XP.XD.XRL.b XP.XD.load XP.XD.loadb XP.XD.XD12.X0.XM.fb XP.XD.ck

save XP.XD.ct0 XP.XD.ct1 XP.XD.cb XP.XD.d6 XP.XD.r0 XP.XD.r4 XP.XD.r6 XP.XD.fb

tran tran stop=6u strobeperiod=2n strobeoutput=strobeonly skipdc=yes readic="core_pulsetrip_late_seed_tt.ic" maxstep=1p method=gear2only errpreset=conservative writefinal="__FINAL_STATE__"

// Testbench observer only: draws no current and does not control the PLL.
ahdl_include "lc_loop_observer.va"
XOBS (XP.vp XP.vn XP.refb XP.ctrl out 0 obsphase obscycles obsctrl obsdivcycles) lc_loop_observer
save obsphase obscycles obsctrl obsdivcycles
save vdd XP.acquired XP.amp_good
save XP.clock_b XP.clock_mux XP.count_clock XP.d1 XP.d2 XP.d5 XP.en
save XP.phase_good XP.q0 XP.q2 XP.q3 XP.q4 XP.q5 XP.q6
save XP.q7 XP.q8 XP.q9 XP.q10 XP.q11 XP.q12 XP.q13 XP.qx1 XP.rt_vdd XP.rx_vdd XP.s0
save XP.sn XP.sp XP.VFIX_acquired:p XP.VFIX_d1:p XP.VFIX_d2:p XP.VFIX_d5:p XP.VFIX_en:p XP.VFIX_s0:p
save XP.vco_vdd XP.vmid XP.XCOARSE0.clkb XP.XCOARSE0.qm XP.XCOARSE0.resetb XP.XCOARSE0.XM.qb XP.XCOARSE0.XM.XN.x XP.XCOARSE0.XM.x XP.XCOARSE0.XS.qb XP.XCOARSE0.XS.XN.x
save XP.XCOARSE0.XS.x XP.XCOARSE1.clkb XP.XCOARSE1.qm XP.XCOARSE1.resetb XP.XCOARSE1.XM.qb XP.XCOARSE1.XM.XN.x XP.XCOARSE1.XM.x XP.XCOARSE1.XS.qb XP.XCOARSE1.XS.XN.x XP.XCOARSE1.XS.x XP.XCOARSE2.clkb XP.XCOARSE2.qm
save XP.XCOARSE2.resetb XP.XCOARSE2.XM.qb XP.XCOARSE2.XM.XN.x XP.XCOARSE2.XM.x XP.XCOARSE2.XS.qb XP.XCOARSE2.XS.XN.x XP.XCOARSE2.XS.x XP.XCOARSE3.clkb XP.XCOARSE3.qm XP.XCOARSE3.resetb XP.XCOARSE3.XM.qb XP.XCOARSE3.XM.XN.x
save XP.XCOARSE3.XM.x XP.XCOARSE3.XS.qb XP.XCOARSE3.XS.XN.x XP.XCOARSE3.XS.x XP.XCOARSE4.clkb XP.XCOARSE4.qm XP.XCOARSE4.resetb XP.XCOARSE4.XM.qb XP.XCOARSE4.XM.XN.x XP.XCOARSE4.XM.x XP.XCOARSE4.XS.qb XP.XCOARSE4.XS.XN.x
save XP.XCOARSE4.XS.x XP.XCOARSE5.clkb XP.XCOARSE5.qm XP.XCOARSE5.resetb XP.XCOARSE5.XM.qb XP.XCOARSE5.XM.XN.x XP.XCOARSE5.XM.x XP.XCOARSE5.XS.qb XP.XCOARSE5.XS.XN.x XP.XCOARSE5.XS.x XP.XCOARSE6.clkb XP.XCOARSE6.qm
save XP.XCOARSE6.resetb XP.XCOARSE6.XM.qb XP.XCOARSE6.XM.XN.x XP.XCOARSE6.XM.x XP.XCOARSE6.XS.qb XP.XCOARSE6.XS.XN.x XP.XCOARSE6.XS.x XP.XCOARSE7.clkb XP.XCOARSE7.qm XP.XCOARSE7.resetb XP.XCOARSE7.XM.qb XP.XCOARSE7.XM.XN.x
save XP.XCOARSE7.XM.x XP.XCOARSE7.XS.qb XP.XCOARSE7.XS.XN.x XP.XCOARSE7.XS.x XP.XCOUNT.clkb XP.XCOUNT.gclk XP.XCOUNT.qb0 XP.XCOUNT.qb1 XP.XCOUNT.qb2 XP.XCOUNT.qb3 XP.XCOUNT.qb4 XP.XCOUNT.qb5
save XP.XCOUNT.qb6 XP.XCOUNT.qb7 XP.XCOUNT.qb8 XP.XCOUNT.qb9 XP.XCOUNT.qb10 XP.XCOUNT.qb11 XP.XCOUNT.qb12 XP.XCOUNT.qb13 XP.XCOUNT.safe_gate XP.XCOUNT.XF0.XF.clkb XP.XCOUNT.XF0.XF.qm XP.XCOUNT.XF0.XF.resetb
save XP.XCOUNT.XF0.XF.XM.qb XP.XCOUNT.XF0.XF.XM.XN.x XP.XCOUNT.XF0.XF.XM.x XP.XCOUNT.XF0.XF.XS.qb XP.XCOUNT.XF0.XF.XS.XN.x XP.XCOUNT.XF0.XF.XS.x XP.XCOUNT.XF1.XF.clkb XP.XCOUNT.XF1.XF.qm XP.XCOUNT.XF1.XF.resetb XP.XCOUNT.XF1.XF.XM.qb XP.XCOUNT.XF1.XF.XM.XN.x XP.XCOUNT.XF1.XF.XM.x
save XP.XCOUNT.XF1.XF.XS.qb XP.XCOUNT.XF1.XF.XS.XN.x XP.XCOUNT.XF1.XF.XS.x XP.XCOUNT.XF2.XF.clkb XP.XCOUNT.XF2.XF.qm XP.XCOUNT.XF2.XF.resetb XP.XCOUNT.XF2.XF.XM.qb XP.XCOUNT.XF2.XF.XM.XN.x XP.XCOUNT.XF2.XF.XM.x XP.XCOUNT.XF2.XF.XS.qb XP.XCOUNT.XF2.XF.XS.XN.x XP.XCOUNT.XF2.XF.XS.x
save XP.XCOUNT.XF3.XF.clkb XP.XCOUNT.XF3.XF.qm XP.XCOUNT.XF3.XF.resetb XP.XCOUNT.XF3.XF.XM.qb XP.XCOUNT.XF3.XF.XM.XN.x XP.XCOUNT.XF3.XF.XM.x XP.XCOUNT.XF3.XF.XS.qb XP.XCOUNT.XF3.XF.XS.XN.x XP.XCOUNT.XF3.XF.XS.x XP.XCOUNT.XF4.XF.clkb XP.XCOUNT.XF4.XF.qm XP.XCOUNT.XF4.XF.resetb
save XP.XCOUNT.XF4.XF.XM.qb XP.XCOUNT.XF4.XF.XM.XN.x XP.XCOUNT.XF4.XF.XM.x XP.XCOUNT.XF4.XF.XS.qb XP.XCOUNT.XF4.XF.XS.XN.x XP.XCOUNT.XF4.XF.XS.x XP.XCOUNT.XF5.XF.clkb XP.XCOUNT.XF5.XF.qm XP.XCOUNT.XF5.XF.resetb XP.XCOUNT.XF5.XF.XM.qb XP.XCOUNT.XF5.XF.XM.XN.x XP.XCOUNT.XF5.XF.XM.x
save XP.XCOUNT.XF5.XF.XS.qb XP.XCOUNT.XF5.XF.XS.XN.x XP.XCOUNT.XF5.XF.XS.x XP.XCOUNT.XF6.XF.clkb XP.XCOUNT.XF6.XF.qm XP.XCOUNT.XF6.XF.resetb XP.XCOUNT.XF6.XF.XM.qb XP.XCOUNT.XF6.XF.XM.XN.x XP.XCOUNT.XF6.XF.XM.x XP.XCOUNT.XF6.XF.XS.qb XP.XCOUNT.XF6.XF.XS.XN.x XP.XCOUNT.XF6.XF.XS.x
save XP.XCOUNT.XF7.XF.clkb XP.XCOUNT.XF7.XF.qm XP.XCOUNT.XF7.XF.resetb XP.XCOUNT.XF7.XF.XM.qb XP.XCOUNT.XF7.XF.XM.XN.x XP.XCOUNT.XF7.XF.XM.x XP.XCOUNT.XF7.XF.XS.qb XP.XCOUNT.XF7.XF.XS.XN.x XP.XCOUNT.XF7.XF.XS.x XP.XCOUNT.XF8.XF.clkb XP.XCOUNT.XF8.XF.qm XP.XCOUNT.XF8.XF.resetb
save XP.XCOUNT.XF8.XF.XM.qb XP.XCOUNT.XF8.XF.XM.XN.x XP.XCOUNT.XF8.XF.XM.x XP.XCOUNT.XF8.XF.XS.qb XP.XCOUNT.XF8.XF.XS.XN.x XP.XCOUNT.XF8.XF.XS.x XP.XCOUNT.XF9.XF.clkb XP.XCOUNT.XF9.XF.qm XP.XCOUNT.XF9.XF.resetb XP.XCOUNT.XF9.XF.XM.qb XP.XCOUNT.XF9.XF.XM.XN.x XP.XCOUNT.XF9.XF.XM.x
save XP.XCOUNT.XF9.XF.XS.qb XP.XCOUNT.XF9.XF.XS.XN.x XP.XCOUNT.XF9.XF.XS.x XP.XCOUNT.XF10.XF.clkb XP.XCOUNT.XF10.XF.qm XP.XCOUNT.XF10.XF.resetb XP.XCOUNT.XF10.XF.XM.qb XP.XCOUNT.XF10.XF.XM.XN.x XP.XCOUNT.XF10.XF.XM.x XP.XCOUNT.XF10.XF.XS.qb XP.XCOUNT.XF10.XF.XS.XN.x XP.XCOUNT.XF10.XF.XS.x
save XP.XCOUNT.XF11.XF.clkb XP.XCOUNT.XF11.XF.qm XP.XCOUNT.XF11.XF.resetb XP.XCOUNT.XF11.XF.XM.qb XP.XCOUNT.XF11.XF.XM.XN.x XP.XCOUNT.XF11.XF.XM.x XP.XCOUNT.XF11.XF.XS.qb XP.XCOUNT.XF11.XF.XS.XN.x XP.XCOUNT.XF11.XF.XS.x XP.XCOUNT.XF12.XF.clkb XP.XCOUNT.XF12.XF.qm XP.XCOUNT.XF12.XF.resetb
save XP.XCOUNT.XF12.XF.XM.qb XP.XCOUNT.XF12.XF.XM.XN.x XP.XCOUNT.XF12.XF.XM.x XP.XCOUNT.XF12.XF.XS.qb XP.XCOUNT.XF12.XF.XS.XN.x XP.XCOUNT.XF12.XF.XS.x XP.XCOUNT.XF13.XF.clkb XP.XCOUNT.XF13.XF.qm XP.XCOUNT.XF13.XF.resetb XP.XCOUNT.XF13.XF.XM.qb XP.XCOUNT.XF13.XF.XM.XN.x XP.XCOUNT.XF13.XF.XM.x
save XP.XCOUNT.XF13.XF.XS.qb XP.XCOUNT.XF13.XF.XS.XN.x XP.XCOUNT.XF13.XF.XS.x XP.XCOUNT.XG.n XP.XCOUNT.XG.XN.x XP.XCOUNT.XGE.qb XP.XCOUNT.XGE.x XP.XCP.gate XP.XCP.gateb XP.XCP.mir XP.XCP.nb XP.XCP.ng
save XP.XCP.tail XP.XCP.XG.x XP.XCPULSE.d1 XP.XCPULSE.d2 XP.XCPULSE.d3 XP.XCPULSE.d4 XP.XCPULSE.d5 XP.XCPULSE.d6 XP.XCPULSE.d7 XP.XCPULSE.d8 XP.XCPULSE.d9 XP.XCPULSE.d10
save XP.XCPULSE.d11 XP.XCPULSE.d12 XP.XCPULSE.d13 XP.XCPULSE.d14 XP.XCPULSE.d15 XP.XCPULSE.d16 XP.XCPULSE.d17 XP.XCPULSE.d18 XP.XCPULSE.d19 XP.XCPULSE.d20 XP.XCPULSE.d21 XP.XCPULSE.d22
save XP.XCPULSE.d23 XP.XCPULSE.d24 XP.XCPULSE.d24b XP.XCPULSE.en_hold XP.XCPULSE.enabled XP.XCPULSE.held XP.XCPULSE.raw XP.XCPULSE.refb XP.XCPULSE.resetb XP.XCPULSE.XE.qb XP.XCPULSE.XE.XN.x XP.XCPULSE.XE.x
save XP.XCPULSE.XEN.n XP.XCPULSE.XEN.XN.x XP.XCPULSE.XP.n XP.XCPULSE.XP.XN.x XP.XCPULSE.XRESET.n XP.XCPULSE.XRESET.XN.x XP.XCPULSE.XS.n XP.XCPULSE.XS.XN.x XP.XD.b40 XP.XD.b41
save XP.XD.d4 XP.XD.d4b XP.XD.d8b XP.XD.eb0 XP.XD.eb1 XP.XD.eb2 XP.XD.eb3
save XP.XD.eb4 XP.XD.eb5 XP.XD.es0 XP.XD.es1 XP.XD.es2 XP.XD.es3 XP.XD.es4 XP.XD.es5 XP.XD.fab
save XP.XD.mux XP.XD.ob XP.XD.q0 XP.XD.qb0 XP.XD.r1 XP.XD.r2 XP.XD.r3 XP.XD.r5 XP.XD.resetb
save XP.XD.sb3 XP.XD.sb5 XP.XD.XD4.a XP.XD.XD4.b XP.XD.XD4.n1 XP.XD.XD4.n2 XP.XD.XD4.p0 XP.XD.XD6.clkb XP.XD.XD6.d0 XP.XD.XD6.ob XP.XD.XD6.q0 XP.XD.XD6.q1
save XP.XD.XD6.X0.qm XP.XD.XD6.X0.XM.fb XP.XD.XD6.X0.XM.x XP.XD.XD6.X0.XS.fb XP.XD.XD6.X0.XS.x XP.XD.XD6.X1.qm XP.XD.XD6.X1.XM.fb XP.XD.XD6.X1.XM.x XP.XD.XD6.X1.XS.fb XP.XD.XD6.X1.XS.x XP.XD.XD6.XN.p XP.XD.XD8.a
save XP.XD.XD8.b XP.XD.XD8.n1 XP.XD.XD8.n2 XP.XD.XD8.p0 XP.XD.XD12.clkb XP.XD.XD12.d0 XP.XD.XD12.ob XP.XD.XD12.q0 XP.XD.XD12.q1 XP.XD.XD12.X0.qm XP.XD.XD12.X0.XM.x
save XP.XD.XD12.X0.XS.fb XP.XD.XD12.X0.XS.x XP.XD.XD12.X1.qm XP.XD.XD12.X1.XM.fb XP.XD.XD12.X1.XM.x XP.XD.XD12.X1.XS.fb XP.XD.XD12.X1.XS.x XP.XD.XD12.XN.p XP.XD.XF0.din XP.XD.XF0.XF.qb XP.XD.XF0.XF.XF.a XP.XD.XF0.XF.XF.b
save XP.XD.XF0.XF.XF.n1 XP.XD.XF0.XF.XF.n2 XP.XD.XF0.XF.XF.p0 XP.XD.XF1.din XP.XD.XF1.XF.qb XP.XD.XF1.XF.XF.a XP.XD.XF1.XF.XF.b XP.XD.XF1.XF.XF.n1 XP.XD.XF1.XF.XF.n2 XP.XD.XF1.XF.XF.p0 XP.XD.XF2.din XP.XD.XF2.XF.qb
save XP.XD.XF2.XF.XF.a XP.XD.XF2.XF.XF.b XP.XD.XF2.XF.XF.n1 XP.XD.XF2.XF.XF.n2 XP.XD.XF2.XF.XF.p0 XP.XD.XF3.din XP.XD.XF3.XF.qb XP.XD.XF3.XF.XF.a XP.XD.XF3.XF.XF.b XP.XD.XF3.XF.XF.n1 XP.XD.XF3.XF.XF.n2 XP.XD.XF3.XF.XF.p0
save XP.XD.XF4.din XP.XD.XF4.XF.qb XP.XD.XF4.XF.XF.a XP.XD.XF4.XF.XF.b XP.XD.XF4.XF.XF.n1 XP.XD.XF4.XF.XF.n2 XP.XD.XF4.XF.XF.p0 XP.XD.XF5.dclose XP.XD.XF5.din XP.XD.XF5.dopen XP.XD.XF5.XEN.n XP.XD.XF5.XEN.XN.x
save XP.XD.XF5.XF.qb XP.XD.XF5.XF.XF.a XP.XD.XF5.XF.XF.b XP.XD.XF5.XF.XF.n1 XP.XD.XF5.XF.XF.n2 XP.XD.XF5.XF.XF.p0 XP.XD.XF6.dclose XP.XD.XF6.din XP.XD.XF6.dopen XP.XD.XF6.XEN.n XP.XD.XF6.XEN.XN.x XP.XD.XF6.XF.qb
save XP.XD.XF6.XF.XF.a XP.XD.XF6.XF.XF.b XP.XD.XF6.XF.XF.n1 XP.XD.XF6.XF.XF.n2 XP.XD.XF6.XF.XF.p0 XP.XD.XPRE.a XP.XD.XPRE.b XP.XD.XPRE.dn XP.XD.XPRE.n1 XP.XD.XPRE.n2 XP.XD.XPRE.p0
save XP.XD.XRL.n1 XP.XD.XRL.n2 XP.XD.XRL.p0 XP.XD.XSEB0.x XP.XD.XSEB1.x XP.XD.XSEB2.x XP.XD.XSEB3.x XP.XD.XSEB4.x XP.XD.XSEB5.x XP.XDAC.b0 XP.XDAC.b1
save XP.XDAC.b2 XP.XDAC.b3 XP.XDAC.b4 XP.XDAC.b5 XP.XDAC.r0 XP.XDAC.r1 XP.XDAC.r2 XP.XDAC.r3 XP.XDAC.r4 XP.XDAC.v0 XP.XDAC.v1 XP.XDAC.v2
save XP.XDAC.v3 XP.XDAC.v4 XP.XDAC.v5 XP.XDAC.vd XP.XDET.env XP.XDET.envref XP.XDET.lower_ok XP.XDET.threshold XP.XDET.upper_ok XP.XDET.wh XP.XDET.window_ok XP.XDET.wl
save XP.XDET.XA.inv XP.XDET.XA.left XP.XDET.XA.nb XP.XDET.XA.sense XP.XDET.XA.tail XP.XDET.XG.n XP.XDET.XG.XN.x XP.XDET.XH.inv XP.XDET.XH.left XP.XDET.XH.nb XP.XDET.XH.sense XP.XDET.XH.tail
save XP.XDET.XL.inv XP.XDET.XL.left XP.XDET.XL.nb XP.XDET.XL.sense XP.XDET.XL.tail XP.XDET.XW.n XP.XDET.XW.XN.x XP.XLF.enb XP.XR.ob XP.XR.qb XP.XR.XFF.a XP.XR.XFF.b
save XP.XR.XFF.n1 XP.XR.XFF.n2 XP.XR.XFF.p0 XP.XREF.a XP.XREF.b XP.XREF.c XP.XRX.g0 XP.XS.refb XP.XV.XBN.MP0:int_d XP.XV.XBN.MP0:int_s XP.XV.XBN.MP1:int_d XP.XV.XBN.MP1:int_s
save XP.XV.XBN.MP2:int_d XP.XV.XBN.MP2:int_s XP.XV.XBN.MP3:int_d XP.XV.XBN.MP3:int_s XP.XV.XBN.MP4:int_d XP.XV.XBN.MP4:int_s XP.XV.XBN.MP5:int_d XP.XV.XBN.MP5:int_s XP.XV.XBN.MP6:int_d XP.XV.XBN.MP6:int_s XP.XV.XBN.MP7:int_d XP.XV.XBN.MP7:int_s
save XP.XV.XBN.x0 XP.XV.XBN.x1 XP.XV.XBN.x2 XP.XV.XBN.x3 XP.XV.XBN.x4 XP.XV.XBN.x5 XP.XV.XBN.x6 XP.XV.XBN.x7 XP.XV.XBP.MP0:int_d XP.XV.XBP.MP0:int_s XP.XV.XBP.MP1:int_d XP.XV.XBP.MP1:int_s
save XP.XV.XBP.MP2:int_d XP.XV.XBP.MP2:int_s XP.XV.XBP.MP3:int_d XP.XV.XBP.MP3:int_s XP.XV.XBP.MP4:int_d XP.XV.XBP.MP4:int_s XP.XV.XBP.MP5:int_d XP.XV.XBP.MP5:int_s XP.XV.XBP.MP6:int_d XP.XV.XBP.MP6:int_s XP.XV.XBP.MP7:int_d XP.XV.XBP.MP7:int_s
save XP.XV.XBP.x0 XP.XV.XBP.x1 XP.XV.XBP.x2 XP.XV.XBP.x3 XP.XV.XBP.x4 XP.XV.XBP.x5 XP.XV.XBP.x6 XP.XV.XBP.x7 XP.XV.XL.nb XP.XV.XL.nfilt XP.XV.XL.s3 XP.XV.XL.s4
save XP.XV.XL.s5 XP.XV.XL.s6 XP.XV.XL.s7 XP.XV.XL.tail XP.XV.XL.XN.LW:1 XP.XV.XL.XN.sn XP.XV.XL.XN.sp XP.XV.XL.XN.x XP.XV.XL.XP.LW:1 XP.XV.XL.XP.sn XP.XV.XL.XP.sp XP.XV.XL.XP.x
