simulator lang=spectre
global 0
include "/home/process/tsmc180bcd_gen2_2022/PDK/TSMC180BCD/models/spectre/c018bcd_gen2_v1d6.scs" section=tt
include "/home/process/tsmc180bcd_gen2_2022/PDK/TSMC180BCD/models/spectre/c018bcd_gen2_v1d6.scs" section=stat_noise
simulator lang=spectre insensitive=no
include "/home/process/tsmc180bcd_gen2_2022/PDK/TSMC180BCD/models/spectre/c018bcd_gen2_v1d6.scs" section=tt_bbmvar
simulator lang=spectre insensitive=no
include "pll_capture_rt4bank_v14.scs"
simulatorOptions options temp=27 reltol=1e-4 vabstol=1e-6 iabstol=1e-12
VDD (vdd_source 0) vsource dc=1.2
VMEAS (vdd_source vdd) vsource dc=0
VR (ref 0) vsource type=pulse val0=0 val1=1.2 period=41.6666666666667n width=20.8233333333333n rise=10p fall=10p delay=1n
VRST (reset 0) vsource dc=0
VAP (apply 0) vsource dc=0
VK0 (k0 0) vsource dc=1.2
VK1 (k1 0) vsource dc=0
VK2 (k2 0) vsource dc=0
VK3 (k3 0) vsource dc=1.2
VK4 (k4 0) vsource dc=0
VK5 (k5 0) vsource dc=1.2
XP (ref reset apply k0 k1 k2 k3 k4 k5 out qualified range_error cfg_ready frequency_good phase_good amp_good vdd 0) pll_capture_rt4bank_v14
CL (out 0) capacitor c=10f
precision_steps paramset {
time maxstep reltol vabstol iabstol isnoisy
0 4e-12 0.0001 1e-06 1e-12 0
1e-06 3.75e-12 0.0001 1e-06 1e-12 0
2e-06 3.5e-12 0.0001 1e-06 1e-12 0
3e-06 3.25e-12 0.0001 1e-06 1e-12 0
4e-06 3e-12 0.0001 1e-06 1e-12 0
5e-06 2.75e-12 0.0001 1e-06 1e-12 0
6e-06 2.5e-12 0.0001 1e-06 1e-12 0
7e-06 2.25e-12 0.0001 1e-06 1e-12 0
8e-06 2e-12 0.0001 1e-06 1e-12 0
9e-06 1.75e-12 0.0001 1e-06 1e-12 0
1e-05 1.5e-12 0.0001 1e-06 1e-12 0
1.1e-05 1.25e-12 0.0001 1e-06 1e-12 0
1.2e-05 1e-12 0.0001 1e-06 1e-12 0
1.3e-05 7.5e-13 0.0001 1e-06 1e-12 0
1.4e-05 5e-13 0.0001 1e-06 1e-12 0
1.5e-05 5e-13 1e-05 1e-07 1e-12 0
1.6e-05 5e-13 1e-06 1e-09 1e-12 0
}
tran tran stop=20u maxstep=4p strobeperiod=2n strobeoutput=strobeonly method=traponly errpreset=moderate readic="rt4bank_cold64_no_observer.ic" skipdc=yes noisefmax=160G noisefmin=1M noiseseed=11 paramset=precision_steps writefinal="__FINAL_STATE__"
saveOptions options save=selected
save XP.restart XP.hp XP.hn XP.vc1 out ref qualified range_error cfg_ready frequency_good phase_good amp_good XP.ctrl XP.vp XP.vn XP.refb XP.XC.phase_held XP.XC.acquired XP.en VDD:p XP.VVCO:p XP.VRX:p XP.VRT:p
