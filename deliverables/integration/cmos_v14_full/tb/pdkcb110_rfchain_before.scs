simulator lang=spectre
global 0
include "/home/process/tsmc180bcd_gen2_2022/PDK/TSMC180BCD/models/spectre/c018bcd_gen2_v1d6.scs" section=tt
simulator lang=spectre insensitive=no
include "/home/process/tsmc180bcd_gen2_2022/PDK/TSMC180BCD/models/spectre/c018bcd_gen2_v1d6.scs" section=stat_noise
simulator lang=spectre insensitive=no
include "/home/process/tsmc180bcd_gen2_2022/PDK/TSMC180BCD/models/spectre/c018bcd_gen2_v1d6.scs" section=tt_bbmvar
simulator lang=spectre insensitive=no
include "rt4_callback110_before.scs"
simulatorOptions options reltol=1e-3 vabstol=1e-6 iabstol=1e-12 temp=27
VDD (vdd 0) vsource dc=1.2
VRF (vp 0) vsource type=sine dc=1.2 ampl=.4 freq=3.936G
VDRESET (div_reset 0) vsource type=pwl wave=[0 1.2 20n 1.2 20.01n 0]
XRX (vp clk vdd 0) rf_light24s12_v14_base110_19
XD (clk div_reset vdd 0 0 0 0 0 q1 data acqclk vdd 0) bank_pulsetrip_v14_base110_21
XR (data clk out vdd 0) rt_noise_scale4_v14_base110_49
CL (out 0) capacitor c=10f
save vp clk q1 data out acqclk VDD:p
tran tran stop=1.2e-07 start=0 strobeperiod=5e-12 maxstep=8p method=traponly errpreset=moderate writefinal="__FINAL_STATE__"
saveOptions options save=selected
