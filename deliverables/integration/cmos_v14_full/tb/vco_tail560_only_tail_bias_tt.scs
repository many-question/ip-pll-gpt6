simulator lang=spectre
global 0
include "/home/process/tsmc180bcd_gen2_2022/PDK/TSMC180BCD/models/spectre/c018bcd_gen2_v1d6.scs" section=tt
include "/home/process/tsmc180bcd_gen2_2022/PDK/TSMC180BCD/models/spectre/c018bcd_gen2_v1d6.scs" section=stat_noise
simulator lang=spectre insensitive=no
include "/home/process/tsmc180bcd_gen2_2022/PDK/TSMC180BCD/models/spectre/c018bcd_gen2_v1d6.scs" section=tt_bbmvar
simulator lang=spectre insensitive=no
include "cells.scs"
simulatorOptions options reltol=1e-5 vabstol=1e-7 iabstol=1e-13 temp=27 noiseon_inst=[XV.XL.MT XV.XL.MR XV.XL.RREF XV.XL.RF XV.XL.MA3 XV.XL.MA4 XV.XL.MA5 XV.XL.MA6 XV.XL.MA7 XV.XL.ME3 XV.XL.ME4 XV.XL.ME5 XV.XL.ME6 XV.XL.ME7] noiseon_type=all
include "lc_vco_cf40_tail560_v14.scs"
VDD (vdd 0) vsource dc=1.2
VVCO (vco_vdd vdd) vsource dc=0
VPRE (preset 0) vsource dc=0.68
include "loop_filter_v5.scs"
XLF (ctrl vc1 en preset vdd 0) tx_loop_filter_v5 rlf=100k
VB0 (b0 0) vsource dc=1.2
VB1 (b1 0) vsource dc=0
VB2 (b2 0) vsource dc=1.2
VB3 (b3 0) vsource dc=0
VB4 (b4 0) vsource dc=1.2
VB5 (b5 0) vsource dc=0
VB6 (b6 0) vsource dc=0
VB7 (b7 0) vsource dc=0
XV (vp vn ctrl b0 b1 b2 b3 b4 b5 b6 b7 vco_vdd 0) lc_vco_cf40_tail560_v14 bias_r=2500
include "cp_physical_v14.scs"
include "digital_cells_v2.scs"
include "cp_timing.scs"
include "sampler_bias_v5.scs"
XBM (vdd 0 vmid) tx_bias_mid_v5
CCP (vp sp) capacitor c=120f
CCN (vn sn) capacitor c=120f
RBP (sp vmid) resistor r=10k
RBN (sn vmid) resistor r=10k
VR (ref 0) vsource dc=0
XREF (ref refb vdd 0) tx_reference_buffer
CR (refb 0) capacitor c=60f
XS (refb sp sn hp hn vdd 0) tx_sampler
XA (refb en rst pulse vdd 0) tx_cp_timing
VE (en 0) vsource dc=1.2
XCP (hp hn pulse en cpout vdd 0) cp_physical_v14
VO (cpout ctrl) vsource dc=0
VRST (rst 0) vsource dc=0
include "rf_light24s12_v14.scs"
include "div_fb50buf24_v14.scs"
include "rtcomb_v13.scs"
include "rt_light24s12_out083_v14.scs"
VRX (rx_vdd vdd) vsource dc=0
VRT (rt_vdd vdd) vsource dc=0
XRX (vp clk rx_vdd 0) rf_light24s12_v14
XD (clk q1 data vdd 0) div_fb50buf24_v14
XR (data clk out rt_vdd 0) rt_light24s12_out083_v14
CL (out 0) capacitor c=10f
VC (ctrl 0) vsource dc=0.74116905779740294
include "validity_physical_v14.scs"
XDET (vp hp hn amp_good phase_good vdd 0) validity_physical_v14
// External fixed control/coarse bits; reference held low. No functionalVA.
ic vp=1.20001 vn=1.2
pss (out 0) pss fund=984M harms=127 tstab=300n maxstep=0.25p method=traponly errpreset=conservative maxperiods=30 saveinit=no writefinal="__FINAL_STATE__"
pn (vp vn) pnoise values=[1M 10M 100M] maxsideband=511 noiseout=[usb am pm] sweeptype=relative relharmnum=4
save vp vn clk q1 data out ctrl hp hn XV.XL.nb XV.XL.nfilt XV.XL.tail VDD:p VVCO:p VRX:p VRT:p
saveOptions options save=selected
