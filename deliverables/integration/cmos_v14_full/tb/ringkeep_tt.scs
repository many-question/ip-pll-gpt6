simulator lang=spectre
global 0
include "/home/process/tsmc180bcd_gen2_2022/PDK/TSMC180BCD/models/spectre/c018bcd_gen2_v1d6.scs" section=tt
include "/home/process/tsmc180bcd_gen2_2022/PDK/TSMC180BCD/models/spectre/c018bcd_gen2_v1d6.scs" section=stat_noise
simulator lang=spectre insensitive=no
include "cells.scs"
include "digital_cells_v2.scs"
include "ring_c2keep_v14.scs"
simulatorOptions options temp=27 reltol=1e-5 vabstol=1e-7 iabstol=1e-13
VDD (vdd 0) vsource dc=1.2
VCK (clk 0) vsource type=pulse val0=0 val1=1.2 period=666.6666666667p width=313.3333333333p rise=20p fall=20p delay=8.5n
VCB (clkb 0) vsource type=pulse val0=1.2 val1=0 period=666.6666666667p width=313.3333333333p rise=20p fall=20p delay=8.5n
VR (rst 0) vsource type=pwl wave=[0 1.2 8n 1.2 8.01n 0]
VRB (rstb 0) vsource type=pwl wave=[0 0 8n 0 8.01n 1.2]
X0 (q2 clk clkb rst rstb q0 vdd 0) ring_c2k_r1_v14
X1 (q0 clk clkb rst rstb q1 vdd 0) ring_c2k_r0_v14
X2 (q1 clk clkb rst rstb q2 vdd 0) ring_c2k_r0_v14
CL (q0 0) capacitor c=2f
tran tran stop=40n maxstep=1p method=traponly errpreset=conservative
save clk clkb rst q0 q1 q2 X0.qb X1.qb X2.qb VDD:p
saveOptions options save=selected
