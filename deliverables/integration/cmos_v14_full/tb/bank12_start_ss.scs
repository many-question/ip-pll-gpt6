simulator lang=spectre
global 0
include "/home/process/tsmc180bcd_gen2_2022/PDK/TSMC180BCD/models/spectre/c018bcd_gen2_v1d6.scs" section=ss
include "/home/process/tsmc180bcd_gen2_2022/PDK/TSMC180BCD/models/spectre/c018bcd_gen2_v1d6.scs" section=stat_noise
simulator lang=spectre insensitive=no
include "cells.scs"
include "digital_cells_v2.scs"
include "cmos_even_bank_r12_v14.scs"
simulatorOptions options temp=60 reltol=1e-5 vabstol=1e-7 iabstol=1e-13
VDD (vdd 0) vsource dc=1.2
VCLK (clk 0) vsource type=pulse val0=0 val1=1.2 period=3.306878306878307e-10 width=1.453439153439153e-10 rise=20p fall=20p
VRST (reset 0) vsource type=pwl wave=[0 1.2 8n 1.2 8.01n 0]
VS0 (s0 0) vsource dc=0
VS1 (s1 0) vsource dc=0
VS2 (s2 0) vsource dc=0
VS3 (s3 0) vsource dc=0
VS4 (s4 0) vsource dc=0
VS5 (s5 0) vsource dc=1.2
XD (clk reset s0 s1 s2 s3 s4 s5 q1 data vdd 0) cmos_even_bank_r12_v14
CL (data 0) capacitor c=10f
tran tran stop=25n outputstart=0 maxstep=1p method=traponly errpreset=conservative
save clk q1 data reset VDD:p XD.q0 XD.qb0 XD.ci XD.gn XD.cb XD.ck XD.ckb XD.run XD.load XD.loadb XD.fb XD.r0 XD.r1 XD.r2 XD.r3 XD.r4 XD.r5 XD.r6
saveOptions options save=selected

save XD.XF0.din XD.XF0.qm XD.XF4.din XD.XF4.qm XD.XF0.XM.x XD.XF0.XS.x XD.XRL.b XD.XRL.a
