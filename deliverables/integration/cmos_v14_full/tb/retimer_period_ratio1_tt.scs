simulator lang=spectre
global 0
include "/home/process/tsmc180bcd_gen2_2022/PDK/TSMC180BCD/models/spectre/c018bcd_gen2_v1d6.scs" section=tt
include "/home/process/tsmc180bcd_gen2_2022/PDK/TSMC180BCD/models/spectre/c018bcd_gen2_v1d6.scs" section=stat_noise
simulator lang=spectre insensitive=no
include "cells.scs"
include "rtcomb_v13.scs"
include "rt_noise_scale4_v14.scs"
simulatorOptions options temp=27 reltol=1e-5 vabstol=1e-7 iabstol=1e-13
VDD (vdd 0) vsource dc=1.2
VIN (in 0) vsource type=pulse val0=0 val1=1.2 period=1.016260162601626e-09 width=4.9813008130081302e-10 rise=10p fall=10p delay=30p
// Actual RT4 retimer and output stages; ideal data/RF clock isolate measurement.
VCLK (clk 0) vsource type=pulse val0=0 val1=1.2 period=2.5406504065040649e-10 width=1.1703252032520326e-10 rise=10p fall=10p
XR (in clk out vdd 0) rt_noise_scale4_v14
CL (out 0) capacitor c=10f
save in clk XR.ob XR.qb XR.XFF.a XR.XFF.b out VDD:p
saveOptions options save=selected
pss pss fund=984000000 harms=128 tstab=30n maxstep=0.5p maxacfreq=504G method=traponly errpreset=conservative maxperiods=30 saveinit=no writefinal="__FINAL_STATE__" writepss="__PERIODIC_STATE__"
pn pnoise values=[10000 1000000 100000000 163999999 164000001 327999999 328000001 491990000 491999999 492000000] pnoisemethod=fullspectrum noisetype=sampled measurement=[edge] sampleratio=1 maxsideband=128
edge jitterevent trigger=[out] triggerthresh=0.6 triggernum=1 triggerdir=rise target=[out] jittercal=[Jee]
