// Local diagnostic only, no controller. Original real RF/CF bias network.
simulator lang=spectre
global 0
include "/home/process/tsmc180bcd_gen2_2022/PDK/TSMC180BCD/models/spectre/c018bcd_gen2_v1d6.scs" section=tt
include "/home/process/tsmc180bcd_gen2_2022/PDK/TSMC180BCD/models/spectre/c018bcd_gen2_v1d6.scs" section=stat_noise
simulator lang=spectre insensitive=no
include "/home/process/tsmc180bcd_gen2_2022/PDK/TSMC180BCD/models/spectre/c018bcd_gen2_v1d6.scs" section=tt_bbmvar
simulator lang=spectre insensitive=no
include "cells.scs"
simulatorOptions options reltol=1e-3 vabstol=1e-6 iabstol=1e-12 temp=27
include "lc_vco_physical_v14.scs"
VDD (vdd 0) vsource dc=1.2
VVCO (vco_vdd vdd) vsource dc=0
VC (ctrl 0) vsource type=pwl wave=[0 .2 2000n .2 2000.01n .84]
VB0 (b0 0) vsource type=pwl wave=[0 1.2 1000n 1.2 1000.01n 0]
VB1 (b1 0) vsource type=pwl wave=[0 1.2 1000n 1.2 1000.01n 0]
VB2 (b2 0) vsource type=pwl wave=[0 0 1000n 0 1000.01n 1.2]
VB3 (b3 0) vsource type=pwl wave=[0 0 1000n 0 1000.01n 0]
VB4 (b4 0) vsource type=pwl wave=[0 1.2 1000n 1.2 1000.01n 1.2]
VB5 (b5 0) vsource type=pwl wave=[0 0 1000n 0 1000.01n 0]
VB6 (b6 0) vsource type=pwl wave=[0 0 1000n 0 1000.01n 0]
VB7 (b7 0) vsource type=pwl wave=[0 0 1000n 0 1000.01n 0]
XV (vp vn ctrl b0 b1 b2 b3 b4 b5 b6 b7 vco_vdd 0) lc_vco_physical_v14 bias_r=2500 unit_c=4.8f
include "cp_physical_v14.scs"
include "digital_cells_v2.scs"
include "cp_timing.scs"
include "sampler_bias_v5.scs"
XBM (vdd 0 vmid) tx_bias_mid_v5
CCP (vp sp) capacitor c=120f
CCN (vn sn) capacitor c=120f
RBP (sp vmid) resistor r=10k
RBN (sn vmid) resistor r=10k
VR (ref 0) vsource type=pulse val0=0 val1=1.2 period=41.6666666666667n width=20.8233333333333n rise=10p fall=10p delay=1n
XREF (ref refb vdd 0) tx_reference_buffer
CR (refb 0) capacitor c=60f
XS (refb sp sn hp hn vdd 0) tx_sampler
XA (refb en rst pulse vdd 0) tx_cp_timing
VE (en 0) vsource dc=0
XCP (hp hn pulse en cpout vdd 0) cp_physical_v14 bias_r=24000
VO (cpout 0) vsource dc=.6
VRST (rst 0) vsource dc=0
include "rf_light24s12_v14.scs"
include "bank_pulsetrip_v14.scs"
include "validity_physical_v14.scs"
include "rtcomb_v13.scs"
include "rt_noise_scale4_v14.scs"
VRX (rx_vdd vdd) vsource dc=0
VRT (rt_vdd vdd) vsource dc=0
XRX (vp clk rx_vdd 0) rf_light24s12_v14
VDRESET (div_reset 0) vsource type=pwl wave=[0 1.2 20n 1.2 20.01n 0]
XD (clk div_reset vdd 0 0 0 0 0 q1 data acqclk vdd 0) bank_pulsetrip_v14
XDET (vp hp hn amp_good phase_good vdd 0) validity_physical_v14
XR (data clk out rt_vdd 0) rt_noise_scale4_v14
CL (out 0) capacitor c=10f
// Diagnostic warm bias IC from completed full record; released at t=0, not clamped.
ic vp=1.20001 vn=1.2 XV.XL.nfilt=.728
tran tran stop=3u strobeperiod=2n strobeoutput=strobeonly maxstep=8p method=traponly errpreset=moderate writefinal="__FINAL_STATE__"
save vp vn clk q1 data out ctrl sp sn hp hn refb XV.XL.nb XV.XL.nfilt XV.XL.tail VDD:p VVCO:p VRX:p VRT:p
saveOptions options save=selected

save XCP.nb

save amp_good phase_good acqclk

ahdl_include "lc_loop_observer.va"
XOBS (vp vn refb ctrl out 0 obsphase obscycles obsctrl obsdivcycles) lc_loop_observer
save obsphase obscycles obsctrl obsdivcycles
