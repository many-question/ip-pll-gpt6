simulator lang=spectre
global 0
include "/home/process/tsmc180bcd_gen2_2022/PDK/TSMC180BCD/models/spectre/c018bcd_gen2_v1d6.scs" section=ss
include "/home/process/tsmc180bcd_gen2_2022/PDK/TSMC180BCD/models/spectre/c018bcd_gen2_v1d6.scs" section=stat_noise
simulator lang=spectre insensitive=no
include "cells.scs"
include "digital_cells_v2.scs"
include "bank_clock_isolation_v14.scs"
include "rtcomb_v13.scs"
include "rt_light24s12_out083_v14.scs"
simulatorOptions options temp=60 reltol=1e-5 vabstol=1e-7 iabstol=1e-13
VDD (vdd 0) vsource dc=1.2
VCLK (clk 0) vsource type=pulse val0=0 val1=1.2 period=3.306878306878307e-10 width=1.453439153439153e-10 rise=20p fall=20p
VRST (reset 0) vsource type=pwl wave=[0 1.2 8n 1.2 8.01n 0]
VS0 (s0 0) vsource dc=0
VS1 (s1 0) vsource dc=0
VS2 (s2 0) vsource dc=0
VS3 (s3 0) vsource dc=0
VS4 (s4 0) vsource dc=0
VS5 (s5 0) vsource dc=1.2
XD (clk reset s0 s1 s2 s3 s4 s5 q1 predata acqclk ck ckb vdd 0) bank_clock_isolation_v14
XR (predata clk data vdd 0) rt_light24s12_out083_v14
CL (data 0) capacitor c=10f
tran tran stop=40n maxstep=1p method=traponly errpreset=conservative
save predata acqclk clk q1 data reset VDD:p XD.d4 XD.d6 XD.d8 XD.d12 ck ckb XD.load XD.fb XD.XD6.q0 XD.XD6.q1 XD.XD6.d0 XD.mux XD.r0 XD.r1 XD.r2 XD.r3 XD.r4 XD.r5 XD.r6
saveOptions options save=selected

VCK (ck 0) vsource type=pulse val0=0 val1=1.2 period=6.6137566137566138e-10 rise=1.9999999999999999e-11 fall=1.9999999999999999e-11 width=3.1068783068783071e-10
VCKB (ckb 0) vsource type=pulse val0=1.2 val1=0 period=6.6137566137566138e-10 rise=1.9999999999999999e-11 fall=1.9999999999999999e-11 width=3.1068783068783071e-10
save XD.XD6.clkb XD.XD6.X0.qm XD.XD6.X0.XM.x XD.XD6.X0.XS.x
save XD.loadb XD.XF0.din XD.XF0.qm XD.XF0.XM.x XD.XF0.XS.x XD.XF0.XM.fb XD.XF0.XS.fb XD.XF1.din XD.XF1.qm XD.XF1.XM.x XD.XF1.XS.x XD.XF6.din XD.XF6.qm XD.XF6.XM.x XD.XF6.XS.x
