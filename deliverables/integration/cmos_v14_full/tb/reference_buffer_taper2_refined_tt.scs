simulator lang=spectre
global 0
include "/home/process/tsmc180bcd_gen2_2022/PDK/TSMC180BCD/models/spectre/c018bcd_gen2_v1d6.scs" section=tt
include "/home/process/tsmc180bcd_gen2_2022/PDK/TSMC180BCD/models/spectre/c018bcd_gen2_v1d6.scs" section=stat_noise
simulator lang=spectre insensitive=no
include "cells.scs"
include "reference_buffer_taper2_v14.scs"
simulatorOptions options temp=27 reltol=1e-5 vabstol=1e-7 iabstol=1e-13
VDD (vdd 0) vsource dc=1.2
VR (ref 0) vsource type=pulse val0=0 val1=1.2 period=41.6666666666667n width=20.8233333333333n rise=10p fall=10p delay=1n
XR (ref out vdd 0) reference_buffer_taper2_v14
CL (out 0) capacitor c=2p
save ref out XR.a XR.b XR.c VDD:p VR:p
saveOptions options save=selected
pss pss fund=24M harms=2047 tstab=100n maxstep=0.5p maxacfreq=192G method=gear2only tstabmethod=gear2only errpreset=conservative maxperiods=20 saveinit=no writefinal="__FINAL_STATE__" writepss="__PERIODIC_STATE__"
pn pnoise start=10k stop=12M dec=20 pnoisemethod=fullspectrum noisetype=sampled measurement=[edge] sampleratio=1 maxsideband=2047
edge jitterevent trigger=[out] triggerthresh=0.6 triggernum=1 triggerdir=rise target=[out] jittercal=[Jee]
