simulator lang=spectre
global 0
include "/home/process/tsmc180bcd_gen2_2022/PDK/TSMC180BCD/models/spectre/c018bcd_gen2_v1d6.scs" section=ss
include "/home/process/tsmc180bcd_gen2_2022/PDK/TSMC180BCD/models/spectre/c018bcd_gen2_v1d6.scs" section=stat_noise
simulator lang=spectre insensitive=no
include "/home/process/tsmc180bcd_gen2_2022/PDK/TSMC180BCD/models/spectre/c018bcd_gen2_v1d6.scs" section=ss_bbmvar
simulator lang=spectre insensitive=no
include "pll_complete_v14.scs"
simulatorOptions options temp=60 reltol=1e-5 vabstol=1e-7 iabstol=1e-13
VDD (vdd_source 0) vsource dc=1.2
ahdl_include "supply_energy_observer.va"
XE (vdd_source vdd 0 energy_nj power_mw) supply_energy_observer
VR (ref 0) vsource type=pulse val0=0 val1=1.2 period=41.6666666666667n width=20.8233333333333n rise=10p fall=10p delay=42.6666666666667n
VRST (reset 0) vsource dc=0
VAP (apply 0) vsource dc=0
VK0 (k0 0) vsource dc=1.2
VK1 (k1 0) vsource dc=0
VK2 (k2 0) vsource dc=0
VK3 (k3 0) vsource dc=1.2
VK4 (k4 0) vsource dc=0
VK5 (k5 0) vsource dc=1.2
XP (ref reset apply k0 k1 k2 k3 k4 k5 out qualified range_error cfg_ready frequency_good phase_good amp_good vdd 0) pll_complete_v14
CL (out 0) capacitor c=10f
ahdl_include "lc_loop_observer.va"
XOBS (XP.vp XP.vn XP.refb XP.ctrl out 0 obsphase obscycles obsctrl obsdivcycles) lc_loop_observer
tran tran stop=100n outputstart=50n readic="ss_interface_seed.ic" maxstep=1p method=traponly errpreset=conservative writefinal="__FINAL_STATE__"
save energy_nj power_mw XP.XC.phase_held
save obsphase obscycles obsctrl obsdivcycles out ref qualified range_error cfg_ready frequency_good phase_good amp_good XP.ctrl XP.vc1 XP.preset XP.en XP.hp XP.hn XP.XV.XL.nb XP.XV.XL.nfilt XP.XV.XL.tail VDD:p XP.VVCO:p XP.VRX:p XP.VRT:p
save XP.count_gate XP.count_reset XP.restart XP.XC.acquired XP.XC.state0 XP.XC.state1 XP.XC.state2 XP.b0 XP.b1 XP.b2 XP.b3 XP.b4 XP.b5 XP.b6 XP.b7 XP.XC.d0 XP.XC.d1 XP.XC.d2 XP.XC.d3 XP.XC.d4 XP.XC.d5 XP.XC.m0 XP.XC.m1 XP.XC.m2 XP.XC.m3 XP.XC.m4 XP.XC.m5 XP.XC.m6 XP.XC.m7 XP.XC.m8 XP.XC.m9 XP.XC.m10 XP.XC.m11 XP.XC.m12 XP.XC.m13
saveOptions options save=selected

ahdl_include "tb_edge_observer.va"
ahdl_include "tb_power_integrator.va"
XME_reference (XP.refb vdd 0 reference_rise_ns reference_fall_ns reference_period_ns reference_duty_percent) tb_edge_observer
save reference_rise_ns reference_fall_ns reference_period_ns reference_duty_percent
XME_rfclock (XP.clk vdd 0 rfclock_rise_ns rfclock_fall_ns rfclock_period_ns rfclock_duty_percent) tb_edge_observer
save rfclock_rise_ns rfclock_fall_ns rfclock_period_ns rfclock_duty_percent
XME_output (out vdd 0 output_rise_ns output_fall_ns output_period_ns output_duty_percent) tb_edge_observer
save output_rise_ns output_fall_ns output_period_ns output_duty_percent
BM_vco (power_vco_w 0) bsource v=-v(vdd)*i("XP.VVCO:1")
XEM_vco (power_vco_w 0 energy_vco_nj) tb_power_integrator
save energy_vco_nj
BM_rx (power_rx_w 0) bsource v=-v(vdd)*i("XP.VRX:1")
XEM_rx (power_rx_w 0 energy_rx_nj) tb_power_integrator
save energy_rx_nj
BM_rt (power_rt_w 0) bsource v=-v(vdd)*i("XP.VRT:1")
XEM_rt (power_rt_w 0 energy_rt_nj) tb_power_integrator
save energy_rt_nj
save XP.refb XP.clk XP.vp XP.vn
save XP.vp XP.vn XP.refb XP.clk XP.q1 XP.data
