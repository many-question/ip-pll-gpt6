simulator lang=spectre
global 0
include "/home/process/tsmc180bcd_gen2_2022/PDK/TSMC180BCD/models/spectre/c018bcd_gen2_v1d6.scs" section=tt
include "/home/process/tsmc180bcd_gen2_2022/PDK/TSMC180BCD/models/spectre/c018bcd_gen2_v1d6.scs" section=stat_noise
simulator lang=spectre insensitive=no
include "cells.scs"
include "digital_cells_v2.scs"
include "validity_physical_v14.scs"
simulatorOptions options temp=27 reltol=1e-5 vabstol=1e-7 iabstol=1e-13
VDD (vdd 0) vsource dc=1.2
VRF (rf 0) vsource type=pwl wave=[0 1.2 3.17581300813e-11 1.2 6.35162601626e-11 1.2 9.52743902439e-11 1.2 1.27032520325e-10 1.2 1.58790650407e-10 1.2 1.90548780488e-10 1.2 2.22306910569e-10 1.2 2.5406504065e-10 1.2 2.85823170732e-10 1.2 3.17581300813e-10 1.2 3.49339430894e-10 1.2 3.81097560976e-10 1.2 4.12855691057e-10 1.2 4.44613821138e-10 1.2 4.7637195122e-10 1.2 5.08130081301e-10 1.2 5.39888211382e-10 1.2 5.71646341463e-10 1.2 6.03404471545e-10 1.2 6.35162601626e-10 1.2 6.66920731707e-10 1.2 6.98678861789e-10 1.2 7.3043699187e-10 1.2 7.62195121951e-10 1.2 7.93953252033e-10 1.2 8.25711382114e-10 1.2 8.57469512195e-10 1.2 8.89227642276e-10 1.2 9.20985772358e-10 1.2 9.52743902439e-10 1.2 9.8450203252e-10 1.2 1.0162601626e-09 1.2 1.04801829268e-09 1.2 1.07977642276e-09 1.2 1.11153455285e-09 1.2 1.14329268293e-09 1.2 1.17505081301e-09 1.2 1.20680894309e-09 1.2 1.23856707317e-09 1.2 1.27032520325e-09 1.2 1.30208333333e-09 1.2 1.33384146341e-09 1.2 1.3655995935e-09 1.2 1.39735772358e-09 1.2 1.42911585366e-09 1.2 1.46087398374e-09 1.2 1.49263211382e-09 1.2 1.5243902439e-09 1.2 1.55614837398e-09 1.2 1.58790650407e-09 1.2 1.61966463415e-09 1.2 1.65142276423e-09 1.2 1.68318089431e-09 1.2 1.71493902439e-09 1.2 1.74669715447e-09 1.2 1.77845528455e-09 1.2 1.81021341463e-09 1.2 1.84197154472e-09 1.2 1.8737296748e-09 1.2 1.90548780488e-09 1.2 1.93724593496e-09 1.2 1.96900406504e-09 1.2 2.00076219512e-09 1.2 2.0325203252e-09 1.2 2.06427845528e-09 1.2 2.09603658537e-09 1.2 2.12779471545e-09 1.2 2.15955284553e-09 1.2 2.19131097561e-09 1.2 2.22306910569e-09 1.2 2.25482723577e-09 1.2 2.28658536585e-09 1.2 2.31834349593e-09 1.2 2.35010162602e-09 1.2 2.3818597561e-09 1.2 2.41361788618e-09 1.2 2.44537601626e-09 1.2 2.47713414634e-09 1.2 2.50889227642e-09 1.2 2.5406504065e-09 1.2 2.57240853659e-09 1.2 2.60416666667e-09 1.2 2.63592479675e-09 1.2 2.66768292683e-09 1.2 2.69944105691e-09 1.2 2.73119918699e-09 1.2 2.76295731707e-09 1.2 2.79471544715e-09 1.2 2.82647357724e-09 1.2 2.85823170732e-09 1.2 2.8899898374e-09 1.2 2.92174796748e-09 1.2 2.95350609756e-09 1.2 2.98526422764e-09 1.2 3.01702235772e-09 1.2 3.0487804878e-09 1.2 3.08053861789e-09 1.2 3.11229674797e-09 1.2 3.14405487805e-09 1.2 3.17581300813e-09 1.2 3.20757113821e-09 1.2 3.23932926829e-09 1.2 3.27108739837e-09 1.2 3.30284552846e-09 1.2 3.33460365854e-09 1.2 3.36636178862e-09 1.2 3.3981199187e-09 1.2 3.42987804878e-09 1.2 3.46163617886e-09 1.2 3.49339430894e-09 1.2 3.52515243902e-09 1.2 3.55691056911e-09 1.2 3.58866869919e-09 1.2 3.62042682927e-09 1.2 3.65218495935e-09 1.2 3.68394308943e-09 1.2 3.71570121951e-09 1.2 3.74745934959e-09 1.2 3.77921747967e-09 1.2 3.81097560976e-09 1.2 3.84273373984e-09 1.2 3.87449186992e-09 1.2 3.90625e-09 1.2 3.93800813008e-09 1.2 3.96976626016e-09 1.2 4.00152439024e-09 1.2 4.03328252033e-09 1.2 4.06504065041e-09 1.2 4.09679878049e-09 1.2 4.12855691057e-09 1.2 4.16031504065e-09 1.2 4.19207317073e-09 1.2 4.22383130081e-09 1.2 4.25558943089e-09 1.2 4.28734756098e-09 1.2 4.31910569106e-09 1.2 4.35086382114e-09 1.2 4.38262195122e-09 1.2 4.4143800813e-09 1.2 4.44613821138e-09 1.2 4.47789634146e-09 1.2 4.50965447154e-09 1.2 4.54141260163e-09 1.2 4.57317073171e-09 1.2 4.60492886179e-09 1.2 4.63668699187e-09 1.2 4.66844512195e-09 1.2 4.70020325203e-09 1.2 4.73196138211e-09 1.2 4.7637195122e-09 1.2 4.79547764228e-09 1.2 4.82723577236e-09 1.2 4.85899390244e-09 1.2 4.89075203252e-09 1.2 4.9225101626e-09 1.2 4.95426829268e-09 1.2 4.98602642276e-09 1.2 5.01778455285e-09 1.2 5.04954268293e-09 1.2 5.08130081301e-09 1.2 5.11305894309e-09 1.2 5.14481707317e-09 1.2 5.17657520325e-09 1.2 5.20833333333e-09 1.2 5.24009146341e-09 1.2 5.2718495935e-09 1.2 5.30360772358e-09 1.2 5.33536585366e-09 1.2 5.36712398374e-09 1.2 5.39888211382e-09 1.2 5.4306402439e-09 1.2 5.46239837398e-09 1.2 5.49415650407e-09 1.2 5.52591463415e-09 1.2 5.55767276423e-09 1.2 5.58943089431e-09 1.2 5.62118902439e-09 1.2 5.65294715447e-09 1.2 5.68470528455e-09 1.2 5.71646341463e-09 1.2 5.74822154472e-09 1.2 5.7799796748e-09 1.2 5.81173780488e-09 1.2 5.84349593496e-09 1.2 5.87525406504e-09 1.2 5.90701219512e-09 1.2 5.9387703252e-09 1.2 5.97052845528e-09 1.2 6.00228658537e-09 1.2 6.03404471545e-09 1.2 6.06580284553e-09 1.2 6.09756097561e-09 1.2 6.12931910569e-09 1.2 6.16107723577e-09 1.2 6.19283536585e-09 1.2 6.22459349593e-09 1.2 6.25635162602e-09 1.2 6.2881097561e-09 1.2 6.31986788618e-09 1.2 6.35162601626e-09 1.2 6.38338414634e-09 1.2 6.41514227642e-09 1.2 6.4469004065e-09 1.2 6.47865853659e-09 1.2 6.51041666667e-09 1.2 6.54217479675e-09 1.2 6.57393292683e-09 1.2 6.60569105691e-09 1.2 6.63744918699e-09 1.2 6.66920731707e-09 1.2 6.70096544715e-09 1.2 6.73272357724e-09 1.2 6.76448170732e-09 1.2 6.7962398374e-09 1.2 6.82799796748e-09 1.2 6.85975609756e-09 1.2 6.89151422764e-09 1.2 6.92327235772e-09 1.2 6.9550304878e-09 1.2 6.98678861789e-09 1.2 7.01854674797e-09 1.2 7.05030487805e-09 1.2 7.08206300813e-09 1.2 7.11382113821e-09 1.2 7.14557926829e-09 1.2 7.17733739837e-09 1.2 7.20909552846e-09 1.2 7.24085365854e-09 1.2 7.27261178862e-09 1.2 7.3043699187e-09 1.2 7.33612804878e-09 1.2 7.36788617886e-09 1.2 7.39964430894e-09 1.2 7.43140243902e-09 1.2 7.46316056911e-09 1.2 7.49491869919e-09 1.2 7.52667682927e-09 1.2 7.55843495935e-09 1.2 7.59019308943e-09 1.2 7.62195121951e-09 1.2 7.65370934959e-09 1.2 7.68546747967e-09 1.2 7.71722560976e-09 1.2 7.74898373984e-09 1.2 7.78074186992e-09 1.2 7.8125e-09 1.2 7.84425813008e-09 1.2 7.87601626016e-09 1.2 7.90777439024e-09 1.2 7.93953252033e-09 1.2 7.97129065041e-09 1.2 8.00304878049e-09 1.2 8.03480691057e-09 1.2 8.06656504065e-09 1.2 8.09832317073e-09 1.2 8.13008130081e-09 1.2 8.16183943089e-09 1.2 8.19359756098e-09 1.2 8.22535569106e-09 1.2 8.25711382114e-09 1.2 8.28887195122e-09 1.2 8.3206300813e-09 1.2 8.35238821138e-09 1.2 8.38414634146e-09 1.2 8.41590447154e-09 1.2 8.44766260163e-09 1.2 8.47942073171e-09 1.2 8.51117886179e-09 1.2 8.54293699187e-09 1.2 8.57469512195e-09 1.2 8.60645325203e-09 1.2 8.63821138211e-09 1.2 8.6699695122e-09 1.2 8.70172764228e-09 1.2 8.73348577236e-09 1.2 8.76524390244e-09 1.2 8.79700203252e-09 1.2 8.8287601626e-09 1.2 8.86051829268e-09 1.2 8.89227642276e-09 1.2 8.92403455285e-09 1.2 8.95579268293e-09 1.2 8.98755081301e-09 1.2 9.01930894309e-09 1.2 9.05106707317e-09 1.2 9.08282520325e-09 1.2 9.11458333333e-09 1.2 9.14634146341e-09 1.2 9.1780995935e-09 1.2 9.20985772358e-09 1.2 9.24161585366e-09 1.2 9.27337398374e-09 1.2 9.30513211382e-09 1.2 9.3368902439e-09 1.2 9.36864837398e-09 1.2 9.40040650407e-09 1.2 9.43216463415e-09 1.2 9.46392276423e-09 1.2 9.49568089431e-09 1.2 9.52743902439e-09 1.2 9.55919715447e-09 1.2 9.59095528455e-09 1.2 9.62271341463e-09 1.2 9.65447154472e-09 1.2 9.6862296748e-09 1.2 9.71798780488e-09 1.2 9.74974593496e-09 1.2 9.78150406504e-09 1.2 9.81326219512e-09 1.2 9.8450203252e-09 1.2 9.87677845528e-09 1.2 9.90853658537e-09 1.2 9.94029471545e-09 1.2 9.97205284553e-09 1.2 1.00038109756e-08 1.2 1.00355691057e-08 1.2 1.00673272358e-08 1.2 1.00990853659e-08 1.2 1.01308434959e-08 1.2 1.0162601626e-08 1.2 1.01943597561e-08 1.2 1.02261178862e-08 1.2 1.02578760163e-08 1.2 1.02896341463e-08 1.2 1.03213922764e-08 1.2 1.03531504065e-08 1.2 1.03849085366e-08 1.2 1.04166666667e-08 1.2 1.04484247967e-08 1.2 1.04801829268e-08 1.2 1.05119410569e-08 1.2 1.0543699187e-08 1.2 1.05754573171e-08 1.2 1.06072154472e-08 1.2 1.06389735772e-08 1.2 1.06707317073e-08 1.2 1.07024898374e-08 1.2 1.07342479675e-08 1.2 1.07660060976e-08 1.2 1.07977642276e-08 1.2 1.08295223577e-08 1.2 1.08612804878e-08 1.2 1.08930386179e-08 1.2 1.0924796748e-08 1.2 1.0956554878e-08 1.2 1.09883130081e-08 1.2 1.10200711382e-08 1.2 1.10518292683e-08 1.2 1.10835873984e-08 1.2 1.11153455285e-08 1.2 1.11471036585e-08 1.2 1.11788617886e-08 1.2 1.12106199187e-08 1.2 1.12423780488e-08 1.2 1.12741361789e-08 1.2 1.13058943089e-08 1.2 1.1337652439e-08 1.2 1.13694105691e-08 1.2 1.14011686992e-08 1.2 1.14329268293e-08 1.2 1.14646849593e-08 1.2 1.14964430894e-08 1.2 1.15282012195e-08 1.2 1.15599593496e-08 1.2 1.15917174797e-08 1.2 1.16234756098e-08 1.2 1.16552337398e-08 1.2 1.16869918699e-08 1.2 1.171875e-08 1.2 1.17505081301e-08 1.2 1.17822662602e-08 1.2 1.18140243902e-08 1.2 1.18457825203e-08 1.2 1.18775406504e-08 1.2 1.19092987805e-08 1.2 1.19410569106e-08 1.2 1.19728150407e-08 1.2 1.20045731707e-08 1.2 1.20363313008e-08 1.2 1.20680894309e-08 1.2 1.2099847561e-08 1.2 1.21316056911e-08 1.2 1.21633638211e-08 1.2 1.21951219512e-08 1.2 1.22268800813e-08 1.2 1.22586382114e-08 1.2 1.22903963415e-08 1.2 1.23221544715e-08 1.2 1.23539126016e-08 1.2 1.23856707317e-08 1.2 1.24174288618e-08 1.2 1.24491869919e-08 1.2 1.2480945122e-08 1.2 1.2512703252e-08 1.2 1.25444613821e-08 1.2 1.25762195122e-08 1.2 1.26079776423e-08 1.2 1.26397357724e-08 1.2 1.26714939024e-08 1.2 1.27032520325e-08 1.2 1.27350101626e-08 1.2 1.27667682927e-08 1.2 1.27985264228e-08 1.2 1.28302845528e-08 1.2 1.28620426829e-08 1.2 1.2893800813e-08 1.2 1.29255589431e-08 1.2 1.29573170732e-08 1.2 1.29890752033e-08 1.2 1.30208333333e-08 1.2 1.30525914634e-08 1.2 1.30843495935e-08 1.2 1.31161077236e-08 1.2 1.31478658537e-08 1.2 1.31796239837e-08 1.2 1.32113821138e-08 1.2 1.32431402439e-08 1.2 1.3274898374e-08 1.2 1.33066565041e-08 1.2 1.33384146341e-08 1.2 1.33701727642e-08 1.2 1.34019308943e-08 1.2 1.34336890244e-08 1.2 1.34654471545e-08 1.2 1.34972052846e-08 1.2 1.35289634146e-08 1.2 1.35607215447e-08 1.2 1.35924796748e-08 1.2 1.36242378049e-08 1.2 1.3655995935e-08 1.2 1.3687754065e-08 1.2 1.37195121951e-08 1.2 1.37512703252e-08 1.2 1.37830284553e-08 1.2 1.38147865854e-08 1.2 1.38465447154e-08 1.2 1.38783028455e-08 1.2 1.39100609756e-08 1.2 1.39418191057e-08 1.2 1.39735772358e-08 1.2 1.40053353659e-08 1.2 1.40370934959e-08 1.2 1.4068851626e-08 1.2 1.41006097561e-08 1.2 1.41323678862e-08 1.2 1.41641260163e-08 1.2 1.41958841463e-08 1.2 1.42276422764e-08 1.2 1.42594004065e-08 1.2 1.42911585366e-08 1.2 1.43229166667e-08 1.2 1.43546747967e-08 1.2 1.43864329268e-08 1.2 1.44181910569e-08 1.2 1.4449949187e-08 1.2 1.44817073171e-08 1.2 1.45134654472e-08 1.2 1.45452235772e-08 1.2 1.45769817073e-08 1.2 1.46087398374e-08 1.2 1.46404979675e-08 1.2 1.46722560976e-08 1.2 1.47040142276e-08 1.2 1.47357723577e-08 1.2 1.47675304878e-08 1.2 1.47992886179e-08 1.2 1.4831046748e-08 1.2 1.4862804878e-08 1.2 1.48945630081e-08 1.2 1.49263211382e-08 1.2 1.49580792683e-08 1.2 1.49898373984e-08 1.2 1.50215955285e-08 1.2 1.50533536585e-08 1.2 1.50851117886e-08 1.2 1.51168699187e-08 1.2 1.51486280488e-08 1.2 1.51803861789e-08 1.2 1.52121443089e-08 1.2 1.5243902439e-08 1.2 1.52756605691e-08 1.2 1.53074186992e-08 1.2 1.53391768293e-08 1.2 1.53709349593e-08 1.2 1.54026930894e-08 1.2 1.54344512195e-08 1.2 1.54662093496e-08 1.2 1.54979674797e-08 1.2 1.55297256098e-08 1.2 1.55614837398e-08 1.2 1.55932418699e-08 1.2 1.5625e-08 1.2 1.56567581301e-08 1.2 1.56885162602e-08 1.2 1.57202743902e-08 1.2 1.57520325203e-08 1.2 1.57837906504e-08 1.2 1.58155487805e-08 1.2 1.58473069106e-08 1.2 1.58790650407e-08 1.2 1.59108231707e-08 1.2 1.59425813008e-08 1.2 1.59743394309e-08 1.2 1.6006097561e-08 1.2 1.60378556911e-08 1.2 1.60696138211e-08 1.2 1.61013719512e-08 1.2 1.61331300813e-08 1.2 1.61648882114e-08 1.2 1.61966463415e-08 1.2 1.62284044715e-08 1.2 1.62601626016e-08 1.2 1.62919207317e-08 1.2 1.63236788618e-08 1.2 1.63554369919e-08 1.2 1.6387195122e-08 1.2 1.6418953252e-08 1.2 1.64507113821e-08 1.2 1.64824695122e-08 1.2 1.65142276423e-08 1.2 1.65459857724e-08 1.2 1.65777439024e-08 1.2 1.66095020325e-08 1.2 1.66412601626e-08 1.2 1.66730182927e-08 1.2 1.67047764228e-08 1.2 1.67365345528e-08 1.2 1.67682926829e-08 1.2 1.6800050813e-08 1.2 1.68318089431e-08 1.2 1.68635670732e-08 1.2 1.68953252033e-08 1.2 1.69270833333e-08 1.2 1.69588414634e-08 1.2 1.69905995935e-08 1.2 1.70223577236e-08 1.2 1.70541158537e-08 1.2 1.70858739837e-08 1.2 1.71176321138e-08 1.2 1.71493902439e-08 1.2 1.7181148374e-08 1.2 1.72129065041e-08 1.2 1.72446646341e-08 1.2 1.72764227642e-08 1.2 1.73081808943e-08 1.2 1.73399390244e-08 1.2 1.73716971545e-08 1.2 1.74034552846e-08 1.2 1.74352134146e-08 1.2 1.74669715447e-08 1.2 1.74987296748e-08 1.2 1.75304878049e-08 1.2 1.7562245935e-08 1.2 1.7594004065e-08 1.2 1.76257621951e-08 1.2 1.76575203252e-08 1.2 1.76892784553e-08 1.2 1.77210365854e-08 1.2 1.77527947154e-08 1.2 1.77845528455e-08 1.2 1.78163109756e-08 1.2 1.78480691057e-08 1.2 1.78798272358e-08 1.2 1.79115853659e-08 1.2 1.79433434959e-08 1.2 1.7975101626e-08 1.2 1.80068597561e-08 1.2 1.80386178862e-08 1.2 1.80703760163e-08 1.2 1.81021341463e-08 1.2 1.81338922764e-08 1.2 1.81656504065e-08 1.2 1.81974085366e-08 1.2 1.82291666667e-08 1.2 1.82609247967e-08 1.2 1.82926829268e-08 1.2 1.83244410569e-08 1.2 1.8356199187e-08 1.2 1.83879573171e-08 1.2 1.84197154472e-08 1.2 1.84514735772e-08 1.2 1.84832317073e-08 1.2 1.85149898374e-08 1.2 1.85467479675e-08 1.2 1.85785060976e-08 1.2 1.86102642276e-08 1.2 1.86420223577e-08 1.2 1.86737804878e-08 1.2 1.87055386179e-08 1.2 1.8737296748e-08 1.2 1.8769054878e-08 1.2 1.88008130081e-08 1.2 1.88325711382e-08 1.2 1.88643292683e-08 1.2 1.88960873984e-08 1.2 1.89278455285e-08 1.2 1.89596036585e-08 1.2 1.89913617886e-08 1.2 1.90231199187e-08 1.2 1.90548780488e-08 1.2 1.90866361789e-08 1.2 1.91183943089e-08 1.2 1.9150152439e-08 1.2 1.91819105691e-08 1.2 1.92136686992e-08 1.2 1.92454268293e-08 1.2 1.92771849593e-08 1.2 1.93089430894e-08 1.2 1.93407012195e-08 1.2 1.93724593496e-08 1.2 1.94042174797e-08 1.2 1.94359756098e-08 1.2 1.94677337398e-08 1.2 1.94994918699e-08 1.2 1.953125e-08 1.2 1.95630081301e-08 1.2 1.95947662602e-08 1.2 1.96265243902e-08 1.2 1.96582825203e-08 1.2 1.96900406504e-08 1.2 1.97217987805e-08 1.2 1.97535569106e-08 1.2 1.97853150407e-08 1.2 1.98170731707e-08 1.2 1.98488313008e-08 1.2 1.98805894309e-08 1.2 1.9912347561e-08 1.2 1.99441056911e-08 1.2 1.99758638211e-08 1.2 2.00076219512e-08 1.2 2.00393800813e-08 1.2 2.00711382114e-08 1.2 2.01028963415e-08 1.2 2.01346544715e-08 1.2 2.01664126016e-08 1.2 2.01981707317e-08 1.2 2.02299288618e-08 1.2 2.02616869919e-08 1.2 2.0293445122e-08 1.2 2.0325203252e-08 1.2 2.03569613821e-08 1.2 2.03887195122e-08 1.2 2.04204776423e-08 1.2 2.04522357724e-08 1.2 2.04839939024e-08 1.2 2.05157520325e-08 1.2 2.05475101626e-08 1.2 2.05792682927e-08 1.2 2.06110264228e-08 1.2 2.06427845528e-08 1.2 2.06745426829e-08 1.2 2.0706300813e-08 1.2 2.07380589431e-08 1.2 2.07698170732e-08 1.2 2.08015752033e-08 1.2 2.08333333333e-08 1.2 2.08650914634e-08 1.2 2.08968495935e-08 1.2 2.09286077236e-08 1.2 2.09603658537e-08 1.2 2.09921239837e-08 1.2 2.10238821138e-08 1.2 2.10556402439e-08 1.2 2.1087398374e-08 1.2 2.11191565041e-08 1.2 2.11509146341e-08 1.2 2.11826727642e-08 1.2 2.12144308943e-08 1.2 2.12461890244e-08 1.2 2.12779471545e-08 1.2 2.13097052846e-08 1.2 2.13414634146e-08 1.2 2.13732215447e-08 1.2 2.14049796748e-08 1.2 2.14367378049e-08 1.2 2.1468495935e-08 1.2 2.1500254065e-08 1.2 2.15320121951e-08 1.2 2.15637703252e-08 1.2 2.15955284553e-08 1.2 2.16272865854e-08 1.2 2.16590447154e-08 1.2 2.16908028455e-08 1.2 2.17225609756e-08 1.2 2.17543191057e-08 1.2 2.17860772358e-08 1.2 2.18178353659e-08 1.2 2.18495934959e-08 1.2 2.1881351626e-08 1.2 2.19131097561e-08 1.2 2.19448678862e-08 1.2 2.19766260163e-08 1.2 2.20083841463e-08 1.2 2.20401422764e-08 1.2 2.20719004065e-08 1.2 2.21036585366e-08 1.2 2.21354166667e-08 1.2 2.21671747967e-08 1.2 2.21989329268e-08 1.2 2.22306910569e-08 1.2 2.2262449187e-08 1.2 2.22942073171e-08 1.2 2.23259654472e-08 1.2 2.23577235772e-08 1.2 2.23894817073e-08 1.2 2.24212398374e-08 1.2 2.24529979675e-08 1.2 2.24847560976e-08 1.2 2.25165142276e-08 1.2 2.25482723577e-08 1.2 2.25800304878e-08 1.2 2.26117886179e-08 1.2 2.2643546748e-08 1.2 2.2675304878e-08 1.2 2.27070630081e-08 1.2 2.27388211382e-08 1.2 2.27705792683e-08 1.2 2.28023373984e-08 1.2 2.28340955285e-08 1.2 2.28658536585e-08 1.2 2.28976117886e-08 1.2 2.29293699187e-08 1.2 2.29611280488e-08 1.2 2.29928861789e-08 1.2 2.30246443089e-08 1.2 2.3056402439e-08 1.2 2.30881605691e-08 1.2 2.31199186992e-08 1.2 2.31516768293e-08 1.2 2.31834349593e-08 1.2 2.32151930894e-08 1.2 2.32469512195e-08 1.2 2.32787093496e-08 1.2 2.33104674797e-08 1.2 2.33422256098e-08 1.2 2.33739837398e-08 1.2 2.34057418699e-08 1.2 2.34375e-08 1.2 2.34692581301e-08 1.2 2.35010162602e-08 1.2 2.35327743902e-08 1.2 2.35645325203e-08 1.2 2.35962906504e-08 1.2 2.36280487805e-08 1.2 2.36598069106e-08 1.2 2.36915650407e-08 1.2 2.37233231707e-08 1.2 2.37550813008e-08 1.2 2.37868394309e-08 1.2 2.3818597561e-08 1.2 2.38503556911e-08 1.2 2.38821138211e-08 1.2 2.39138719512e-08 1.2 2.39456300813e-08 1.2 2.39773882114e-08 1.2 2.40091463415e-08 1.2 2.40409044715e-08 1.2 2.40726626016e-08 1.2 2.41044207317e-08 1.2 2.41361788618e-08 1.2 2.41679369919e-08 1.2 2.4199695122e-08 1.2 2.4231453252e-08 1.2 2.42632113821e-08 1.2 2.42949695122e-08 1.2 2.43267276423e-08 1.2 2.43584857724e-08 1.2 2.43902439024e-08 1.2 2.44220020325e-08 1.2 2.44537601626e-08 1.2 2.44855182927e-08 1.2 2.45172764228e-08 1.2 2.45490345528e-08 1.2 2.45807926829e-08 1.2 2.4612550813e-08 1.2 2.46443089431e-08 1.2 2.46760670732e-08 1.2 2.47078252033e-08 1.2 2.47395833333e-08 1.2 2.47713414634e-08 1.2 2.48030995935e-08 1.2 2.48348577236e-08 1.2 2.48666158537e-08 1.2 2.48983739837e-08 1.2 2.49301321138e-08 1.2 2.49618902439e-08 1.2 2.4993648374e-08 1.2 2.50254065041e-08 1.2 2.50571646341e-08 1.2 2.50889227642e-08 1.2 2.51206808943e-08 1.2 2.51524390244e-08 1.2 2.51841971545e-08 1.2 2.52159552846e-08 1.2 2.52477134146e-08 1.2 2.52794715447e-08 1.2 2.53112296748e-08 1.2 2.53429878049e-08 1.2 2.5374745935e-08 1.2 2.5406504065e-08 1.2 2.54382621951e-08 1.2 2.54700203252e-08 1.2 2.55017784553e-08 1.2 2.55335365854e-08 1.2 2.55652947154e-08 1.2 2.55970528455e-08 1.2 2.56288109756e-08 1.2 2.56605691057e-08 1.2 2.56923272358e-08 1.2 2.57240853659e-08 1.2 2.57558434959e-08 1.2 2.5787601626e-08 1.2 2.58193597561e-08 1.2 2.58511178862e-08 1.2 2.58828760163e-08 1.2 2.59146341463e-08 1.2 2.59463922764e-08 1.2 2.59781504065e-08 1.2 2.60099085366e-08 1.2 2.60416666667e-08 1.2 2.60734247967e-08 1.2 2.61051829268e-08 1.2 2.61369410569e-08 1.2 2.6168699187e-08 1.2 2.62004573171e-08 1.2 2.62322154472e-08 1.2 2.62639735772e-08 1.2 2.62957317073e-08 1.2 2.63274898374e-08 1.2 2.63592479675e-08 1.2 2.63910060976e-08 1.2 2.64227642276e-08 1.2 2.64545223577e-08 1.2 2.64862804878e-08 1.2 2.65180386179e-08 1.2 2.6549796748e-08 1.2 2.6581554878e-08 1.2 2.66133130081e-08 1.2 2.66450711382e-08 1.2 2.66768292683e-08 1.2 2.67085873984e-08 1.2 2.67403455285e-08 1.2 2.67721036585e-08 1.2 2.68038617886e-08 1.2 2.68356199187e-08 1.2 2.68673780488e-08 1.2 2.68991361789e-08 1.2 2.69308943089e-08 1.2 2.6962652439e-08 1.2 2.69944105691e-08 1.2 2.70261686992e-08 1.2 2.70579268293e-08 1.2 2.70896849593e-08 1.2 2.71214430894e-08 1.2 2.71532012195e-08 1.2 2.71849593496e-08 1.2 2.72167174797e-08 1.2 2.72484756098e-08 1.2 2.72802337398e-08 1.2 2.73119918699e-08 1.2 2.734375e-08 1.2 2.73755081301e-08 1.2 2.74072662602e-08 1.2 2.74390243902e-08 1.2 2.74707825203e-08 1.2 2.75025406504e-08 1.2 2.75342987805e-08 1.2 2.75660569106e-08 1.2 2.75978150407e-08 1.2 2.76295731707e-08 1.2 2.76613313008e-08 1.2 2.76930894309e-08 1.2 2.7724847561e-08 1.2 2.77566056911e-08 1.2 2.77883638211e-08 1.2 2.78201219512e-08 1.2 2.78518800813e-08 1.2 2.78836382114e-08 1.2 2.79153963415e-08 1.2 2.79471544715e-08 1.2 2.79789126016e-08 1.2 2.80106707317e-08 1.2 2.80424288618e-08 1.2 2.80741869919e-08 1.2 2.8105945122e-08 1.2 2.8137703252e-08 1.2 2.81694613821e-08 1.2 2.82012195122e-08 1.2 2.82329776423e-08 1.2 2.82647357724e-08 1.2 2.82964939024e-08 1.2 2.83282520325e-08 1.2 2.83600101626e-08 1.2 2.83917682927e-08 1.2 2.84235264228e-08 1.2 2.84552845528e-08 1.2 2.84870426829e-08 1.2 2.8518800813e-08 1.2 2.85505589431e-08 1.2 2.85823170732e-08 1.2 2.86140752033e-08 1.2 2.86458333333e-08 1.2 2.86775914634e-08 1.2 2.87093495935e-08 1.2 2.87411077236e-08 1.2 2.87728658537e-08 1.2 2.88046239837e-08 1.2 2.88363821138e-08 1.2 2.88681402439e-08 1.2 2.8899898374e-08 1.2 2.89316565041e-08 1.2 2.89634146341e-08 1.2 2.89951727642e-08 1.2 2.90269308943e-08 1.2 2.90586890244e-08 1.2 2.90904471545e-08 1.2 2.91222052846e-08 1.2 2.91539634146e-08 1.2 2.91857215447e-08 1.2 2.92174796748e-08 1.2 2.92492378049e-08 1.2 2.9280995935e-08 1.2 2.9312754065e-08 1.2 2.93445121951e-08 1.2 2.93762703252e-08 1.2 2.94080284553e-08 1.2 2.94397865854e-08 1.2 2.94715447154e-08 1.2 2.95033028455e-08 1.2 2.95350609756e-08 1.2 2.95668191057e-08 1.2 2.95985772358e-08 1.2 2.96303353659e-08 1.2 2.96620934959e-08 1.2 2.9693851626e-08 1.2 2.97256097561e-08 1.2 2.97573678862e-08 1.2 2.97891260163e-08 1.2 2.98208841463e-08 1.2 2.98526422764e-08 1.2 2.98844004065e-08 1.2 2.99161585366e-08 1.2 2.99479166667e-08 1.2 2.99796747967e-08 1.2 3.00114329268e-08 1.2 3.00431910569e-08 1.2 3.0074949187e-08 1.2 3.01067073171e-08 1.2 3.01384654472e-08 1.2 3.01702235772e-08 1.2 3.02019817073e-08 1.2 3.02337398374e-08 1.2 3.02654979675e-08 1.2 3.02972560976e-08 1.2 3.03290142276e-08 1.2 3.03607723577e-08 1.2 3.03925304878e-08 1.2 3.04242886179e-08 1.2 3.0456046748e-08 1.2 3.0487804878e-08 1.2 3.05195630081e-08 1.2 3.05513211382e-08 1.2 3.05830792683e-08 1.2 3.06148373984e-08 1.2 3.06465955285e-08 1.2 3.06783536585e-08 1.2 3.07101117886e-08 1.2 3.07418699187e-08 1.2 3.07736280488e-08 1.2 3.08053861789e-08 1.2 3.08371443089e-08 1.2 3.0868902439e-08 1.2 3.09006605691e-08 1.2 3.09324186992e-08 1.2 3.09641768293e-08 1.2 3.09959349593e-08 1.2 3.10276930894e-08 1.2 3.10594512195e-08 1.2 3.10912093496e-08 1.2 3.11229674797e-08 1.2 3.11547256098e-08 1.2 3.11864837398e-08 1.2 3.12182418699e-08 1.2 3.125e-08 1.2 3.12817581301e-08 1.2 3.13135162602e-08 1.2 3.13452743902e-08 1.2 3.13770325203e-08 1.2 3.14087906504e-08 1.2 3.14405487805e-08 1.2 3.14723069106e-08 1.2 3.15040650407e-08 1.2 3.15358231707e-08 1.2 3.15675813008e-08 1.2 3.15993394309e-08 1.2 3.1631097561e-08 1.2 3.16628556911e-08 1.2 3.16946138211e-08 1.2 3.17263719512e-08 1.2 3.17581300813e-08 1.2 3.17898882114e-08 1.2 3.18216463415e-08 1.2 3.18534044715e-08 1.2 3.18851626016e-08 1.2 3.19169207317e-08 1.2 3.19486788618e-08 1.2 3.19804369919e-08 1.2 3.2012195122e-08 1.2 3.2043953252e-08 1.2 3.20757113821e-08 1.2 3.21074695122e-08 1.2 3.21392276423e-08 1.2 3.21709857724e-08 1.2 3.22027439024e-08 1.2 3.22345020325e-08 1.2 3.22662601626e-08 1.2 3.22980182927e-08 1.2 3.23297764228e-08 1.2 3.23615345528e-08 1.2 3.23932926829e-08 1.2 3.2425050813e-08 1.2 3.24568089431e-08 1.2 3.24885670732e-08 1.2 3.25203252033e-08 1.2 3.25520833333e-08 1.2 3.25838414634e-08 1.2 3.26155995935e-08 1.2 3.26473577236e-08 1.2 3.26791158537e-08 1.2 3.27108739837e-08 1.2 3.27426321138e-08 1.2 3.27743902439e-08 1.2 3.2806148374e-08 1.2 3.28379065041e-08 1.2 3.28696646341e-08 1.2 3.29014227642e-08 1.2 3.29331808943e-08 1.2 3.29649390244e-08 1.2 3.29966971545e-08 1.2 3.30284552846e-08 1.2 3.30602134146e-08 1.2 3.30919715447e-08 1.2 3.31237296748e-08 1.2 3.31554878049e-08 1.2 3.3187245935e-08 1.2 3.3219004065e-08 1.2 3.32507621951e-08 1.2 3.32825203252e-08 1.2 3.33142784553e-08 1.2 3.33460365854e-08 1.2 3.33777947154e-08 1.2 3.34095528455e-08 1.2 3.34413109756e-08 1.2 3.34730691057e-08 1.2 3.35048272358e-08 1.2 3.35365853659e-08 1.2 3.35683434959e-08 1.2 3.3600101626e-08 1.2 3.36318597561e-08 1.2 3.36636178862e-08 1.2 3.36953760163e-08 1.2 3.37271341463e-08 1.2 3.37588922764e-08 1.2 3.37906504065e-08 1.2 3.38224085366e-08 1.2 3.38541666667e-08 1.2 3.38859247967e-08 1.2 3.39176829268e-08 1.2 3.39494410569e-08 1.2 3.3981199187e-08 1.2 3.40129573171e-08 1.2 3.40447154472e-08 1.2 3.40764735772e-08 1.2 3.41082317073e-08 1.2 3.41399898374e-08 1.2 3.41717479675e-08 1.2 3.42035060976e-08 1.2 3.42352642276e-08 1.2 3.42670223577e-08 1.2 3.42987804878e-08 1.2 3.43305386179e-08 1.2 3.4362296748e-08 1.2 3.4394054878e-08 1.2 3.44258130081e-08 1.2 3.44575711382e-08 1.2 3.44893292683e-08 1.2 3.45210873984e-08 1.2 3.45528455285e-08 1.2 3.45846036585e-08 1.2 3.46163617886e-08 1.2 3.46481199187e-08 1.2 3.46798780488e-08 1.2 3.47116361789e-08 1.2 3.47433943089e-08 1.2 3.4775152439e-08 1.2 3.48069105691e-08 1.2 3.48386686992e-08 1.2 3.48704268293e-08 1.2 3.49021849593e-08 1.2 3.49339430894e-08 1.2 3.49657012195e-08 1.2 3.49974593496e-08 1.2 3.50292174797e-08 1.2 3.50609756098e-08 1.2 3.50927337398e-08 1.2 3.51244918699e-08 1.2 3.515625e-08 1.2 3.51880081301e-08 1.2 3.52197662602e-08 1.2 3.52515243902e-08 1.2 3.52832825203e-08 1.2 3.53150406504e-08 1.2 3.53467987805e-08 1.2 3.53785569106e-08 1.2 3.54103150407e-08 1.2 3.54420731707e-08 1.2 3.54738313008e-08 1.2 3.55055894309e-08 1.2 3.5537347561e-08 1.2 3.55691056911e-08 1.2 3.56008638211e-08 1.2 3.56326219512e-08 1.2 3.56643800813e-08 1.2 3.56961382114e-08 1.2 3.57278963415e-08 1.2 3.57596544715e-08 1.2 3.57914126016e-08 1.2 3.58231707317e-08 1.2 3.58549288618e-08 1.2 3.58866869919e-08 1.2 3.5918445122e-08 1.2 3.5950203252e-08 1.2 3.59819613821e-08 1.2 3.60137195122e-08 1.2 3.60454776423e-08 1.2 3.60772357724e-08 1.2 3.61089939024e-08 1.2 3.61407520325e-08 1.2 3.61725101626e-08 1.2 3.62042682927e-08 1.2 3.62360264228e-08 1.2 3.62677845528e-08 1.2 3.62995426829e-08 1.2 3.6331300813e-08 1.2 3.63630589431e-08 1.2 3.63948170732e-08 1.2 3.64265752033e-08 1.2 3.64583333333e-08 1.2 3.64900914634e-08 1.2 3.65218495935e-08 1.2 3.65536077236e-08 1.2 3.65853658537e-08 1.2 3.66171239837e-08 1.2 3.66488821138e-08 1.2 3.66806402439e-08 1.2 3.6712398374e-08 1.2 3.67441565041e-08 1.2 3.67759146341e-08 1.2 3.68076727642e-08 1.2 3.68394308943e-08 1.2 3.68711890244e-08 1.2 3.69029471545e-08 1.2 3.69347052846e-08 1.2 3.69664634146e-08 1.2 3.69982215447e-08 1.2 3.70299796748e-08 1.2 3.70617378049e-08 1.2 3.7093495935e-08 1.2 3.7125254065e-08 1.2 3.71570121951e-08 1.2 3.71887703252e-08 1.2 3.72205284553e-08 1.2 3.72522865854e-08 1.2 3.72840447154e-08 1.2 3.73158028455e-08 1.2 3.73475609756e-08 1.2 3.73793191057e-08 1.2 3.74110772358e-08 1.2 3.74428353659e-08 1.2 3.74745934959e-08 1.2 3.7506351626e-08 1.2 3.75381097561e-08 1.2 3.75698678862e-08 1.2 3.76016260163e-08 1.2 3.76333841463e-08 1.2 3.76651422764e-08 1.2 3.76969004065e-08 1.2 3.77286585366e-08 1.2 3.77604166667e-08 1.2 3.77921747967e-08 1.2 3.78239329268e-08 1.2 3.78556910569e-08 1.2 3.7887449187e-08 1.2 3.79192073171e-08 1.2 3.79509654472e-08 1.2 3.79827235772e-08 1.2 3.80144817073e-08 1.2 3.80462398374e-08 1.2 3.80779979675e-08 1.2 3.81097560976e-08 1.2 3.81415142276e-08 1.2 3.81732723577e-08 1.2 3.82050304878e-08 1.2 3.82367886179e-08 1.2 3.8268546748e-08 1.2 3.8300304878e-08 1.2 3.83320630081e-08 1.2 3.83638211382e-08 1.2 3.83955792683e-08 1.2 3.84273373984e-08 1.2 3.84590955285e-08 1.2 3.84908536585e-08 1.2 3.85226117886e-08 1.2 3.85543699187e-08 1.2 3.85861280488e-08 1.2 3.86178861789e-08 1.2 3.86496443089e-08 1.2 3.8681402439e-08 1.2 3.87131605691e-08 1.2 3.87449186992e-08 1.2 3.87766768293e-08 1.2 3.88084349593e-08 1.2 3.88401930894e-08 1.2 3.88719512195e-08 1.2 3.89037093496e-08 1.2 3.89354674797e-08 1.2 3.89672256098e-08 1.2 3.89989837398e-08 1.2 3.90307418699e-08 1.2 3.90625e-08 1.2 3.90942581301e-08 1.2 3.91260162602e-08 1.2 3.91577743902e-08 1.2 3.91895325203e-08 1.2 3.92212906504e-08 1.2 3.92530487805e-08 1.2 3.92848069106e-08 1.2 3.93165650407e-08 1.2 3.93483231707e-08 1.2 3.93800813008e-08 1.2 3.94118394309e-08 1.2 3.9443597561e-08 1.2 3.94753556911e-08 1.2 3.95071138211e-08 1.2 3.95388719512e-08 1.2 3.95706300813e-08 1.2 3.96023882114e-08 1.2 3.96341463415e-08 1.2 3.96659044715e-08 1.2 3.96976626016e-08 1.2 3.97294207317e-08 1.2 3.97611788618e-08 1.2 3.97929369919e-08 1.2 3.9824695122e-08 1.2 3.9856453252e-08 1.2 3.98882113821e-08 1.2 3.99199695122e-08 1.2 3.99517276423e-08 1.2 3.99834857724e-08 1.2 4.00152439024e-08 1.2 4.00470020325e-08 1.2 4.00787601626e-08 1.2 4.01105182927e-08 1.2 4.01422764228e-08 1.2 4.01740345528e-08 1.2 4.02057926829e-08 1.2 4.0237550813e-08 1.2 4.02693089431e-08 1.2 4.03010670732e-08 1.2 4.03328252033e-08 1.2 4.03645833333e-08 1.2 4.03963414634e-08 1.2 4.04280995935e-08 1.2 4.04598577236e-08 1.2 4.04916158537e-08 1.2 4.05233739837e-08 1.2 4.05551321138e-08 1.2 4.05868902439e-08 1.2 4.0618648374e-08 1.2 4.06504065041e-08 1.2 4.06821646341e-08 1.2 4.07139227642e-08 1.2 4.07456808943e-08 1.2 4.07774390244e-08 1.2 4.08091971545e-08 1.2 4.08409552846e-08 1.2 4.08727134146e-08 1.2 4.09044715447e-08 1.2 4.09362296748e-08 1.2 4.09679878049e-08 1.2 4.0999745935e-08 1.2 4.1031504065e-08 1.2 4.10632621951e-08 1.2 4.10950203252e-08 1.2 4.11267784553e-08 1.2 4.11585365854e-08 1.2 4.11902947154e-08 1.2 4.12220528455e-08 1.2 4.12538109756e-08 1.2 4.12855691057e-08 1.2 4.13173272358e-08 1.2 4.13490853659e-08 1.2 4.13808434959e-08 1.2 4.1412601626e-08 1.2 4.14443597561e-08 1.2 4.14761178862e-08 1.2 4.15078760163e-08 1.2 4.15396341463e-08 1.2 4.15713922764e-08 1.2 4.16031504065e-08 1.2 4.16349085366e-08 1.2 4.16666666667e-08 1.2 4.16984247967e-08 1.2 4.17301829268e-08 1.2 4.17619410569e-08 1.2 4.1793699187e-08 1.2 4.18254573171e-08 1.2 4.18572154472e-08 1.2 4.18889735772e-08 1.2 4.19207317073e-08 1.2 4.19524898374e-08 1.2 4.19842479675e-08 1.2 4.20160060976e-08 1.2 4.20477642276e-08 1.2 4.20795223577e-08 1.2 4.21112804878e-08 1.2 4.21430386179e-08 1.2 4.2174796748e-08 1.2 4.2206554878e-08 1.2 4.22383130081e-08 1.2 4.22700711382e-08 1.2 4.23018292683e-08 1.2 4.23335873984e-08 1.2 4.23653455285e-08 1.2 4.23971036585e-08 1.2 4.24288617886e-08 1.2 4.24606199187e-08 1.2 4.24923780488e-08 1.2 4.25241361789e-08 1.2 4.25558943089e-08 1.2 4.2587652439e-08 1.2 4.26194105691e-08 1.2 4.26511686992e-08 1.2 4.26829268293e-08 1.2 4.27146849593e-08 1.2 4.27464430894e-08 1.2 4.27782012195e-08 1.2 4.28099593496e-08 1.2 4.28417174797e-08 1.2 4.28734756098e-08 1.2 4.29052337398e-08 1.2 4.29369918699e-08 1.2 4.296875e-08 1.2 4.30005081301e-08 1.2 4.30322662602e-08 1.2 4.30640243902e-08 1.2 4.30957825203e-08 1.2 4.31275406504e-08 1.2 4.31592987805e-08 1.2 4.31910569106e-08 1.2 4.32228150407e-08 1.2 4.32545731707e-08 1.2 4.32863313008e-08 1.2 4.33180894309e-08 1.2 4.3349847561e-08 1.2 4.33816056911e-08 1.2 4.34133638211e-08 1.2 4.34451219512e-08 1.2 4.34768800813e-08 1.2 4.35086382114e-08 1.2 4.35403963415e-08 1.2 4.35721544715e-08 1.2 4.36039126016e-08 1.2 4.36356707317e-08 1.2 4.36674288618e-08 1.2 4.36991869919e-08 1.2 4.3730945122e-08 1.2 4.3762703252e-08 1.2 4.37944613821e-08 1.2 4.38262195122e-08 1.2 4.38579776423e-08 1.2 4.38897357724e-08 1.2 4.39214939024e-08 1.2 4.39532520325e-08 1.2 4.39850101626e-08 1.2 4.40167682927e-08 1.2 4.40485264228e-08 1.2 4.40802845528e-08 1.2 4.41120426829e-08 1.2 4.4143800813e-08 1.2 4.41755589431e-08 1.2 4.42073170732e-08 1.2 4.42390752033e-08 1.2 4.42708333333e-08 1.2 4.43025914634e-08 1.2 4.43343495935e-08 1.2 4.43661077236e-08 1.2 4.43978658537e-08 1.2 4.44296239837e-08 1.2 4.44613821138e-08 1.2 4.44931402439e-08 1.2 4.4524898374e-08 1.2 4.45566565041e-08 1.2 4.45884146341e-08 1.2 4.46201727642e-08 1.2 4.46519308943e-08 1.2 4.46836890244e-08 1.2 4.47154471545e-08 1.2 4.47472052846e-08 1.2 4.47789634146e-08 1.2 4.48107215447e-08 1.2 4.48424796748e-08 1.2 4.48742378049e-08 1.2 4.4905995935e-08 1.2 4.4937754065e-08 1.2 4.49695121951e-08 1.2 4.50012703252e-08 1.2 4.50330284553e-08 1.2 4.50647865854e-08 1.2 4.50965447154e-08 1.2 4.51283028455e-08 1.2 4.51600609756e-08 1.2 4.51918191057e-08 1.2 4.52235772358e-08 1.2 4.52553353659e-08 1.2 4.52870934959e-08 1.2 4.5318851626e-08 1.2 4.53506097561e-08 1.2 4.53823678862e-08 1.2 4.54141260163e-08 1.2 4.54458841463e-08 1.2 4.54776422764e-08 1.2 4.55094004065e-08 1.2 4.55411585366e-08 1.2 4.55729166667e-08 1.2 4.56046747967e-08 1.2 4.56364329268e-08 1.2 4.56681910569e-08 1.2 4.5699949187e-08 1.2 4.57317073171e-08 1.2 4.57634654472e-08 1.2 4.57952235772e-08 1.2 4.58269817073e-08 1.2 4.58587398374e-08 1.2 4.58904979675e-08 1.2 4.59222560976e-08 1.2 4.59540142276e-08 1.2 4.59857723577e-08 1.2 4.60175304878e-08 1.2 4.60492886179e-08 1.2 4.6081046748e-08 1.2 4.6112804878e-08 1.2 4.61445630081e-08 1.2 4.61763211382e-08 1.2 4.62080792683e-08 1.2 4.62398373984e-08 1.2 4.62715955285e-08 1.2 4.63033536585e-08 1.2 4.63351117886e-08 1.2 4.63668699187e-08 1.2 4.63986280488e-08 1.2 4.64303861789e-08 1.2 4.64621443089e-08 1.2 4.6493902439e-08 1.2 4.65256605691e-08 1.2 4.65574186992e-08 1.2 4.65891768293e-08 1.2 4.66209349593e-08 1.2 4.66526930894e-08 1.2 4.66844512195e-08 1.2 4.67162093496e-08 1.2 4.67479674797e-08 1.2 4.67797256098e-08 1.2 4.68114837398e-08 1.2 4.68432418699e-08 1.2 4.6875e-08 1.2 4.69067581301e-08 1.2 4.69385162602e-08 1.2 4.69702743902e-08 1.2 4.70020325203e-08 1.2 4.70337906504e-08 1.2 4.70655487805e-08 1.2 4.70973069106e-08 1.2 4.71290650407e-08 1.2 4.71608231707e-08 1.2 4.71925813008e-08 1.2 4.72243394309e-08 1.2 4.7256097561e-08 1.2 4.72878556911e-08 1.2 4.73196138211e-08 1.2 4.73513719512e-08 1.2 4.73831300813e-08 1.2 4.74148882114e-08 1.2 4.74466463415e-08 1.2 4.74784044715e-08 1.2 4.75101626016e-08 1.2 4.75419207317e-08 1.2 4.75736788618e-08 1.2 4.76054369919e-08 1.2 4.7637195122e-08 1.2 4.7668953252e-08 1.2 4.77007113821e-08 1.2 4.77324695122e-08 1.2 4.77642276423e-08 1.2 4.77959857724e-08 1.2 4.78277439024e-08 1.2 4.78595020325e-08 1.2 4.78912601626e-08 1.2 4.79230182927e-08 1.2 4.79547764228e-08 1.2 4.79865345528e-08 1.2 4.80182926829e-08 1.2 4.8050050813e-08 1.2 4.80818089431e-08 1.2 4.81135670732e-08 1.2 4.81453252033e-08 1.2 4.81770833333e-08 1.2 4.82088414634e-08 1.2 4.82405995935e-08 1.2 4.82723577236e-08 1.2 4.83041158537e-08 1.2 4.83358739837e-08 1.2 4.83676321138e-08 1.2 4.83993902439e-08 1.2 4.8431148374e-08 1.2 4.84629065041e-08 1.2 4.84946646341e-08 1.2 4.85264227642e-08 1.2 4.85581808943e-08 1.2 4.85899390244e-08 1.2 4.86216971545e-08 1.2 4.86534552846e-08 1.2 4.86852134146e-08 1.2 4.87169715447e-08 1.2 4.87487296748e-08 1.2 4.87804878049e-08 1.2 4.8812245935e-08 1.2 4.8844004065e-08 1.2 4.88757621951e-08 1.2 4.89075203252e-08 1.2 4.89392784553e-08 1.2 4.89710365854e-08 1.2 4.90027947154e-08 1.2 4.90345528455e-08 1.2 4.90663109756e-08 1.2 4.90980691057e-08 1.2 4.91298272358e-08 1.2 4.91615853659e-08 1.2 4.91933434959e-08 1.2 4.9225101626e-08 1.2 4.92568597561e-08 1.2 4.92886178862e-08 1.2 4.93203760163e-08 1.2 4.93521341463e-08 1.2 4.93838922764e-08 1.2 4.94156504065e-08 1.2 4.94474085366e-08 1.2 4.94791666667e-08 1.2 4.95109247967e-08 1.2 4.95426829268e-08 1.2 4.95744410569e-08 1.2 4.9606199187e-08 1.2 4.96379573171e-08 1.2 4.96697154472e-08 1.2 4.97014735772e-08 1.2 4.97332317073e-08 1.2 4.97649898374e-08 1.2 4.97967479675e-08 1.2 4.98285060976e-08 1.2 4.98602642276e-08 1.2 4.98920223577e-08 1.2 4.99237804878e-08 1.2 4.99555386179e-08 1.2 4.9987296748e-08 1.2 5.0019054878e-08 1.2 5.00508130081e-08 1.2 5.00825711382e-08 1.2 5.01143292683e-08 1.2 5.01460873984e-08 1.2 5.01778455285e-08 1.2 5.02096036585e-08 1.2 5.02413617886e-08 1.2 5.02731199187e-08 1.2 5.03048780488e-08 1.2 5.03366361789e-08 1.2 5.03683943089e-08 1.2 5.0400152439e-08 1.2 5.04319105691e-08 1.2 5.04636686992e-08 1.2 5.04954268293e-08 1.2 5.05271849593e-08 1.2 5.05589430894e-08 1.2 5.05907012195e-08 1.2 5.06224593496e-08 1.2 5.06542174797e-08 1.2 5.06859756098e-08 1.2 5.07177337398e-08 1.2 5.07494918699e-08 1.2 5.078125e-08 1.2 5.08130081301e-08 1.2 5.08447662602e-08 1.2 5.08765243902e-08 1.2 5.09082825203e-08 1.2 5.09400406504e-08 1.2 5.09717987805e-08 1.2 5.10035569106e-08 1.2 5.10353150407e-08 1.2 5.10670731707e-08 1.2 5.10988313008e-08 1.2 5.11305894309e-08 1.2 5.1162347561e-08 1.2 5.11941056911e-08 1.2 5.12258638211e-08 1.2 5.12576219512e-08 1.2 5.12893800813e-08 1.2 5.13211382114e-08 1.2 5.13528963415e-08 1.2 5.13846544715e-08 1.2 5.14164126016e-08 1.2 5.14481707317e-08 1.2 5.14799288618e-08 1.2 5.15116869919e-08 1.2 5.1543445122e-08 1.2 5.1575203252e-08 1.2 5.16069613821e-08 1.2 5.16387195122e-08 1.2 5.16704776423e-08 1.2 5.17022357724e-08 1.2 5.17339939024e-08 1.2 5.17657520325e-08 1.2 5.17975101626e-08 1.2 5.18292682927e-08 1.2 5.18610264228e-08 1.2 5.18927845528e-08 1.2 5.19245426829e-08 1.2 5.1956300813e-08 1.2 5.19880589431e-08 1.2 5.20198170732e-08 1.2 5.20515752033e-08 1.2 5.20833333333e-08 1.2 5.21150914634e-08 1.2 5.21468495935e-08 1.2 5.21786077236e-08 1.2 5.22103658537e-08 1.2 5.22421239837e-08 1.2 5.22738821138e-08 1.2 5.23056402439e-08 1.2 5.2337398374e-08 1.2 5.23691565041e-08 1.2 5.24009146341e-08 1.2 5.24326727642e-08 1.2 5.24644308943e-08 1.2 5.24961890244e-08 1.2 5.25279471545e-08 1.2 5.25597052846e-08 1.2 5.25914634146e-08 1.2 5.26232215447e-08 1.2 5.26549796748e-08 1.2 5.26867378049e-08 1.2 5.2718495935e-08 1.2 5.2750254065e-08 1.2 5.27820121951e-08 1.2 5.28137703252e-08 1.2 5.28455284553e-08 1.2 5.28772865854e-08 1.2 5.29090447154e-08 1.2 5.29408028455e-08 1.2 5.29725609756e-08 1.2 5.30043191057e-08 1.2 5.30360772358e-08 1.2 5.30678353659e-08 1.2 5.30995934959e-08 1.2 5.3131351626e-08 1.2 5.31631097561e-08 1.2 5.31948678862e-08 1.2 5.32266260163e-08 1.2 5.32583841463e-08 1.2 5.32901422764e-08 1.2 5.33219004065e-08 1.2 5.33536585366e-08 1.2 5.33854166667e-08 1.2 5.34171747967e-08 1.2 5.34489329268e-08 1.2 5.34806910569e-08 1.2 5.3512449187e-08 1.2 5.35442073171e-08 1.2 5.35759654472e-08 1.2 5.36077235772e-08 1.2 5.36394817073e-08 1.2 5.36712398374e-08 1.2 5.37029979675e-08 1.2 5.37347560976e-08 1.2 5.37665142276e-08 1.2 5.37982723577e-08 1.2 5.38300304878e-08 1.2 5.38617886179e-08 1.2 5.3893546748e-08 1.2 5.3925304878e-08 1.2 5.39570630081e-08 1.2 5.39888211382e-08 1.2 5.40205792683e-08 1.2 5.40523373984e-08 1.2 5.40840955285e-08 1.2 5.41158536585e-08 1.2 5.41476117886e-08 1.2 5.41793699187e-08 1.2 5.42111280488e-08 1.2 5.42428861789e-08 1.2 5.42746443089e-08 1.2 5.4306402439e-08 1.2 5.43381605691e-08 1.2 5.43699186992e-08 1.2 5.44016768293e-08 1.2 5.44334349593e-08 1.2 5.44651930894e-08 1.2 5.44969512195e-08 1.2 5.45287093496e-08 1.2 5.45604674797e-08 1.2 5.45922256098e-08 1.2 5.46239837398e-08 1.2 5.46557418699e-08 1.2 5.46875e-08 1.2 5.47192581301e-08 1.2 5.47510162602e-08 1.2 5.47827743902e-08 1.2 5.48145325203e-08 1.2 5.48462906504e-08 1.2 5.48780487805e-08 1.2 5.49098069106e-08 1.2 5.49415650407e-08 1.2 5.49733231707e-08 1.2 5.50050813008e-08 1.2 5.50368394309e-08 1.2 5.5068597561e-08 1.2 5.51003556911e-08 1.2 5.51321138211e-08 1.2 5.51638719512e-08 1.2 5.51956300813e-08 1.2 5.52273882114e-08 1.2 5.52591463415e-08 1.2 5.52909044715e-08 1.2 5.53226626016e-08 1.2 5.53544207317e-08 1.2 5.53861788618e-08 1.2 5.54179369919e-08 1.2 5.5449695122e-08 1.2 5.5481453252e-08 1.2 5.55132113821e-08 1.2 5.55449695122e-08 1.2 5.55767276423e-08 1.2 5.56084857724e-08 1.2 5.56402439024e-08 1.2 5.56720020325e-08 1.2 5.57037601626e-08 1.2 5.57355182927e-08 1.2 5.57672764228e-08 1.2 5.57990345528e-08 1.2 5.58307926829e-08 1.2 5.5862550813e-08 1.2 5.58943089431e-08 1.2 5.59260670732e-08 1.2 5.59578252033e-08 1.2 5.59895833333e-08 1.2 5.60213414634e-08 1.2 5.60530995935e-08 1.2 5.60848577236e-08 1.2 5.61166158537e-08 1.2 5.61483739837e-08 1.2 5.61801321138e-08 1.2 5.62118902439e-08 1.2 5.6243648374e-08 1.2 5.62754065041e-08 1.2 5.63071646341e-08 1.2 5.63389227642e-08 1.2 5.63706808943e-08 1.2 5.64024390244e-08 1.2 5.64341971545e-08 1.2 5.64659552846e-08 1.2 5.64977134146e-08 1.2 5.65294715447e-08 1.2 5.65612296748e-08 1.2 5.65929878049e-08 1.2 5.6624745935e-08 1.2 5.6656504065e-08 1.2 5.66882621951e-08 1.2 5.67200203252e-08 1.2 5.67517784553e-08 1.2 5.67835365854e-08 1.2 5.68152947154e-08 1.2 5.68470528455e-08 1.2 5.68788109756e-08 1.2 5.69105691057e-08 1.2 5.69423272358e-08 1.2 5.69740853659e-08 1.2 5.70058434959e-08 1.2 5.7037601626e-08 1.2 5.70693597561e-08 1.2 5.71011178862e-08 1.2 5.71328760163e-08 1.2 5.71646341463e-08 1.2 5.71963922764e-08 1.2 5.72281504065e-08 1.2 5.72599085366e-08 1.2 5.72916666667e-08 1.2 5.73234247967e-08 1.2 5.73551829268e-08 1.2 5.73869410569e-08 1.2 5.7418699187e-08 1.2 5.74504573171e-08 1.2 5.74822154472e-08 1.2 5.75139735772e-08 1.2 5.75457317073e-08 1.2 5.75774898374e-08 1.2 5.76092479675e-08 1.2 5.76410060976e-08 1.2 5.76727642276e-08 1.2 5.77045223577e-08 1.2 5.77362804878e-08 1.2 5.77680386179e-08 1.2 5.7799796748e-08 1.2 5.7831554878e-08 1.2 5.78633130081e-08 1.2 5.78950711382e-08 1.2 5.79268292683e-08 1.2 5.79585873984e-08 1.2 5.79903455285e-08 1.2 5.80221036585e-08 1.2 5.80538617886e-08 1.2 5.80856199187e-08 1.2 5.81173780488e-08 1.2 5.81491361789e-08 1.2 5.81808943089e-08 1.2 5.8212652439e-08 1.2 5.82444105691e-08 1.2 5.82761686992e-08 1.2 5.83079268293e-08 1.2 5.83396849593e-08 1.2 5.83714430894e-08 1.2 5.84032012195e-08 1.2 5.84349593496e-08 1.2 5.84667174797e-08 1.2 5.84984756098e-08 1.2 5.85302337398e-08 1.2 5.85619918699e-08 1.2 5.859375e-08 1.2 5.86255081301e-08 1.2 5.86572662602e-08 1.2 5.86890243902e-08 1.2 5.87207825203e-08 1.2 5.87525406504e-08 1.2 5.87842987805e-08 1.2 5.88160569106e-08 1.2 5.88478150407e-08 1.2 5.88795731707e-08 1.2 5.89113313008e-08 1.2 5.89430894309e-08 1.2 5.8974847561e-08 1.2 5.90066056911e-08 1.2 5.90383638211e-08 1.2 5.90701219512e-08 1.2 5.91018800813e-08 1.2 5.91336382114e-08 1.2 5.91653963415e-08 1.2 5.91971544715e-08 1.2 5.92289126016e-08 1.2 5.92606707317e-08 1.2 5.92924288618e-08 1.2 5.93241869919e-08 1.2 5.9355945122e-08 1.2 5.9387703252e-08 1.2 5.94194613821e-08 1.2 5.94512195122e-08 1.2 5.94829776423e-08 1.2 5.95147357724e-08 1.2 5.95464939024e-08 1.2 5.95782520325e-08 1.2 5.96100101626e-08 1.2 5.96417682927e-08 1.2 5.96735264228e-08 1.2 5.97052845528e-08 1.2 5.97370426829e-08 1.2 5.9768800813e-08 1.2 5.98005589431e-08 1.2 5.98323170732e-08 1.2 5.98640752033e-08 1.2 5.98958333333e-08 1.2 5.99275914634e-08 1.2 5.99593495935e-08 1.2 5.99911077236e-08 1.2 6.00228658537e-08 1.2 6.00546239837e-08 1.2 6.00863821138e-08 1.2 6.01181402439e-08 1.2 6.0149898374e-08 1.2 6.01816565041e-08 1.2 6.02134146341e-08 1.2 6.02451727642e-08 1.2 6.02769308943e-08 1.2 6.03086890244e-08 1.2 6.03404471545e-08 1.2 6.03722052846e-08 1.2 6.04039634146e-08 1.2 6.04357215447e-08 1.2 6.04674796748e-08 1.2 6.04992378049e-08 1.2 6.0530995935e-08 1.2 6.0562754065e-08 1.2 6.05945121951e-08 1.2 6.06262703252e-08 1.2 6.06580284553e-08 1.2 6.06897865854e-08 1.2 6.07215447154e-08 1.2 6.07533028455e-08 1.2 6.07850609756e-08 1.2 6.08168191057e-08 1.2 6.08485772358e-08 1.2 6.08803353659e-08 1.2 6.09120934959e-08 1.2 6.0943851626e-08 1.2 6.09756097561e-08 1.2 6.10073678862e-08 1.2 6.10391260163e-08 1.2 6.10708841463e-08 1.2 6.11026422764e-08 1.2 6.11344004065e-08 1.2 6.11661585366e-08 1.2 6.11979166667e-08 1.2 6.12296747967e-08 1.2 6.12614329268e-08 1.2 6.12931910569e-08 1.2 6.1324949187e-08 1.2 6.13567073171e-08 1.2 6.13884654472e-08 1.2 6.14202235772e-08 1.2 6.14519817073e-08 1.2 6.14837398374e-08 1.2 6.15154979675e-08 1.2 6.15472560976e-08 1.2 6.15790142276e-08 1.2 6.16107723577e-08 1.2 6.16425304878e-08 1.2 6.16742886179e-08 1.2 6.1706046748e-08 1.2 6.1737804878e-08 1.2 6.17695630081e-08 1.2 6.18013211382e-08 1.2 6.18330792683e-08 1.2 6.18648373984e-08 1.2 6.18965955285e-08 1.2 6.19283536585e-08 1.2 6.19601117886e-08 1.2 6.19918699187e-08 1.2 6.20236280488e-08 1.2 6.20553861789e-08 1.2 6.20871443089e-08 1.2 6.2118902439e-08 1.2 6.21506605691e-08 1.2 6.21824186992e-08 1.2 6.22141768293e-08 1.2 6.22459349593e-08 1.2 6.22776930894e-08 1.2 6.23094512195e-08 1.2 6.23412093496e-08 1.2 6.23729674797e-08 1.2 6.24047256098e-08 1.2 6.24364837398e-08 1.2 6.24682418699e-08 1.2 6.25e-08 1.2 6.25317581301e-08 1.2 6.25635162602e-08 1.2 6.25952743902e-08 1.2 6.26270325203e-08 1.2 6.26587906504e-08 1.2 6.26905487805e-08 1.2 6.27223069106e-08 1.2 6.27540650407e-08 1.2 6.27858231707e-08 1.2 6.28175813008e-08 1.2 6.28493394309e-08 1.2 6.2881097561e-08 1.2 6.29128556911e-08 1.2 6.29446138211e-08 1.2 6.29763719512e-08 1.2 6.30081300813e-08 1.2 6.30398882114e-08 1.2 6.30716463415e-08 1.2 6.31034044715e-08 1.2 6.31351626016e-08 1.2 6.31669207317e-08 1.2 6.31986788618e-08 1.2 6.32304369919e-08 1.2 6.3262195122e-08 1.2 6.3293953252e-08 1.2 6.33257113821e-08 1.2 6.33574695122e-08 1.2 6.33892276423e-08 1.2 6.34209857724e-08 1.2 6.34527439024e-08 1.2 6.34845020325e-08 1.2 6.35162601626e-08 1.2 6.35480182927e-08 1.2 6.35797764228e-08 1.2 6.36115345528e-08 1.2 6.36432926829e-08 1.2 6.3675050813e-08 1.2 6.37068089431e-08 1.2 6.37385670732e-08 1.2 6.37703252033e-08 1.2 6.38020833333e-08 1.2 6.38338414634e-08 1.2 6.38655995935e-08 1.2 6.38973577236e-08 1.2 6.39291158537e-08 1.2 6.39608739837e-08 1.2 6.39926321138e-08 1.2 6.40243902439e-08 1.2 6.4056148374e-08 1.2 6.40879065041e-08 1.2 6.41196646341e-08 1.2 6.41514227642e-08 1.2 6.41831808943e-08 1.2 6.42149390244e-08 1.2 6.42466971545e-08 1.2 6.42784552846e-08 1.2 6.43102134146e-08 1.2 6.43419715447e-08 1.2 6.43737296748e-08 1.2 6.44054878049e-08 1.2 6.4437245935e-08 1.2 6.4469004065e-08 1.2 6.45007621951e-08 1.2 6.45325203252e-08 1.2 6.45642784553e-08 1.2 6.45960365854e-08 1.2 6.46277947154e-08 1.2 6.46595528455e-08 1.2 6.46913109756e-08 1.2 6.47230691057e-08 1.2 6.47548272358e-08 1.2 6.47865853659e-08 1.2 6.48183434959e-08 1.2 6.4850101626e-08 1.2 6.48818597561e-08 1.2 6.49136178862e-08 1.2 6.49453760163e-08 1.2 6.49771341463e-08 1.2 6.50088922764e-08 1.2 6.50406504065e-08 1.2 6.50724085366e-08 1.2 6.51041666667e-08 1.2 6.51359247967e-08 1.2 6.51676829268e-08 1.2 6.51994410569e-08 1.2 6.5231199187e-08 1.2 6.52629573171e-08 1.2 6.52947154472e-08 1.2 6.53264735772e-08 1.2 6.53582317073e-08 1.2 6.53899898374e-08 1.2 6.54217479675e-08 1.2 6.54535060976e-08 1.2 6.54852642276e-08 1.2 6.55170223577e-08 1.2 6.55487804878e-08 1.2 6.55805386179e-08 1.2 6.5612296748e-08 1.2 6.5644054878e-08 1.2 6.56758130081e-08 1.2 6.57075711382e-08 1.2 6.57393292683e-08 1.2 6.57710873984e-08 1.2 6.58028455285e-08 1.2 6.58346036585e-08 1.2 6.58663617886e-08 1.2 6.58981199187e-08 1.2 6.59298780488e-08 1.2 6.59616361789e-08 1.2 6.59933943089e-08 1.2 6.6025152439e-08 1.2 6.60569105691e-08 1.2 6.60886686992e-08 1.2 6.61204268293e-08 1.2 6.61521849593e-08 1.2 6.61839430894e-08 1.2 6.62157012195e-08 1.2 6.62474593496e-08 1.2 6.62792174797e-08 1.2 6.63109756098e-08 1.2 6.63427337398e-08 1.2 6.63744918699e-08 1.2 6.640625e-08 1.2 6.64380081301e-08 1.2 6.64697662602e-08 1.2 6.65015243902e-08 1.2 6.65332825203e-08 1.2 6.65650406504e-08 1.2 6.65967987805e-08 1.2 6.66285569106e-08 1.2 6.66603150407e-08 1.2 6.66920731707e-08 1.2 6.67238313008e-08 1.2 6.67555894309e-08 1.2 6.6787347561e-08 1.2 6.68191056911e-08 1.2 6.68508638211e-08 1.2 6.68826219512e-08 1.2 6.69143800813e-08 1.2 6.69461382114e-08 1.2 6.69778963415e-08 1.2 6.70096544715e-08 1.2 6.70414126016e-08 1.2 6.70731707317e-08 1.2 6.71049288618e-08 1.2 6.71366869919e-08 1.2 6.7168445122e-08 1.2 6.7200203252e-08 1.2 6.72319613821e-08 1.2 6.72637195122e-08 1.2 6.72954776423e-08 1.2 6.73272357724e-08 1.2 6.73589939024e-08 1.2 6.73907520325e-08 1.2 6.74225101626e-08 1.2 6.74542682927e-08 1.2 6.74860264228e-08 1.2 6.75177845528e-08 1.2 6.75495426829e-08 1.2 6.7581300813e-08 1.2 6.76130589431e-08 1.2 6.76448170732e-08 1.2 6.76765752033e-08 1.2 6.77083333333e-08 1.2 6.77400914634e-08 1.2 6.77718495935e-08 1.2 6.78036077236e-08 1.2 6.78353658537e-08 1.2 6.78671239837e-08 1.2 6.78988821138e-08 1.2 6.79306402439e-08 1.2 6.7962398374e-08 1.2 6.79941565041e-08 1.2 6.80259146341e-08 1.2 6.80576727642e-08 1.2 6.80894308943e-08 1.2 6.81211890244e-08 1.2 6.81529471545e-08 1.2 6.81847052846e-08 1.2 6.82164634146e-08 1.2 6.82482215447e-08 1.2 6.82799796748e-08 1.2 6.83117378049e-08 1.2 6.8343495935e-08 1.2 6.8375254065e-08 1.2 6.84070121951e-08 1.2 6.84387703252e-08 1.2 6.84705284553e-08 1.2 6.85022865854e-08 1.2 6.85340447154e-08 1.2 6.85658028455e-08 1.2 6.85975609756e-08 1.2 6.86293191057e-08 1.2 6.86610772358e-08 1.2 6.86928353659e-08 1.2 6.87245934959e-08 1.2 6.8756351626e-08 1.2 6.87881097561e-08 1.2 6.88198678862e-08 1.2 6.88516260163e-08 1.2 6.88833841463e-08 1.2 6.89151422764e-08 1.2 6.89469004065e-08 1.2 6.89786585366e-08 1.2 6.90104166667e-08 1.2 6.90421747967e-08 1.2 6.90739329268e-08 1.2 6.91056910569e-08 1.2 6.9137449187e-08 1.2 6.91692073171e-08 1.2 6.92009654472e-08 1.2 6.92327235772e-08 1.2 6.92644817073e-08 1.2 6.92962398374e-08 1.2 6.93279979675e-08 1.2 6.93597560976e-08 1.2 6.93915142276e-08 1.2 6.94232723577e-08 1.2 6.94550304878e-08 1.2 6.94867886179e-08 1.2 6.9518546748e-08 1.2 6.9550304878e-08 1.2 6.95820630081e-08 1.2 6.96138211382e-08 1.2 6.96455792683e-08 1.2 6.96773373984e-08 1.2 6.97090955285e-08 1.2 6.97408536585e-08 1.2 6.97726117886e-08 1.2 6.98043699187e-08 1.2 6.98361280488e-08 1.2 6.98678861789e-08 1.2 6.98996443089e-08 1.2 6.9931402439e-08 1.2 6.99631605691e-08 1.2 6.99949186992e-08 1.2 7.00266768293e-08 1.2 7.00584349593e-08 1.2 7.00901930894e-08 1.2 7.01219512195e-08 1.2 7.01537093496e-08 1.2 7.01854674797e-08 1.2 7.02172256098e-08 1.2 7.02489837398e-08 1.2 7.02807418699e-08 1.2 7.03125e-08 1.2 7.03442581301e-08 1.2 7.03760162602e-08 1.2 7.04077743902e-08 1.2 7.04395325203e-08 1.2 7.04712906504e-08 1.2 7.05030487805e-08 1.2 7.05348069106e-08 1.2 7.05665650407e-08 1.2 7.05983231707e-08 1.2 7.06300813008e-08 1.2 7.06618394309e-08 1.2 7.0693597561e-08 1.2 7.07253556911e-08 1.2 7.07571138211e-08 1.2 7.07888719512e-08 1.2 7.08206300813e-08 1.2 7.08523882114e-08 1.2 7.08841463415e-08 1.2 7.09159044715e-08 1.2 7.09476626016e-08 1.2 7.09794207317e-08 1.2 7.10111788618e-08 1.2 7.10429369919e-08 1.2 7.1074695122e-08 1.2 7.1106453252e-08 1.2 7.11382113821e-08 1.2 7.11699695122e-08 1.2 7.12017276423e-08 1.2 7.12334857724e-08 1.2 7.12652439024e-08 1.2 7.12970020325e-08 1.2 7.13287601626e-08 1.2 7.13605182927e-08 1.2 7.13922764228e-08 1.2 7.14240345528e-08 1.2 7.14557926829e-08 1.2 7.1487550813e-08 1.2 7.15193089431e-08 1.2 7.15510670732e-08 1.2 7.15828252033e-08 1.2 7.16145833333e-08 1.2 7.16463414634e-08 1.2 7.16780995935e-08 1.2 7.17098577236e-08 1.2 7.17416158537e-08 1.2 7.17733739837e-08 1.2 7.18051321138e-08 1.2 7.18368902439e-08 1.2 7.1868648374e-08 1.2 7.19004065041e-08 1.2 7.19321646341e-08 1.2 7.19639227642e-08 1.2 7.19956808943e-08 1.2 7.20274390244e-08 1.2 7.20591971545e-08 1.2 7.20909552846e-08 1.2 7.21227134146e-08 1.2 7.21544715447e-08 1.2 7.21862296748e-08 1.2 7.22179878049e-08 1.2 7.2249745935e-08 1.2 7.2281504065e-08 1.2 7.23132621951e-08 1.2 7.23450203252e-08 1.2 7.23767784553e-08 1.2 7.24085365854e-08 1.2 7.24402947154e-08 1.2 7.24720528455e-08 1.2 7.25038109756e-08 1.2 7.25355691057e-08 1.2 7.25673272358e-08 1.2 7.25990853659e-08 1.2 7.26308434959e-08 1.2 7.2662601626e-08 1.2 7.26943597561e-08 1.2 7.27261178862e-08 1.2 7.27578760163e-08 1.2 7.27896341463e-08 1.2 7.28213922764e-08 1.2 7.28531504065e-08 1.2 7.28849085366e-08 1.2 7.29166666667e-08 1.2 7.29484247967e-08 1.2 7.29801829268e-08 1.2 7.30119410569e-08 1.2 7.3043699187e-08 1.2 7.30754573171e-08 1.2 7.31072154472e-08 1.2 7.31389735772e-08 1.2 7.31707317073e-08 1.2 7.32024898374e-08 1.2 7.32342479675e-08 1.2 7.32660060976e-08 1.2 7.32977642276e-08 1.2 7.33295223577e-08 1.2 7.33612804878e-08 1.2 7.33930386179e-08 1.2 7.3424796748e-08 1.2 7.3456554878e-08 1.2 7.34883130081e-08 1.2 7.35200711382e-08 1.2 7.35518292683e-08 1.2 7.35835873984e-08 1.2 7.36153455285e-08 1.2 7.36471036585e-08 1.2 7.36788617886e-08 1.2 7.37106199187e-08 1.2 7.37423780488e-08 1.2 7.37741361789e-08 1.2 7.38058943089e-08 1.2 7.3837652439e-08 1.2 7.38694105691e-08 1.2 7.39011686992e-08 1.2 7.39329268293e-08 1.2 7.39646849593e-08 1.2 7.39964430894e-08 1.2 7.40282012195e-08 1.2 7.40599593496e-08 1.2 7.40917174797e-08 1.2 7.41234756098e-08 1.2 7.41552337398e-08 1.2 7.41869918699e-08 1.2 7.421875e-08 1.2 7.42505081301e-08 1.2 7.42822662602e-08 1.2 7.43140243902e-08 1.2 7.43457825203e-08 1.2 7.43775406504e-08 1.2 7.44092987805e-08 1.2 7.44410569106e-08 1.2 7.44728150407e-08 1.2 7.45045731707e-08 1.2 7.45363313008e-08 1.2 7.45680894309e-08 1.2 7.4599847561e-08 1.2 7.46316056911e-08 1.2 7.46633638211e-08 1.2 7.46951219512e-08 1.2 7.47268800813e-08 1.2 7.47586382114e-08 1.2 7.47903963415e-08 1.2 7.48221544715e-08 1.2 7.48539126016e-08 1.2 7.48856707317e-08 1.2 7.49174288618e-08 1.2 7.49491869919e-08 1.2 7.4980945122e-08 1.2 7.5012703252e-08 1.2 7.50444613821e-08 1.2 7.50762195122e-08 1.2 7.51079776423e-08 1.2 7.51397357724e-08 1.2 7.51714939024e-08 1.2 7.52032520325e-08 1.2 7.52350101626e-08 1.2 7.52667682927e-08 1.2 7.52985264228e-08 1.2 7.53302845528e-08 1.2 7.53620426829e-08 1.2 7.5393800813e-08 1.2 7.54255589431e-08 1.2 7.54573170732e-08 1.2 7.54890752033e-08 1.2 7.55208333333e-08 1.2 7.55525914634e-08 1.2 7.55843495935e-08 1.2 7.56161077236e-08 1.2 7.56478658537e-08 1.2 7.56796239837e-08 1.2 7.57113821138e-08 1.2 7.57431402439e-08 1.2 7.5774898374e-08 1.2 7.58066565041e-08 1.2 7.58384146341e-08 1.2 7.58701727642e-08 1.2 7.59019308943e-08 1.2 7.59336890244e-08 1.2 7.59654471545e-08 1.2 7.59972052846e-08 1.2 7.60289634146e-08 1.2 7.60607215447e-08 1.2 7.60924796748e-08 1.2 7.61242378049e-08 1.2 7.6155995935e-08 1.2 7.6187754065e-08 1.2 7.62195121951e-08 1.2 7.62512703252e-08 1.2 7.62830284553e-08 1.2 7.63147865854e-08 1.2 7.63465447154e-08 1.2 7.63783028455e-08 1.2 7.64100609756e-08 1.2 7.64418191057e-08 1.2 7.64735772358e-08 1.2 7.65053353659e-08 1.2 7.65370934959e-08 1.2 7.6568851626e-08 1.2 7.66006097561e-08 1.2 7.66323678862e-08 1.2 7.66641260163e-08 1.2 7.66958841463e-08 1.2 7.67276422764e-08 1.2 7.67594004065e-08 1.2 7.67911585366e-08 1.2 7.68229166667e-08 1.2 7.68546747967e-08 1.2 7.68864329268e-08 1.2 7.69181910569e-08 1.2 7.6949949187e-08 1.2 7.69817073171e-08 1.2 7.70134654472e-08 1.2 7.70452235772e-08 1.2 7.70769817073e-08 1.2 7.71087398374e-08 1.2 7.71404979675e-08 1.2 7.71722560976e-08 1.2 7.72040142276e-08 1.2 7.72357723577e-08 1.2 7.72675304878e-08 1.2 7.72992886179e-08 1.2 7.7331046748e-08 1.2 7.7362804878e-08 1.2 7.73945630081e-08 1.2 7.74263211382e-08 1.2 7.74580792683e-08 1.2 7.74898373984e-08 1.2 7.75215955285e-08 1.2 7.75533536585e-08 1.2 7.75851117886e-08 1.2 7.76168699187e-08 1.2 7.76486280488e-08 1.2 7.76803861789e-08 1.2 7.77121443089e-08 1.2 7.7743902439e-08 1.2 7.77756605691e-08 1.2 7.78074186992e-08 1.2 7.78391768293e-08 1.2 7.78709349593e-08 1.2 7.79026930894e-08 1.2 7.79344512195e-08 1.2 7.79662093496e-08 1.2 7.79979674797e-08 1.2 7.80297256098e-08 1.2 7.80614837398e-08 1.2 7.80932418699e-08 1.2 7.8125e-08 1.2 7.81567581301e-08 1.2 7.81885162602e-08 1.2 7.82202743902e-08 1.2 7.82520325203e-08 1.2 7.82837906504e-08 1.2 7.83155487805e-08 1.2 7.83473069106e-08 1.2 7.83790650407e-08 1.2 7.84108231707e-08 1.2 7.84425813008e-08 1.2 7.84743394309e-08 1.2 7.8506097561e-08 1.2 7.85378556911e-08 1.2 7.85696138211e-08 1.2 7.86013719512e-08 1.2 7.86331300813e-08 1.2 7.86648882114e-08 1.2 7.86966463415e-08 1.2 7.87284044715e-08 1.2 7.87601626016e-08 1.2 7.87919207317e-08 1.2 7.88236788618e-08 1.2 7.88554369919e-08 1.2 7.8887195122e-08 1.2 7.8918953252e-08 1.2 7.89507113821e-08 1.2 7.89824695122e-08 1.2 7.90142276423e-08 1.2 7.90459857724e-08 1.2 7.90777439024e-08 1.2 7.91095020325e-08 1.2 7.91412601626e-08 1.2 7.91730182927e-08 1.2 7.92047764228e-08 1.2 7.92365345528e-08 1.2 7.92682926829e-08 1.2 7.9300050813e-08 1.2 7.93318089431e-08 1.2 7.93635670732e-08 1.2 7.93953252033e-08 1.2 7.94270833333e-08 1.2 7.94588414634e-08 1.2 7.94905995935e-08 1.2 7.95223577236e-08 1.2 7.95541158537e-08 1.2 7.95858739837e-08 1.2 7.96176321138e-08 1.2 7.96493902439e-08 1.2 7.9681148374e-08 1.2 7.97129065041e-08 1.2 7.97446646341e-08 1.2 7.97764227642e-08 1.2 7.98081808943e-08 1.2 7.98399390244e-08 1.2 7.98716971545e-08 1.2 7.99034552846e-08 1.2 7.99352134146e-08 1.2 7.99669715447e-08 1.2 7.99987296748e-08 1.2 8.00304878049e-08 1.2 8.0062245935e-08 1.2 8.0094004065e-08 1.2 8.01257621951e-08 1.2 8.01575203252e-08 1.2 8.01892784553e-08 1.2 8.02210365854e-08 1.2 8.02527947154e-08 1.2 8.02845528455e-08 1.2 8.03163109756e-08 1.2 8.03480691057e-08 1.2 8.03798272358e-08 1.2 8.04115853659e-08 1.2 8.04433434959e-08 1.2 8.0475101626e-08 1.2 8.05068597561e-08 1.2 8.05386178862e-08 1.2 8.05703760163e-08 1.2 8.06021341463e-08 1.2 8.06338922764e-08 1.2 8.06656504065e-08 1.2 8.06974085366e-08 1.2 8.07291666667e-08 1.2 8.07609247967e-08 1.2 8.07926829268e-08 1.2 8.08244410569e-08 1.2 8.0856199187e-08 1.2 8.08879573171e-08 1.2 8.09197154472e-08 1.2 8.09514735772e-08 1.2 8.09832317073e-08 1.2 8.10149898374e-08 1.2 8.10467479675e-08 1.2 8.10785060976e-08 1.2 8.11102642276e-08 1.2 8.11420223577e-08 1.2 8.11737804878e-08 1.2 8.12055386179e-08 1.2 8.1237296748e-08 1.2 8.1269054878e-08 1.2 8.13008130081e-08 1.2 8.13325711382e-08 1.2 8.13643292683e-08 1.2 8.13960873984e-08 1.2 8.14278455285e-08 1.2 8.14596036585e-08 1.2 8.14913617886e-08 1.2 8.15231199187e-08 1.2 8.15548780488e-08 1.2 8.15866361789e-08 1.2 8.16183943089e-08 1.2 8.1650152439e-08 1.2 8.16819105691e-08 1.2 8.17136686992e-08 1.2 8.17454268293e-08 1.2 8.17771849593e-08 1.2 8.18089430894e-08 1.2 8.18407012195e-08 1.2 8.18724593496e-08 1.2 8.19042174797e-08 1.2 8.19359756098e-08 1.2 8.19677337398e-08 1.2 8.19994918699e-08 1.2 8.203125e-08 1.2 8.20630081301e-08 1.2 8.20947662602e-08 1.2 8.21265243902e-08 1.2 8.21582825203e-08 1.2 8.21900406504e-08 1.2 8.22217987805e-08 1.2 8.22535569106e-08 1.2 8.22853150407e-08 1.2 8.23170731707e-08 1.2 8.23488313008e-08 1.2 8.23805894309e-08 1.2 8.2412347561e-08 1.2 8.24441056911e-08 1.2 8.24758638211e-08 1.2 8.25076219512e-08 1.2 8.25393800813e-08 1.2 8.25711382114e-08 1.2 8.26028963415e-08 1.2 8.26346544715e-08 1.2 8.26664126016e-08 1.2 8.26981707317e-08 1.2 8.27299288618e-08 1.2 8.27616869919e-08 1.2 8.2793445122e-08 1.2 8.2825203252e-08 1.2 8.28569613821e-08 1.2 8.28887195122e-08 1.2 8.29204776423e-08 1.2 8.29522357724e-08 1.2 8.29839939024e-08 1.2 8.30157520325e-08 1.2 8.30475101626e-08 1.2 8.30792682927e-08 1.2 8.31110264228e-08 1.2 8.31427845528e-08 1.2 8.31745426829e-08 1.2 8.3206300813e-08 1.2 8.32380589431e-08 1.2 8.32698170732e-08 1.2 8.33015752033e-08 1.2 8.33333333333e-08 1.2 8.33650914634e-08 1.2 8.33968495935e-08 1.2 8.34286077236e-08 1.2 8.34603658537e-08 1.2 8.34921239837e-08 1.2 8.35238821138e-08 1.2 8.35556402439e-08 1.2 8.3587398374e-08 1.2 8.36191565041e-08 1.2 8.36509146341e-08 1.2 8.36826727642e-08 1.2 8.37144308943e-08 1.2 8.37461890244e-08 1.2 8.37779471545e-08 1.2 8.38097052846e-08 1.2 8.38414634146e-08 1.2 8.38732215447e-08 1.2 8.39049796748e-08 1.2 8.39367378049e-08 1.2 8.3968495935e-08 1.2 8.4000254065e-08 1.2 8.40320121951e-08 1.2 8.40637703252e-08 1.2 8.40955284553e-08 1.2 8.41272865854e-08 1.2 8.41590447154e-08 1.2 8.41908028455e-08 1.2 8.42225609756e-08 1.2 8.42543191057e-08 1.2 8.42860772358e-08 1.2 8.43178353659e-08 1.2 8.43495934959e-08 1.2 8.4381351626e-08 1.2 8.44131097561e-08 1.2 8.44448678862e-08 1.2 8.44766260163e-08 1.2 8.45083841463e-08 1.2 8.45401422764e-08 1.2 8.45719004065e-08 1.2 8.46036585366e-08 1.2 8.46354166667e-08 1.2 8.46671747967e-08 1.2 8.46989329268e-08 1.2 8.47306910569e-08 1.2 8.4762449187e-08 1.2 8.47942073171e-08 1.2 8.48259654472e-08 1.2 8.48577235772e-08 1.2 8.48894817073e-08 1.2 8.49212398374e-08 1.2 8.49529979675e-08 1.2 8.49847560976e-08 1.2 8.50165142276e-08 1.2 8.50482723577e-08 1.2 8.50800304878e-08 1.2 8.51117886179e-08 1.2 8.5143546748e-08 1.2 8.5175304878e-08 1.2 8.52070630081e-08 1.2 8.52388211382e-08 1.2 8.52705792683e-08 1.2 8.53023373984e-08 1.2 8.53340955285e-08 1.2 8.53658536585e-08 1.2 8.53976117886e-08 1.2 8.54293699187e-08 1.2 8.54611280488e-08 1.2 8.54928861789e-08 1.2 8.55246443089e-08 1.2 8.5556402439e-08 1.2 8.55881605691e-08 1.2 8.56199186992e-08 1.2 8.56516768293e-08 1.2 8.56834349593e-08 1.2 8.57151930894e-08 1.2 8.57469512195e-08 1.2 8.57787093496e-08 1.2 8.58104674797e-08 1.2 8.58422256098e-08 1.2 8.58739837398e-08 1.2 8.59057418699e-08 1.2 8.59375e-08 1.2 8.59692581301e-08 1.2 8.60010162602e-08 1.2 8.60327743902e-08 1.2 8.60645325203e-08 1.2 8.60962906504e-08 1.2 8.61280487805e-08 1.2 8.61598069106e-08 1.2 8.61915650407e-08 1.2 8.62233231707e-08 1.2 8.62550813008e-08 1.2 8.62868394309e-08 1.2 8.6318597561e-08 1.2 8.63503556911e-08 1.2 8.63821138211e-08 1.2 8.64138719512e-08 1.2 8.64456300813e-08 1.2 8.64773882114e-08 1.2 8.65091463415e-08 1.2 8.65409044715e-08 1.2 8.65726626016e-08 1.2 8.66044207317e-08 1.2 8.66361788618e-08 1.2 8.66679369919e-08 1.2 8.6699695122e-08 1.2 8.6731453252e-08 1.2 8.67632113821e-08 1.2 8.67949695122e-08 1.2 8.68267276423e-08 1.2 8.68584857724e-08 1.2 8.68902439024e-08 1.2 8.69220020325e-08 1.2 8.69537601626e-08 1.2 8.69855182927e-08 1.2 8.70172764228e-08 1.2 8.70490345528e-08 1.2 8.70807926829e-08 1.2 8.7112550813e-08 1.2 8.71443089431e-08 1.2 8.71760670732e-08 1.2 8.72078252033e-08 1.2 8.72395833333e-08 1.2 8.72713414634e-08 1.2 8.73030995935e-08 1.2 8.73348577236e-08 1.2 8.73666158537e-08 1.2 8.73983739837e-08 1.2 8.74301321138e-08 1.2 8.74618902439e-08 1.2 8.7493648374e-08 1.2 8.75254065041e-08 1.2 8.75571646341e-08 1.2 8.75889227642e-08 1.2 8.76206808943e-08 1.2 8.76524390244e-08 1.2 8.76841971545e-08 1.2 8.77159552846e-08 1.2 8.77477134146e-08 1.2 8.77794715447e-08 1.2 8.78112296748e-08 1.2 8.78429878049e-08 1.2 8.7874745935e-08 1.2 8.7906504065e-08 1.2 8.79382621951e-08 1.2 8.79700203252e-08 1.2 8.80017784553e-08 1.2 8.80335365854e-08 1.2 8.80652947154e-08 1.2 8.80970528455e-08 1.2 8.81288109756e-08 1.2 8.81605691057e-08 1.2 8.81923272358e-08 1.2 8.82240853659e-08 1.2 8.82558434959e-08 1.2 8.8287601626e-08 1.2 8.83193597561e-08 1.2 8.83511178862e-08 1.2 8.83828760163e-08 1.2 8.84146341463e-08 1.2 8.84463922764e-08 1.2 8.84781504065e-08 1.2 8.85099085366e-08 1.2 8.85416666667e-08 1.2 8.85734247967e-08 1.2 8.86051829268e-08 1.2 8.86369410569e-08 1.2 8.8668699187e-08 1.2 8.87004573171e-08 1.2 8.87322154472e-08 1.2 8.87639735772e-08 1.2 8.87957317073e-08 1.2 8.88274898374e-08 1.2 8.88592479675e-08 1.2 8.88910060976e-08 1.2 8.89227642276e-08 1.2 8.89545223577e-08 1.2 8.89862804878e-08 1.2 8.90180386179e-08 1.2 8.9049796748e-08 1.2 8.9081554878e-08 1.2 8.91133130081e-08 1.2 8.91450711382e-08 1.2 8.91768292683e-08 1.2 8.92085873984e-08 1.2 8.92403455285e-08 1.2 8.92721036585e-08 1.2 8.93038617886e-08 1.2 8.93356199187e-08 1.2 8.93673780488e-08 1.2 8.93991361789e-08 1.2 8.94308943089e-08 1.2 8.9462652439e-08 1.2 8.94944105691e-08 1.2 8.95261686992e-08 1.2 8.95579268293e-08 1.2 8.95896849593e-08 1.2 8.96214430894e-08 1.2 8.96532012195e-08 1.2 8.96849593496e-08 1.2 8.97167174797e-08 1.2 8.97484756098e-08 1.2 8.97802337398e-08 1.2 8.98119918699e-08 1.2 8.984375e-08 1.2 8.98755081301e-08 1.2 8.99072662602e-08 1.2 8.99390243902e-08 1.2 8.99707825203e-08 1.2 9.00025406504e-08 1.2 9.00342987805e-08 1.2 9.00660569106e-08 1.2 9.00978150407e-08 1.2 9.01295731707e-08 1.2 9.01613313008e-08 1.2 9.01930894309e-08 1.2 9.0224847561e-08 1.2 9.02566056911e-08 1.2 9.02883638211e-08 1.2 9.03201219512e-08 1.2 9.03518800813e-08 1.2 9.03836382114e-08 1.2 9.04153963415e-08 1.2 9.04471544715e-08 1.2 9.04789126016e-08 1.2 9.05106707317e-08 1.2 9.05424288618e-08 1.2 9.05741869919e-08 1.2 9.0605945122e-08 1.2 9.0637703252e-08 1.2 9.06694613821e-08 1.2 9.07012195122e-08 1.2 9.07329776423e-08 1.2 9.07647357724e-08 1.2 9.07964939024e-08 1.2 9.08282520325e-08 1.2 9.08600101626e-08 1.2 9.08917682927e-08 1.2 9.09235264228e-08 1.2 9.09552845528e-08 1.2 9.09870426829e-08 1.2 9.1018800813e-08 1.2 9.10505589431e-08 1.2 9.10823170732e-08 1.2 9.11140752033e-08 1.2 9.11458333333e-08 1.2 9.11775914634e-08 1.2 9.12093495935e-08 1.2 9.12411077236e-08 1.2 9.12728658537e-08 1.2 9.13046239837e-08 1.2 9.13363821138e-08 1.2 9.13681402439e-08 1.2 9.1399898374e-08 1.2 9.14316565041e-08 1.2 9.14634146341e-08 1.2 9.14951727642e-08 1.2 9.15269308943e-08 1.2 9.15586890244e-08 1.2 9.15904471545e-08 1.2 9.16222052846e-08 1.2 9.16539634146e-08 1.2 9.16857215447e-08 1.2 9.17174796748e-08 1.2 9.17492378049e-08 1.2 9.1780995935e-08 1.2 9.1812754065e-08 1.2 9.18445121951e-08 1.2 9.18762703252e-08 1.2 9.19080284553e-08 1.2 9.19397865854e-08 1.2 9.19715447154e-08 1.2 9.20033028455e-08 1.2 9.20350609756e-08 1.2 9.20668191057e-08 1.2 9.20985772358e-08 1.2 9.21303353659e-08 1.2 9.21620934959e-08 1.2 9.2193851626e-08 1.2 9.22256097561e-08 1.2 9.22573678862e-08 1.2 9.22891260163e-08 1.2 9.23208841463e-08 1.2 9.23526422764e-08 1.2 9.23844004065e-08 1.2 9.24161585366e-08 1.2 9.24479166667e-08 1.2 9.24796747967e-08 1.2 9.25114329268e-08 1.2 9.25431910569e-08 1.2 9.2574949187e-08 1.2 9.26067073171e-08 1.2 9.26384654472e-08 1.2 9.26702235772e-08 1.2 9.27019817073e-08 1.2 9.27337398374e-08 1.2 9.27654979675e-08 1.2 9.27972560976e-08 1.2 9.28290142276e-08 1.2 9.28607723577e-08 1.2 9.28925304878e-08 1.2 9.29242886179e-08 1.2 9.2956046748e-08 1.2 9.2987804878e-08 1.2 9.30195630081e-08 1.2 9.30513211382e-08 1.2 9.30830792683e-08 1.2 9.31148373984e-08 1.2 9.31465955285e-08 1.2 9.31783536585e-08 1.2 9.32101117886e-08 1.2 9.32418699187e-08 1.2 9.32736280488e-08 1.2 9.33053861789e-08 1.2 9.33371443089e-08 1.2 9.3368902439e-08 1.2 9.34006605691e-08 1.2 9.34324186992e-08 1.2 9.34641768293e-08 1.2 9.34959349593e-08 1.2 9.35276930894e-08 1.2 9.35594512195e-08 1.2 9.35912093496e-08 1.2 9.36229674797e-08 1.2 9.36547256098e-08 1.2 9.36864837398e-08 1.2 9.37182418699e-08 1.2 9.375e-08 1.2 9.37817581301e-08 1.2 9.38135162602e-08 1.2 9.38452743902e-08 1.2 9.38770325203e-08 1.2 9.39087906504e-08 1.2 9.39405487805e-08 1.2 9.39723069106e-08 1.2 9.40040650407e-08 1.2 9.40358231707e-08 1.2 9.40675813008e-08 1.2 9.40993394309e-08 1.2 9.4131097561e-08 1.2 9.41628556911e-08 1.2 9.41946138211e-08 1.2 9.42263719512e-08 1.2 9.42581300813e-08 1.2 9.42898882114e-08 1.2 9.43216463415e-08 1.2 9.43534044715e-08 1.2 9.43851626016e-08 1.2 9.44169207317e-08 1.2 9.44486788618e-08 1.2 9.44804369919e-08 1.2 9.4512195122e-08 1.2 9.4543953252e-08 1.2 9.45757113821e-08 1.2 9.46074695122e-08 1.2 9.46392276423e-08 1.2 9.46709857724e-08 1.2 9.47027439024e-08 1.2 9.47345020325e-08 1.2 9.47662601626e-08 1.2 9.47980182927e-08 1.2 9.48297764228e-08 1.2 9.48615345528e-08 1.2 9.48932926829e-08 1.2 9.4925050813e-08 1.2 9.49568089431e-08 1.2 9.49885670732e-08 1.2 9.50203252033e-08 1.2 9.50520833333e-08 1.2 9.50838414634e-08 1.2 9.51155995935e-08 1.2 9.51473577236e-08 1.2 9.51791158537e-08 1.2 9.52108739837e-08 1.2 9.52426321138e-08 1.2 9.52743902439e-08 1.2 9.5306148374e-08 1.2 9.53379065041e-08 1.2 9.53696646341e-08 1.2 9.54014227642e-08 1.2 9.54331808943e-08 1.2 9.54649390244e-08 1.2 9.54966971545e-08 1.2 9.55284552846e-08 1.2 9.55602134146e-08 1.2 9.55919715447e-08 1.2 9.56237296748e-08 1.2 9.56554878049e-08 1.2 9.5687245935e-08 1.2 9.5719004065e-08 1.2 9.57507621951e-08 1.2 9.57825203252e-08 1.2 9.58142784553e-08 1.2 9.58460365854e-08 1.2 9.58777947154e-08 1.2 9.59095528455e-08 1.2 9.59413109756e-08 1.2 9.59730691057e-08 1.2 9.60048272358e-08 1.2 9.60365853659e-08 1.2 9.60683434959e-08 1.2 9.6100101626e-08 1.2 9.61318597561e-08 1.2 9.61636178862e-08 1.2 9.61953760163e-08 1.2 9.62271341463e-08 1.2 9.62588922764e-08 1.2 9.62906504065e-08 1.2 9.63224085366e-08 1.2 9.63541666667e-08 1.2 9.63859247967e-08 1.2 9.64176829268e-08 1.2 9.64494410569e-08 1.2 9.6481199187e-08 1.2 9.65129573171e-08 1.2 9.65447154472e-08 1.2 9.65764735772e-08 1.2 9.66082317073e-08 1.2 9.66399898374e-08 1.2 9.66717479675e-08 1.2 9.67035060976e-08 1.2 9.67352642276e-08 1.2 9.67670223577e-08 1.2 9.67987804878e-08 1.2 9.68305386179e-08 1.2 9.6862296748e-08 1.2 9.6894054878e-08 1.2 9.69258130081e-08 1.2 9.69575711382e-08 1.2 9.69893292683e-08 1.2 9.70210873984e-08 1.2 9.70528455285e-08 1.2 9.70846036585e-08 1.2 9.71163617886e-08 1.2 9.71481199187e-08 1.2 9.71798780488e-08 1.2 9.72116361789e-08 1.2 9.72433943089e-08 1.2 9.7275152439e-08 1.2 9.73069105691e-08 1.2 9.73386686992e-08 1.2 9.73704268293e-08 1.2 9.74021849593e-08 1.2 9.74339430894e-08 1.2 9.74657012195e-08 1.2 9.74974593496e-08 1.2 9.75292174797e-08 1.2 9.75609756098e-08 1.2 9.75927337398e-08 1.2 9.76244918699e-08 1.2 9.765625e-08 1.2 9.76880081301e-08 1.2 9.77197662602e-08 1.2 9.77515243902e-08 1.2 9.77832825203e-08 1.2 9.78150406504e-08 1.2 9.78467987805e-08 1.2 9.78785569106e-08 1.2 9.79103150407e-08 1.2 9.79420731707e-08 1.2 9.79738313008e-08 1.2 9.80055894309e-08 1.2 9.8037347561e-08 1.2 9.80691056911e-08 1.2 9.81008638211e-08 1.2 9.81326219512e-08 1.2 9.81643800813e-08 1.2 9.81961382114e-08 1.2 9.82278963415e-08 1.2 9.82596544715e-08 1.2 9.82914126016e-08 1.2 9.83231707317e-08 1.2 9.83549288618e-08 1.2 9.83866869919e-08 1.2 9.8418445122e-08 1.2 9.8450203252e-08 1.2 9.84819613821e-08 1.2 9.85137195122e-08 1.2 9.85454776423e-08 1.2 9.85772357724e-08 1.2 9.86089939024e-08 1.2 9.86407520325e-08 1.2 9.86725101626e-08 1.2 9.87042682927e-08 1.2 9.87360264228e-08 1.2 9.87677845528e-08 1.2 9.87995426829e-08 1.2 9.8831300813e-08 1.2 9.88630589431e-08 1.2 9.88948170732e-08 1.2 9.89265752033e-08 1.2 9.89583333333e-08 1.2 9.89900914634e-08 1.2 9.90218495935e-08 1.2 9.90536077236e-08 1.2 9.90853658537e-08 1.2 9.91171239837e-08 1.2 9.91488821138e-08 1.2 9.91806402439e-08 1.2 9.9212398374e-08 1.2 9.92441565041e-08 1.2 9.92759146341e-08 1.2 9.93076727642e-08 1.2 9.93394308943e-08 1.2 9.93711890244e-08 1.2 9.94029471545e-08 1.2 9.94347052846e-08 1.2 9.94664634146e-08 1.2 9.94982215447e-08 1.2 9.95299796748e-08 1.2 9.95617378049e-08 1.2 9.9593495935e-08 1.2 9.9625254065e-08 1.2 9.96570121951e-08 1.2 9.96887703252e-08 1.2 9.97205284553e-08 1.2 9.97522865854e-08 1.2 9.97840447154e-08 1.2 9.98158028455e-08 1.2 9.98475609756e-08 1.2 9.98793191057e-08 1.2 9.99110772358e-08 1.2 9.99428353659e-08 1.2 9.99745934959e-08 1.2 1.00006351626e-07 1.2 1.00038109756e-07 1.2 1.00069867886e-07 1.2 1.00101626016e-07 1.2 1.00133384146e-07 1.2 1.00165142276e-07 1.2 1.00196900407e-07 1.2 1.00228658537e-07 1.2 1.00260416667e-07 1.2 1.00292174797e-07 1.2 1.00323932927e-07 1.2 1.00355691057e-07 1.2 1.00387449187e-07 1.2 1.00419207317e-07 1.2 1.00450965447e-07 1.2 1.00482723577e-07 1.2 1.00514481707e-07 1.2 1.00546239837e-07 1.2 1.00577997967e-07 1.2 1.00609756098e-07 1.2 1.00641514228e-07 1.2 1.00673272358e-07 1.2 1.00705030488e-07 1.2 1.00736788618e-07 1.2 1.00768546748e-07 1.2 1.00800304878e-07 1.2 1.00832063008e-07 1.2 1.00863821138e-07 1.2 1.00895579268e-07 1.2 1.00927337398e-07 1.2 1.00959095528e-07 1.2 1.00990853659e-07 1.2 1.01022611789e-07 1.2 1.01054369919e-07 1.2 1.01086128049e-07 1.2 1.01117886179e-07 1.2 1.01149644309e-07 1.2 1.01181402439e-07 1.2 1.01213160569e-07 1.2 1.01244918699e-07 1.2 1.01276676829e-07 1.2 1.01308434959e-07 1.2 1.01340193089e-07 1.2 1.0137195122e-07 1.2 1.0140370935e-07 1.2 1.0143546748e-07 1.2 1.0146722561e-07 1.2 1.0149898374e-07 1.2 1.0153074187e-07 1.2 1.015625e-07 1.2 1.0159425813e-07 1.2 1.0162601626e-07 1.2 1.0165777439e-07 1.2 1.0168953252e-07 1.2 1.0172129065e-07 1.2 1.0175304878e-07 1.2 1.01784806911e-07 1.2 1.01816565041e-07 1.2 1.01848323171e-07 1.2 1.01880081301e-07 1.2 1.01911839431e-07 1.2 1.01943597561e-07 1.2 1.01975355691e-07 1.2 1.02007113821e-07 1.2 1.02038871951e-07 1.2 1.02070630081e-07 1.2 1.02102388211e-07 1.2 1.02134146341e-07 1.2 1.02165904472e-07 1.2 1.02197662602e-07 1.2 1.02229420732e-07 1.2 1.02261178862e-07 1.2 1.02292936992e-07 1.2 1.02324695122e-07 1.2 1.02356453252e-07 1.2 1.02388211382e-07 1.2 1.02419969512e-07 1.2 1.02451727642e-07 1.2 1.02483485772e-07 1.2 1.02515243902e-07 1.2 1.02547002033e-07 1.2 1.02578760163e-07 1.2 1.02610518293e-07 1.2 1.02642276423e-07 1.2 1.02674034553e-07 1.2 1.02705792683e-07 1.2 1.02737550813e-07 1.2 1.02769308943e-07 1.2 1.02801067073e-07 1.2 1.02832825203e-07 1.2 1.02864583333e-07 1.2 1.02896341463e-07 1.2 1.02928099593e-07 1.2 1.02959857724e-07 1.2 1.02991615854e-07 1.2 1.03023373984e-07 1.2 1.03055132114e-07 1.2 1.03086890244e-07 1.2 1.03118648374e-07 1.2 1.03150406504e-07 1.2 1.03182164634e-07 1.2 1.03213922764e-07 1.2 1.03245680894e-07 1.2 1.03277439024e-07 1.2 1.03309197154e-07 1.2 1.03340955285e-07 1.2 1.03372713415e-07 1.2 1.03404471545e-07 1.2 1.03436229675e-07 1.2 1.03467987805e-07 1.2 1.03499745935e-07 1.2 1.03531504065e-07 1.2 1.03563262195e-07 1.2 1.03595020325e-07 1.2 1.03626778455e-07 1.2 1.03658536585e-07 1.2 1.03690294715e-07 1.2 1.03722052846e-07 1.2 1.03753810976e-07 1.2 1.03785569106e-07 1.2 1.03817327236e-07 1.2 1.03849085366e-07 1.2 1.03880843496e-07 1.2 1.03912601626e-07 1.2 1.03944359756e-07 1.2 1.03976117886e-07 1.2 1.04007876016e-07 1.2 1.04039634146e-07 1.2 1.04071392276e-07 1.2 1.04103150407e-07 1.2 1.04134908537e-07 1.2 1.04166666667e-07 1.2 1.04198424797e-07 1.2 1.04230182927e-07 1.2 1.04261941057e-07 1.2 1.04293699187e-07 1.2 1.04325457317e-07 1.2 1.04357215447e-07 1.2 1.04388973577e-07 1.2 1.04420731707e-07 1.2 1.04452489837e-07 1.2 1.04484247967e-07 1.2 1.04516006098e-07 1.2 1.04547764228e-07 1.2 1.04579522358e-07 1.2 1.04611280488e-07 1.2 1.04643038618e-07 1.2 1.04674796748e-07 1.2 1.04706554878e-07 1.2 1.04738313008e-07 1.2 1.04770071138e-07 1.2 1.04801829268e-07 1.2 1.04833587398e-07 1.2 1.04865345528e-07 1.2 1.04897103659e-07 1.2 1.04928861789e-07 1.2 1.04960619919e-07 1.2 1.04992378049e-07 1.2 1.05024136179e-07 1.2 1.05055894309e-07 1.2 1.05087652439e-07 1.2 1.05119410569e-07 1.2 1.05151168699e-07 1.2 1.05182926829e-07 1.2 1.05214684959e-07 1.2 1.05246443089e-07 1.2 1.0527820122e-07 1.2 1.0530995935e-07 1.2 1.0534171748e-07 1.2 1.0537347561e-07 1.2 1.0540523374e-07 1.2 1.0543699187e-07 1.2 1.0546875e-07 1.2 1.0550050813e-07 1.2 1.0553226626e-07 1.2 1.0556402439e-07 1.2 1.0559578252e-07 1.2 1.0562754065e-07 1.2 1.0565929878e-07 1.2 1.05691056911e-07 1.2 1.05722815041e-07 1.2 1.05754573171e-07 1.2 1.05786331301e-07 1.2 1.05818089431e-07 1.2 1.05849847561e-07 1.2 1.05881605691e-07 1.2 1.05913363821e-07 1.2 1.05945121951e-07 1.2 1.05976880081e-07 1.2 1.06008638211e-07 1.2 1.06040396341e-07 1.2 1.06072154472e-07 1.2 1.06103912602e-07 1.2 1.06135670732e-07 1.2 1.06167428862e-07 1.2 1.06199186992e-07 1.2 1.06230945122e-07 1.2 1.06262703252e-07 1.2 1.06294461382e-07 1.2 1.06326219512e-07 1.2 1.06357977642e-07 1.2 1.06389735772e-07 1.2 1.06421493902e-07 1.2 1.06453252033e-07 1.2 1.06485010163e-07 1.2 1.06516768293e-07 1.2 1.06548526423e-07 1.2 1.06580284553e-07 1.2 1.06612042683e-07 1.2 1.06643800813e-07 1.2 1.06675558943e-07 1.2 1.06707317073e-07 1.2 1.06739075203e-07 1.2 1.06770833333e-07 1.2 1.06802591463e-07 1.2 1.06834349593e-07 1.2 1.06866107724e-07 1.2 1.06897865854e-07 1.2 1.06929623984e-07 1.2 1.06961382114e-07 1.2 1.06993140244e-07 1.2 1.07024898374e-07 1.2 1.07056656504e-07 1.2 1.07088414634e-07 1.2 1.07120172764e-07 1.2 1.07151930894e-07 1.2 1.07183689024e-07 1.2 1.07215447154e-07 1.2 1.07247205285e-07 1.2 1.07278963415e-07 1.2 1.07310721545e-07 1.2 1.07342479675e-07 1.2 1.07374237805e-07 1.2 1.07405995935e-07 1.2 1.07437754065e-07 1.2 1.07469512195e-07 1.2 1.07501270325e-07 1.2 1.07533028455e-07 1.2 1.07564786585e-07 1.2 1.07596544715e-07 1.2 1.07628302846e-07 1.2 1.07660060976e-07 1.2 1.07691819106e-07 1.2 1.07723577236e-07 1.2 1.07755335366e-07 1.2 1.07787093496e-07 1.2 1.07818851626e-07 1.2 1.07850609756e-07 1.2 1.07882367886e-07 1.2 1.07914126016e-07 1.2 1.07945884146e-07 1.2 1.07977642276e-07 1.2 1.08009400407e-07 1.2 1.08041158537e-07 1.2 1.08072916667e-07 1.2 1.08104674797e-07 1.2 1.08136432927e-07 1.2 1.08168191057e-07 1.2 1.08199949187e-07 1.2 1.08231707317e-07 1.2 1.08263465447e-07 1.2 1.08295223577e-07 1.2 1.08326981707e-07 1.2 1.08358739837e-07 1.2 1.08390497967e-07 1.2 1.08422256098e-07 1.2 1.08454014228e-07 1.2 1.08485772358e-07 1.2 1.08517530488e-07 1.2 1.08549288618e-07 1.2 1.08581046748e-07 1.2 1.08612804878e-07 1.2 1.08644563008e-07 1.2 1.08676321138e-07 1.2 1.08708079268e-07 1.2 1.08739837398e-07 1.2 1.08771595528e-07 1.2 1.08803353659e-07 1.2 1.08835111789e-07 1.2 1.08866869919e-07 1.2 1.08898628049e-07 1.2 1.08930386179e-07 1.2 1.08962144309e-07 1.2 1.08993902439e-07 1.2 1.09025660569e-07 1.2 1.09057418699e-07 1.2 1.09089176829e-07 1.2 1.09120934959e-07 1.2 1.09152693089e-07 1.2 1.0918445122e-07 1.2 1.0921620935e-07 1.2 1.0924796748e-07 1.2 1.0927972561e-07 1.2 1.0931148374e-07 1.2 1.0934324187e-07 1.2 1.09375e-07 1.2 1.0940675813e-07 1.2 1.0943851626e-07 1.2 1.0947027439e-07 1.2 1.0950203252e-07 1.2 1.0953379065e-07 1.2 1.0956554878e-07 1.2 1.09597306911e-07 1.2 1.09629065041e-07 1.2 1.09660823171e-07 1.2 1.09692581301e-07 1.2 1.09724339431e-07 1.2 1.09756097561e-07 1.2 1.09787855691e-07 1.2 1.09819613821e-07 1.2 1.09851371951e-07 1.2 1.09883130081e-07 1.2 1.09914888211e-07 1.2 1.09946646341e-07 1.2 1.09978404472e-07 1.2 1.10010162602e-07 1.2 1.10041920732e-07 1.2 1.10073678862e-07 1.2 1.10105436992e-07 1.2 1.10137195122e-07 1.2 1.10168953252e-07 1.2 1.10200711382e-07 1.2 1.10232469512e-07 1.2 1.10264227642e-07 1.2 1.10295985772e-07 1.2 1.10327743902e-07 1.2 1.10359502033e-07 1.2 1.10391260163e-07 1.2 1.10423018293e-07 1.2 1.10454776423e-07 1.2 1.10486534553e-07 1.2 1.10518292683e-07 1.2 1.10550050813e-07 1.2 1.10581808943e-07 1.2 1.10613567073e-07 1.2 1.10645325203e-07 1.2 1.10677083333e-07 1.2 1.10708841463e-07 1.2 1.10740599593e-07 1.2 1.10772357724e-07 1.2 1.10804115854e-07 1.2 1.10835873984e-07 1.2 1.10867632114e-07 1.2 1.10899390244e-07 1.2 1.10931148374e-07 1.2 1.10962906504e-07 1.2 1.10994664634e-07 1.2 1.11026422764e-07 1.2 1.11058180894e-07 1.2 1.11089939024e-07 1.2 1.11121697154e-07 1.2 1.11153455285e-07 1.2 1.11185213415e-07 1.2 1.11216971545e-07 1.2 1.11248729675e-07 1.2 1.11280487805e-07 1.2 1.11312245935e-07 1.2 1.11344004065e-07 1.2 1.11375762195e-07 1.2 1.11407520325e-07 1.2 1.11439278455e-07 1.2 1.11471036585e-07 1.2 1.11502794715e-07 1.2 1.11534552846e-07 1.2 1.11566310976e-07 1.2 1.11598069106e-07 1.2 1.11629827236e-07 1.2 1.11661585366e-07 1.2 1.11693343496e-07 1.2 1.11725101626e-07 1.2 1.11756859756e-07 1.2 1.11788617886e-07 1.2 1.11820376016e-07 1.2 1.11852134146e-07 1.2 1.11883892276e-07 1.2 1.11915650407e-07 1.2 1.11947408537e-07 1.2 1.11979166667e-07 1.2 1.12010924797e-07 1.2 1.12042682927e-07 1.2 1.12074441057e-07 1.2 1.12106199187e-07 1.2 1.12137957317e-07 1.2 1.12169715447e-07 1.2 1.12201473577e-07 1.2 1.12233231707e-07 1.2 1.12264989837e-07 1.2 1.12296747967e-07 1.2 1.12328506098e-07 1.2 1.12360264228e-07 1.2 1.12392022358e-07 1.2 1.12423780488e-07 1.2 1.12455538618e-07 1.2 1.12487296748e-07 1.2 1.12519054878e-07 1.2 1.12550813008e-07 1.2 1.12582571138e-07 1.2 1.12614329268e-07 1.2 1.12646087398e-07 1.2 1.12677845528e-07 1.2 1.12709603659e-07 1.2 1.12741361789e-07 1.2 1.12773119919e-07 1.2 1.12804878049e-07 1.2 1.12836636179e-07 1.2 1.12868394309e-07 1.2 1.12900152439e-07 1.2 1.12931910569e-07 1.2 1.12963668699e-07 1.2 1.12995426829e-07 1.2 1.13027184959e-07 1.2 1.13058943089e-07 1.2 1.1309070122e-07 1.2 1.1312245935e-07 1.2 1.1315421748e-07 1.2 1.1318597561e-07 1.2 1.1321773374e-07 1.2 1.1324949187e-07 1.2 1.1328125e-07 1.2 1.1331300813e-07 1.2 1.1334476626e-07 1.2 1.1337652439e-07 1.2 1.1340828252e-07 1.2 1.1344004065e-07 1.2 1.1347179878e-07 1.2 1.13503556911e-07 1.2 1.13535315041e-07 1.2 1.13567073171e-07 1.2 1.13598831301e-07 1.2 1.13630589431e-07 1.2 1.13662347561e-07 1.2 1.13694105691e-07 1.2 1.13725863821e-07 1.2 1.13757621951e-07 1.2 1.13789380081e-07 1.2 1.13821138211e-07 1.2 1.13852896341e-07 1.2 1.13884654472e-07 1.2 1.13916412602e-07 1.2 1.13948170732e-07 1.2 1.13979928862e-07 1.2 1.14011686992e-07 1.2 1.14043445122e-07 1.2 1.14075203252e-07 1.2 1.14106961382e-07 1.2 1.14138719512e-07 1.2 1.14170477642e-07 1.2 1.14202235772e-07 1.2 1.14233993902e-07 1.2 1.14265752033e-07 1.2 1.14297510163e-07 1.2 1.14329268293e-07 1.2 1.14361026423e-07 1.2 1.14392784553e-07 1.2 1.14424542683e-07 1.2 1.14456300813e-07 1.2 1.14488058943e-07 1.2 1.14519817073e-07 1.2 1.14551575203e-07 1.2 1.14583333333e-07 1.2 1.14615091463e-07 1.2 1.14646849593e-07 1.2 1.14678607724e-07 1.2 1.14710365854e-07 1.2 1.14742123984e-07 1.2 1.14773882114e-07 1.2 1.14805640244e-07 1.2 1.14837398374e-07 1.2 1.14869156504e-07 1.2 1.14900914634e-07 1.2 1.14932672764e-07 1.2 1.14964430894e-07 1.2 1.14996189024e-07 1.2 1.15027947154e-07 1.2 1.15059705285e-07 1.2 1.15091463415e-07 1.2 1.15123221545e-07 1.2 1.15154979675e-07 1.2 1.15186737805e-07 1.2 1.15218495935e-07 1.2 1.15250254065e-07 1.2 1.15282012195e-07 1.2 1.15313770325e-07 1.2 1.15345528455e-07 1.2 1.15377286585e-07 1.2 1.15409044715e-07 1.2 1.15440802846e-07 1.2 1.15472560976e-07 1.2 1.15504319106e-07 1.2 1.15536077236e-07 1.2 1.15567835366e-07 1.2 1.15599593496e-07 1.2 1.15631351626e-07 1.2 1.15663109756e-07 1.2 1.15694867886e-07 1.2 1.15726626016e-07 1.2 1.15758384146e-07 1.2 1.15790142276e-07 1.2 1.15821900407e-07 1.2 1.15853658537e-07 1.2 1.15885416667e-07 1.2 1.15917174797e-07 1.2 1.15948932927e-07 1.2 1.15980691057e-07 1.2 1.16012449187e-07 1.2 1.16044207317e-07 1.2 1.16075965447e-07 1.2 1.16107723577e-07 1.2 1.16139481707e-07 1.2 1.16171239837e-07 1.2 1.16202997967e-07 1.2 1.16234756098e-07 1.2 1.16266514228e-07 1.2 1.16298272358e-07 1.2 1.16330030488e-07 1.2 1.16361788618e-07 1.2 1.16393546748e-07 1.2 1.16425304878e-07 1.2 1.16457063008e-07 1.2 1.16488821138e-07 1.2 1.16520579268e-07 1.2 1.16552337398e-07 1.2 1.16584095528e-07 1.2 1.16615853659e-07 1.2 1.16647611789e-07 1.2 1.16679369919e-07 1.2 1.16711128049e-07 1.2 1.16742886179e-07 1.2 1.16774644309e-07 1.2 1.16806402439e-07 1.2 1.16838160569e-07 1.2 1.16869918699e-07 1.2 1.16901676829e-07 1.2 1.16933434959e-07 1.2 1.16965193089e-07 1.2 1.1699695122e-07 1.2 1.1702870935e-07 1.2 1.1706046748e-07 1.2 1.1709222561e-07 1.2 1.1712398374e-07 1.2 1.1715574187e-07 1.2 1.171875e-07 1.2 1.1721925813e-07 1.2 1.1725101626e-07 1.2 1.1728277439e-07 1.2 1.1731453252e-07 1.2 1.1734629065e-07 1.2 1.1737804878e-07 1.2 1.17409806911e-07 1.2 1.17441565041e-07 1.2 1.17473323171e-07 1.2 1.17505081301e-07 1.2 1.17536839431e-07 1.2 1.17568597561e-07 1.2 1.17600355691e-07 1.2 1.17632113821e-07 1.2 1.17663871951e-07 1.2 1.17695630081e-07 1.2 1.17727388211e-07 1.2 1.17759146341e-07 1.2 1.17790904472e-07 1.2 1.17822662602e-07 1.2 1.17854420732e-07 1.2 1.17886178862e-07 1.2 1.17917936992e-07 1.2 1.17949695122e-07 1.2 1.17981453252e-07 1.2 1.18013211382e-07 1.2 1.18044969512e-07 1.2 1.18076727642e-07 1.2 1.18108485772e-07 1.2 1.18140243902e-07 1.2 1.18172002033e-07 1.2 1.18203760163e-07 1.2 1.18235518293e-07 1.2 1.18267276423e-07 1.2 1.18299034553e-07 1.2 1.18330792683e-07 1.2 1.18362550813e-07 1.2 1.18394308943e-07 1.2 1.18426067073e-07 1.2 1.18457825203e-07 1.2 1.18489583333e-07 1.2 1.18521341463e-07 1.2 1.18553099593e-07 1.2 1.18584857724e-07 1.2 1.18616615854e-07 1.2 1.18648373984e-07 1.2 1.18680132114e-07 1.2 1.18711890244e-07 1.2 1.18743648374e-07 1.2 1.18775406504e-07 1.2 1.18807164634e-07 1.2 1.18838922764e-07 1.2 1.18870680894e-07 1.2 1.18902439024e-07 1.2 1.18934197154e-07 1.2 1.18965955285e-07 1.2 1.18997713415e-07 1.2 1.19029471545e-07 1.2 1.19061229675e-07 1.2 1.19092987805e-07 1.2 1.19124745935e-07 1.2 1.19156504065e-07 1.2 1.19188262195e-07 1.2 1.19220020325e-07 1.2 1.19251778455e-07 1.2 1.19283536585e-07 1.2 1.19315294715e-07 1.2 1.19347052846e-07 1.2 1.19378810976e-07 1.2 1.19410569106e-07 1.2 1.19442327236e-07 1.2 1.19474085366e-07 1.2 1.19505843496e-07 1.2 1.19537601626e-07 1.2 1.19569359756e-07 1.2 1.19601117886e-07 1.2 1.19632876016e-07 1.2 1.19664634146e-07 1.2 1.19696392276e-07 1.2 1.19728150407e-07 1.2 1.19759908537e-07 1.2 1.19791666667e-07 1.2 1.19823424797e-07 1.2 1.19855182927e-07 1.2 1.19886941057e-07 1.2 1.19918699187e-07 1.2 1.19950457317e-07 1.2 1.19982215447e-07 1.2 1.20013973577e-07 1.2 1.20045731707e-07 1.2 1.20077489837e-07 1.2 1.20109247967e-07 1.2 1.20141006098e-07 1.2 1.20172764228e-07 1.2 1.20204522358e-07 1.2 1.20236280488e-07 1.2 1.20268038618e-07 1.2 1.20299796748e-07 1.2 1.20331554878e-07 1.2 1.20363313008e-07 1.2 1.20395071138e-07 1.2 1.20426829268e-07 1.2 1.20458587398e-07 1.2 1.20490345528e-07 1.2 1.20522103659e-07 1.2 1.20553861789e-07 1.2 1.20585619919e-07 1.2 1.20617378049e-07 1.2 1.20649136179e-07 1.2 1.20680894309e-07 1.2 1.20712652439e-07 1.2 1.20744410569e-07 1.2 1.20776168699e-07 1.2 1.20807926829e-07 1.2 1.20839684959e-07 1.2 1.20871443089e-07 1.2 1.2090320122e-07 1.2 1.2093495935e-07 1.2 1.2096671748e-07 1.2 1.2099847561e-07 1.2 1.2103023374e-07 1.2 1.2106199187e-07 1.2 1.2109375e-07 1.2 1.2112550813e-07 1.2 1.2115726626e-07 1.2 1.2118902439e-07 1.2 1.2122078252e-07 1.2 1.2125254065e-07 1.2 1.2128429878e-07 1.2 1.21316056911e-07 1.2 1.21347815041e-07 1.2 1.21379573171e-07 1.2 1.21411331301e-07 1.2 1.21443089431e-07 1.2 1.21474847561e-07 1.2 1.21506605691e-07 1.2 1.21538363821e-07 1.2 1.21570121951e-07 1.2 1.21601880081e-07 1.2 1.21633638211e-07 1.2 1.21665396341e-07 1.2 1.21697154472e-07 1.2 1.21728912602e-07 1.2 1.21760670732e-07 1.2 1.21792428862e-07 1.2 1.21824186992e-07 1.2 1.21855945122e-07 1.2 1.21887703252e-07 1.2 1.21919461382e-07 1.2 1.21951219512e-07 1.2 1.21982977642e-07 1.2 1.22014735772e-07 1.2 1.22046493902e-07 1.2 1.22078252033e-07 1.2 1.22110010163e-07 1.2 1.22141768293e-07 1.2 1.22173526423e-07 1.2 1.22205284553e-07 1.2 1.22237042683e-07 1.2 1.22268800813e-07 1.2 1.22300558943e-07 1.2 1.22332317073e-07 1.2 1.22364075203e-07 1.2 1.22395833333e-07 1.2 1.22427591463e-07 1.2 1.22459349593e-07 1.2 1.22491107724e-07 1.2 1.22522865854e-07 1.2 1.22554623984e-07 1.2 1.22586382114e-07 1.2 1.22618140244e-07 1.2 1.22649898374e-07 1.2 1.22681656504e-07 1.2 1.22713414634e-07 1.2 1.22745172764e-07 1.2 1.22776930894e-07 1.2 1.22808689024e-07 1.2 1.22840447154e-07 1.2 1.22872205285e-07 1.2 1.22903963415e-07 1.2 1.22935721545e-07 1.2 1.22967479675e-07 1.2 1.22999237805e-07 1.2 1.23030995935e-07 1.2 1.23062754065e-07 1.2 1.23094512195e-07 1.2 1.23126270325e-07 1.2 1.23158028455e-07 1.2 1.23189786585e-07 1.2 1.23221544715e-07 1.2 1.23253302846e-07 1.2 1.23285060976e-07 1.2 1.23316819106e-07 1.2 1.23348577236e-07 1.2 1.23380335366e-07 1.2 1.23412093496e-07 1.2 1.23443851626e-07 1.2 1.23475609756e-07 1.2 1.23507367886e-07 1.2 1.23539126016e-07 1.2 1.23570884146e-07 1.2 1.23602642276e-07 1.2 1.23634400407e-07 1.2 1.23666158537e-07 1.2 1.23697916667e-07 1.2 1.23729674797e-07 1.2 1.23761432927e-07 1.2 1.23793191057e-07 1.2 1.23824949187e-07 1.2 1.23856707317e-07 1.2 1.23888465447e-07 1.2 1.23920223577e-07 1.2 1.23951981707e-07 1.2 1.23983739837e-07 1.2 1.24015497967e-07 1.2 1.24047256098e-07 1.2 1.24079014228e-07 1.2 1.24110772358e-07 1.2 1.24142530488e-07 1.2 1.24174288618e-07 1.2 1.24206046748e-07 1.2 1.24237804878e-07 1.2 1.24269563008e-07 1.2 1.24301321138e-07 1.2 1.24333079268e-07 1.2 1.24364837398e-07 1.2 1.24396595528e-07 1.2 1.24428353659e-07 1.2 1.24460111789e-07 1.2 1.24491869919e-07 1.2 1.24523628049e-07 1.2 1.24555386179e-07 1.2 1.24587144309e-07 1.2 1.24618902439e-07 1.2 1.24650660569e-07 1.2 1.24682418699e-07 1.2 1.24714176829e-07 1.2 1.24745934959e-07 1.2 1.24777693089e-07 1.2 1.2480945122e-07 1.2 1.2484120935e-07 1.2 1.2487296748e-07 1.2 1.2490472561e-07 1.2 1.2493648374e-07 1.2 1.2496824187e-07 1.2 1.25e-07 1.2 1.2503175813e-07 1.2 1.2506351626e-07 1.2 1.2509527439e-07 1.2 1.2512703252e-07 1.2 1.2515879065e-07 1.2 1.2519054878e-07 1.2 1.25222306911e-07 1.2 1.25254065041e-07 1.2 1.25285823171e-07 1.2 1.25317581301e-07 1.2 1.25349339431e-07 1.2 1.25381097561e-07 1.2 1.25412855691e-07 1.2 1.25444613821e-07 1.2 1.25476371951e-07 1.2 1.25508130081e-07 1.2 1.25539888211e-07 1.2 1.25571646341e-07 1.2 1.25603404472e-07 1.2 1.25635162602e-07 1.2 1.25666920732e-07 1.2 1.25698678862e-07 1.2 1.25730436992e-07 1.2 1.25762195122e-07 1.2 1.25793953252e-07 1.2 1.25825711382e-07 1.2 1.25857469512e-07 1.2 1.25889227642e-07 1.2 1.25920985772e-07 1.2 1.25952743902e-07 1.2 1.25984502033e-07 1.2 1.26016260163e-07 1.2 1.26048018293e-07 1.2 1.26079776423e-07 1.2 1.26111534553e-07 1.2 1.26143292683e-07 1.2 1.26175050813e-07 1.2 1.26206808943e-07 1.2 1.26238567073e-07 1.2 1.26270325203e-07 1.2 1.26302083333e-07 1.2 1.26333841463e-07 1.2 1.26365599593e-07 1.2 1.26397357724e-07 1.2 1.26429115854e-07 1.2 1.26460873984e-07 1.2 1.26492632114e-07 1.2 1.26524390244e-07 1.2 1.26556148374e-07 1.2 1.26587906504e-07 1.2 1.26619664634e-07 1.2 1.26651422764e-07 1.2 1.26683180894e-07 1.2 1.26714939024e-07 1.2 1.26746697154e-07 1.2 1.26778455285e-07 1.2 1.26810213415e-07 1.2 1.26841971545e-07 1.2 1.26873729675e-07 1.2 1.26905487805e-07 1.2 1.26937245935e-07 1.2 1.26969004065e-07 1.2 1.27000762195e-07 1.2 1.27032520325e-07 1.2 1.27064278455e-07 1.2 1.27096036585e-07 1.2 1.27127794715e-07 1.2 1.27159552846e-07 1.2 1.27191310976e-07 1.2 1.27223069106e-07 1.2 1.27254827236e-07 1.2 1.27286585366e-07 1.2 1.27318343496e-07 1.2 1.27350101626e-07 1.2 1.27381859756e-07 1.2 1.27413617886e-07 1.2 1.27445376016e-07 1.2 1.27477134146e-07 1.2 1.27508892276e-07 1.2 1.27540650407e-07 1.2 1.27572408537e-07 1.2 1.27604166667e-07 1.2 1.27635924797e-07 1.2 1.27667682927e-07 1.2 1.27699441057e-07 1.2 1.27731199187e-07 1.2 1.27762957317e-07 1.2 1.27794715447e-07 1.2 1.27826473577e-07 1.2 1.27858231707e-07 1.2 1.27889989837e-07 1.2 1.27921747967e-07 1.2 1.27953506098e-07 1.2 1.27985264228e-07 1.2 1.28017022358e-07 1.2 1.28048780488e-07 1.2 1.28080538618e-07 1.2 1.28112296748e-07 1.2 1.28144054878e-07 1.2 1.28175813008e-07 1.2 1.28207571138e-07 1.2 1.28239329268e-07 1.2 1.28271087398e-07 1.2 1.28302845528e-07 1.2 1.28334603659e-07 1.2 1.28366361789e-07 1.2 1.28398119919e-07 1.2 1.28429878049e-07 1.2 1.28461636179e-07 1.2 1.28493394309e-07 1.2 1.28525152439e-07 1.2 1.28556910569e-07 1.2 1.28588668699e-07 1.2 1.28620426829e-07 1.2 1.28652184959e-07 1.2 1.28683943089e-07 1.2 1.2871570122e-07 1.2 1.2874745935e-07 1.2 1.2877921748e-07 1.2 1.2881097561e-07 1.2 1.2884273374e-07 1.2 1.2887449187e-07 1.2 1.2890625e-07 1.2 1.2893800813e-07 1.2 1.2896976626e-07 1.2 1.2900152439e-07 1.2 1.2903328252e-07 1.2 1.2906504065e-07 1.2 1.2909679878e-07 1.2 1.29128556911e-07 1.2 1.29160315041e-07 1.2 1.29192073171e-07 1.2 1.29223831301e-07 1.2 1.29255589431e-07 1.2 1.29287347561e-07 1.2 1.29319105691e-07 1.2 1.29350863821e-07 1.2 1.29382621951e-07 1.2 1.29414380081e-07 1.2 1.29446138211e-07 1.2 1.29477896341e-07 1.2 1.29509654472e-07 1.2 1.29541412602e-07 1.2 1.29573170732e-07 1.2 1.29604928862e-07 1.2 1.29636686992e-07 1.2 1.29668445122e-07 1.2 1.29700203252e-07 1.2 1.29731961382e-07 1.2 1.29763719512e-07 1.2 1.29795477642e-07 1.2 1.29827235772e-07 1.2 1.29858993902e-07 1.2 1.29890752033e-07 1.2 1.29922510163e-07 1.2 1.29954268293e-07 1.2 1.29986026423e-07 1.2 1.30017784553e-07 1.2 1.30049542683e-07 1.2 1.30081300813e-07 1.2 1.30113058943e-07 1.2 1.30144817073e-07 1.2 1.30176575203e-07 1.2 1.30208333333e-07 1.2 1.30240091463e-07 1.2 1.30271849593e-07 1.2 1.30303607724e-07 1.2 1.30335365854e-07 1.2 1.30367123984e-07 1.2 1.30398882114e-07 1.2 1.30430640244e-07 1.2 1.30462398374e-07 1.2 1.30494156504e-07 1.2 1.30525914634e-07 1.2 1.30557672764e-07 1.2 1.30589430894e-07 1.2 1.30621189024e-07 1.2 1.30652947154e-07 1.2 1.30684705285e-07 1.2 1.30716463415e-07 1.2 1.30748221545e-07 1.2 1.30779979675e-07 1.2 1.30811737805e-07 1.2 1.30843495935e-07 1.2 1.30875254065e-07 1.2 1.30907012195e-07 1.2 1.30938770325e-07 1.2 1.30970528455e-07 1.2 1.31002286585e-07 1.2 1.31034044715e-07 1.2 1.31065802846e-07 1.2 1.31097560976e-07 1.2 1.31129319106e-07 1.2 1.31161077236e-07 1.2 1.31192835366e-07 1.2 1.31224593496e-07 1.2 1.31256351626e-07 1.2 1.31288109756e-07 1.2 1.31319867886e-07 1.2 1.31351626016e-07 1.2 1.31383384146e-07 1.2 1.31415142276e-07 1.2 1.31446900407e-07 1.2 1.31478658537e-07 1.2 1.31510416667e-07 1.2 1.31542174797e-07 1.2 1.31573932927e-07 1.2 1.31605691057e-07 1.2 1.31637449187e-07 1.2 1.31669207317e-07 1.2 1.31700965447e-07 1.2 1.31732723577e-07 1.2 1.31764481707e-07 1.2 1.31796239837e-07 1.2 1.31827997967e-07 1.2 1.31859756098e-07 1.2 1.31891514228e-07 1.2 1.31923272358e-07 1.2 1.31955030488e-07 1.2 1.31986788618e-07 1.2 1.32018546748e-07 1.2 1.32050304878e-07 1.2 1.32082063008e-07 1.2 1.32113821138e-07 1.2 1.32145579268e-07 1.2 1.32177337398e-07 1.2 1.32209095528e-07 1.2 1.32240853659e-07 1.2 1.32272611789e-07 1.2 1.32304369919e-07 1.2 1.32336128049e-07 1.2 1.32367886179e-07 1.2 1.32399644309e-07 1.2 1.32431402439e-07 1.2 1.32463160569e-07 1.2 1.32494918699e-07 1.2 1.32526676829e-07 1.2 1.32558434959e-07 1.2 1.32590193089e-07 1.2 1.3262195122e-07 1.2 1.3265370935e-07 1.2 1.3268546748e-07 1.2 1.3271722561e-07 1.2 1.3274898374e-07 1.2 1.3278074187e-07 1.2 1.328125e-07 1.2 1.3284425813e-07 1.2 1.3287601626e-07 1.2 1.3290777439e-07 1.2 1.3293953252e-07 1.2 1.3297129065e-07 1.2 1.3300304878e-07 1.2 1.33034806911e-07 1.2 1.33066565041e-07 1.2 1.33098323171e-07 1.2 1.33130081301e-07 1.2 1.33161839431e-07 1.2 1.33193597561e-07 1.2 1.33225355691e-07 1.2 1.33257113821e-07 1.2 1.33288871951e-07 1.2 1.33320630081e-07 1.2 1.33352388211e-07 1.2 1.33384146341e-07 1.2 1.33415904472e-07 1.2 1.33447662602e-07 1.2 1.33479420732e-07 1.2 1.33511178862e-07 1.2 1.33542936992e-07 1.2 1.33574695122e-07 1.2 1.33606453252e-07 1.2 1.33638211382e-07 1.2 1.33669969512e-07 1.2 1.33701727642e-07 1.2 1.33733485772e-07 1.2 1.33765243902e-07 1.2 1.33797002033e-07 1.2 1.33828760163e-07 1.2 1.33860518293e-07 1.2 1.33892276423e-07 1.2 1.33924034553e-07 1.2 1.33955792683e-07 1.2 1.33987550813e-07 1.2 1.34019308943e-07 1.2 1.34051067073e-07 1.2 1.34082825203e-07 1.2 1.34114583333e-07 1.2 1.34146341463e-07 1.2 1.34178099593e-07 1.2 1.34209857724e-07 1.2 1.34241615854e-07 1.2 1.34273373984e-07 1.2 1.34305132114e-07 1.2 1.34336890244e-07 1.2 1.34368648374e-07 1.2 1.34400406504e-07 1.2 1.34432164634e-07 1.2 1.34463922764e-07 1.2 1.34495680894e-07 1.2 1.34527439024e-07 1.2 1.34559197154e-07 1.2 1.34590955285e-07 1.2 1.34622713415e-07 1.2 1.34654471545e-07 1.2 1.34686229675e-07 1.2 1.34717987805e-07 1.2 1.34749745935e-07 1.2 1.34781504065e-07 1.2 1.34813262195e-07 1.2 1.34845020325e-07 1.2 1.34876778455e-07 1.2 1.34908536585e-07 1.2 1.34940294715e-07 1.2 1.34972052846e-07 1.2 1.35003810976e-07 1.2 1.35035569106e-07 1.2 1.35067327236e-07 1.2 1.35099085366e-07 1.2 1.35130843496e-07 1.2 1.35162601626e-07 1.2 1.35194359756e-07 1.2 1.35226117886e-07 1.2 1.35257876016e-07 1.2 1.35289634146e-07 1.2 1.35321392276e-07 1.2 1.35353150407e-07 1.2 1.35384908537e-07 1.2 1.35416666667e-07 1.2 1.35448424797e-07 1.2 1.35480182927e-07 1.2 1.35511941057e-07 1.2 1.35543699187e-07 1.2 1.35575457317e-07 1.2 1.35607215447e-07 1.2 1.35638973577e-07 1.2 1.35670731707e-07 1.2 1.35702489837e-07 1.2 1.35734247967e-07 1.2 1.35766006098e-07 1.2 1.35797764228e-07 1.2 1.35829522358e-07 1.2 1.35861280488e-07 1.2 1.35893038618e-07 1.2 1.35924796748e-07 1.2 1.35956554878e-07 1.2 1.35988313008e-07 1.2 1.36020071138e-07 1.2 1.36051829268e-07 1.2 1.36083587398e-07 1.2 1.36115345528e-07 1.2 1.36147103659e-07 1.2 1.36178861789e-07 1.2 1.36210619919e-07 1.2 1.36242378049e-07 1.2 1.36274136179e-07 1.2 1.36305894309e-07 1.2 1.36337652439e-07 1.2 1.36369410569e-07 1.2 1.36401168699e-07 1.2 1.36432926829e-07 1.2 1.36464684959e-07 1.2 1.36496443089e-07 1.2 1.3652820122e-07 1.2 1.3655995935e-07 1.2 1.3659171748e-07 1.2 1.3662347561e-07 1.2 1.3665523374e-07 1.2 1.3668699187e-07 1.2 1.3671875e-07 1.2 1.3675050813e-07 1.2 1.3678226626e-07 1.2 1.3681402439e-07 1.2 1.3684578252e-07 1.2 1.3687754065e-07 1.2 1.3690929878e-07 1.2 1.36941056911e-07 1.2 1.36972815041e-07 1.2 1.37004573171e-07 1.2 1.37036331301e-07 1.2 1.37068089431e-07 1.2 1.37099847561e-07 1.2 1.37131605691e-07 1.2 1.37163363821e-07 1.2 1.37195121951e-07 1.2 1.37226880081e-07 1.2 1.37258638211e-07 1.2 1.37290396341e-07 1.2 1.37322154472e-07 1.2 1.37353912602e-07 1.2 1.37385670732e-07 1.2 1.37417428862e-07 1.2 1.37449186992e-07 1.2 1.37480945122e-07 1.2 1.37512703252e-07 1.2 1.37544461382e-07 1.2 1.37576219512e-07 1.2 1.37607977642e-07 1.2 1.37639735772e-07 1.2 1.37671493902e-07 1.2 1.37703252033e-07 1.2 1.37735010163e-07 1.2 1.37766768293e-07 1.2 1.37798526423e-07 1.2 1.37830284553e-07 1.2 1.37862042683e-07 1.2 1.37893800813e-07 1.2 1.37925558943e-07 1.2 1.37957317073e-07 1.2 1.37989075203e-07 1.2 1.38020833333e-07 1.2 1.38052591463e-07 1.2 1.38084349593e-07 1.2 1.38116107724e-07 1.2 1.38147865854e-07 1.2 1.38179623984e-07 1.2 1.38211382114e-07 1.2 1.38243140244e-07 1.2 1.38274898374e-07 1.2 1.38306656504e-07 1.2 1.38338414634e-07 1.2 1.38370172764e-07 1.2 1.38401930894e-07 1.2 1.38433689024e-07 1.2 1.38465447154e-07 1.2 1.38497205285e-07 1.2 1.38528963415e-07 1.2 1.38560721545e-07 1.2 1.38592479675e-07 1.2 1.38624237805e-07 1.2 1.38655995935e-07 1.2 1.38687754065e-07 1.2 1.38719512195e-07 1.2 1.38751270325e-07 1.2 1.38783028455e-07 1.2 1.38814786585e-07 1.2 1.38846544715e-07 1.2 1.38878302846e-07 1.2 1.38910060976e-07 1.2 1.38941819106e-07 1.2 1.38973577236e-07 1.2 1.39005335366e-07 1.2 1.39037093496e-07 1.2 1.39068851626e-07 1.2 1.39100609756e-07 1.2 1.39132367886e-07 1.2 1.39164126016e-07 1.2 1.39195884146e-07 1.2 1.39227642276e-07 1.2 1.39259400407e-07 1.2 1.39291158537e-07 1.2 1.39322916667e-07 1.2 1.39354674797e-07 1.2 1.39386432927e-07 1.2 1.39418191057e-07 1.2 1.39449949187e-07 1.2 1.39481707317e-07 1.2 1.39513465447e-07 1.2 1.39545223577e-07 1.2 1.39576981707e-07 1.2 1.39608739837e-07 1.2 1.39640497967e-07 1.2 1.39672256098e-07 1.2 1.39704014228e-07 1.2 1.39735772358e-07 1.2 1.39767530488e-07 1.2 1.39799288618e-07 1.2 1.39831046748e-07 1.2 1.39862804878e-07 1.2 1.39894563008e-07 1.2 1.39926321138e-07 1.2 1.39958079268e-07 1.2 1.39989837398e-07 1.2 1.40021595528e-07 1.2 1.40053353659e-07 1.2 1.40085111789e-07 1.2 1.40116869919e-07 1.2 1.40148628049e-07 1.2 1.40180386179e-07 1.2 1.40212144309e-07 1.2 1.40243902439e-07 1.2 1.40275660569e-07 1.2 1.40307418699e-07 1.2 1.40339176829e-07 1.2 1.40370934959e-07 1.2 1.40402693089e-07 1.2 1.4043445122e-07 1.2 1.4046620935e-07 1.2 1.4049796748e-07 1.2 1.4052972561e-07 1.2 1.4056148374e-07 1.2 1.4059324187e-07 1.2 1.40625e-07 1.2 1.4065675813e-07 1.2 1.4068851626e-07 1.2 1.4072027439e-07 1.2 1.4075203252e-07 1.2 1.4078379065e-07 1.2 1.4081554878e-07 1.2 1.40847306911e-07 1.2 1.40879065041e-07 1.2 1.40910823171e-07 1.2 1.40942581301e-07 1.2 1.40974339431e-07 1.2 1.41006097561e-07 1.2 1.41037855691e-07 1.2 1.41069613821e-07 1.2 1.41101371951e-07 1.2 1.41133130081e-07 1.2 1.41164888211e-07 1.2 1.41196646341e-07 1.2 1.41228404472e-07 1.2 1.41260162602e-07 1.2 1.41291920732e-07 1.2 1.41323678862e-07 1.2 1.41355436992e-07 1.2 1.41387195122e-07 1.2 1.41418953252e-07 1.2 1.41450711382e-07 1.2 1.41482469512e-07 1.2 1.41514227642e-07 1.2 1.41545985772e-07 1.2 1.41577743902e-07 1.2 1.41609502033e-07 1.2 1.41641260163e-07 1.2 1.41673018293e-07 1.2 1.41704776423e-07 1.2 1.41736534553e-07 1.2 1.41768292683e-07 1.2 1.41800050813e-07 1.2 1.41831808943e-07 1.2 1.41863567073e-07 1.2 1.41895325203e-07 1.2 1.41927083333e-07 1.2 1.41958841463e-07 1.2 1.41990599593e-07 1.2 1.42022357724e-07 1.2 1.42054115854e-07 1.2 1.42085873984e-07 1.2 1.42117632114e-07 1.2 1.42149390244e-07 1.2 1.42181148374e-07 1.2 1.42212906504e-07 1.2 1.42244664634e-07 1.2 1.42276422764e-07 1.2 1.42308180894e-07 1.2 1.42339939024e-07 1.2 1.42371697154e-07 1.2 1.42403455285e-07 1.2 1.42435213415e-07 1.2 1.42466971545e-07 1.2 1.42498729675e-07 1.2 1.42530487805e-07 1.2 1.42562245935e-07 1.2 1.42594004065e-07 1.2 1.42625762195e-07 1.2 1.42657520325e-07 1.2 1.42689278455e-07 1.2 1.42721036585e-07 1.2 1.42752794715e-07 1.2 1.42784552846e-07 1.2 1.42816310976e-07 1.2 1.42848069106e-07 1.2 1.42879827236e-07 1.2 1.42911585366e-07 1.2 1.42943343496e-07 1.2 1.42975101626e-07 1.2 1.43006859756e-07 1.2 1.43038617886e-07 1.2 1.43070376016e-07 1.2 1.43102134146e-07 1.2 1.43133892276e-07 1.2 1.43165650407e-07 1.2 1.43197408537e-07 1.2 1.43229166667e-07 1.2 1.43260924797e-07 1.2 1.43292682927e-07 1.2 1.43324441057e-07 1.2 1.43356199187e-07 1.2 1.43387957317e-07 1.2 1.43419715447e-07 1.2 1.43451473577e-07 1.2 1.43483231707e-07 1.2 1.43514989837e-07 1.2 1.43546747967e-07 1.2 1.43578506098e-07 1.2 1.43610264228e-07 1.2 1.43642022358e-07 1.2 1.43673780488e-07 1.2 1.43705538618e-07 1.2 1.43737296748e-07 1.2 1.43769054878e-07 1.2 1.43800813008e-07 1.2 1.43832571138e-07 1.2 1.43864329268e-07 1.2 1.43896087398e-07 1.2 1.43927845528e-07 1.2 1.43959603659e-07 1.2 1.43991361789e-07 1.2 1.44023119919e-07 1.2 1.44054878049e-07 1.2 1.44086636179e-07 1.2 1.44118394309e-07 1.2 1.44150152439e-07 1.2 1.44181910569e-07 1.2 1.44213668699e-07 1.2 1.44245426829e-07 1.2 1.44277184959e-07 1.2 1.44308943089e-07 1.2 1.4434070122e-07 1.2 1.4437245935e-07 1.2 1.4440421748e-07 1.2 1.4443597561e-07 1.2 1.4446773374e-07 1.2 1.4449949187e-07 1.2 1.4453125e-07 1.2 1.4456300813e-07 1.2 1.4459476626e-07 1.2 1.4462652439e-07 1.2 1.4465828252e-07 1.2 1.4469004065e-07 1.2 1.4472179878e-07 1.2 1.44753556911e-07 1.2 1.44785315041e-07 1.2 1.44817073171e-07 1.2 1.44848831301e-07 1.2 1.44880589431e-07 1.2 1.44912347561e-07 1.2 1.44944105691e-07 1.2 1.44975863821e-07 1.2 1.45007621951e-07 1.2 1.45039380081e-07 1.2 1.45071138211e-07 1.2 1.45102896341e-07 1.2 1.45134654472e-07 1.2 1.45166412602e-07 1.2 1.45198170732e-07 1.2 1.45229928862e-07 1.2 1.45261686992e-07 1.2 1.45293445122e-07 1.2 1.45325203252e-07 1.2 1.45356961382e-07 1.2 1.45388719512e-07 1.2 1.45420477642e-07 1.2 1.45452235772e-07 1.2 1.45483993902e-07 1.2 1.45515752033e-07 1.2 1.45547510163e-07 1.2 1.45579268293e-07 1.2 1.45611026423e-07 1.2 1.45642784553e-07 1.2 1.45674542683e-07 1.2 1.45706300813e-07 1.2 1.45738058943e-07 1.2 1.45769817073e-07 1.2 1.45801575203e-07 1.2 1.45833333333e-07 1.2 1.45865091463e-07 1.2 1.45896849593e-07 1.2 1.45928607724e-07 1.2 1.45960365854e-07 1.2 1.45992123984e-07 1.2 1.46023882114e-07 1.2 1.46055640244e-07 1.2 1.46087398374e-07 1.2 1.46119156504e-07 1.2 1.46150914634e-07 1.2 1.46182672764e-07 1.2 1.46214430894e-07 1.2 1.46246189024e-07 1.2 1.46277947154e-07 1.2 1.46309705285e-07 1.2 1.46341463415e-07 1.2 1.46373221545e-07 1.2 1.46404979675e-07 1.2 1.46436737805e-07 1.2 1.46468495935e-07 1.2 1.46500254065e-07 1.2 1.46532012195e-07 1.2 1.46563770325e-07 1.2 1.46595528455e-07 1.2 1.46627286585e-07 1.2 1.46659044715e-07 1.2 1.46690802846e-07 1.2 1.46722560976e-07 1.2 1.46754319106e-07 1.2 1.46786077236e-07 1.2 1.46817835366e-07 1.2 1.46849593496e-07 1.2 1.46881351626e-07 1.2 1.46913109756e-07 1.2 1.46944867886e-07 1.2 1.46976626016e-07 1.2 1.47008384146e-07 1.2 1.47040142276e-07 1.2 1.47071900407e-07 1.2 1.47103658537e-07 1.2 1.47135416667e-07 1.2 1.47167174797e-07 1.2 1.47198932927e-07 1.2 1.47230691057e-07 1.2 1.47262449187e-07 1.2 1.47294207317e-07 1.2 1.47325965447e-07 1.2 1.47357723577e-07 1.2 1.47389481707e-07 1.2 1.47421239837e-07 1.2 1.47452997967e-07 1.2 1.47484756098e-07 1.2 1.47516514228e-07 1.2 1.47548272358e-07 1.2 1.47580030488e-07 1.2 1.47611788618e-07 1.2 1.47643546748e-07 1.2 1.47675304878e-07 1.2 1.47707063008e-07 1.2 1.47738821138e-07 1.2 1.47770579268e-07 1.2 1.47802337398e-07 1.2 1.47834095528e-07 1.2 1.47865853659e-07 1.2 1.47897611789e-07 1.2 1.47929369919e-07 1.2 1.47961128049e-07 1.2 1.47992886179e-07 1.2 1.48024644309e-07 1.2 1.48056402439e-07 1.2 1.48088160569e-07 1.2 1.48119918699e-07 1.2 1.48151676829e-07 1.2 1.48183434959e-07 1.2 1.48215193089e-07 1.2 1.4824695122e-07 1.2 1.4827870935e-07 1.2 1.4831046748e-07 1.2 1.4834222561e-07 1.2 1.4837398374e-07 1.2 1.4840574187e-07 1.2 1.484375e-07 1.2 1.4846925813e-07 1.2 1.4850101626e-07 1.2 1.4853277439e-07 1.2 1.4856453252e-07 1.2 1.4859629065e-07 1.2 1.4862804878e-07 1.2 1.48659806911e-07 1.2 1.48691565041e-07 1.2 1.48723323171e-07 1.2 1.48755081301e-07 1.2 1.48786839431e-07 1.2 1.48818597561e-07 1.2 1.48850355691e-07 1.2 1.48882113821e-07 1.2 1.48913871951e-07 1.2 1.48945630081e-07 1.2 1.48977388211e-07 1.2 1.49009146341e-07 1.2 1.49040904472e-07 1.2 1.49072662602e-07 1.2 1.49104420732e-07 1.2 1.49136178862e-07 1.2 1.49167936992e-07 1.2 1.49199695122e-07 1.2 1.49231453252e-07 1.2 1.49263211382e-07 1.2 1.49294969512e-07 1.2 1.49326727642e-07 1.2 1.49358485772e-07 1.2 1.49390243902e-07 1.2 1.49422002033e-07 1.2 1.49453760163e-07 1.2 1.49485518293e-07 1.2 1.49517276423e-07 1.2 1.49549034553e-07 1.2 1.49580792683e-07 1.2 1.49612550813e-07 1.2 1.49644308943e-07 1.2 1.49676067073e-07 1.2 1.49707825203e-07 1.2 1.49739583333e-07 1.2 1.49771341463e-07 1.2 1.49803099593e-07 1.2 1.49834857724e-07 1.2 1.49866615854e-07 1.2 1.49898373984e-07 1.2 1.49930132114e-07 1.2 1.49961890244e-07 1.2 1.49993648374e-07 1.2 1.50025406504e-07 1.2 1.50057164634e-07 1.2 1.50088922764e-07 1.2 1.50120680894e-07 1.2 1.50152439024e-07 1.2 1.50184197154e-07 1.2 1.50215955285e-07 1.2 1.50247713415e-07 1.2 1.50279471545e-07 1.2 1.50311229675e-07 1.2 1.50342987805e-07 1.2 1.50374745935e-07 1.2 1.50406504065e-07 1.2 1.50438262195e-07 1.2 1.50470020325e-07 1.2 1.50501778455e-07 1.2 1.50533536585e-07 1.2 1.50565294715e-07 1.2 1.50597052846e-07 1.2 1.50628810976e-07 1.2 1.50660569106e-07 1.2 1.50692327236e-07 1.2 1.50724085366e-07 1.2 1.50755843496e-07 1.2 1.50787601626e-07 1.2 1.50819359756e-07 1.2 1.50851117886e-07 1.2 1.50882876016e-07 1.2 1.50914634146e-07 1.2 1.50946392276e-07 1.2 1.50978150407e-07 1.2 1.51009908537e-07 1.2 1.51041666667e-07 1.2 1.51073424797e-07 1.2 1.51105182927e-07 1.2 1.51136941057e-07 1.2 1.51168699187e-07 1.2 1.51200457317e-07 1.2 1.51232215447e-07 1.2 1.51263973577e-07 1.2 1.51295731707e-07 1.2 1.51327489837e-07 1.2 1.51359247967e-07 1.2 1.51391006098e-07 1.2 1.51422764228e-07 1.2 1.51454522358e-07 1.2 1.51486280488e-07 1.2 1.51518038618e-07 1.2 1.51549796748e-07 1.2 1.51581554878e-07 1.2 1.51613313008e-07 1.2 1.51645071138e-07 1.2 1.51676829268e-07 1.2 1.51708587398e-07 1.2 1.51740345528e-07 1.2 1.51772103659e-07 1.2 1.51803861789e-07 1.2 1.51835619919e-07 1.2 1.51867378049e-07 1.2 1.51899136179e-07 1.2 1.51930894309e-07 1.2 1.51962652439e-07 1.2 1.51994410569e-07 1.2 1.52026168699e-07 1.2 1.52057926829e-07 1.2 1.52089684959e-07 1.2 1.52121443089e-07 1.2 1.5215320122e-07 1.2 1.5218495935e-07 1.2 1.5221671748e-07 1.2 1.5224847561e-07 1.2 1.5228023374e-07 1.2 1.5231199187e-07 1.2 1.5234375e-07 1.2 1.5237550813e-07 1.2 1.5240726626e-07 1.2 1.5243902439e-07 1.2 1.5247078252e-07 1.2 1.5250254065e-07 1.2 1.5253429878e-07 1.2 1.52566056911e-07 1.2 1.52597815041e-07 1.2 1.52629573171e-07 1.2 1.52661331301e-07 1.2 1.52693089431e-07 1.2 1.52724847561e-07 1.2 1.52756605691e-07 1.2 1.52788363821e-07 1.2 1.52820121951e-07 1.2 1.52851880081e-07 1.2 1.52883638211e-07 1.2 1.52915396341e-07 1.2 1.52947154472e-07 1.2 1.52978912602e-07 1.2 1.53010670732e-07 1.2 1.53042428862e-07 1.2 1.53074186992e-07 1.2 1.53105945122e-07 1.2 1.53137703252e-07 1.2 1.53169461382e-07 1.2 1.53201219512e-07 1.2 1.53232977642e-07 1.2 1.53264735772e-07 1.2 1.53296493902e-07 1.2 1.53328252033e-07 1.2 1.53360010163e-07 1.2 1.53391768293e-07 1.2 1.53423526423e-07 1.2 1.53455284553e-07 1.2 1.53487042683e-07 1.2 1.53518800813e-07 1.2 1.53550558943e-07 1.2 1.53582317073e-07 1.2 1.53614075203e-07 1.2 1.53645833333e-07 1.2 1.53677591463e-07 1.2 1.53709349593e-07 1.2 1.53741107724e-07 1.2 1.53772865854e-07 1.2 1.53804623984e-07 1.2 1.53836382114e-07 1.2 1.53868140244e-07 1.2 1.53899898374e-07 1.2 1.53931656504e-07 1.2 1.53963414634e-07 1.2 1.53995172764e-07 1.2 1.54026930894e-07 1.2 1.54058689024e-07 1.2 1.54090447154e-07 1.2 1.54122205285e-07 1.2 1.54153963415e-07 1.2 1.54185721545e-07 1.2 1.54217479675e-07 1.2 1.54249237805e-07 1.2 1.54280995935e-07 1.2 1.54312754065e-07 1.2 1.54344512195e-07 1.2 1.54376270325e-07 1.2 1.54408028455e-07 1.2 1.54439786585e-07 1.2 1.54471544715e-07 1.2 1.54503302846e-07 1.2 1.54535060976e-07 1.2 1.54566819106e-07 1.2 1.54598577236e-07 1.2 1.54630335366e-07 1.2 1.54662093496e-07 1.2 1.54693851626e-07 1.2 1.54725609756e-07 1.2 1.54757367886e-07 1.2 1.54789126016e-07 1.2 1.54820884146e-07 1.2 1.54852642276e-07 1.2 1.54884400407e-07 1.2 1.54916158537e-07 1.2 1.54947916667e-07 1.2 1.54979674797e-07 1.2 1.55011432927e-07 1.2 1.55043191057e-07 1.2 1.55074949187e-07 1.2 1.55106707317e-07 1.2 1.55138465447e-07 1.2 1.55170223577e-07 1.2 1.55201981707e-07 1.2 1.55233739837e-07 1.2 1.55265497967e-07 1.2 1.55297256098e-07 1.2 1.55329014228e-07 1.2 1.55360772358e-07 1.2 1.55392530488e-07 1.2 1.55424288618e-07 1.2 1.55456046748e-07 1.2 1.55487804878e-07 1.2 1.55519563008e-07 1.2 1.55551321138e-07 1.2 1.55583079268e-07 1.2 1.55614837398e-07 1.2 1.55646595528e-07 1.2 1.55678353659e-07 1.2 1.55710111789e-07 1.2 1.55741869919e-07 1.2 1.55773628049e-07 1.2 1.55805386179e-07 1.2 1.55837144309e-07 1.2 1.55868902439e-07 1.2 1.55900660569e-07 1.2 1.55932418699e-07 1.2 1.55964176829e-07 1.2 1.55995934959e-07 1.2 1.56027693089e-07 1.2 1.5605945122e-07 1.2 1.5609120935e-07 1.2 1.5612296748e-07 1.2 1.5615472561e-07 1.2 1.5618648374e-07 1.2 1.5621824187e-07 1.2 1.5625e-07 1.2 1.5628175813e-07 1.2 1.5631351626e-07 1.2 1.5634527439e-07 1.2 1.5637703252e-07 1.2 1.5640879065e-07 1.2 1.5644054878e-07 1.2 1.56472306911e-07 1.2 1.56504065041e-07 1.2 1.56535823171e-07 1.2 1.56567581301e-07 1.2 1.56599339431e-07 1.2 1.56631097561e-07 1.2 1.56662855691e-07 1.2 1.56694613821e-07 1.2 1.56726371951e-07 1.2 1.56758130081e-07 1.2 1.56789888211e-07 1.2 1.56821646341e-07 1.2 1.56853404472e-07 1.2 1.56885162602e-07 1.2 1.56916920732e-07 1.2 1.56948678862e-07 1.2 1.56980436992e-07 1.2 1.57012195122e-07 1.2 1.57043953252e-07 1.2 1.57075711382e-07 1.2 1.57107469512e-07 1.2 1.57139227642e-07 1.2 1.57170985772e-07 1.2 1.57202743902e-07 1.2 1.57234502033e-07 1.2 1.57266260163e-07 1.2 1.57298018293e-07 1.2 1.57329776423e-07 1.2 1.57361534553e-07 1.2 1.57393292683e-07 1.2 1.57425050813e-07 1.2 1.57456808943e-07 1.2 1.57488567073e-07 1.2 1.57520325203e-07 1.2 1.57552083333e-07 1.2 1.57583841463e-07 1.2 1.57615599593e-07 1.2 1.57647357724e-07 1.2 1.57679115854e-07 1.2 1.57710873984e-07 1.2 1.57742632114e-07 1.2 1.57774390244e-07 1.2 1.57806148374e-07 1.2 1.57837906504e-07 1.2 1.57869664634e-07 1.2 1.57901422764e-07 1.2 1.57933180894e-07 1.2 1.57964939024e-07 1.2 1.57996697154e-07 1.2 1.58028455285e-07 1.2 1.58060213415e-07 1.2 1.58091971545e-07 1.2 1.58123729675e-07 1.2 1.58155487805e-07 1.2 1.58187245935e-07 1.2 1.58219004065e-07 1.2 1.58250762195e-07 1.2 1.58282520325e-07 1.2 1.58314278455e-07 1.2 1.58346036585e-07 1.2 1.58377794715e-07 1.2 1.58409552846e-07 1.2 1.58441310976e-07 1.2 1.58473069106e-07 1.2 1.58504827236e-07 1.2 1.58536585366e-07 1.2 1.58568343496e-07 1.2 1.58600101626e-07 1.2 1.58631859756e-07 1.2 1.58663617886e-07 1.2 1.58695376016e-07 1.2 1.58727134146e-07 1.2 1.58758892276e-07 1.2 1.58790650407e-07 1.2 1.58822408537e-07 1.2 1.58854166667e-07 1.2 1.58885924797e-07 1.2 1.58917682927e-07 1.2 1.58949441057e-07 1.2 1.58981199187e-07 1.2 1.59012957317e-07 1.2 1.59044715447e-07 1.2 1.59076473577e-07 1.2 1.59108231707e-07 1.2 1.59139989837e-07 1.2 1.59171747967e-07 1.2 1.59203506098e-07 1.2 1.59235264228e-07 1.2 1.59267022358e-07 1.2 1.59298780488e-07 1.2 1.59330538618e-07 1.2 1.59362296748e-07 1.2 1.59394054878e-07 1.2 1.59425813008e-07 1.2 1.59457571138e-07 1.2 1.59489329268e-07 1.2 1.59521087398e-07 1.2 1.59552845528e-07 1.2 1.59584603659e-07 1.2 1.59616361789e-07 1.2 1.59648119919e-07 1.2 1.59679878049e-07 1.2 1.59711636179e-07 1.2 1.59743394309e-07 1.2 1.59775152439e-07 1.2 1.59806910569e-07 1.2 1.59838668699e-07 1.2 1.59870426829e-07 1.2 1.59902184959e-07 1.2 1.59933943089e-07 1.2 1.5996570122e-07 1.2 1.5999745935e-07 1.2 1.6002921748e-07 1.2 1.6006097561e-07 1.2 1.6009273374e-07 1.2 1.6012449187e-07 1.2 1.6015625e-07 1.2 1.6018800813e-07 1.2 1.6021976626e-07 1.2 1.6025152439e-07 1.2 1.6028328252e-07 1.2 1.6031504065e-07 1.2 1.6034679878e-07 1.2 1.60378556911e-07 1.2 1.60410315041e-07 1.2 1.60442073171e-07 1.2 1.60473831301e-07 1.2 1.60505589431e-07 1.2 1.60537347561e-07 1.2 1.60569105691e-07 1.2 1.60600863821e-07 1.2 1.60632621951e-07 1.2 1.60664380081e-07 1.2 1.60696138211e-07 1.2 1.60727896341e-07 1.2 1.60759654472e-07 1.2 1.60791412602e-07 1.2 1.60823170732e-07 1.2 1.60854928862e-07 1.2 1.60886686992e-07 1.2 1.60918445122e-07 1.2 1.60950203252e-07 1.2 1.60981961382e-07 1.2 1.61013719512e-07 1.2 1.61045477642e-07 1.2 1.61077235772e-07 1.2 1.61108993902e-07 1.2 1.61140752033e-07 1.2 1.61172510163e-07 1.2 1.61204268293e-07 1.2 1.61236026423e-07 1.2 1.61267784553e-07 1.2 1.61299542683e-07 1.2 1.61331300813e-07 1.2 1.61363058943e-07 1.2 1.61394817073e-07 1.2 1.61426575203e-07 1.2 1.61458333333e-07 1.2 1.61490091463e-07 1.2 1.61521849593e-07 1.2 1.61553607724e-07 1.2 1.61585365854e-07 1.2 1.61617123984e-07 1.2 1.61648882114e-07 1.2 1.61680640244e-07 1.2 1.61712398374e-07 1.2 1.61744156504e-07 1.2 1.61775914634e-07 1.2 1.61807672764e-07 1.2 1.61839430894e-07 1.2 1.61871189024e-07 1.2 1.61902947154e-07 1.2 1.61934705285e-07 1.2 1.61966463415e-07 1.2 1.61998221545e-07 1.2 1.62029979675e-07 1.2 1.62061737805e-07 1.2 1.62093495935e-07 1.2 1.62125254065e-07 1.2 1.62157012195e-07 1.2 1.62188770325e-07 1.2 1.62220528455e-07 1.2 1.62252286585e-07 1.2 1.62284044715e-07 1.2 1.62315802846e-07 1.2 1.62347560976e-07 1.2 1.62379319106e-07 1.2 1.62411077236e-07 1.2 1.62442835366e-07 1.2 1.62474593496e-07 1.2 1.62506351626e-07 1.2 1.62538109756e-07 1.2 1.62569867886e-07 1.2 1.62601626016e-07 1.2 1.62633384146e-07 1.2 1.62665142276e-07 1.2 1.62696900407e-07 1.2 1.62728658537e-07 1.2 1.62760416667e-07 1.2 1.62792174797e-07 1.2 1.62823932927e-07 1.2 1.62855691057e-07 1.2 1.62887449187e-07 1.2 1.62919207317e-07 1.2 1.62950965447e-07 1.2 1.62982723577e-07 1.2 1.63014481707e-07 1.2 1.63046239837e-07 1.2 1.63077997967e-07 1.2 1.63109756098e-07 1.2 1.63141514228e-07 1.2 1.63173272358e-07 1.2 1.63205030488e-07 1.2 1.63236788618e-07 1.2 1.63268546748e-07 1.2 1.63300304878e-07 1.2 1.63332063008e-07 1.2 1.63363821138e-07 1.2 1.63395579268e-07 1.2 1.63427337398e-07 1.2 1.63459095528e-07 1.2 1.63490853659e-07 1.2 1.63522611789e-07 1.2 1.63554369919e-07 1.2 1.63586128049e-07 1.2 1.63617886179e-07 1.2 1.63649644309e-07 1.2 1.63681402439e-07 1.2 1.63713160569e-07 1.2 1.63744918699e-07 1.2 1.63776676829e-07 1.2 1.63808434959e-07 1.2 1.63840193089e-07 1.2 1.6387195122e-07 1.2 1.6390370935e-07 1.2 1.6393546748e-07 1.2 1.6396722561e-07 1.2 1.6399898374e-07 1.2 1.6403074187e-07 1.2 1.640625e-07 1.2 1.6409425813e-07 1.2 1.6412601626e-07 1.2 1.6415777439e-07 1.2 1.6418953252e-07 1.2 1.6422129065e-07 1.2 1.6425304878e-07 1.2 1.64284806911e-07 1.2 1.64316565041e-07 1.2 1.64348323171e-07 1.2 1.64380081301e-07 1.2 1.64411839431e-07 1.2 1.64443597561e-07 1.2 1.64475355691e-07 1.2 1.64507113821e-07 1.2 1.64538871951e-07 1.2 1.64570630081e-07 1.2 1.64602388211e-07 1.2 1.64634146341e-07 1.2 1.64665904472e-07 1.2 1.64697662602e-07 1.2 1.64729420732e-07 1.2 1.64761178862e-07 1.2 1.64792936992e-07 1.2 1.64824695122e-07 1.2 1.64856453252e-07 1.2 1.64888211382e-07 1.2 1.64919969512e-07 1.2 1.64951727642e-07 1.2 1.64983485772e-07 1.2 1.65015243902e-07 1.2 1.65047002033e-07 1.2 1.65078760163e-07 1.2 1.65110518293e-07 1.2 1.65142276423e-07 1.2 1.65174034553e-07 1.2 1.65205792683e-07 1.2 1.65237550813e-07 1.2 1.65269308943e-07 1.2 1.65301067073e-07 1.2 1.65332825203e-07 1.2 1.65364583333e-07 1.2 1.65396341463e-07 1.2 1.65428099593e-07 1.2 1.65459857724e-07 1.2 1.65491615854e-07 1.2 1.65523373984e-07 1.2 1.65555132114e-07 1.2 1.65586890244e-07 1.2 1.65618648374e-07 1.2 1.65650406504e-07 1.2 1.65682164634e-07 1.2 1.65713922764e-07 1.2 1.65745680894e-07 1.2 1.65777439024e-07 1.2 1.65809197154e-07 1.2 1.65840955285e-07 1.2 1.65872713415e-07 1.2 1.65904471545e-07 1.2 1.65936229675e-07 1.2 1.65967987805e-07 1.2 1.65999745935e-07 1.2 1.66031504065e-07 1.2 1.66063262195e-07 1.2 1.66095020325e-07 1.2 1.66126778455e-07 1.2 1.66158536585e-07 1.2 1.66190294715e-07 1.2 1.66222052846e-07 1.2 1.66253810976e-07 1.2 1.66285569106e-07 1.2 1.66317327236e-07 1.2 1.66349085366e-07 1.2 1.66380843496e-07 1.2 1.66412601626e-07 1.2 1.66444359756e-07 1.2 1.66476117886e-07 1.2 1.66507876016e-07 1.2 1.66539634146e-07 1.2 1.66571392276e-07 1.2 1.66603150407e-07 1.2 1.66634908537e-07 1.2 1.66666666667e-07 1.2 1.66698424797e-07 1.2 1.66730182927e-07 1.2 1.66761941057e-07 1.2 1.66793699187e-07 1.2 1.66825457317e-07 1.2 1.66857215447e-07 1.2 1.66888973577e-07 1.2 1.66920731707e-07 1.2 1.66952489837e-07 1.2 1.66984247967e-07 1.2 1.67016006098e-07 1.2 1.67047764228e-07 1.2 1.67079522358e-07 1.2 1.67111280488e-07 1.2 1.67143038618e-07 1.2 1.67174796748e-07 1.2 1.67206554878e-07 1.2 1.67238313008e-07 1.2 1.67270071138e-07 1.2 1.67301829268e-07 1.2 1.67333587398e-07 1.2 1.67365345528e-07 1.2 1.67397103659e-07 1.2 1.67428861789e-07 1.2 1.67460619919e-07 1.2 1.67492378049e-07 1.2 1.67524136179e-07 1.2 1.67555894309e-07 1.2 1.67587652439e-07 1.2 1.67619410569e-07 1.2 1.67651168699e-07 1.2 1.67682926829e-07 1.2 1.67714684959e-07 1.2 1.67746443089e-07 1.2 1.6777820122e-07 1.2 1.6780995935e-07 1.2 1.6784171748e-07 1.2 1.6787347561e-07 1.2 1.6790523374e-07 1.2 1.6793699187e-07 1.2 1.6796875e-07 1.2 1.6800050813e-07 1.2 1.6803226626e-07 1.2 1.6806402439e-07 1.2 1.6809578252e-07 1.2 1.6812754065e-07 1.2 1.6815929878e-07 1.2 1.68191056911e-07 1.2 1.68222815041e-07 1.2 1.68254573171e-07 1.2 1.68286331301e-07 1.2 1.68318089431e-07 1.2 1.68349847561e-07 1.2 1.68381605691e-07 1.2 1.68413363821e-07 1.2 1.68445121951e-07 1.2 1.68476880081e-07 1.2 1.68508638211e-07 1.2 1.68540396341e-07 1.2 1.68572154472e-07 1.2 1.68603912602e-07 1.2 1.68635670732e-07 1.2 1.68667428862e-07 1.2 1.68699186992e-07 1.2 1.68730945122e-07 1.2 1.68762703252e-07 1.2 1.68794461382e-07 1.2 1.68826219512e-07 1.2 1.68857977642e-07 1.2 1.68889735772e-07 1.2 1.68921493902e-07 1.2 1.68953252033e-07 1.2 1.68985010163e-07 1.2 1.69016768293e-07 1.2 1.69048526423e-07 1.2 1.69080284553e-07 1.2 1.69112042683e-07 1.2 1.69143800813e-07 1.2 1.69175558943e-07 1.2 1.69207317073e-07 1.2 1.69239075203e-07 1.2 1.69270833333e-07 1.2 1.69302591463e-07 1.2 1.69334349593e-07 1.2 1.69366107724e-07 1.2 1.69397865854e-07 1.2 1.69429623984e-07 1.2 1.69461382114e-07 1.2 1.69493140244e-07 1.2 1.69524898374e-07 1.2 1.69556656504e-07 1.2 1.69588414634e-07 1.2 1.69620172764e-07 1.2 1.69651930894e-07 1.2 1.69683689024e-07 1.2 1.69715447154e-07 1.2 1.69747205285e-07 1.2 1.69778963415e-07 1.2 1.69810721545e-07 1.2 1.69842479675e-07 1.2 1.69874237805e-07 1.2 1.69905995935e-07 1.2 1.69937754065e-07 1.2 1.69969512195e-07 1.2 1.70001270325e-07 1.2 1.70033028455e-07 1.2 1.70064786585e-07 1.2 1.70096544715e-07 1.2 1.70128302846e-07 1.2 1.70160060976e-07 1.2 1.70191819106e-07 1.2 1.70223577236e-07 1.2 1.70255335366e-07 1.2 1.70287093496e-07 1.2 1.70318851626e-07 1.2 1.70350609756e-07 1.2 1.70382367886e-07 1.2 1.70414126016e-07 1.2 1.70445884146e-07 1.2 1.70477642276e-07 1.2 1.70509400407e-07 1.2 1.70541158537e-07 1.2 1.70572916667e-07 1.2 1.70604674797e-07 1.2 1.70636432927e-07 1.2 1.70668191057e-07 1.2 1.70699949187e-07 1.2 1.70731707317e-07 1.2 1.70763465447e-07 1.2 1.70795223577e-07 1.2 1.70826981707e-07 1.2 1.70858739837e-07 1.2 1.70890497967e-07 1.2 1.70922256098e-07 1.2 1.70954014228e-07 1.2 1.70985772358e-07 1.2 1.71017530488e-07 1.2 1.71049288618e-07 1.2 1.71081046748e-07 1.2 1.71112804878e-07 1.2 1.71144563008e-07 1.2 1.71176321138e-07 1.2 1.71208079268e-07 1.2 1.71239837398e-07 1.2 1.71271595528e-07 1.2 1.71303353659e-07 1.2 1.71335111789e-07 1.2 1.71366869919e-07 1.2 1.71398628049e-07 1.2 1.71430386179e-07 1.2 1.71462144309e-07 1.2 1.71493902439e-07 1.2 1.71525660569e-07 1.2 1.71557418699e-07 1.2 1.71589176829e-07 1.2 1.71620934959e-07 1.2 1.71652693089e-07 1.2 1.7168445122e-07 1.2 1.7171620935e-07 1.2 1.7174796748e-07 1.2 1.7177972561e-07 1.2 1.7181148374e-07 1.2 1.7184324187e-07 1.2 1.71875e-07 1.2 1.7190675813e-07 1.2 1.7193851626e-07 1.2 1.7197027439e-07 1.2 1.7200203252e-07 1.2 1.7203379065e-07 1.2 1.7206554878e-07 1.2 1.72097306911e-07 1.2 1.72129065041e-07 1.2 1.72160823171e-07 1.2 1.72192581301e-07 1.2 1.72224339431e-07 1.2 1.72256097561e-07 1.2 1.72287855691e-07 1.2 1.72319613821e-07 1.2 1.72351371951e-07 1.2 1.72383130081e-07 1.2 1.72414888211e-07 1.2 1.72446646341e-07 1.2 1.72478404472e-07 1.2 1.72510162602e-07 1.2 1.72541920732e-07 1.2 1.72573678862e-07 1.2 1.72605436992e-07 1.2 1.72637195122e-07 1.2 1.72668953252e-07 1.2 1.72700711382e-07 1.2 1.72732469512e-07 1.2 1.72764227642e-07 1.2 1.72795985772e-07 1.2 1.72827743902e-07 1.2 1.72859502033e-07 1.2 1.72891260163e-07 1.2 1.72923018293e-07 1.2 1.72954776423e-07 1.2 1.72986534553e-07 1.2 1.73018292683e-07 1.2 1.73050050813e-07 1.2 1.73081808943e-07 1.2 1.73113567073e-07 1.2 1.73145325203e-07 1.2 1.73177083333e-07 1.2 1.73208841463e-07 1.2 1.73240599593e-07 1.2 1.73272357724e-07 1.2 1.73304115854e-07 1.2 1.73335873984e-07 1.2 1.73367632114e-07 1.2 1.73399390244e-07 1.2 1.73431148374e-07 1.2 1.73462906504e-07 1.2 1.73494664634e-07 1.2 1.73526422764e-07 1.2 1.73558180894e-07 1.2 1.73589939024e-07 1.2 1.73621697154e-07 1.2 1.73653455285e-07 1.2 1.73685213415e-07 1.2 1.73716971545e-07 1.2 1.73748729675e-07 1.2 1.73780487805e-07 1.2 1.73812245935e-07 1.2 1.73844004065e-07 1.2 1.73875762195e-07 1.2 1.73907520325e-07 1.2 1.73939278455e-07 1.2 1.73971036585e-07 1.2 1.74002794715e-07 1.2 1.74034552846e-07 1.2 1.74066310976e-07 1.2 1.74098069106e-07 1.2 1.74129827236e-07 1.2 1.74161585366e-07 1.2 1.74193343496e-07 1.2 1.74225101626e-07 1.2 1.74256859756e-07 1.2 1.74288617886e-07 1.2 1.74320376016e-07 1.2 1.74352134146e-07 1.2 1.74383892276e-07 1.2 1.74415650407e-07 1.2 1.74447408537e-07 1.2 1.74479166667e-07 1.2 1.74510924797e-07 1.2 1.74542682927e-07 1.2 1.74574441057e-07 1.2 1.74606199187e-07 1.2 1.74637957317e-07 1.2 1.74669715447e-07 1.2 1.74701473577e-07 1.2 1.74733231707e-07 1.2 1.74764989837e-07 1.2 1.74796747967e-07 1.2 1.74828506098e-07 1.2 1.74860264228e-07 1.2 1.74892022358e-07 1.2 1.74923780488e-07 1.2 1.74955538618e-07 1.2 1.74987296748e-07 1.2 1.75019054878e-07 1.2 1.75050813008e-07 1.2 1.75082571138e-07 1.2 1.75114329268e-07 1.2 1.75146087398e-07 1.2 1.75177845528e-07 1.2 1.75209603659e-07 1.2 1.75241361789e-07 1.2 1.75273119919e-07 1.2 1.75304878049e-07 1.2 1.75336636179e-07 1.2 1.75368394309e-07 1.2 1.75400152439e-07 1.2 1.75431910569e-07 1.2 1.75463668699e-07 1.2 1.75495426829e-07 1.2 1.75527184959e-07 1.2 1.75558943089e-07 1.2 1.7559070122e-07 1.2 1.7562245935e-07 1.2 1.7565421748e-07 1.2 1.7568597561e-07 1.2 1.7571773374e-07 1.2 1.7574949187e-07 1.2 1.7578125e-07 1.2 1.7581300813e-07 1.2 1.7584476626e-07 1.2 1.7587652439e-07 1.2 1.7590828252e-07 1.2 1.7594004065e-07 1.2 1.7597179878e-07 1.2 1.76003556911e-07 1.2 1.76035315041e-07 1.2 1.76067073171e-07 1.2 1.76098831301e-07 1.2 1.76130589431e-07 1.2 1.76162347561e-07 1.2 1.76194105691e-07 1.2 1.76225863821e-07 1.2 1.76257621951e-07 1.2 1.76289380081e-07 1.2 1.76321138211e-07 1.2 1.76352896341e-07 1.2 1.76384654472e-07 1.2 1.76416412602e-07 1.2 1.76448170732e-07 1.2 1.76479928862e-07 1.2 1.76511686992e-07 1.2 1.76543445122e-07 1.2 1.76575203252e-07 1.2 1.76606961382e-07 1.2 1.76638719512e-07 1.2 1.76670477642e-07 1.2 1.76702235772e-07 1.2 1.76733993902e-07 1.2 1.76765752033e-07 1.2 1.76797510163e-07 1.2 1.76829268293e-07 1.2 1.76861026423e-07 1.2 1.76892784553e-07 1.2 1.76924542683e-07 1.2 1.76956300813e-07 1.2 1.76988058943e-07 1.2 1.77019817073e-07 1.2 1.77051575203e-07 1.2 1.77083333333e-07 1.2 1.77115091463e-07 1.2 1.77146849593e-07 1.2 1.77178607724e-07 1.2 1.77210365854e-07 1.2 1.77242123984e-07 1.2 1.77273882114e-07 1.2 1.77305640244e-07 1.2 1.77337398374e-07 1.2 1.77369156504e-07 1.2 1.77400914634e-07 1.2 1.77432672764e-07 1.2 1.77464430894e-07 1.2 1.77496189024e-07 1.2 1.77527947154e-07 1.2 1.77559705285e-07 1.2 1.77591463415e-07 1.2 1.77623221545e-07 1.2 1.77654979675e-07 1.2 1.77686737805e-07 1.2 1.77718495935e-07 1.2 1.77750254065e-07 1.2 1.77782012195e-07 1.2 1.77813770325e-07 1.2 1.77845528455e-07 1.2 1.77877286585e-07 1.2 1.77909044715e-07 1.2 1.77940802846e-07 1.2 1.77972560976e-07 1.2 1.78004319106e-07 1.2 1.78036077236e-07 1.2 1.78067835366e-07 1.2 1.78099593496e-07 1.2 1.78131351626e-07 1.2 1.78163109756e-07 1.2 1.78194867886e-07 1.2 1.78226626016e-07 1.2 1.78258384146e-07 1.2 1.78290142276e-07 1.2 1.78321900407e-07 1.2 1.78353658537e-07 1.2 1.78385416667e-07 1.2 1.78417174797e-07 1.2 1.78448932927e-07 1.2 1.78480691057e-07 1.2 1.78512449187e-07 1.2 1.78544207317e-07 1.2 1.78575965447e-07 1.2 1.78607723577e-07 1.2 1.78639481707e-07 1.2 1.78671239837e-07 1.2 1.78702997967e-07 1.2 1.78734756098e-07 1.2 1.78766514228e-07 1.2 1.78798272358e-07 1.2 1.78830030488e-07 1.2 1.78861788618e-07 1.2 1.78893546748e-07 1.2 1.78925304878e-07 1.2 1.78957063008e-07 1.2 1.78988821138e-07 1.2 1.79020579268e-07 1.2 1.79052337398e-07 1.2 1.79084095528e-07 1.2 1.79115853659e-07 1.2 1.79147611789e-07 1.2 1.79179369919e-07 1.2 1.79211128049e-07 1.2 1.79242886179e-07 1.2 1.79274644309e-07 1.2 1.79306402439e-07 1.2 1.79338160569e-07 1.2 1.79369918699e-07 1.2 1.79401676829e-07 1.2 1.79433434959e-07 1.2 1.79465193089e-07 1.2 1.7949695122e-07 1.2 1.7952870935e-07 1.2 1.7956046748e-07 1.2 1.7959222561e-07 1.2 1.7962398374e-07 1.2 1.7965574187e-07 1.2 1.796875e-07 1.2 1.7971925813e-07 1.2 1.7975101626e-07 1.2 1.7978277439e-07 1.2 1.7981453252e-07 1.2 1.7984629065e-07 1.2 1.7987804878e-07 1.2 1.79909806911e-07 1.2 1.79941565041e-07 1.2 1.79973323171e-07 1.2 1.80005081301e-07 1.2 1.80036839431e-07 1.2 1.80068597561e-07 1.2 1.80100355691e-07 1.2 1.80132113821e-07 1.2 1.80163871951e-07 1.2 1.80195630081e-07 1.2 1.80227388211e-07 1.2 1.80259146341e-07 1.2 1.80290904472e-07 1.2 1.80322662602e-07 1.2 1.80354420732e-07 1.2 1.80386178862e-07 1.2 1.80417936992e-07 1.2 1.80449695122e-07 1.2 1.80481453252e-07 1.2 1.80513211382e-07 1.2 1.80544969512e-07 1.2 1.80576727642e-07 1.2 1.80608485772e-07 1.2 1.80640243902e-07 1.2 1.80672002033e-07 1.2 1.80703760163e-07 1.2 1.80735518293e-07 1.2 1.80767276423e-07 1.2 1.80799034553e-07 1.2 1.80830792683e-07 1.2 1.80862550813e-07 1.2 1.80894308943e-07 1.2 1.80926067073e-07 1.2 1.80957825203e-07 1.2 1.80989583333e-07 1.2 1.81021341463e-07 1.2 1.81053099593e-07 1.2 1.81084857724e-07 1.2 1.81116615854e-07 1.2 1.81148373984e-07 1.2 1.81180132114e-07 1.2 1.81211890244e-07 1.2 1.81243648374e-07 1.2 1.81275406504e-07 1.2 1.81307164634e-07 1.2 1.81338922764e-07 1.2 1.81370680894e-07 1.2 1.81402439024e-07 1.2 1.81434197154e-07 1.2 1.81465955285e-07 1.2 1.81497713415e-07 1.2 1.81529471545e-07 1.2 1.81561229675e-07 1.2 1.81592987805e-07 1.2 1.81624745935e-07 1.2 1.81656504065e-07 1.2 1.81688262195e-07 1.2 1.81720020325e-07 1.2 1.81751778455e-07 1.2 1.81783536585e-07 1.2 1.81815294715e-07 1.2 1.81847052846e-07 1.2 1.81878810976e-07 1.2 1.81910569106e-07 1.2 1.81942327236e-07 1.2 1.81974085366e-07 1.2 1.82005843496e-07 1.2 1.82037601626e-07 1.2 1.82069359756e-07 1.2 1.82101117886e-07 1.2 1.82132876016e-07 1.2 1.82164634146e-07 1.2 1.82196392276e-07 1.2 1.82228150407e-07 1.2 1.82259908537e-07 1.2 1.82291666667e-07 1.2 1.82323424797e-07 1.2 1.82355182927e-07 1.2 1.82386941057e-07 1.2 1.82418699187e-07 1.2 1.82450457317e-07 1.2 1.82482215447e-07 1.2 1.82513973577e-07 1.2 1.82545731707e-07 1.2 1.82577489837e-07 1.2 1.82609247967e-07 1.2 1.82641006098e-07 1.2 1.82672764228e-07 1.2 1.82704522358e-07 1.2 1.82736280488e-07 1.2 1.82768038618e-07 1.2 1.82799796748e-07 1.2 1.82831554878e-07 1.2 1.82863313008e-07 1.2 1.82895071138e-07 1.2 1.82926829268e-07 1.2 1.82958587398e-07 1.2 1.82990345528e-07 1.2 1.83022103659e-07 1.2 1.83053861789e-07 1.2 1.83085619919e-07 1.2 1.83117378049e-07 1.2 1.83149136179e-07 1.2 1.83180894309e-07 1.2 1.83212652439e-07 1.2 1.83244410569e-07 1.2 1.83276168699e-07 1.2 1.83307926829e-07 1.2 1.83339684959e-07 1.2 1.83371443089e-07 1.2 1.8340320122e-07 1.2 1.8343495935e-07 1.2 1.8346671748e-07 1.2 1.8349847561e-07 1.2 1.8353023374e-07 1.2 1.8356199187e-07 1.2 1.8359375e-07 1.2 1.8362550813e-07 1.2 1.8365726626e-07 1.2 1.8368902439e-07 1.2 1.8372078252e-07 1.2 1.8375254065e-07 1.2 1.8378429878e-07 1.2 1.83816056911e-07 1.2 1.83847815041e-07 1.2 1.83879573171e-07 1.2 1.83911331301e-07 1.2 1.83943089431e-07 1.2 1.83974847561e-07 1.2 1.84006605691e-07 1.2 1.84038363821e-07 1.2 1.84070121951e-07 1.2 1.84101880081e-07 1.2 1.84133638211e-07 1.2 1.84165396341e-07 1.2 1.84197154472e-07 1.2 1.84228912602e-07 1.2 1.84260670732e-07 1.2 1.84292428862e-07 1.2 1.84324186992e-07 1.2 1.84355945122e-07 1.2 1.84387703252e-07 1.2 1.84419461382e-07 1.2 1.84451219512e-07 1.2 1.84482977642e-07 1.2 1.84514735772e-07 1.2 1.84546493902e-07 1.2 1.84578252033e-07 1.2 1.84610010163e-07 1.2 1.84641768293e-07 1.2 1.84673526423e-07 1.2 1.84705284553e-07 1.2 1.84737042683e-07 1.2 1.84768800813e-07 1.2 1.84800558943e-07 1.2 1.84832317073e-07 1.2 1.84864075203e-07 1.2 1.84895833333e-07 1.2 1.84927591463e-07 1.2 1.84959349593e-07 1.2 1.84991107724e-07 1.2 1.85022865854e-07 1.2 1.85054623984e-07 1.2 1.85086382114e-07 1.2 1.85118140244e-07 1.2 1.85149898374e-07 1.2 1.85181656504e-07 1.2 1.85213414634e-07 1.2 1.85245172764e-07 1.2 1.85276930894e-07 1.2 1.85308689024e-07 1.2 1.85340447154e-07 1.2 1.85372205285e-07 1.2 1.85403963415e-07 1.2 1.85435721545e-07 1.2 1.85467479675e-07 1.2 1.85499237805e-07 1.2 1.85530995935e-07 1.2 1.85562754065e-07 1.2 1.85594512195e-07 1.2 1.85626270325e-07 1.2 1.85658028455e-07 1.2 1.85689786585e-07 1.2 1.85721544715e-07 1.2 1.85753302846e-07 1.2 1.85785060976e-07 1.2 1.85816819106e-07 1.2 1.85848577236e-07 1.2 1.85880335366e-07 1.2 1.85912093496e-07 1.2 1.85943851626e-07 1.2 1.85975609756e-07 1.2 1.86007367886e-07 1.2 1.86039126016e-07 1.2 1.86070884146e-07 1.2 1.86102642276e-07 1.2 1.86134400407e-07 1.2 1.86166158537e-07 1.2 1.86197916667e-07 1.2 1.86229674797e-07 1.2 1.86261432927e-07 1.2 1.86293191057e-07 1.2 1.86324949187e-07 1.2 1.86356707317e-07 1.2 1.86388465447e-07 1.2 1.86420223577e-07 1.2 1.86451981707e-07 1.2 1.86483739837e-07 1.2 1.86515497967e-07 1.2 1.86547256098e-07 1.2 1.86579014228e-07 1.2 1.86610772358e-07 1.2 1.86642530488e-07 1.2 1.86674288618e-07 1.2 1.86706046748e-07 1.2 1.86737804878e-07 1.2 1.86769563008e-07 1.2 1.86801321138e-07 1.2 1.86833079268e-07 1.2 1.86864837398e-07 1.2 1.86896595528e-07 1.2 1.86928353659e-07 1.2 1.86960111789e-07 1.2 1.86991869919e-07 1.2 1.87023628049e-07 1.2 1.87055386179e-07 1.2 1.87087144309e-07 1.2 1.87118902439e-07 1.2 1.87150660569e-07 1.2 1.87182418699e-07 1.2 1.87214176829e-07 1.2 1.87245934959e-07 1.2 1.87277693089e-07 1.2 1.8730945122e-07 1.2 1.8734120935e-07 1.2 1.8737296748e-07 1.2 1.8740472561e-07 1.2 1.8743648374e-07 1.2 1.8746824187e-07 1.2 1.875e-07 1.2 1.8753175813e-07 1.2 1.8756351626e-07 1.2 1.8759527439e-07 1.2 1.8762703252e-07 1.2 1.8765879065e-07 1.2 1.8769054878e-07 1.2 1.87722306911e-07 1.2 1.87754065041e-07 1.2 1.87785823171e-07 1.2 1.87817581301e-07 1.2 1.87849339431e-07 1.2 1.87881097561e-07 1.2 1.87912855691e-07 1.2 1.87944613821e-07 1.2 1.87976371951e-07 1.2 1.88008130081e-07 1.2 1.88039888211e-07 1.2 1.88071646341e-07 1.2 1.88103404472e-07 1.2 1.88135162602e-07 1.2 1.88166920732e-07 1.2 1.88198678862e-07 1.2 1.88230436992e-07 1.2 1.88262195122e-07 1.2 1.88293953252e-07 1.2 1.88325711382e-07 1.2 1.88357469512e-07 1.2 1.88389227642e-07 1.2 1.88420985772e-07 1.2 1.88452743902e-07 1.2 1.88484502033e-07 1.2 1.88516260163e-07 1.2 1.88548018293e-07 1.2 1.88579776423e-07 1.2 1.88611534553e-07 1.2 1.88643292683e-07 1.2 1.88675050813e-07 1.2 1.88706808943e-07 1.2 1.88738567073e-07 1.2 1.88770325203e-07 1.2 1.88802083333e-07 1.2 1.88833841463e-07 1.2 1.88865599593e-07 1.2 1.88897357724e-07 1.2 1.88929115854e-07 1.2 1.88960873984e-07 1.2 1.88992632114e-07 1.2 1.89024390244e-07 1.2 1.89056148374e-07 1.2 1.89087906504e-07 1.2 1.89119664634e-07 1.2 1.89151422764e-07 1.2 1.89183180894e-07 1.2 1.89214939024e-07 1.2 1.89246697154e-07 1.2 1.89278455285e-07 1.2 1.89310213415e-07 1.2 1.89341971545e-07 1.2 1.89373729675e-07 1.2 1.89405487805e-07 1.2 1.89437245935e-07 1.2 1.89469004065e-07 1.2 1.89500762195e-07 1.2 1.89532520325e-07 1.2 1.89564278455e-07 1.2 1.89596036585e-07 1.2 1.89627794715e-07 1.2 1.89659552846e-07 1.2 1.89691310976e-07 1.2 1.89723069106e-07 1.2 1.89754827236e-07 1.2 1.89786585366e-07 1.2 1.89818343496e-07 1.2 1.89850101626e-07 1.2 1.89881859756e-07 1.2 1.89913617886e-07 1.2 1.89945376016e-07 1.2 1.89977134146e-07 1.2 1.90008892276e-07 1.2 1.90040650407e-07 1.2 1.90072408537e-07 1.2 1.90104166667e-07 1.2 1.90135924797e-07 1.2 1.90167682927e-07 1.2 1.90199441057e-07 1.2 1.90231199187e-07 1.2 1.90262957317e-07 1.2 1.90294715447e-07 1.2 1.90326473577e-07 1.2 1.90358231707e-07 1.2 1.90389989837e-07 1.2 1.90421747967e-07 1.2 1.90453506098e-07 1.2 1.90485264228e-07 1.2 1.90517022358e-07 1.2 1.90548780488e-07 1.2 1.90580538618e-07 1.2 1.90612296748e-07 1.2 1.90644054878e-07 1.2 1.90675813008e-07 1.2 1.90707571138e-07 1.2 1.90739329268e-07 1.2 1.90771087398e-07 1.2 1.90802845528e-07 1.2 1.90834603659e-07 1.2 1.90866361789e-07 1.2 1.90898119919e-07 1.2 1.90929878049e-07 1.2 1.90961636179e-07 1.2 1.90993394309e-07 1.2 1.91025152439e-07 1.2 1.91056910569e-07 1.2 1.91088668699e-07 1.2 1.91120426829e-07 1.2 1.91152184959e-07 1.2 1.91183943089e-07 1.2 1.9121570122e-07 1.2 1.9124745935e-07 1.2 1.9127921748e-07 1.2 1.9131097561e-07 1.2 1.9134273374e-07 1.2 1.9137449187e-07 1.2 1.9140625e-07 1.2 1.9143800813e-07 1.2 1.9146976626e-07 1.2 1.9150152439e-07 1.2 1.9153328252e-07 1.2 1.9156504065e-07 1.2 1.9159679878e-07 1.2 1.91628556911e-07 1.2 1.91660315041e-07 1.2 1.91692073171e-07 1.2 1.91723831301e-07 1.2 1.91755589431e-07 1.2 1.91787347561e-07 1.2 1.91819105691e-07 1.2 1.91850863821e-07 1.2 1.91882621951e-07 1.2 1.91914380081e-07 1.2 1.91946138211e-07 1.2 1.91977896341e-07 1.2 1.92009654472e-07 1.2 1.92041412602e-07 1.2 1.92073170732e-07 1.2 1.92104928862e-07 1.2 1.92136686992e-07 1.2 1.92168445122e-07 1.2 1.92200203252e-07 1.2 1.92231961382e-07 1.2 1.92263719512e-07 1.2 1.92295477642e-07 1.2 1.92327235772e-07 1.2 1.92358993902e-07 1.2 1.92390752033e-07 1.2 1.92422510163e-07 1.2 1.92454268293e-07 1.2 1.92486026423e-07 1.2 1.92517784553e-07 1.2 1.92549542683e-07 1.2 1.92581300813e-07 1.2 1.92613058943e-07 1.2 1.92644817073e-07 1.2 1.92676575203e-07 1.2 1.92708333333e-07 1.2 1.92740091463e-07 1.2 1.92771849593e-07 1.2 1.92803607724e-07 1.2 1.92835365854e-07 1.2 1.92867123984e-07 1.2 1.92898882114e-07 1.2 1.92930640244e-07 1.2 1.92962398374e-07 1.2 1.92994156504e-07 1.2 1.93025914634e-07 1.2 1.93057672764e-07 1.2 1.93089430894e-07 1.2 1.93121189024e-07 1.2 1.93152947154e-07 1.2 1.93184705285e-07 1.2 1.93216463415e-07 1.2 1.93248221545e-07 1.2 1.93279979675e-07 1.2 1.93311737805e-07 1.2 1.93343495935e-07 1.2 1.93375254065e-07 1.2 1.93407012195e-07 1.2 1.93438770325e-07 1.2 1.93470528455e-07 1.2 1.93502286585e-07 1.2 1.93534044715e-07 1.2 1.93565802846e-07 1.2 1.93597560976e-07 1.2 1.93629319106e-07 1.2 1.93661077236e-07 1.2 1.93692835366e-07 1.2 1.93724593496e-07 1.2 1.93756351626e-07 1.2 1.93788109756e-07 1.2 1.93819867886e-07 1.2 1.93851626016e-07 1.2 1.93883384146e-07 1.2 1.93915142276e-07 1.2 1.93946900407e-07 1.2 1.93978658537e-07 1.2 1.94010416667e-07 1.2 1.94042174797e-07 1.2 1.94073932927e-07 1.2 1.94105691057e-07 1.2 1.94137449187e-07 1.2 1.94169207317e-07 1.2 1.94200965447e-07 1.2 1.94232723577e-07 1.2 1.94264481707e-07 1.2 1.94296239837e-07 1.2 1.94327997967e-07 1.2 1.94359756098e-07 1.2 1.94391514228e-07 1.2 1.94423272358e-07 1.2 1.94455030488e-07 1.2 1.94486788618e-07 1.2 1.94518546748e-07 1.2 1.94550304878e-07 1.2 1.94582063008e-07 1.2 1.94613821138e-07 1.2 1.94645579268e-07 1.2 1.94677337398e-07 1.2 1.94709095528e-07 1.2 1.94740853659e-07 1.2 1.94772611789e-07 1.2 1.94804369919e-07 1.2 1.94836128049e-07 1.2 1.94867886179e-07 1.2 1.94899644309e-07 1.2 1.94931402439e-07 1.2 1.94963160569e-07 1.2 1.94994918699e-07 1.2 1.95026676829e-07 1.2 1.95058434959e-07 1.2 1.95090193089e-07 1.2 1.9512195122e-07 1.2 1.9515370935e-07 1.2 1.9518546748e-07 1.2 1.9521722561e-07 1.2 1.9524898374e-07 1.2 1.9528074187e-07 1.2 1.953125e-07 1.2 1.9534425813e-07 1.2 1.9537601626e-07 1.2 1.9540777439e-07 1.2 1.9543953252e-07 1.2 1.9547129065e-07 1.2 1.9550304878e-07 1.2 1.95534806911e-07 1.2 1.95566565041e-07 1.2 1.95598323171e-07 1.2 1.95630081301e-07 1.2 1.95661839431e-07 1.2 1.95693597561e-07 1.2 1.95725355691e-07 1.2 1.95757113821e-07 1.2 1.95788871951e-07 1.2 1.95820630081e-07 1.2 1.95852388211e-07 1.2 1.95884146341e-07 1.2 1.95915904472e-07 1.2 1.95947662602e-07 1.2 1.95979420732e-07 1.2 1.96011178862e-07 1.2 1.96042936992e-07 1.2 1.96074695122e-07 1.2 1.96106453252e-07 1.2 1.96138211382e-07 1.2 1.96169969512e-07 1.2 1.96201727642e-07 1.2 1.96233485772e-07 1.2 1.96265243902e-07 1.2 1.96297002033e-07 1.2 1.96328760163e-07 1.2 1.96360518293e-07 1.2 1.96392276423e-07 1.2 1.96424034553e-07 1.2 1.96455792683e-07 1.2 1.96487550813e-07 1.2 1.96519308943e-07 1.2 1.96551067073e-07 1.2 1.96582825203e-07 1.2 1.96614583333e-07 1.2 1.96646341463e-07 1.2 1.96678099593e-07 1.2 1.96709857724e-07 1.2 1.96741615854e-07 1.2 1.96773373984e-07 1.2 1.96805132114e-07 1.2 1.96836890244e-07 1.2 1.96868648374e-07 1.2 1.96900406504e-07 1.2 1.96932164634e-07 1.2 1.96963922764e-07 1.2 1.96995680894e-07 1.2 1.97027439024e-07 1.2 1.97059197154e-07 1.2 1.97090955285e-07 1.2 1.97122713415e-07 1.2 1.97154471545e-07 1.2 1.97186229675e-07 1.2 1.97217987805e-07 1.2 1.97249745935e-07 1.2 1.97281504065e-07 1.2 1.97313262195e-07 1.2 1.97345020325e-07 1.2 1.97376778455e-07 1.2 1.97408536585e-07 1.2 1.97440294715e-07 1.2 1.97472052846e-07 1.2 1.97503810976e-07 1.2 1.97535569106e-07 1.2 1.97567327236e-07 1.2 1.97599085366e-07 1.2 1.97630843496e-07 1.2 1.97662601626e-07 1.2 1.97694359756e-07 1.2 1.97726117886e-07 1.2 1.97757876016e-07 1.2 1.97789634146e-07 1.2 1.97821392276e-07 1.2 1.97853150407e-07 1.2 1.97884908537e-07 1.2 1.97916666667e-07 1.2 1.97948424797e-07 1.2 1.97980182927e-07 1.2 1.98011941057e-07 1.2 1.98043699187e-07 1.2 1.98075457317e-07 1.2 1.98107215447e-07 1.2 1.98138973577e-07 1.2 1.98170731707e-07 1.2 1.98202489837e-07 1.2 1.98234247967e-07 1.2 1.98266006098e-07 1.2 1.98297764228e-07 1.2 1.98329522358e-07 1.2 1.98361280488e-07 1.2 1.98393038618e-07 1.2 1.98424796748e-07 1.2 1.98456554878e-07 1.2 1.98488313008e-07 1.2 1.98520071138e-07 1.2 1.98551829268e-07 1.2 1.98583587398e-07 1.2 1.98615345528e-07 1.2 1.98647103659e-07 1.2 1.98678861789e-07 1.2 1.98710619919e-07 1.2 1.98742378049e-07 1.2 1.98774136179e-07 1.2 1.98805894309e-07 1.2 1.98837652439e-07 1.2 1.98869410569e-07 1.2 1.98901168699e-07 1.2 1.98932926829e-07 1.2 1.98964684959e-07 1.2 1.98996443089e-07 1.2 1.9902820122e-07 1.2 1.9905995935e-07 1.2 1.9909171748e-07 1.2 1.9912347561e-07 1.2 1.9915523374e-07 1.2 1.9918699187e-07 1.2 1.9921875e-07 1.2 1.9925050813e-07 1.2 1.9928226626e-07 1.2 1.9931402439e-07 1.2 1.9934578252e-07 1.2 1.9937754065e-07 1.2 1.9940929878e-07 1.2 1.99441056911e-07 1.2 1.99472815041e-07 1.2 1.99504573171e-07 1.2 1.99536331301e-07 1.2 1.99568089431e-07 1.2 1.99599847561e-07 1.2 1.99631605691e-07 1.2 1.99663363821e-07 1.2 1.99695121951e-07 1.2 1.99726880081e-07 1.2 1.99758638211e-07 1.2 1.99790396341e-07 1.2 1.99822154472e-07 1.2 1.99853912602e-07 1.2 1.99885670732e-07 1.2 1.99917428862e-07 1.2 1.99949186992e-07 1.2 1.99980945122e-07 1.2 2.00012703252e-07 1.55 2.00044461382e-07 1.44748737342 2.00076219512e-07 1.2 2.00107977642e-07 0.952512626585 2.00139735772e-07 0.85 2.00171493902e-07 0.952512626585 2.00203252033e-07 1.2 2.00235010163e-07 1.44748737342 2.00266768293e-07 1.55 2.00298526423e-07 1.44748737342 2.00330284553e-07 1.2 2.00362042683e-07 0.952512626585 2.00393800813e-07 0.85 2.00425558943e-07 0.952512626585 2.00457317073e-07 1.2 2.00489075203e-07 1.44748737342 2.00520833333e-07 1.55 2.00552591463e-07 1.44748737342 2.00584349593e-07 1.2 2.00616107724e-07 0.952512626585 2.00647865854e-07 0.85 2.00679623984e-07 0.952512626585 2.00711382114e-07 1.2 2.00743140244e-07 1.44748737342 2.00774898374e-07 1.55 2.00806656504e-07 1.44748737342 2.00838414634e-07 1.2 2.00870172764e-07 0.952512626585 2.00901930894e-07 0.85 2.00933689024e-07 0.952512626585 2.00965447154e-07 1.2 2.00997205285e-07 1.44748737342 2.01028963415e-07 1.55 2.01060721545e-07 1.44748737342 2.01092479675e-07 1.2 2.01124237805e-07 0.952512626585 2.01155995935e-07 0.85 2.01187754065e-07 0.952512626585 2.01219512195e-07 1.2 2.01251270325e-07 1.44748737342 2.01283028455e-07 1.55 2.01314786585e-07 1.44748737342 2.01346544715e-07 1.2 2.01378302846e-07 0.952512626585 2.01410060976e-07 0.85 2.01441819106e-07 0.952512626585 2.01473577236e-07 1.2 2.01505335366e-07 1.44748737342 2.01537093496e-07 1.55 2.01568851626e-07 1.44748737342 2.01600609756e-07 1.2 2.01632367886e-07 0.952512626585 2.01664126016e-07 0.85 2.01695884146e-07 0.952512626585 2.01727642276e-07 1.2 2.01759400407e-07 1.44748737342 2.01791158537e-07 1.55 2.01822916667e-07 1.44748737342 2.01854674797e-07 1.2 2.01886432927e-07 0.952512626585 2.01918191057e-07 0.85 2.01949949187e-07 0.952512626585 2.01981707317e-07 1.2 2.02013465447e-07 1.44748737342 2.02045223577e-07 1.55 2.02076981707e-07 1.44748737342 2.02108739837e-07 1.2 2.02140497967e-07 0.952512626585 2.02172256098e-07 0.85 2.02204014228e-07 0.952512626585 2.02235772358e-07 1.2 2.02267530488e-07 1.44748737342 2.02299288618e-07 1.55 2.02331046748e-07 1.44748737342 2.02362804878e-07 1.2 2.02394563008e-07 0.952512626585 2.02426321138e-07 0.85 2.02458079268e-07 0.952512626585 2.02489837398e-07 1.2 2.02521595528e-07 1.44748737342 2.02553353659e-07 1.55 2.02585111789e-07 1.44748737342 2.02616869919e-07 1.2 2.02648628049e-07 0.952512626585 2.02680386179e-07 0.85 2.02712144309e-07 0.952512626585 2.02743902439e-07 1.2 2.02775660569e-07 1.44748737342 2.02807418699e-07 1.55 2.02839176829e-07 1.44748737342 2.02870934959e-07 1.2 2.02902693089e-07 0.952512626585 2.0293445122e-07 0.85 2.0296620935e-07 0.952512626585 2.0299796748e-07 1.2 2.0302972561e-07 1.44748737342 2.0306148374e-07 1.55 2.0309324187e-07 1.44748737342 2.03125e-07 1.2 2.0315675813e-07 0.952512626585 2.0318851626e-07 0.85 2.0322027439e-07 0.952512626585 2.0325203252e-07 1.2 2.0328379065e-07 1.44748737342 2.0331554878e-07 1.55 2.03347306911e-07 1.44748737342 2.03379065041e-07 1.2 2.03410823171e-07 0.952512626585 2.03442581301e-07 0.85 2.03474339431e-07 0.952512626585 2.03506097561e-07 1.2 2.03537855691e-07 1.44748737342 2.03569613821e-07 1.55 2.03601371951e-07 1.44748737342 2.03633130081e-07 1.2 2.03664888211e-07 0.952512626585 2.03696646341e-07 0.85 2.03728404472e-07 0.952512626585 2.03760162602e-07 1.2 2.03791920732e-07 1.44748737342 2.03823678862e-07 1.55 2.03855436992e-07 1.44748737342 2.03887195122e-07 1.2 2.03918953252e-07 0.952512626585 2.03950711382e-07 0.85 2.03982469512e-07 0.952512626585 2.04014227642e-07 1.2 2.04045985772e-07 1.44748737342 2.04077743902e-07 1.55 2.04109502033e-07 1.44748737342 2.04141260163e-07 1.2 2.04173018293e-07 0.952512626585 2.04204776423e-07 0.85 2.04236534553e-07 0.952512626585 2.04268292683e-07 1.2 2.04300050813e-07 1.44748737342 2.04331808943e-07 1.55 2.04363567073e-07 1.44748737342 2.04395325203e-07 1.2 2.04427083333e-07 0.952512626585 2.04458841463e-07 0.85 2.04490599593e-07 0.952512626585 2.04522357724e-07 1.2 2.04554115854e-07 1.44748737342 2.04585873984e-07 1.55 2.04617632114e-07 1.44748737342 2.04649390244e-07 1.2 2.04681148374e-07 0.952512626585 2.04712906504e-07 0.85 2.04744664634e-07 0.952512626585 2.04776422764e-07 1.2 2.04808180894e-07 1.44748737342 2.04839939024e-07 1.55 2.04871697154e-07 1.44748737342 2.04903455285e-07 1.2 2.04935213415e-07 0.952512626585 2.04966971545e-07 0.85 2.04998729675e-07 0.952512626585 2.05030487805e-07 1.2 2.05062245935e-07 1.44748737342 2.05094004065e-07 1.55 2.05125762195e-07 1.44748737342 2.05157520325e-07 1.2 2.05189278455e-07 0.952512626585 2.05221036585e-07 0.85 2.05252794715e-07 0.952512626585 2.05284552846e-07 1.2 2.05316310976e-07 1.44748737342 2.05348069106e-07 1.55 2.05379827236e-07 1.44748737342 2.05411585366e-07 1.2 2.05443343496e-07 0.952512626585 2.05475101626e-07 0.85 2.05506859756e-07 0.952512626585 2.05538617886e-07 1.2 2.05570376016e-07 1.44748737342 2.05602134146e-07 1.55 2.05633892276e-07 1.44748737342 2.05665650407e-07 1.2 2.05697408537e-07 0.952512626585 2.05729166667e-07 0.85 2.05760924797e-07 0.952512626585 2.05792682927e-07 1.2 2.05824441057e-07 1.44748737342 2.05856199187e-07 1.55 2.05887957317e-07 1.44748737342 2.05919715447e-07 1.2 2.05951473577e-07 0.952512626585 2.05983231707e-07 0.85 2.06014989837e-07 0.952512626585 2.06046747967e-07 1.2 2.06078506098e-07 1.44748737342 2.06110264228e-07 1.55 2.06142022358e-07 1.44748737342 2.06173780488e-07 1.2 2.06205538618e-07 0.952512626585 2.06237296748e-07 0.85 2.06269054878e-07 0.952512626585 2.06300813008e-07 1.2 2.06332571138e-07 1.44748737342 2.06364329268e-07 1.55 2.06396087398e-07 1.44748737342 2.06427845528e-07 1.2 2.06459603659e-07 0.952512626585 2.06491361789e-07 0.85 2.06523119919e-07 0.952512626585 2.06554878049e-07 1.2 2.06586636179e-07 1.44748737342 2.06618394309e-07 1.55 2.06650152439e-07 1.44748737342 2.06681910569e-07 1.2 2.06713668699e-07 0.952512626585 2.06745426829e-07 0.85 2.06777184959e-07 0.952512626585 2.06808943089e-07 1.2 2.0684070122e-07 1.44748737342 2.0687245935e-07 1.55 2.0690421748e-07 1.44748737342 2.0693597561e-07 1.2 2.0696773374e-07 0.952512626585 2.0699949187e-07 0.85 2.0703125e-07 0.952512626585 2.0706300813e-07 1.2 2.0709476626e-07 1.44748737342 2.0712652439e-07 1.55 2.0715828252e-07 1.44748737342 2.0719004065e-07 1.2 2.0722179878e-07 0.952512626585 2.07253556911e-07 0.85 2.07285315041e-07 0.952512626585 2.07317073171e-07 1.2 2.07348831301e-07 1.44748737342 2.07380589431e-07 1.55 2.07412347561e-07 1.44748737342 2.07444105691e-07 1.2 2.07475863821e-07 0.952512626585 2.07507621951e-07 0.85 2.07539380081e-07 0.952512626585 2.07571138211e-07 1.2 2.07602896341e-07 1.44748737342 2.07634654472e-07 1.55 2.07666412602e-07 1.44748737342 2.07698170732e-07 1.2 2.07729928862e-07 0.952512626585 2.07761686992e-07 0.85 2.07793445122e-07 0.952512626585 2.07825203252e-07 1.2 2.07856961382e-07 1.44748737342 2.07888719512e-07 1.55 2.07920477642e-07 1.44748737342 2.07952235772e-07 1.2 2.07983993902e-07 0.952512626585 2.08015752033e-07 0.85 2.08047510163e-07 0.952512626585 2.08079268293e-07 1.2 2.08111026423e-07 1.44748737342 2.08142784553e-07 1.55 2.08174542683e-07 1.44748737342 2.08206300813e-07 1.2 2.08238058943e-07 0.952512626585 2.08269817073e-07 0.85 2.08301575203e-07 0.952512626585 2.08333333333e-07 1.2 2.08365091463e-07 1.44748737342 2.08396849593e-07 1.55 2.08428607724e-07 1.44748737342 2.08460365854e-07 1.2 2.08492123984e-07 0.952512626585 2.08523882114e-07 0.85 2.08555640244e-07 0.952512626585 2.08587398374e-07 1.2 2.08619156504e-07 1.44748737342 2.08650914634e-07 1.55 2.08682672764e-07 1.44748737342 2.08714430894e-07 1.2 2.08746189024e-07 0.952512626585 2.08777947154e-07 0.85 2.08809705285e-07 0.952512626585 2.08841463415e-07 1.2 2.08873221545e-07 1.44748737342 2.08904979675e-07 1.55 2.08936737805e-07 1.44748737342 2.08968495935e-07 1.2 2.09000254065e-07 0.952512626585 2.09032012195e-07 0.85 2.09063770325e-07 0.952512626585 2.09095528455e-07 1.2 2.09127286585e-07 1.44748737342 2.09159044715e-07 1.55 2.09190802846e-07 1.44748737342 2.09222560976e-07 1.2 2.09254319106e-07 0.952512626585 2.09286077236e-07 0.85 2.09317835366e-07 0.952512626585 2.09349593496e-07 1.2 2.09381351626e-07 1.44748737342 2.09413109756e-07 1.55 2.09444867886e-07 1.44748737342 2.09476626016e-07 1.2 2.09508384146e-07 0.952512626585 2.09540142276e-07 0.85 2.09571900407e-07 0.952512626585 2.09603658537e-07 1.2 2.09635416667e-07 1.44748737342 2.09667174797e-07 1.55 2.09698932927e-07 1.44748737342 2.09730691057e-07 1.2 2.09762449187e-07 0.952512626585 2.09794207317e-07 0.85 2.09825965447e-07 0.952512626585 2.09857723577e-07 1.2 2.09889481707e-07 1.44748737342 2.09921239837e-07 1.55 2.09952997967e-07 1.44748737342 2.09984756098e-07 1.2 2.10016514228e-07 0.952512626585 2.10048272358e-07 0.85 2.10080030488e-07 0.952512626585 2.10111788618e-07 1.2 2.10143546748e-07 1.44748737342 2.10175304878e-07 1.55 2.10207063008e-07 1.44748737342 2.10238821138e-07 1.2 2.10270579268e-07 0.952512626585 2.10302337398e-07 0.85 2.10334095528e-07 0.952512626585 2.10365853659e-07 1.2 2.10397611789e-07 1.44748737342 2.10429369919e-07 1.55 2.10461128049e-07 1.44748737342 2.10492886179e-07 1.2 2.10524644309e-07 0.952512626585 2.10556402439e-07 0.85 2.10588160569e-07 0.952512626585 2.10619918699e-07 1.2 2.10651676829e-07 1.44748737342 2.10683434959e-07 1.55 2.10715193089e-07 1.44748737342 2.1074695122e-07 1.2 2.1077870935e-07 0.952512626585 2.1081046748e-07 0.85 2.1084222561e-07 0.952512626585 2.1087398374e-07 1.2 2.1090574187e-07 1.44748737342 2.109375e-07 1.55 2.1096925813e-07 1.44748737342 2.1100101626e-07 1.2 2.1103277439e-07 0.952512626585 2.1106453252e-07 0.85 2.1109629065e-07 0.952512626585 2.1112804878e-07 1.2 2.11159806911e-07 1.44748737342 2.11191565041e-07 1.55 2.11223323171e-07 1.44748737342 2.11255081301e-07 1.2 2.11286839431e-07 0.952512626585 2.11318597561e-07 0.85 2.11350355691e-07 0.952512626585 2.11382113821e-07 1.2 2.11413871951e-07 1.44748737342 2.11445630081e-07 1.55 2.11477388211e-07 1.44748737342 2.11509146341e-07 1.2 2.11540904472e-07 0.952512626585 2.11572662602e-07 0.85 2.11604420732e-07 0.952512626585 2.11636178862e-07 1.2 2.11667936992e-07 1.44748737342 2.11699695122e-07 1.55 2.11731453252e-07 1.44748737342 2.11763211382e-07 1.2 2.11794969512e-07 0.952512626585 2.11826727642e-07 0.85 2.11858485772e-07 0.952512626585 2.11890243902e-07 1.2 2.11922002033e-07 1.44748737342 2.11953760163e-07 1.55 2.11985518293e-07 1.44748737342 2.12017276423e-07 1.2 2.12049034553e-07 0.952512626585 2.12080792683e-07 0.85 2.12112550813e-07 0.952512626585 2.12144308943e-07 1.2 2.12176067073e-07 1.44748737342 2.12207825203e-07 1.55 2.12239583333e-07 1.44748737342 2.12271341463e-07 1.2 2.12303099593e-07 0.952512626585 2.12334857724e-07 0.85 2.12366615854e-07 0.952512626585 2.12398373984e-07 1.2 2.12430132114e-07 1.44748737342 2.12461890244e-07 1.55 2.12493648374e-07 1.44748737342 2.12525406504e-07 1.2 2.12557164634e-07 0.952512626585 2.12588922764e-07 0.85 2.12620680894e-07 0.952512626585 2.12652439024e-07 1.2 2.12684197154e-07 1.44748737342 2.12715955285e-07 1.55 2.12747713415e-07 1.44748737342 2.12779471545e-07 1.2 2.12811229675e-07 0.952512626585 2.12842987805e-07 0.85 2.12874745935e-07 0.952512626585 2.12906504065e-07 1.2 2.12938262195e-07 1.44748737342 2.12970020325e-07 1.55 2.13001778455e-07 1.44748737342 2.13033536585e-07 1.2 2.13065294715e-07 0.952512626585 2.13097052846e-07 0.85 2.13128810976e-07 0.952512626585 2.13160569106e-07 1.2 2.13192327236e-07 1.44748737342 2.13224085366e-07 1.55 2.13255843496e-07 1.44748737342 2.13287601626e-07 1.2 2.13319359756e-07 0.952512626585 2.13351117886e-07 0.85 2.13382876016e-07 0.952512626585 2.13414634146e-07 1.2 2.13446392276e-07 1.44748737342 2.13478150407e-07 1.55 2.13509908537e-07 1.44748737342 2.13541666667e-07 1.2 2.13573424797e-07 0.952512626585 2.13605182927e-07 0.85 2.13636941057e-07 0.952512626585 2.13668699187e-07 1.2 2.13700457317e-07 1.44748737342 2.13732215447e-07 1.55 2.13763973577e-07 1.44748737342 2.13795731707e-07 1.2 2.13827489837e-07 0.952512626585 2.13859247967e-07 0.85 2.13891006098e-07 0.952512626585 2.13922764228e-07 1.2 2.13954522358e-07 1.44748737342 2.13986280488e-07 1.55 2.14018038618e-07 1.44748737342 2.14049796748e-07 1.2 2.14081554878e-07 0.952512626585 2.14113313008e-07 0.85 2.14145071138e-07 0.952512626585 2.14176829268e-07 1.2 2.14208587398e-07 1.44748737342 2.14240345528e-07 1.55 2.14272103659e-07 1.44748737342 2.14303861789e-07 1.2 2.14335619919e-07 0.952512626585 2.14367378049e-07 0.85 2.14399136179e-07 0.952512626585 2.14430894309e-07 1.2 2.14462652439e-07 1.44748737342 2.14494410569e-07 1.55 2.14526168699e-07 1.44748737342 2.14557926829e-07 1.2 2.14589684959e-07 0.952512626585 2.14621443089e-07 0.85 2.1465320122e-07 0.952512626585 2.1468495935e-07 1.2 2.1471671748e-07 1.44748737342 2.1474847561e-07 1.55 2.1478023374e-07 1.44748737342 2.1481199187e-07 1.2 2.1484375e-07 0.952512626585 2.1487550813e-07 0.85 2.1490726626e-07 0.952512626585 2.1493902439e-07 1.2 2.1497078252e-07 1.44748737342 2.1500254065e-07 1.55 2.1503429878e-07 1.44748737342 2.15066056911e-07 1.2 2.15097815041e-07 0.952512626585 2.15129573171e-07 0.85 2.15161331301e-07 0.952512626585 2.15193089431e-07 1.2 2.15224847561e-07 1.44748737342 2.15256605691e-07 1.55 2.15288363821e-07 1.44748737342 2.15320121951e-07 1.2 2.15351880081e-07 0.952512626585 2.15383638211e-07 0.85 2.15415396341e-07 0.952512626585 2.15447154472e-07 1.2 2.15478912602e-07 1.44748737342 2.15510670732e-07 1.55 2.15542428862e-07 1.44748737342 2.15574186992e-07 1.2 2.15605945122e-07 0.952512626585 2.15637703252e-07 0.85 2.15669461382e-07 0.952512626585 2.15701219512e-07 1.2 2.15732977642e-07 1.44748737342 2.15764735772e-07 1.55 2.15796493902e-07 1.44748737342 2.15828252033e-07 1.2 2.15860010163e-07 0.952512626585 2.15891768293e-07 0.85 2.15923526423e-07 0.952512626585 2.15955284553e-07 1.2 2.15987042683e-07 1.44748737342 2.16018800813e-07 1.55 2.16050558943e-07 1.44748737342 2.16082317073e-07 1.2 2.16114075203e-07 0.952512626585 2.16145833333e-07 0.85 2.16177591463e-07 0.952512626585 2.16209349593e-07 1.2 2.16241107724e-07 1.44748737342 2.16272865854e-07 1.55 2.16304623984e-07 1.44748737342 2.16336382114e-07 1.2 2.16368140244e-07 0.952512626585 2.16399898374e-07 0.85 2.16431656504e-07 0.952512626585 2.16463414634e-07 1.2 2.16495172764e-07 1.44748737342 2.16526930894e-07 1.55 2.16558689024e-07 1.44748737342 2.16590447154e-07 1.2 2.16622205285e-07 0.952512626585 2.16653963415e-07 0.85 2.16685721545e-07 0.952512626585 2.16717479675e-07 1.2 2.16749237805e-07 1.44748737342 2.16780995935e-07 1.55 2.16812754065e-07 1.44748737342 2.16844512195e-07 1.2 2.16876270325e-07 0.952512626585 2.16908028455e-07 0.85 2.16939786585e-07 0.952512626585 2.16971544715e-07 1.2 2.17003302846e-07 1.44748737342 2.17035060976e-07 1.55 2.17066819106e-07 1.44748737342 2.17098577236e-07 1.2 2.17130335366e-07 0.952512626585 2.17162093496e-07 0.85 2.17193851626e-07 0.952512626585 2.17225609756e-07 1.2 2.17257367886e-07 1.44748737342 2.17289126016e-07 1.55 2.17320884146e-07 1.44748737342 2.17352642276e-07 1.2 2.17384400407e-07 0.952512626585 2.17416158537e-07 0.85 2.17447916667e-07 0.952512626585 2.17479674797e-07 1.2 2.17511432927e-07 1.44748737342 2.17543191057e-07 1.55 2.17574949187e-07 1.44748737342 2.17606707317e-07 1.2 2.17638465447e-07 0.952512626585 2.17670223577e-07 0.85 2.17701981707e-07 0.952512626585 2.17733739837e-07 1.2 2.17765497967e-07 1.44748737342 2.17797256098e-07 1.55 2.17829014228e-07 1.44748737342 2.17860772358e-07 1.2 2.17892530488e-07 0.952512626585 2.17924288618e-07 0.85 2.17956046748e-07 0.952512626585 2.17987804878e-07 1.2 2.18019563008e-07 1.44748737342 2.18051321138e-07 1.55 2.18083079268e-07 1.44748737342 2.18114837398e-07 1.2 2.18146595528e-07 0.952512626585 2.18178353659e-07 0.85 2.18210111789e-07 0.952512626585 2.18241869919e-07 1.2 2.18273628049e-07 1.44748737342 2.18305386179e-07 1.55 2.18337144309e-07 1.44748737342 2.18368902439e-07 1.2 2.18400660569e-07 0.952512626585 2.18432418699e-07 0.85 2.18464176829e-07 0.952512626585 2.18495934959e-07 1.2 2.18527693089e-07 1.44748737342 2.1855945122e-07 1.55 2.1859120935e-07 1.44748737342 2.1862296748e-07 1.2 2.1865472561e-07 0.952512626585 2.1868648374e-07 0.85 2.1871824187e-07 0.952512626585 2.1875e-07 1.2 2.1878175813e-07 1.44748737342 2.1881351626e-07 1.55 2.1884527439e-07 1.44748737342 2.1887703252e-07 1.2 2.1890879065e-07 0.952512626585 2.1894054878e-07 0.85 2.18972306911e-07 0.952512626585 2.19004065041e-07 1.2 2.19035823171e-07 1.44748737342 2.19067581301e-07 1.55 2.19099339431e-07 1.44748737342 2.19131097561e-07 1.2 2.19162855691e-07 0.952512626585 2.19194613821e-07 0.85 2.19226371951e-07 0.952512626585 2.19258130081e-07 1.2 2.19289888211e-07 1.44748737342 2.19321646341e-07 1.55 2.19353404472e-07 1.44748737342 2.19385162602e-07 1.2 2.19416920732e-07 0.952512626585 2.19448678862e-07 0.85 2.19480436992e-07 0.952512626585 2.19512195122e-07 1.2 2.19543953252e-07 1.44748737342 2.19575711382e-07 1.55 2.19607469512e-07 1.44748737342 2.19639227642e-07 1.2 2.19670985772e-07 0.952512626585 2.19702743902e-07 0.85 2.19734502033e-07 0.952512626585 2.19766260163e-07 1.2 2.19798018293e-07 1.44748737342 2.19829776423e-07 1.55 2.19861534553e-07 1.44748737342 2.19893292683e-07 1.2 2.19925050813e-07 0.952512626585 2.19956808943e-07 0.85 2.19988567073e-07 0.952512626585 2.20020325203e-07 1.2 2.20052083333e-07 1.44748737342 2.20083841463e-07 1.55 2.20115599593e-07 1.44748737342 2.20147357724e-07 1.2 2.20179115854e-07 0.952512626585 2.20210873984e-07 0.85 2.20242632114e-07 0.952512626585 2.20274390244e-07 1.2 2.20306148374e-07 1.44748737342 2.20337906504e-07 1.55 2.20369664634e-07 1.44748737342 2.20401422764e-07 1.2 2.20433180894e-07 0.952512626585 2.20464939024e-07 0.85 2.20496697154e-07 0.952512626585 2.20528455285e-07 1.2 2.20560213415e-07 1.44748737342 2.20591971545e-07 1.55 2.20623729675e-07 1.44748737342 2.20655487805e-07 1.2 2.20687245935e-07 0.952512626585 2.20719004065e-07 0.85 2.20750762195e-07 0.952512626585 2.20782520325e-07 1.2 2.20814278455e-07 1.44748737342 2.20846036585e-07 1.55 2.20877794715e-07 1.44748737342 2.20909552846e-07 1.2 2.20941310976e-07 0.952512626585 2.20973069106e-07 0.85 2.21004827236e-07 0.952512626585 2.21036585366e-07 1.2 2.21068343496e-07 1.44748737342 2.21100101626e-07 1.55 2.21131859756e-07 1.44748737342 2.21163617886e-07 1.2 2.21195376016e-07 0.952512626585 2.21227134146e-07 0.85 2.21258892276e-07 0.952512626585 2.21290650407e-07 1.2 2.21322408537e-07 1.44748737342 2.21354166667e-07 1.55 2.21385924797e-07 1.44748737342 2.21417682927e-07 1.2 2.21449441057e-07 0.952512626585 2.21481199187e-07 0.85 2.21512957317e-07 0.952512626585 2.21544715447e-07 1.2 2.21576473577e-07 1.44748737342 2.21608231707e-07 1.55 2.21639989837e-07 1.44748737342 2.21671747967e-07 1.2 2.21703506098e-07 0.952512626585 2.21735264228e-07 0.85 2.21767022358e-07 0.952512626585 2.21798780488e-07 1.2 2.21830538618e-07 1.44748737342 2.21862296748e-07 1.55 2.21894054878e-07 1.44748737342 2.21925813008e-07 1.2 2.21957571138e-07 0.952512626585 2.21989329268e-07 0.85 2.22021087398e-07 0.952512626585 2.22052845528e-07 1.2 2.22084603659e-07 1.44748737342 2.22116361789e-07 1.55 2.22148119919e-07 1.44748737342 2.22179878049e-07 1.2 2.22211636179e-07 0.952512626585 2.22243394309e-07 0.85 2.22275152439e-07 0.952512626585 2.22306910569e-07 1.2 2.22338668699e-07 1.44748737342 2.22370426829e-07 1.55 2.22402184959e-07 1.44748737342 2.22433943089e-07 1.2 2.2246570122e-07 0.952512626585 2.2249745935e-07 0.85 2.2252921748e-07 0.952512626585 2.2256097561e-07 1.2 2.2259273374e-07 1.44748737342 2.2262449187e-07 1.55 2.2265625e-07 1.44748737342 2.2268800813e-07 1.2 2.2271976626e-07 0.952512626585 2.2275152439e-07 0.85 2.2278328252e-07 0.952512626585 2.2281504065e-07 1.2 2.2284679878e-07 1.44748737342 2.22878556911e-07 1.55 2.22910315041e-07 1.44748737342 2.22942073171e-07 1.2 2.22973831301e-07 0.952512626585 2.23005589431e-07 0.85 2.23037347561e-07 0.952512626585 2.23069105691e-07 1.2 2.23100863821e-07 1.44748737342 2.23132621951e-07 1.55 2.23164380081e-07 1.44748737342 2.23196138211e-07 1.2 2.23227896341e-07 0.952512626585 2.23259654472e-07 0.85 2.23291412602e-07 0.952512626585 2.23323170732e-07 1.2 2.23354928862e-07 1.44748737342 2.23386686992e-07 1.55 2.23418445122e-07 1.44748737342 2.23450203252e-07 1.2 2.23481961382e-07 0.952512626585 2.23513719512e-07 0.85 2.23545477642e-07 0.952512626585 2.23577235772e-07 1.2 2.23608993902e-07 1.44748737342 2.23640752033e-07 1.55 2.23672510163e-07 1.44748737342 2.23704268293e-07 1.2 2.23736026423e-07 0.952512626585 2.23767784553e-07 0.85 2.23799542683e-07 0.952512626585 2.23831300813e-07 1.2 2.23863058943e-07 1.44748737342 2.23894817073e-07 1.55 2.23926575203e-07 1.44748737342 2.23958333333e-07 1.2 2.23990091463e-07 0.952512626585 2.24021849593e-07 0.85 2.24053607724e-07 0.952512626585 2.24085365854e-07 1.2 2.24117123984e-07 1.44748737342 2.24148882114e-07 1.55 2.24180640244e-07 1.44748737342 2.24212398374e-07 1.2 2.24244156504e-07 0.952512626585 2.24275914634e-07 0.85 2.24307672764e-07 0.952512626585 2.24339430894e-07 1.2 2.24371189024e-07 1.44748737342 2.24402947154e-07 1.55 2.24434705285e-07 1.44748737342 2.24466463415e-07 1.2 2.24498221545e-07 0.952512626585 2.24529979675e-07 0.85 2.24561737805e-07 0.952512626585 2.24593495935e-07 1.2 2.24625254065e-07 1.44748737342 2.24657012195e-07 1.55 2.24688770325e-07 1.44748737342 2.24720528455e-07 1.2 2.24752286585e-07 0.952512626585 2.24784044715e-07 0.85 2.24815802846e-07 0.952512626585 2.24847560976e-07 1.2 2.24879319106e-07 1.44748737342 2.24911077236e-07 1.55 2.24942835366e-07 1.44748737342 2.24974593496e-07 1.2 2.25006351626e-07 0.952512626585 2.25038109756e-07 0.85 2.25069867886e-07 0.952512626585 2.25101626016e-07 1.2 2.25133384146e-07 1.44748737342 2.25165142276e-07 1.55 2.25196900407e-07 1.44748737342 2.25228658537e-07 1.2 2.25260416667e-07 0.952512626585 2.25292174797e-07 0.85 2.25323932927e-07 0.952512626585 2.25355691057e-07 1.2 2.25387449187e-07 1.44748737342 2.25419207317e-07 1.55 2.25450965447e-07 1.44748737342 2.25482723577e-07 1.2 2.25514481707e-07 0.952512626585 2.25546239837e-07 0.85 2.25577997967e-07 0.952512626585 2.25609756098e-07 1.2 2.25641514228e-07 1.44748737342 2.25673272358e-07 1.55 2.25705030488e-07 1.44748737342 2.25736788618e-07 1.2 2.25768546748e-07 0.952512626585 2.25800304878e-07 0.85 2.25832063008e-07 0.952512626585 2.25863821138e-07 1.2 2.25895579268e-07 1.44748737342 2.25927337398e-07 1.55 2.25959095528e-07 1.44748737342 2.25990853659e-07 1.2 2.26022611789e-07 0.952512626585 2.26054369919e-07 0.85 2.26086128049e-07 0.952512626585 2.26117886179e-07 1.2 2.26149644309e-07 1.44748737342 2.26181402439e-07 1.55 2.26213160569e-07 1.44748737342 2.26244918699e-07 1.2 2.26276676829e-07 0.952512626585 2.26308434959e-07 0.85 2.26340193089e-07 0.952512626585 2.2637195122e-07 1.2 2.2640370935e-07 1.44748737342 2.2643546748e-07 1.55 2.2646722561e-07 1.44748737342 2.2649898374e-07 1.2 2.2653074187e-07 0.952512626585 2.265625e-07 0.85 2.2659425813e-07 0.952512626585 2.2662601626e-07 1.2 2.2665777439e-07 1.44748737342 2.2668953252e-07 1.55 2.2672129065e-07 1.44748737342 2.2675304878e-07 1.2 2.26784806911e-07 0.952512626585 2.26816565041e-07 0.85 2.26848323171e-07 0.952512626585 2.26880081301e-07 1.2 2.26911839431e-07 1.44748737342 2.26943597561e-07 1.55 2.26975355691e-07 1.44748737342 2.27007113821e-07 1.2 2.27038871951e-07 0.952512626585 2.27070630081e-07 0.85 2.27102388211e-07 0.952512626585 2.27134146341e-07 1.2 2.27165904472e-07 1.44748737342 2.27197662602e-07 1.55 2.27229420732e-07 1.44748737342 2.27261178862e-07 1.2 2.27292936992e-07 0.952512626585 2.27324695122e-07 0.85 2.27356453252e-07 0.952512626585 2.27388211382e-07 1.2 2.27419969512e-07 1.44748737342 2.27451727642e-07 1.55 2.27483485772e-07 1.44748737342 2.27515243902e-07 1.2 2.27547002033e-07 0.952512626585 2.27578760163e-07 0.85 2.27610518293e-07 0.952512626585 2.27642276423e-07 1.2 2.27674034553e-07 1.44748737342 2.27705792683e-07 1.55 2.27737550813e-07 1.44748737342 2.27769308943e-07 1.2 2.27801067073e-07 0.952512626585 2.27832825203e-07 0.85 2.27864583333e-07 0.952512626585 2.27896341463e-07 1.2 2.27928099593e-07 1.44748737342 2.27959857724e-07 1.55 2.27991615854e-07 1.44748737342 2.28023373984e-07 1.2 2.28055132114e-07 0.952512626585 2.28086890244e-07 0.85 2.28118648374e-07 0.952512626585 2.28150406504e-07 1.2 2.28182164634e-07 1.44748737342 2.28213922764e-07 1.55 2.28245680894e-07 1.44748737342 2.28277439024e-07 1.2 2.28309197154e-07 0.952512626585 2.28340955285e-07 0.85 2.28372713415e-07 0.952512626585 2.28404471545e-07 1.2 2.28436229675e-07 1.44748737342 2.28467987805e-07 1.55 2.28499745935e-07 1.44748737342 2.28531504065e-07 1.2 2.28563262195e-07 0.952512626585 2.28595020325e-07 0.85 2.28626778455e-07 0.952512626585 2.28658536585e-07 1.2 2.28690294715e-07 1.44748737342 2.28722052846e-07 1.55 2.28753810976e-07 1.44748737342 2.28785569106e-07 1.2 2.28817327236e-07 0.952512626585 2.28849085366e-07 0.85 2.28880843496e-07 0.952512626585 2.28912601626e-07 1.2 2.28944359756e-07 1.44748737342 2.28976117886e-07 1.55 2.29007876016e-07 1.44748737342 2.29039634146e-07 1.2 2.29071392276e-07 0.952512626585 2.29103150407e-07 0.85 2.29134908537e-07 0.952512626585 2.29166666667e-07 1.2 2.29198424797e-07 1.44748737342 2.29230182927e-07 1.55 2.29261941057e-07 1.44748737342 2.29293699187e-07 1.2 2.29325457317e-07 0.952512626585 2.29357215447e-07 0.85 2.29388973577e-07 0.952512626585 2.29420731707e-07 1.2 2.29452489837e-07 1.44748737342 2.29484247967e-07 1.55 2.29516006098e-07 1.44748737342 2.29547764228e-07 1.2 2.29579522358e-07 0.952512626585 2.29611280488e-07 0.85 2.29643038618e-07 0.952512626585 2.29674796748e-07 1.2 2.29706554878e-07 1.44748737342 2.29738313008e-07 1.55 2.29770071138e-07 1.44748737342 2.29801829268e-07 1.2 2.29833587398e-07 0.952512626585 2.29865345528e-07 0.85 2.29897103659e-07 0.952512626585 2.29928861789e-07 1.2 2.29960619919e-07 1.44748737342 2.29992378049e-07 1.55 2.30024136179e-07 1.44748737342 2.30055894309e-07 1.2 2.30087652439e-07 0.952512626585 2.30119410569e-07 0.85 2.30151168699e-07 0.952512626585 2.30182926829e-07 1.2 2.30214684959e-07 1.44748737342 2.30246443089e-07 1.55 2.3027820122e-07 1.44748737342 2.3030995935e-07 1.2 2.3034171748e-07 0.952512626585 2.3037347561e-07 0.85 2.3040523374e-07 0.952512626585 2.3043699187e-07 1.2 2.3046875e-07 1.44748737342 2.3050050813e-07 1.55 2.3053226626e-07 1.44748737342 2.3056402439e-07 1.2 2.3059578252e-07 0.952512626585 2.3062754065e-07 0.85 2.3065929878e-07 0.952512626585 2.30691056911e-07 1.2 2.30722815041e-07 1.44748737342 2.30754573171e-07 1.55 2.30786331301e-07 1.44748737342 2.30818089431e-07 1.2 2.30849847561e-07 0.952512626585 2.30881605691e-07 0.85 2.30913363821e-07 0.952512626585 2.30945121951e-07 1.2 2.30976880081e-07 1.44748737342 2.31008638211e-07 1.55 2.31040396341e-07 1.44748737342 2.31072154472e-07 1.2 2.31103912602e-07 0.952512626585 2.31135670732e-07 0.85 2.31167428862e-07 0.952512626585 2.31199186992e-07 1.2 2.31230945122e-07 1.44748737342 2.31262703252e-07 1.55 2.31294461382e-07 1.44748737342 2.31326219512e-07 1.2 2.31357977642e-07 0.952512626585 2.31389735772e-07 0.85 2.31421493902e-07 0.952512626585 2.31453252033e-07 1.2 2.31485010163e-07 1.44748737342 2.31516768293e-07 1.55 2.31548526423e-07 1.44748737342 2.31580284553e-07 1.2 2.31612042683e-07 0.952512626585 2.31643800813e-07 0.85 2.31675558943e-07 0.952512626585 2.31707317073e-07 1.2 2.31739075203e-07 1.44748737342 2.31770833333e-07 1.55 2.31802591463e-07 1.44748737342 2.31834349593e-07 1.2 2.31866107724e-07 0.952512626585 2.31897865854e-07 0.85 2.31929623984e-07 0.952512626585 2.31961382114e-07 1.2 2.31993140244e-07 1.44748737342 2.32024898374e-07 1.55 2.32056656504e-07 1.44748737342 2.32088414634e-07 1.2 2.32120172764e-07 0.952512626585 2.32151930894e-07 0.85 2.32183689024e-07 0.952512626585 2.32215447154e-07 1.2 2.32247205285e-07 1.44748737342 2.32278963415e-07 1.55 2.32310721545e-07 1.44748737342 2.32342479675e-07 1.2 2.32374237805e-07 0.952512626585 2.32405995935e-07 0.85 2.32437754065e-07 0.952512626585 2.32469512195e-07 1.2 2.32501270325e-07 1.44748737342 2.32533028455e-07 1.55 2.32564786585e-07 1.44748737342 2.32596544715e-07 1.2 2.32628302846e-07 0.952512626585 2.32660060976e-07 0.85 2.32691819106e-07 0.952512626585 2.32723577236e-07 1.2 2.32755335366e-07 1.44748737342 2.32787093496e-07 1.55 2.32818851626e-07 1.44748737342 2.32850609756e-07 1.2 2.32882367886e-07 0.952512626585 2.32914126016e-07 0.85 2.32945884146e-07 0.952512626585 2.32977642276e-07 1.2 2.33009400407e-07 1.44748737342 2.33041158537e-07 1.55 2.33072916667e-07 1.44748737342 2.33104674797e-07 1.2 2.33136432927e-07 0.952512626585 2.33168191057e-07 0.85 2.33199949187e-07 0.952512626585 2.33231707317e-07 1.2 2.33263465447e-07 1.44748737342 2.33295223577e-07 1.55 2.33326981707e-07 1.44748737342 2.33358739837e-07 1.2 2.33390497967e-07 0.952512626585 2.33422256098e-07 0.85 2.33454014228e-07 0.952512626585 2.33485772358e-07 1.2 2.33517530488e-07 1.44748737342 2.33549288618e-07 1.55 2.33581046748e-07 1.44748737342 2.33612804878e-07 1.2 2.33644563008e-07 0.952512626585 2.33676321138e-07 0.85 2.33708079268e-07 0.952512626585 2.33739837398e-07 1.2 2.33771595528e-07 1.44748737342 2.33803353659e-07 1.55 2.33835111789e-07 1.44748737342 2.33866869919e-07 1.2 2.33898628049e-07 0.952512626585 2.33930386179e-07 0.85 2.33962144309e-07 0.952512626585 2.33993902439e-07 1.2 2.34025660569e-07 1.44748737342 2.34057418699e-07 1.55 2.34089176829e-07 1.44748737342 2.34120934959e-07 1.2 2.34152693089e-07 0.952512626585 2.3418445122e-07 0.85 2.3421620935e-07 0.952512626585 2.3424796748e-07 1.2 2.3427972561e-07 1.44748737342 2.3431148374e-07 1.55 2.3434324187e-07 1.44748737342 2.34375e-07 1.2 2.3440675813e-07 0.952512626585 2.3443851626e-07 0.85 2.3447027439e-07 0.952512626585 2.3450203252e-07 1.2 2.3453379065e-07 1.44748737342 2.3456554878e-07 1.55 2.34597306911e-07 1.44748737342 2.34629065041e-07 1.2 2.34660823171e-07 0.952512626585 2.34692581301e-07 0.85 2.34724339431e-07 0.952512626585 2.34756097561e-07 1.2 2.34787855691e-07 1.44748737342 2.34819613821e-07 1.55 2.34851371951e-07 1.44748737342 2.34883130081e-07 1.2 2.34914888211e-07 0.952512626585 2.34946646341e-07 0.85 2.34978404472e-07 0.952512626585 2.35010162602e-07 1.2 2.35041920732e-07 1.44748737342 2.35073678862e-07 1.55 2.35105436992e-07 1.44748737342 2.35137195122e-07 1.2 2.35168953252e-07 0.952512626585 2.35200711382e-07 0.85 2.35232469512e-07 0.952512626585 2.35264227642e-07 1.2 2.35295985772e-07 1.44748737342 2.35327743902e-07 1.55 2.35359502033e-07 1.44748737342 2.35391260163e-07 1.2 2.35423018293e-07 0.952512626585 2.35454776423e-07 0.85 2.35486534553e-07 0.952512626585 2.35518292683e-07 1.2 2.35550050813e-07 1.44748737342 2.35581808943e-07 1.55 2.35613567073e-07 1.44748737342 2.35645325203e-07 1.2 2.35677083333e-07 0.952512626585 2.35708841463e-07 0.85 2.35740599593e-07 0.952512626585 2.35772357724e-07 1.2 2.35804115854e-07 1.44748737342 2.35835873984e-07 1.55 2.35867632114e-07 1.44748737342 2.35899390244e-07 1.2 2.35931148374e-07 0.952512626585 2.35962906504e-07 0.85 2.35994664634e-07 0.952512626585 2.36026422764e-07 1.2 2.36058180894e-07 1.44748737342 2.36089939024e-07 1.55 2.36121697154e-07 1.44748737342 2.36153455285e-07 1.2 2.36185213415e-07 0.952512626585 2.36216971545e-07 0.85 2.36248729675e-07 0.952512626585 2.36280487805e-07 1.2 2.36312245935e-07 1.44748737342 2.36344004065e-07 1.55 2.36375762195e-07 1.44748737342 2.36407520325e-07 1.2 2.36439278455e-07 0.952512626585 2.36471036585e-07 0.85 2.36502794715e-07 0.952512626585 2.36534552846e-07 1.2 2.36566310976e-07 1.44748737342 2.36598069106e-07 1.55 2.36629827236e-07 1.44748737342 2.36661585366e-07 1.2 2.36693343496e-07 0.952512626585 2.36725101626e-07 0.85 2.36756859756e-07 0.952512626585 2.36788617886e-07 1.2 2.36820376016e-07 1.44748737342 2.36852134146e-07 1.55 2.36883892276e-07 1.44748737342 2.36915650407e-07 1.2 2.36947408537e-07 0.952512626585 2.36979166667e-07 0.85 2.37010924797e-07 0.952512626585 2.37042682927e-07 1.2 2.37074441057e-07 1.44748737342 2.37106199187e-07 1.55 2.37137957317e-07 1.44748737342 2.37169715447e-07 1.2 2.37201473577e-07 0.952512626585 2.37233231707e-07 0.85 2.37264989837e-07 0.952512626585 2.37296747967e-07 1.2 2.37328506098e-07 1.44748737342 2.37360264228e-07 1.55 2.37392022358e-07 1.44748737342 2.37423780488e-07 1.2 2.37455538618e-07 0.952512626585 2.37487296748e-07 0.85 2.37519054878e-07 0.952512626585 2.37550813008e-07 1.2 2.37582571138e-07 1.44748737342 2.37614329268e-07 1.55 2.37646087398e-07 1.44748737342 2.37677845528e-07 1.2 2.37709603659e-07 0.952512626585 2.37741361789e-07 0.85 2.37773119919e-07 0.952512626585 2.37804878049e-07 1.2 2.37836636179e-07 1.44748737342 2.37868394309e-07 1.55 2.37900152439e-07 1.44748737342 2.37931910569e-07 1.2 2.37963668699e-07 0.952512626585 2.37995426829e-07 0.85 2.38027184959e-07 0.952512626585 2.38058943089e-07 1.2 2.3809070122e-07 1.44748737342 2.3812245935e-07 1.55 2.3815421748e-07 1.44748737342 2.3818597561e-07 1.2 2.3821773374e-07 0.952512626585 2.3824949187e-07 0.85 2.3828125e-07 0.952512626585 2.3831300813e-07 1.2 2.3834476626e-07 1.44748737342 2.3837652439e-07 1.55 2.3840828252e-07 1.44748737342 2.3844004065e-07 1.2 2.3847179878e-07 0.952512626585 2.38503556911e-07 0.85 2.38535315041e-07 0.952512626585 2.38567073171e-07 1.2 2.38598831301e-07 1.44748737342 2.38630589431e-07 1.55 2.38662347561e-07 1.44748737342 2.38694105691e-07 1.2 2.38725863821e-07 0.952512626585 2.38757621951e-07 0.85 2.38789380081e-07 0.952512626585 2.38821138211e-07 1.2 2.38852896341e-07 1.44748737342 2.38884654472e-07 1.55 2.38916412602e-07 1.44748737342 2.38948170732e-07 1.2 2.38979928862e-07 0.952512626585 2.39011686992e-07 0.85 2.39043445122e-07 0.952512626585 2.39075203252e-07 1.2 2.39106961382e-07 1.44748737342 2.39138719512e-07 1.55 2.39170477642e-07 1.44748737342 2.39202235772e-07 1.2 2.39233993902e-07 0.952512626585 2.39265752033e-07 0.85 2.39297510163e-07 0.952512626585 2.39329268293e-07 1.2 2.39361026423e-07 1.44748737342 2.39392784553e-07 1.55 2.39424542683e-07 1.44748737342 2.39456300813e-07 1.2 2.39488058943e-07 0.952512626585 2.39519817073e-07 0.85 2.39551575203e-07 0.952512626585 2.39583333333e-07 1.2 2.39615091463e-07 1.44748737342 2.39646849593e-07 1.55 2.39678607724e-07 1.44748737342 2.39710365854e-07 1.2 2.39742123984e-07 0.952512626585 2.39773882114e-07 0.85 2.39805640244e-07 0.952512626585 2.39837398374e-07 1.2 2.39869156504e-07 1.44748737342 2.39900914634e-07 1.55 2.39932672764e-07 1.44748737342 2.39964430894e-07 1.2 2.39996189024e-07 0.952512626585 2.40027947154e-07 0.85 2.40059705285e-07 0.952512626585 2.40091463415e-07 1.2 2.40123221545e-07 1.44748737342 2.40154979675e-07 1.55 2.40186737805e-07 1.44748737342 2.40218495935e-07 1.2 2.40250254065e-07 0.952512626585 2.40282012195e-07 0.85 2.40313770325e-07 0.952512626585 2.40345528455e-07 1.2 2.40377286585e-07 1.44748737342 2.40409044715e-07 1.55 2.40440802846e-07 1.44748737342 2.40472560976e-07 1.2 2.40504319106e-07 0.952512626585 2.40536077236e-07 0.85 2.40567835366e-07 0.952512626585 2.40599593496e-07 1.2 2.40631351626e-07 1.44748737342 2.40663109756e-07 1.55 2.40694867886e-07 1.44748737342 2.40726626016e-07 1.2 2.40758384146e-07 0.952512626585 2.40790142276e-07 0.85 2.40821900407e-07 0.952512626585 2.40853658537e-07 1.2 2.40885416667e-07 1.44748737342 2.40917174797e-07 1.55 2.40948932927e-07 1.44748737342 2.40980691057e-07 1.2 2.41012449187e-07 0.952512626585 2.41044207317e-07 0.85 2.41075965447e-07 0.952512626585 2.41107723577e-07 1.2 2.41139481707e-07 1.44748737342 2.41171239837e-07 1.55 2.41202997967e-07 1.44748737342 2.41234756098e-07 1.2 2.41266514228e-07 0.952512626585 2.41298272358e-07 0.85 2.41330030488e-07 0.952512626585 2.41361788618e-07 1.2 2.41393546748e-07 1.44748737342 2.41425304878e-07 1.55 2.41457063008e-07 1.44748737342 2.41488821138e-07 1.2 2.41520579268e-07 0.952512626585 2.41552337398e-07 0.85 2.41584095528e-07 0.952512626585 2.41615853659e-07 1.2 2.41647611789e-07 1.44748737342 2.41679369919e-07 1.55 2.41711128049e-07 1.44748737342 2.41742886179e-07 1.2 2.41774644309e-07 0.952512626585 2.41806402439e-07 0.85 2.41838160569e-07 0.952512626584 2.41869918699e-07 1.2 2.41901676829e-07 1.44748737342 2.41933434959e-07 1.55 2.41965193089e-07 1.44748737342 2.4199695122e-07 1.2 2.4202870935e-07 0.952512626585 2.4206046748e-07 0.85 2.4209222561e-07 0.952512626585 2.4212398374e-07 1.2 2.4215574187e-07 1.44748737342 2.421875e-07 1.55 2.4221925813e-07 1.44748737342 2.4225101626e-07 1.2 2.4228277439e-07 0.952512626585 2.4231453252e-07 0.85 2.4234629065e-07 0.952512626585 2.4237804878e-07 1.2 2.42409806911e-07 1.44748737342 2.42441565041e-07 1.55 2.42473323171e-07 1.44748737342 2.42505081301e-07 1.2 2.42536839431e-07 0.952512626585 2.42568597561e-07 0.85 2.42600355691e-07 0.952512626585 2.42632113821e-07 1.2 2.42663871951e-07 1.44748737342 2.42695630081e-07 1.55 2.42727388211e-07 1.44748737342 2.42759146341e-07 1.2 2.42790904472e-07 0.952512626585 2.42822662602e-07 0.85 2.42854420732e-07 0.952512626585 2.42886178862e-07 1.2 2.42917936992e-07 1.44748737342 2.42949695122e-07 1.55 2.42981453252e-07 1.44748737342 2.43013211382e-07 1.2 2.43044969512e-07 0.952512626585 2.43076727642e-07 0.85 2.43108485772e-07 0.952512626585 2.43140243902e-07 1.2 2.43172002033e-07 1.44748737342 2.43203760163e-07 1.55 2.43235518293e-07 1.44748737342 2.43267276423e-07 1.2 2.43299034553e-07 0.952512626584 2.43330792683e-07 0.85 2.43362550813e-07 0.952512626585 2.43394308943e-07 1.2 2.43426067073e-07 1.44748737342 2.43457825203e-07 1.55 2.43489583333e-07 1.44748737342 2.43521341463e-07 1.2 2.43553099593e-07 0.952512626585 2.43584857724e-07 0.85 2.43616615854e-07 0.952512626584 2.43648373984e-07 1.2 2.43680132114e-07 1.44748737342 2.43711890244e-07 1.55 2.43743648374e-07 1.44748737342 2.43775406504e-07 1.2 2.43807164634e-07 0.952512626585 2.43838922764e-07 0.85 2.43870680894e-07 0.952512626585 2.43902439024e-07 1.2 2.43934197154e-07 1.44748737342 2.43965955285e-07 1.55 2.43997713415e-07 1.44748737342 2.44029471545e-07 1.2 2.44061229675e-07 0.952512626585 2.44092987805e-07 0.85 2.44124745935e-07 0.952512626585 2.44156504065e-07 1.2 2.44188262195e-07 1.44748737342 2.44220020325e-07 1.55 2.44251778455e-07 1.44748737342 2.44283536585e-07 1.2 2.44315294715e-07 0.952512626585 2.44347052846e-07 0.85 2.44378810976e-07 0.952512626585 2.44410569106e-07 1.2 2.44442327236e-07 1.44748737342 2.44474085366e-07 1.55 2.44505843496e-07 1.44748737342 2.44537601626e-07 1.2 2.44569359756e-07 0.952512626585 2.44601117886e-07 0.85 2.44632876016e-07 0.952512626585 2.44664634146e-07 1.2 2.44696392276e-07 1.44748737342 2.44728150407e-07 1.55 2.44759908537e-07 1.44748737342 2.44791666667e-07 1.2 2.44823424797e-07 0.952512626585 2.44855182927e-07 0.85 2.44886941057e-07 0.952512626585 2.44918699187e-07 1.2 2.44950457317e-07 1.44748737342 2.44982215447e-07 1.55 2.45013973577e-07 1.44748737342 2.45045731707e-07 1.2 2.45077489837e-07 0.952512626584 2.45109247967e-07 0.85 2.45141006098e-07 0.952512626585 2.45172764228e-07 1.2 2.45204522358e-07 1.44748737342 2.45236280488e-07 1.55 2.45268038618e-07 1.44748737342 2.45299796748e-07 1.2 2.45331554878e-07 0.952512626585 2.45363313008e-07 0.85 2.45395071138e-07 0.952512626584 2.45426829268e-07 1.2 2.45458587398e-07 1.44748737342 2.45490345528e-07 1.55 2.45522103659e-07 1.44748737342 2.45553861789e-07 1.2 2.45585619919e-07 0.952512626585 2.45617378049e-07 0.85 2.45649136179e-07 0.952512626585 2.45680894309e-07 1.2 2.45712652439e-07 1.44748737342 2.45744410569e-07 1.55 2.45776168699e-07 1.44748737342 2.45807926829e-07 1.2 2.45839684959e-07 0.952512626585 2.45871443089e-07 0.85 2.4590320122e-07 0.952512626585 2.4593495935e-07 1.2 2.4596671748e-07 1.44748737342 2.4599847561e-07 1.55 2.4603023374e-07 1.44748737342 2.4606199187e-07 1.2 2.4609375e-07 0.952512626585 2.4612550813e-07 0.85 2.4615726626e-07 0.952512626585 2.4618902439e-07 1.2 2.4622078252e-07 1.44748737342 2.4625254065e-07 1.55 2.4628429878e-07 1.44748737342 2.46316056911e-07 1.2 2.46347815041e-07 0.952512626585 2.46379573171e-07 0.85 2.46411331301e-07 0.952512626585 2.46443089431e-07 1.2 2.46474847561e-07 1.44748737342 2.46506605691e-07 1.55 2.46538363821e-07 1.44748737342 2.46570121951e-07 1.2 2.46601880081e-07 0.952512626585 2.46633638211e-07 0.85 2.46665396341e-07 0.952512626585 2.46697154472e-07 1.2 2.46728912602e-07 1.44748737342 2.46760670732e-07 1.55 2.46792428862e-07 1.44748737342 2.46824186992e-07 1.2 2.46855945122e-07 0.952512626585 2.46887703252e-07 0.85 2.46919461382e-07 0.952512626585 2.46951219512e-07 1.2 2.46982977642e-07 1.44748737342 2.47014735772e-07 1.55 2.47046493902e-07 1.44748737342 2.47078252033e-07 1.2 2.47110010163e-07 0.952512626585 2.47141768293e-07 0.85 2.47173526423e-07 0.952512626585 2.47205284553e-07 1.2 2.47237042683e-07 1.44748737342 2.47268800813e-07 1.55 2.47300558943e-07 1.44748737342 2.47332317073e-07 1.2 2.47364075203e-07 0.952512626585 2.47395833333e-07 0.85 2.47427591463e-07 0.952512626585 2.47459349593e-07 1.2 2.47491107724e-07 1.44748737342 2.47522865854e-07 1.55 2.47554623984e-07 1.44748737342 2.47586382114e-07 1.2 2.47618140244e-07 0.952512626585 2.47649898374e-07 0.85 2.47681656504e-07 0.952512626585 2.47713414634e-07 1.2 2.47745172764e-07 1.44748737342 2.47776930894e-07 1.55 2.47808689024e-07 1.44748737342 2.47840447154e-07 1.2 2.47872205285e-07 0.952512626585 2.47903963415e-07 0.85 2.47935721545e-07 0.952512626585 2.47967479675e-07 1.2 2.47999237805e-07 1.44748737342 2.48030995935e-07 1.55 2.48062754065e-07 1.44748737342 2.48094512195e-07 1.2 2.48126270325e-07 0.952512626585 2.48158028455e-07 0.85 2.48189786585e-07 0.952512626585 2.48221544715e-07 1.2 2.48253302846e-07 1.44748737342 2.48285060976e-07 1.55 2.48316819106e-07 1.44748737342 2.48348577236e-07 1.2 2.48380335366e-07 0.952512626585 2.48412093496e-07 0.85 2.48443851626e-07 0.952512626585 2.48475609756e-07 1.2 2.48507367886e-07 1.44748737342 2.48539126016e-07 1.55 2.48570884146e-07 1.44748737342 2.48602642276e-07 1.2 2.48634400407e-07 0.952512626585 2.48666158537e-07 0.85 2.48697916667e-07 0.952512626585 2.48729674797e-07 1.2 2.48761432927e-07 1.44748737342 2.48793191057e-07 1.55 2.48824949187e-07 1.44748737342 2.48856707317e-07 1.2 2.48888465447e-07 0.952512626585 2.48920223577e-07 0.85 2.48951981707e-07 0.952512626585 2.48983739837e-07 1.2 2.49015497967e-07 1.44748737342 2.49047256098e-07 1.55 2.49079014228e-07 1.44748737342 2.49110772358e-07 1.2 2.49142530488e-07 0.952512626585 2.49174288618e-07 0.85 2.49206046748e-07 0.952512626585 2.49237804878e-07 1.2 2.49269563008e-07 1.44748737342 2.49301321138e-07 1.55 2.49333079268e-07 1.44748737342 2.49364837398e-07 1.2 2.49396595528e-07 0.952512626585 2.49428353659e-07 0.85 2.49460111789e-07 0.952512626585 2.49491869919e-07 1.2 2.49523628049e-07 1.44748737342 2.49555386179e-07 1.55 2.49587144309e-07 1.44748737342 2.49618902439e-07 1.2 2.49650660569e-07 0.952512626585 2.49682418699e-07 0.85 2.49714176829e-07 0.952512626585 2.49745934959e-07 1.2 2.49777693089e-07 1.44748737342 2.4980945122e-07 1.55 2.4984120935e-07 1.44748737342 2.4987296748e-07 1.2 2.4990472561e-07 0.952512626585 2.4993648374e-07 0.85 2.4996824187e-07 0.952512626585 2.5e-07 1.2 2.5003175813e-07 1.44748737342 2.5006351626e-07 1.55 2.5009527439e-07 1.44748737342 2.5012703252e-07 1.2 2.5015879065e-07 0.952512626585 2.5019054878e-07 0.85 2.50222306911e-07 0.952512626585 2.50254065041e-07 1.2 2.50285823171e-07 1.44748737342 2.50317581301e-07 1.55 2.50349339431e-07 1.44748737342 2.50381097561e-07 1.2 2.50412855691e-07 0.952512626585 2.50444613821e-07 0.85 2.50476371951e-07 0.952512626585 2.50508130081e-07 1.2 2.50539888211e-07 1.44748737342 2.50571646341e-07 1.55 2.50603404472e-07 1.44748737342 2.50635162602e-07 1.2 2.50666920732e-07 0.952512626585 2.50698678862e-07 0.85 2.50730436992e-07 0.952512626585 2.50762195122e-07 1.2 2.50793953252e-07 1.44748737342 2.50825711382e-07 1.55 2.50857469512e-07 1.44748737342 2.50889227642e-07 1.2 2.50920985772e-07 0.952512626585 2.50952743902e-07 0.85 2.50984502033e-07 0.952512626585 2.51016260163e-07 1.2 2.51048018293e-07 1.44748737342 2.51079776423e-07 1.55 2.51111534553e-07 1.44748737342 2.51143292683e-07 1.2 2.51175050813e-07 0.952512626585 2.51206808943e-07 0.85 2.51238567073e-07 0.952512626585 2.51270325203e-07 1.2 2.51302083333e-07 1.44748737342 2.51333841463e-07 1.55 2.51365599593e-07 1.44748737342 2.51397357724e-07 1.2 2.51429115854e-07 0.952512626585 2.51460873984e-07 0.85 2.51492632114e-07 0.952512626585 2.51524390244e-07 1.2 2.51556148374e-07 1.44748737342 2.51587906504e-07 1.55 2.51619664634e-07 1.44748737342 2.51651422764e-07 1.2 2.51683180894e-07 0.952512626585 2.51714939024e-07 0.85 2.51746697154e-07 0.952512626585 2.51778455285e-07 1.2 2.51810213415e-07 1.44748737342 2.51841971545e-07 1.55 2.51873729675e-07 1.44748737342 2.51905487805e-07 1.2 2.51937245935e-07 0.952512626585 2.51969004065e-07 0.85 2.52000762195e-07 0.952512626584 2.52032520325e-07 1.2 2.52064278455e-07 1.44748737342 2.52096036585e-07 1.55 2.52127794715e-07 1.44748737342 2.52159552846e-07 1.2 2.52191310976e-07 0.952512626585 2.52223069106e-07 0.85 2.52254827236e-07 0.952512626585 2.52286585366e-07 1.2 2.52318343496e-07 1.44748737342 2.52350101626e-07 1.55 2.52381859756e-07 1.44748737342 2.52413617886e-07 1.2 2.52445376016e-07 0.952512626585 2.52477134146e-07 0.85 2.52508892276e-07 0.952512626585 2.52540650407e-07 1.2 2.52572408537e-07 1.44748737342 2.52604166667e-07 1.55 2.52635924797e-07 1.44748737342 2.52667682927e-07 1.2 2.52699441057e-07 0.952512626585 2.52731199187e-07 0.85 2.52762957317e-07 0.952512626585 2.52794715447e-07 1.2 2.52826473577e-07 1.44748737342 2.52858231707e-07 1.55 2.52889989837e-07 1.44748737342 2.52921747967e-07 1.2 2.52953506098e-07 0.952512626585 2.52985264228e-07 0.85 2.53017022358e-07 0.952512626585 2.53048780488e-07 1.2 2.53080538618e-07 1.44748737342 2.53112296748e-07 1.55 2.53144054878e-07 1.44748737342 2.53175813008e-07 1.2 2.53207571138e-07 0.952512626585 2.53239329268e-07 0.85 2.53271087398e-07 0.952512626585 2.53302845528e-07 1.2 2.53334603659e-07 1.44748737342 2.53366361789e-07 1.55 2.53398119919e-07 1.44748737342 2.53429878049e-07 1.2 2.53461636179e-07 0.952512626585 2.53493394309e-07 0.85 2.53525152439e-07 0.952512626585 2.53556910569e-07 1.2 2.53588668699e-07 1.44748737342 2.53620426829e-07 1.55 2.53652184959e-07 1.44748737342 2.53683943089e-07 1.2 2.5371570122e-07 0.952512626585 2.5374745935e-07 0.85 2.5377921748e-07 0.952512626584 2.5381097561e-07 1.2 2.5384273374e-07 1.44748737342 2.5387449187e-07 1.55 2.5390625e-07 1.44748737342 2.5393800813e-07 1.2 2.5396976626e-07 0.952512626585 2.5400152439e-07 0.85 2.5403328252e-07 0.952512626585 2.5406504065e-07 1.2 2.5409679878e-07 1.44748737342 2.54128556911e-07 1.55 2.54160315041e-07 1.44748737342 2.54192073171e-07 1.2 2.54223831301e-07 0.952512626585 2.54255589431e-07 0.85 2.54287347561e-07 0.952512626585 2.54319105691e-07 1.2 2.54350863821e-07 1.44748737342 2.54382621951e-07 1.55 2.54414380081e-07 1.44748737342 2.54446138211e-07 1.2 2.54477896341e-07 0.952512626585 2.54509654472e-07 0.85 2.54541412602e-07 0.952512626585 2.54573170732e-07 1.2 2.54604928862e-07 1.44748737342 2.54636686992e-07 1.55 2.54668445122e-07 1.44748737342 2.54700203252e-07 1.2 2.54731961382e-07 0.952512626585 2.54763719512e-07 0.85 2.54795477642e-07 0.952512626585 2.54827235772e-07 1.2 2.54858993902e-07 1.44748737342 2.54890752033e-07 1.55 2.54922510163e-07 1.44748737342 2.54954268293e-07 1.2 2.54986026423e-07 0.952512626585 2.55017784553e-07 0.85 2.55049542683e-07 0.952512626585 2.55081300813e-07 1.2 2.55113058943e-07 1.44748737342 2.55144817073e-07 1.55 2.55176575203e-07 1.44748737342 2.55208333333e-07 1.2 2.55240091463e-07 0.952512626585 2.55271849593e-07 0.85 2.55303607724e-07 0.952512626585 2.55335365854e-07 1.2 2.55367123984e-07 1.44748737342 2.55398882114e-07 1.55 2.55430640244e-07 1.44748737342 2.55462398374e-07 1.2 2.55494156504e-07 0.952512626585 2.55525914634e-07 0.85 2.55557672764e-07 0.952512626584 2.55589430894e-07 1.2 2.55621189024e-07 1.44748737342 2.55652947154e-07 1.55 2.55684705285e-07 1.44748737342 2.55716463415e-07 1.2 2.55748221545e-07 0.952512626585 2.55779979675e-07 0.85 2.55811737805e-07 0.952512626585 2.55843495935e-07 1.2 2.55875254065e-07 1.44748737342 2.55907012195e-07 1.55 2.55938770325e-07 1.44748737342 2.55970528455e-07 1.2 2.56002286585e-07 0.952512626585 2.56034044715e-07 0.85 2.56065802846e-07 0.952512626585 2.56097560976e-07 1.2 2.56129319106e-07 1.44748737342 2.56161077236e-07 1.55 2.56192835366e-07 1.44748737342 2.56224593496e-07 1.2 2.56256351626e-07 0.952512626585 2.56288109756e-07 0.85 2.56319867886e-07 0.952512626585 2.56351626016e-07 1.2 2.56383384146e-07 1.44748737342 2.56415142276e-07 1.55 2.56446900407e-07 1.44748737342 2.56478658537e-07 1.2 2.56510416667e-07 0.952512626585 2.56542174797e-07 0.85 2.56573932927e-07 0.952512626585 2.56605691057e-07 1.2 2.56637449187e-07 1.44748737342 2.56669207317e-07 1.55 2.56700965447e-07 1.44748737342 2.56732723577e-07 1.2 2.56764481707e-07 0.952512626585 2.56796239837e-07 0.85 2.56827997967e-07 0.952512626585 2.56859756098e-07 1.2 2.56891514228e-07 1.44748737342 2.56923272358e-07 1.55 2.56955030488e-07 1.44748737342 2.56986788618e-07 1.2 2.57018546748e-07 0.952512626585 2.57050304878e-07 0.85 2.57082063008e-07 0.952512626585 2.57113821138e-07 1.2 2.57145579268e-07 1.44748737342 2.57177337398e-07 1.55 2.57209095528e-07 1.44748737342 2.57240853659e-07 1.2 2.57272611789e-07 0.952512626585 2.57304369919e-07 0.85 2.57336128049e-07 0.952512626585 2.57367886179e-07 1.2 2.57399644309e-07 1.44748737342 2.57431402439e-07 1.55 2.57463160569e-07 1.44748737342 2.57494918699e-07 1.2 2.57526676829e-07 0.952512626585 2.57558434959e-07 0.85 2.57590193089e-07 0.952512626585 2.5762195122e-07 1.2 2.5765370935e-07 1.44748737342 2.5768546748e-07 1.55 2.5771722561e-07 1.44748737342 2.5774898374e-07 1.2 2.5778074187e-07 0.952512626585 2.578125e-07 0.85 2.5784425813e-07 0.952512626585 2.5787601626e-07 1.2 2.5790777439e-07 1.44748737342 2.5793953252e-07 1.55 2.5797129065e-07 1.44748737342 2.5800304878e-07 1.2 2.58034806911e-07 0.952512626585 2.58066565041e-07 0.85 2.58098323171e-07 0.952512626585 2.58130081301e-07 1.2 2.58161839431e-07 1.44748737342 2.58193597561e-07 1.55 2.58225355691e-07 1.44748737342 2.58257113821e-07 1.2 2.58288871951e-07 0.952512626585 2.58320630081e-07 0.85 2.58352388211e-07 0.952512626585 2.58384146341e-07 1.2 2.58415904472e-07 1.44748737342 2.58447662602e-07 1.55 2.58479420732e-07 1.44748737342 2.58511178862e-07 1.2 2.58542936992e-07 0.952512626585 2.58574695122e-07 0.85 2.58606453252e-07 0.952512626585 2.58638211382e-07 1.2 2.58669969512e-07 1.44748737342 2.58701727642e-07 1.55 2.58733485772e-07 1.44748737342 2.58765243902e-07 1.2 2.58797002033e-07 0.952512626585 2.58828760163e-07 0.85 2.58860518293e-07 0.952512626585 2.58892276423e-07 1.2 2.58924034553e-07 1.44748737342 2.58955792683e-07 1.55 2.58987550813e-07 1.44748737342 2.59019308943e-07 1.2 2.59051067073e-07 0.952512626585 2.59082825203e-07 0.85 2.59114583333e-07 0.952512626585 2.59146341463e-07 1.2 2.59178099593e-07 1.44748737342 2.59209857724e-07 1.55 2.59241615854e-07 1.44748737342 2.59273373984e-07 1.2 2.59305132114e-07 0.952512626585 2.59336890244e-07 0.85 2.59368648374e-07 0.952512626585 2.59400406504e-07 1.2 2.59432164634e-07 1.44748737342 2.59463922764e-07 1.55 2.59495680894e-07 1.44748737342 2.59527439024e-07 1.2 2.59559197154e-07 0.952512626585 2.59590955285e-07 0.85 2.59622713415e-07 0.952512626585 2.59654471545e-07 1.2 2.59686229675e-07 1.44748737342 2.59717987805e-07 1.55 2.59749745935e-07 1.44748737342 2.59781504065e-07 1.2 2.59813262195e-07 0.952512626585 2.59845020325e-07 0.85 2.59876778455e-07 0.952512626585 2.59908536585e-07 1.2 2.59940294715e-07 1.44748737342 2.59972052846e-07 1.55 2.60003810976e-07 1.44748737342 2.60035569106e-07 1.2 2.60067327236e-07 0.952512626585 2.60099085366e-07 0.85 2.60130843496e-07 0.952512626585 2.60162601626e-07 1.2 2.60194359756e-07 1.44748737342 2.60226117886e-07 1.55 2.60257876016e-07 1.44748737342 2.60289634146e-07 1.2 2.60321392276e-07 0.952512626585 2.60353150407e-07 0.85 2.60384908537e-07 0.952512626585 2.60416666667e-07 1.2 2.60448424797e-07 1.44748737342 2.60480182927e-07 1.55 2.60511941057e-07 1.44748737342 2.60543699187e-07 1.2 2.60575457317e-07 0.952512626585 2.60607215447e-07 0.85 2.60638973577e-07 0.952512626585 2.60670731707e-07 1.2 2.60702489837e-07 1.44748737342 2.60734247967e-07 1.55 2.60766006098e-07 1.44748737342 2.60797764228e-07 1.2 2.60829522358e-07 0.952512626585 2.60861280488e-07 0.85 2.60893038618e-07 0.952512626585 2.60924796748e-07 1.2 2.60956554878e-07 1.44748737342 2.60988313008e-07 1.55 2.61020071138e-07 1.44748737342 2.61051829268e-07 1.2 2.61083587398e-07 0.952512626585 2.61115345528e-07 0.85 2.61147103659e-07 0.952512626585 2.61178861789e-07 1.2 2.61210619919e-07 1.44748737342 2.61242378049e-07 1.55 2.61274136179e-07 1.44748737342 2.61305894309e-07 1.2 2.61337652439e-07 0.952512626585 2.61369410569e-07 0.85 2.61401168699e-07 0.952512626585 2.61432926829e-07 1.2 2.61464684959e-07 1.44748737342 2.61496443089e-07 1.55 2.6152820122e-07 1.44748737342 2.6155995935e-07 1.2 2.6159171748e-07 0.952512626585 2.6162347561e-07 0.85 2.6165523374e-07 0.952512626585 2.6168699187e-07 1.2 2.6171875e-07 1.44748737342 2.6175050813e-07 1.55 2.6178226626e-07 1.44748737342 2.6181402439e-07 1.2 2.6184578252e-07 0.952512626585 2.6187754065e-07 0.85 2.6190929878e-07 0.952512626585 2.61941056911e-07 1.2 2.61972815041e-07 1.44748737342 2.62004573171e-07 1.55 2.62036331301e-07 1.44748737342 2.62068089431e-07 1.2 2.62099847561e-07 0.952512626585 2.62131605691e-07 0.85 2.62163363821e-07 0.952512626584 2.62195121951e-07 1.2 2.62226880081e-07 1.44748737342 2.62258638211e-07 1.55 2.62290396341e-07 1.44748737342 2.62322154472e-07 1.2 2.62353912602e-07 0.952512626585 2.62385670732e-07 0.85 2.62417428862e-07 0.952512626585 2.62449186992e-07 1.2 2.62480945122e-07 1.44748737342 2.62512703252e-07 1.55 2.62544461382e-07 1.44748737342 2.62576219512e-07 1.2 2.62607977642e-07 0.952512626585 2.62639735772e-07 0.85 2.62671493902e-07 0.952512626585 2.62703252033e-07 1.2 2.62735010163e-07 1.44748737342 2.62766768293e-07 1.55 2.62798526423e-07 1.44748737342 2.62830284553e-07 1.2 2.62862042683e-07 0.952512626585 2.62893800813e-07 0.85 2.62925558943e-07 0.952512626585 2.62957317073e-07 1.2 2.62989075203e-07 1.44748737342 2.63020833333e-07 1.55 2.63052591463e-07 1.44748737342 2.63084349593e-07 1.2 2.63116107724e-07 0.952512626585 2.63147865854e-07 0.85 2.63179623984e-07 0.952512626585 2.63211382114e-07 1.2 2.63243140244e-07 1.44748737342 2.63274898374e-07 1.55 2.63306656504e-07 1.44748737342 2.63338414634e-07 1.2 2.63370172764e-07 0.952512626585 2.63401930894e-07 0.85 2.63433689024e-07 0.952512626585 2.63465447154e-07 1.2 2.63497205285e-07 1.44748737342 2.63528963415e-07 1.55 2.63560721545e-07 1.44748737342 2.63592479675e-07 1.2 2.63624237805e-07 0.952512626585 2.63655995935e-07 0.85 2.63687754065e-07 0.952512626585 2.63719512195e-07 1.2 2.63751270325e-07 1.44748737342 2.63783028455e-07 1.55 2.63814786585e-07 1.44748737342 2.63846544715e-07 1.2 2.63878302846e-07 0.952512626585 2.63910060976e-07 0.85 2.63941819106e-07 0.952512626584 2.63973577236e-07 1.2 2.64005335366e-07 1.44748737342 2.64037093496e-07 1.55 2.64068851626e-07 1.44748737342 2.64100609756e-07 1.2 2.64132367886e-07 0.952512626585 2.64164126016e-07 0.85 2.64195884146e-07 0.952512626585 2.64227642276e-07 1.2 2.64259400407e-07 1.44748737342 2.64291158537e-07 1.55 2.64322916667e-07 1.44748737342 2.64354674797e-07 1.2 2.64386432927e-07 0.952512626585 2.64418191057e-07 0.85 2.64449949187e-07 0.952512626585 2.64481707317e-07 1.2 2.64513465447e-07 1.44748737342 2.64545223577e-07 1.55 2.64576981707e-07 1.44748737342 2.64608739837e-07 1.2 2.64640497967e-07 0.952512626585 2.64672256098e-07 0.85 2.64704014228e-07 0.952512626585 2.64735772358e-07 1.2 2.64767530488e-07 1.44748737342 2.64799288618e-07 1.55 2.64831046748e-07 1.44748737342 2.64862804878e-07 1.2 2.64894563008e-07 0.952512626585 2.64926321138e-07 0.85 2.64958079268e-07 0.952512626585 2.64989837398e-07 1.2 2.65021595528e-07 1.44748737342 2.65053353659e-07 1.55 2.65085111789e-07 1.44748737342 2.65116869919e-07 1.2 2.65148628049e-07 0.952512626585 2.65180386179e-07 0.85 2.65212144309e-07 0.952512626585 2.65243902439e-07 1.2 2.65275660569e-07 1.44748737342 2.65307418699e-07 1.55 2.65339176829e-07 1.44748737342 2.65370934959e-07 1.2 2.65402693089e-07 0.952512626585 2.6543445122e-07 0.85 2.6546620935e-07 0.952512626585 2.6549796748e-07 1.2 2.6552972561e-07 1.44748737342 2.6556148374e-07 1.55 2.6559324187e-07 1.44748737342 2.65625e-07 1.2 2.6565675813e-07 0.952512626585 2.6568851626e-07 0.85 2.6572027439e-07 0.952512626585 2.6575203252e-07 1.2 2.6578379065e-07 1.44748737342 2.6581554878e-07 1.55 2.65847306911e-07 1.44748737342 2.65879065041e-07 1.2 2.65910823171e-07 0.952512626585 2.65942581301e-07 0.85 2.65974339431e-07 0.952512626585 2.66006097561e-07 1.2 2.66037855691e-07 1.44748737342 2.66069613821e-07 1.55 2.66101371951e-07 1.44748737342 2.66133130081e-07 1.2 2.66164888211e-07 0.952512626585 2.66196646341e-07 0.85 2.66228404472e-07 0.952512626585 2.66260162602e-07 1.2 2.66291920732e-07 1.44748737342 2.66323678862e-07 1.55 2.66355436992e-07 1.44748737342 2.66387195122e-07 1.2 2.66418953252e-07 0.952512626585 2.66450711382e-07 0.85 2.66482469512e-07 0.952512626585 2.66514227642e-07 1.2 2.66545985772e-07 1.44748737342 2.66577743902e-07 1.55 2.66609502033e-07 1.44748737342 2.66641260163e-07 1.2 2.66673018293e-07 0.952512626585 2.66704776423e-07 0.85 2.66736534553e-07 0.952512626585 2.66768292683e-07 1.2 2.66800050813e-07 1.44748737342 2.66831808943e-07 1.55 2.66863567073e-07 1.44748737342 2.66895325203e-07 1.2 2.66927083333e-07 0.952512626585 2.66958841463e-07 0.85 2.66990599593e-07 0.952512626585 2.67022357724e-07 1.2 2.67054115854e-07 1.44748737342 2.67085873984e-07 1.55 2.67117632114e-07 1.44748737342 2.67149390244e-07 1.2 2.67181148374e-07 0.952512626585 2.67212906504e-07 0.85 2.67244664634e-07 0.952512626585 2.67276422764e-07 1.2 2.67308180894e-07 1.44748737342 2.67339939024e-07 1.55 2.67371697154e-07 1.44748737342 2.67403455285e-07 1.2 2.67435213415e-07 0.952512626585 2.67466971545e-07 0.85 2.67498729675e-07 0.952512626585 2.67530487805e-07 1.2 2.67562245935e-07 1.44748737342 2.67594004065e-07 1.55 2.67625762195e-07 1.44748737342 2.67657520325e-07 1.2 2.67689278455e-07 0.952512626585 2.67721036585e-07 0.85 2.67752794715e-07 0.952512626585 2.67784552846e-07 1.2 2.67816310976e-07 1.44748737342 2.67848069106e-07 1.55 2.67879827236e-07 1.44748737342 2.67911585366e-07 1.2 2.67943343496e-07 0.952512626585 2.67975101626e-07 0.85 2.68006859756e-07 0.952512626585 2.68038617886e-07 1.2 2.68070376016e-07 1.44748737342 2.68102134146e-07 1.55 2.68133892276e-07 1.44748737342 2.68165650407e-07 1.2 2.68197408537e-07 0.952512626585 2.68229166667e-07 0.85 2.68260924797e-07 0.952512626585 2.68292682927e-07 1.2 2.68324441057e-07 1.44748737342 2.68356199187e-07 1.55 2.68387957317e-07 1.44748737342 2.68419715447e-07 1.2 2.68451473577e-07 0.952512626585 2.68483231707e-07 0.85 2.68514989837e-07 0.952512626585 2.68546747967e-07 1.2 2.68578506098e-07 1.44748737342 2.68610264228e-07 1.55 2.68642022358e-07 1.44748737342 2.68673780488e-07 1.2 2.68705538618e-07 0.952512626585 2.68737296748e-07 0.85 2.68769054878e-07 0.952512626585 2.68800813008e-07 1.2 2.68832571138e-07 1.44748737342 2.68864329268e-07 1.55 2.68896087398e-07 1.44748737342 2.68927845528e-07 1.2 2.68959603659e-07 0.952512626585 2.68991361789e-07 0.85 2.69023119919e-07 0.952512626585 2.69054878049e-07 1.2 2.69086636179e-07 1.44748737342 2.69118394309e-07 1.55 2.69150152439e-07 1.44748737342 2.69181910569e-07 1.2 2.69213668699e-07 0.952512626585 2.69245426829e-07 0.85 2.69277184959e-07 0.952512626585 2.69308943089e-07 1.2 2.6934070122e-07 1.44748737342 2.6937245935e-07 1.55 2.6940421748e-07 1.44748737342 2.6943597561e-07 1.2 2.6946773374e-07 0.952512626585 2.6949949187e-07 0.85 2.6953125e-07 0.952512626585 2.6956300813e-07 1.2 2.6959476626e-07 1.44748737342 2.6962652439e-07 1.55 2.6965828252e-07 1.44748737342 2.6969004065e-07 1.2 2.6972179878e-07 0.952512626585 2.69753556911e-07 0.85 2.69785315041e-07 0.952512626585 2.69817073171e-07 1.2 2.69848831301e-07 1.44748737342 2.69880589431e-07 1.55 2.69912347561e-07 1.44748737342 2.69944105691e-07 1.2 2.69975863821e-07 0.952512626585 2.70007621951e-07 0.85 2.70039380081e-07 0.952512626585 2.70071138211e-07 1.2 2.70102896341e-07 1.44748737342 2.70134654472e-07 1.55 2.70166412602e-07 1.44748737342 2.70198170732e-07 1.2 2.70229928862e-07 0.952512626585 2.70261686992e-07 0.85 2.70293445122e-07 0.952512626585 2.70325203252e-07 1.2 2.70356961382e-07 1.44748737342 2.70388719512e-07 1.55 2.70420477642e-07 1.44748737342 2.70452235772e-07 1.2 2.70483993902e-07 0.952512626585 2.70515752033e-07 0.85 2.70547510163e-07 0.952512626585 2.70579268293e-07 1.2 2.70611026423e-07 1.44748737342 2.70642784553e-07 1.55 2.70674542683e-07 1.44748737342 2.70706300813e-07 1.2 2.70738058943e-07 0.952512626585 2.70769817073e-07 0.85 2.70801575203e-07 0.952512626585 2.70833333333e-07 1.2 2.70865091463e-07 1.44748737342 2.70896849593e-07 1.55 2.70928607724e-07 1.44748737342 2.70960365854e-07 1.2 2.70992123984e-07 0.952512626585 2.71023882114e-07 0.85 2.71055640244e-07 0.952512626585 2.71087398374e-07 1.2 2.71119156504e-07 1.44748737342 2.71150914634e-07 1.55 2.71182672764e-07 1.44748737342 2.71214430894e-07 1.2 2.71246189024e-07 0.952512626585 2.71277947154e-07 0.85 2.71309705285e-07 0.952512626585 2.71341463415e-07 1.2 2.71373221545e-07 1.44748737342 2.71404979675e-07 1.55 2.71436737805e-07 1.44748737342 2.71468495935e-07 1.2 2.71500254065e-07 0.952512626585 2.71532012195e-07 0.85 2.71563770325e-07 0.952512626585 2.71595528455e-07 1.2 2.71627286585e-07 1.44748737342 2.71659044715e-07 1.55 2.71690802846e-07 1.44748737342 2.71722560976e-07 1.2 2.71754319106e-07 0.952512626585 2.71786077236e-07 0.85 2.71817835366e-07 0.952512626585 2.71849593496e-07 1.2 2.71881351626e-07 1.44748737342 2.71913109756e-07 1.55 2.71944867886e-07 1.44748737342 2.71976626016e-07 1.2 2.72008384146e-07 0.952512626585 2.72040142276e-07 0.85 2.72071900407e-07 0.952512626585 2.72103658537e-07 1.2 2.72135416667e-07 1.44748737342 2.72167174797e-07 1.55 2.72198932927e-07 1.44748737342 2.72230691057e-07 1.2 2.72262449187e-07 0.952512626585 2.72294207317e-07 0.85 2.72325965447e-07 0.952512626584 2.72357723577e-07 1.2 2.72389481707e-07 1.44748737342 2.72421239837e-07 1.55 2.72452997967e-07 1.44748737342 2.72484756098e-07 1.2 2.72516514228e-07 0.952512626585 2.72548272358e-07 0.85 2.72580030488e-07 0.952512626585 2.72611788618e-07 1.2 2.72643546748e-07 1.44748737342 2.72675304878e-07 1.55 2.72707063008e-07 1.44748737342 2.72738821138e-07 1.2 2.72770579268e-07 0.952512626585 2.72802337398e-07 0.85 2.72834095528e-07 0.952512626585 2.72865853659e-07 1.2 2.72897611789e-07 1.44748737342 2.72929369919e-07 1.55 2.72961128049e-07 1.44748737342 2.72992886179e-07 1.2 2.73024644309e-07 0.952512626585 2.73056402439e-07 0.85 2.73088160569e-07 0.952512626585 2.73119918699e-07 1.2 2.73151676829e-07 1.44748737342 2.73183434959e-07 1.55 2.73215193089e-07 1.44748737342 2.7324695122e-07 1.2 2.7327870935e-07 0.952512626585 2.7331046748e-07 0.85 2.7334222561e-07 0.952512626585 2.7337398374e-07 1.2 2.7340574187e-07 1.44748737342 2.734375e-07 1.55 2.7346925813e-07 1.44748737342 2.7350101626e-07 1.2 2.7353277439e-07 0.952512626585 2.7356453252e-07 0.85 2.7359629065e-07 0.952512626585 2.7362804878e-07 1.2 2.73659806911e-07 1.44748737342 2.73691565041e-07 1.55 2.73723323171e-07 1.44748737342 2.73755081301e-07 1.2 2.73786839431e-07 0.952512626585 2.73818597561e-07 0.85 2.73850355691e-07 0.952512626585 2.73882113821e-07 1.2 2.73913871951e-07 1.44748737342 2.73945630081e-07 1.55 2.73977388211e-07 1.44748737342 2.74009146341e-07 1.2 2.74040904472e-07 0.952512626585 2.74072662602e-07 0.85 2.74104420732e-07 0.952512626585 2.74136178862e-07 1.2 2.74167936992e-07 1.44748737342 2.74199695122e-07 1.55 2.74231453252e-07 1.44748737342 2.74263211382e-07 1.2 2.74294969512e-07 0.952512626585 2.74326727642e-07 0.85 2.74358485772e-07 0.952512626585 2.74390243902e-07 1.2 2.74422002033e-07 1.44748737342 2.74453760163e-07 1.55 2.74485518293e-07 1.44748737342 2.74517276423e-07 1.2 2.74549034553e-07 0.952512626585 2.74580792683e-07 0.85 2.74612550813e-07 0.952512626585 2.74644308943e-07 1.2 2.74676067073e-07 1.44748737342 2.74707825203e-07 1.55 2.74739583333e-07 1.44748737342 2.74771341463e-07 1.2 2.74803099593e-07 0.952512626585 2.74834857724e-07 0.85 2.74866615854e-07 0.952512626585 2.74898373984e-07 1.2 2.74930132114e-07 1.44748737342 2.74961890244e-07 1.55 2.74993648374e-07 1.44748737342 2.75025406504e-07 1.2 2.75057164634e-07 0.952512626585 2.75088922764e-07 0.85 2.75120680894e-07 0.952512626585 2.75152439024e-07 1.2 2.75184197154e-07 1.44748737342 2.75215955285e-07 1.55 2.75247713415e-07 1.44748737342 2.75279471545e-07 1.2 2.75311229675e-07 0.952512626585 2.75342987805e-07 0.85 2.75374745935e-07 0.952512626585 2.75406504065e-07 1.2 2.75438262195e-07 1.44748737342 2.75470020325e-07 1.55 2.75501778455e-07 1.44748737342 2.75533536585e-07 1.2 2.75565294715e-07 0.952512626585 2.75597052846e-07 0.85 2.75628810976e-07 0.952512626585 2.75660569106e-07 1.2 2.75692327236e-07 1.44748737342 2.75724085366e-07 1.55 2.75755843496e-07 1.44748737342 2.75787601626e-07 1.2 2.75819359756e-07 0.952512626585 2.75851117886e-07 0.85 2.75882876016e-07 0.952512626585 2.75914634146e-07 1.2 2.75946392276e-07 1.44748737342 2.75978150407e-07 1.55 2.76009908537e-07 1.44748737342 2.76041666667e-07 1.2 2.76073424797e-07 0.952512626585 2.76105182927e-07 0.85 2.76136941057e-07 0.952512626585 2.76168699187e-07 1.2 2.76200457317e-07 1.44748737342 2.76232215447e-07 1.55 2.76263973577e-07 1.44748737342 2.76295731707e-07 1.2 2.76327489837e-07 0.952512626585 2.76359247967e-07 0.85 2.76391006098e-07 0.952512626585 2.76422764228e-07 1.2 2.76454522358e-07 1.44748737342 2.76486280488e-07 1.55 2.76518038618e-07 1.44748737342 2.76549796748e-07 1.2 2.76581554878e-07 0.952512626585 2.76613313008e-07 0.85 2.76645071138e-07 0.952512626585 2.76676829268e-07 1.2 2.76708587398e-07 1.44748737342 2.76740345528e-07 1.55 2.76772103659e-07 1.44748737342 2.76803861789e-07 1.2 2.76835619919e-07 0.952512626585 2.76867378049e-07 0.85 2.76899136179e-07 0.952512626585 2.76930894309e-07 1.2 2.76962652439e-07 1.44748737342 2.76994410569e-07 1.55 2.77026168699e-07 1.44748737342 2.77057926829e-07 1.2 2.77089684959e-07 0.952512626585 2.77121443089e-07 0.85 2.7715320122e-07 0.952512626585 2.7718495935e-07 1.2 2.7721671748e-07 1.44748737342 2.7724847561e-07 1.55 2.7728023374e-07 1.44748737342 2.7731199187e-07 1.2 2.7734375e-07 0.952512626585 2.7737550813e-07 0.85 2.7740726626e-07 0.952512626585 2.7743902439e-07 1.2 2.7747078252e-07 1.44748737342 2.7750254065e-07 1.55 2.7753429878e-07 1.44748737342 2.77566056911e-07 1.2 2.77597815041e-07 0.952512626585 2.77629573171e-07 0.85 2.77661331301e-07 0.952512626585 2.77693089431e-07 1.2 2.77724847561e-07 1.44748737342 2.77756605691e-07 1.55 2.77788363821e-07 1.44748737342 2.77820121951e-07 1.2 2.77851880081e-07 0.952512626585 2.77883638211e-07 0.85 2.77915396341e-07 0.952512626585 2.77947154472e-07 1.2 2.77978912602e-07 1.44748737342 2.78010670732e-07 1.55 2.78042428862e-07 1.44748737342 2.78074186992e-07 1.2 2.78105945122e-07 0.952512626585 2.78137703252e-07 0.85 2.78169461382e-07 0.952512626585 2.78201219512e-07 1.2 2.78232977642e-07 1.44748737342 2.78264735772e-07 1.55 2.78296493902e-07 1.44748737342 2.78328252033e-07 1.2 2.78360010163e-07 0.952512626585 2.78391768293e-07 0.85 2.78423526423e-07 0.952512626585 2.78455284553e-07 1.2 2.78487042683e-07 1.44748737342 2.78518800813e-07 1.55 2.78550558943e-07 1.44748737342 2.78582317073e-07 1.2 2.78614075203e-07 0.952512626585 2.78645833333e-07 0.85 2.78677591463e-07 0.952512626585 2.78709349593e-07 1.2 2.78741107724e-07 1.44748737342 2.78772865854e-07 1.55 2.78804623984e-07 1.44748737342 2.78836382114e-07 1.2 2.78868140244e-07 0.952512626585 2.78899898374e-07 0.85 2.78931656504e-07 0.952512626585 2.78963414634e-07 1.2 2.78995172764e-07 1.44748737342 2.79026930894e-07 1.55 2.79058689024e-07 1.44748737342 2.79090447154e-07 1.2 2.79122205285e-07 0.952512626585 2.79153963415e-07 0.85 2.79185721545e-07 0.952512626585 2.79217479675e-07 1.2 2.79249237805e-07 1.44748737342 2.79280995935e-07 1.55 2.79312754065e-07 1.44748737342 2.79344512195e-07 1.2 2.79376270325e-07 0.952512626585 2.79408028455e-07 0.85 2.79439786585e-07 0.952512626585 2.79471544715e-07 1.2 2.79503302846e-07 1.44748737342 2.79535060976e-07 1.55 2.79566819106e-07 1.44748737342 2.79598577236e-07 1.2 2.79630335366e-07 0.952512626585 2.79662093496e-07 0.85 2.79693851626e-07 0.952512626585 2.79725609756e-07 1.2 2.79757367886e-07 1.44748737342 2.79789126016e-07 1.55 2.79820884146e-07 1.44748737342 2.79852642276e-07 1.2 2.79884400407e-07 0.952512626585 2.79916158537e-07 0.85 2.79947916667e-07 0.952512626585 2.79979674797e-07 1.2 2.80011432927e-07 1.44748737342 2.80043191057e-07 1.55 2.80074949187e-07 1.44748737342 2.80106707317e-07 1.2 2.80138465447e-07 0.952512626585 2.80170223577e-07 0.85 2.80201981707e-07 0.952512626585 2.80233739837e-07 1.2 2.80265497967e-07 1.44748737342 2.80297256098e-07 1.55 2.80329014228e-07 1.44748737342 2.80360772358e-07 1.2 2.80392530488e-07 0.952512626585 2.80424288618e-07 0.85 2.80456046748e-07 0.952512626585 2.80487804878e-07 1.2 2.80519563008e-07 1.44748737342 2.80551321138e-07 1.55 2.80583079268e-07 1.44748737342 2.80614837398e-07 1.2 2.80646595528e-07 0.952512626585 2.80678353659e-07 0.85 2.80710111789e-07 0.952512626585 2.80741869919e-07 1.2 2.80773628049e-07 1.44748737342 2.80805386179e-07 1.55 2.80837144309e-07 1.44748737342 2.80868902439e-07 1.2 2.80900660569e-07 0.952512626585 2.80932418699e-07 0.85 2.80964176829e-07 0.952512626585 2.80995934959e-07 1.2 2.81027693089e-07 1.44748737342 2.8105945122e-07 1.55 2.8109120935e-07 1.44748737342 2.8112296748e-07 1.2 2.8115472561e-07 0.952512626585 2.8118648374e-07 0.85 2.8121824187e-07 0.952512626585 2.8125e-07 1.2 2.8128175813e-07 1.44748737342 2.8131351626e-07 1.55 2.8134527439e-07 1.44748737342 2.8137703252e-07 1.2 2.8140879065e-07 0.952512626585 2.8144054878e-07 0.85 2.81472306911e-07 0.952512626585 2.81504065041e-07 1.2 2.81535823171e-07 1.44748737342 2.81567581301e-07 1.55 2.81599339431e-07 1.44748737342 2.81631097561e-07 1.2 2.81662855691e-07 0.952512626585 2.81694613821e-07 0.85 2.81726371951e-07 0.952512626585 2.81758130081e-07 1.2 2.81789888211e-07 1.44748737342 2.81821646341e-07 1.55 2.81853404472e-07 1.44748737342 2.81885162602e-07 1.2 2.81916920732e-07 0.952512626585 2.81948678862e-07 0.85 2.81980436992e-07 0.952512626585 2.82012195122e-07 1.2 2.82043953252e-07 1.44748737342 2.82075711382e-07 1.55 2.82107469512e-07 1.44748737342 2.82139227642e-07 1.2 2.82170985772e-07 0.952512626585 2.82202743902e-07 0.85 2.82234502033e-07 0.952512626585 2.82266260163e-07 1.2 2.82298018293e-07 1.44748737342 2.82329776423e-07 1.55 2.82361534553e-07 1.44748737342 2.82393292683e-07 1.2 2.82425050813e-07 0.952512626585 2.82456808943e-07 0.85 2.82488567073e-07 0.952512626584 2.82520325203e-07 1.2 2.82552083333e-07 1.44748737342 2.82583841463e-07 1.55 2.82615599593e-07 1.44748737342 2.82647357724e-07 1.2 2.82679115854e-07 0.952512626585 2.82710873984e-07 0.85 2.82742632114e-07 0.952512626585 2.82774390244e-07 1.2 2.82806148374e-07 1.44748737342 2.82837906504e-07 1.55 2.82869664634e-07 1.44748737342 2.82901422764e-07 1.2 2.82933180894e-07 0.952512626585 2.82964939024e-07 0.85 2.82996697154e-07 0.952512626585 2.83028455285e-07 1.2 2.83060213415e-07 1.44748737342 2.83091971545e-07 1.55 2.83123729675e-07 1.44748737342 2.83155487805e-07 1.2 2.83187245935e-07 0.952512626585 2.83219004065e-07 0.85 2.83250762195e-07 0.952512626585 2.83282520325e-07 1.2 2.83314278455e-07 1.44748737342 2.83346036585e-07 1.55 2.83377794715e-07 1.44748737342 2.83409552846e-07 1.2 2.83441310976e-07 0.952512626585 2.83473069106e-07 0.85 2.83504827236e-07 0.952512626585 2.83536585366e-07 1.2 2.83568343496e-07 1.44748737342 2.83600101626e-07 1.55 2.83631859756e-07 1.44748737342 2.83663617886e-07 1.2 2.83695376016e-07 0.952512626585 2.83727134146e-07 0.85 2.83758892276e-07 0.952512626585 2.83790650407e-07 1.2 2.83822408537e-07 1.44748737342 2.83854166667e-07 1.55 2.83885924797e-07 1.44748737342 2.83917682927e-07 1.2 2.83949441057e-07 0.952512626585 2.83981199187e-07 0.85 2.84012957317e-07 0.952512626585 2.84044715447e-07 1.2 2.84076473577e-07 1.44748737342 2.84108231707e-07 1.55 2.84139989837e-07 1.44748737342 2.84171747967e-07 1.2 2.84203506098e-07 0.952512626585 2.84235264228e-07 0.85 2.84267022358e-07 0.952512626585 2.84298780488e-07 1.2 2.84330538618e-07 1.44748737342 2.84362296748e-07 1.55 2.84394054878e-07 1.44748737342 2.84425813008e-07 1.2 2.84457571138e-07 0.952512626585 2.84489329268e-07 0.85 2.84521087398e-07 0.952512626585 2.84552845528e-07 1.2 2.84584603659e-07 1.44748737342 2.84616361789e-07 1.55 2.84648119919e-07 1.44748737342 2.84679878049e-07 1.2 2.84711636179e-07 0.952512626585 2.84743394309e-07 0.85 2.84775152439e-07 0.952512626585 2.84806910569e-07 1.2 2.84838668699e-07 1.44748737342 2.84870426829e-07 1.55 2.84902184959e-07 1.44748737342 2.84933943089e-07 1.2 2.8496570122e-07 0.952512626585 2.8499745935e-07 0.85 2.8502921748e-07 0.952512626585 2.8506097561e-07 1.2 2.8509273374e-07 1.44748737342 2.8512449187e-07 1.55 2.8515625e-07 1.44748737342 2.8518800813e-07 1.2 2.8521976626e-07 0.952512626585 2.8525152439e-07 0.85 2.8528328252e-07 0.952512626585 2.8531504065e-07 1.2 2.8534679878e-07 1.44748737342 2.85378556911e-07 1.55 2.85410315041e-07 1.44748737342 2.85442073171e-07 1.2 2.85473831301e-07 0.952512626585 2.85505589431e-07 0.85 2.85537347561e-07 0.952512626585 2.85569105691e-07 1.2 2.85600863821e-07 1.44748737342 2.85632621951e-07 1.55 2.85664380081e-07 1.44748737342 2.85696138211e-07 1.2 2.85727896341e-07 0.952512626585 2.85759654472e-07 0.85 2.85791412602e-07 0.952512626585 2.85823170732e-07 1.2 2.85854928862e-07 1.44748737342 2.85886686992e-07 1.55 2.85918445122e-07 1.44748737342 2.85950203252e-07 1.2 2.85981961382e-07 0.952512626585 2.86013719512e-07 0.85 2.86045477642e-07 0.952512626585 2.86077235772e-07 1.2 2.86108993902e-07 1.44748737342 2.86140752033e-07 1.55 2.86172510163e-07 1.44748737342 2.86204268293e-07 1.2 2.86236026423e-07 0.952512626585 2.86267784553e-07 0.85 2.86299542683e-07 0.952512626585 2.86331300813e-07 1.2 2.86363058943e-07 1.44748737342 2.86394817073e-07 1.55 2.86426575203e-07 1.44748737342 2.86458333333e-07 1.2 2.86490091463e-07 0.952512626585 2.86521849593e-07 0.85 2.86553607724e-07 0.952512626585 2.86585365854e-07 1.2 2.86617123984e-07 1.44748737342 2.86648882114e-07 1.55 2.86680640244e-07 1.44748737342 2.86712398374e-07 1.2 2.86744156504e-07 0.952512626585 2.86775914634e-07 0.85 2.86807672764e-07 0.952512626585 2.86839430894e-07 1.2 2.86871189024e-07 1.44748737342 2.86902947154e-07 1.55 2.86934705285e-07 1.44748737342 2.86966463415e-07 1.2 2.86998221545e-07 0.952512626585 2.87029979675e-07 0.85 2.87061737805e-07 0.952512626585 2.87093495935e-07 1.2 2.87125254065e-07 1.44748737342 2.87157012195e-07 1.55 2.87188770325e-07 1.44748737342 2.87220528455e-07 1.2 2.87252286585e-07 0.952512626585 2.87284044715e-07 0.85 2.87315802846e-07 0.952512626585 2.87347560976e-07 1.2 2.87379319106e-07 1.44748737342 2.87411077236e-07 1.55 2.87442835366e-07 1.44748737342 2.87474593496e-07 1.2 2.87506351626e-07 0.952512626585 2.87538109756e-07 0.85 2.87569867886e-07 0.952512626585 2.87601626016e-07 1.2 2.87633384146e-07 1.44748737342 2.87665142276e-07 1.55 2.87696900407e-07 1.44748737342 2.87728658537e-07 1.2 2.87760416667e-07 0.952512626585 2.87792174797e-07 0.85 2.87823932927e-07 0.952512626585 2.87855691057e-07 1.2 2.87887449187e-07 1.44748737342 2.87919207317e-07 1.55 2.87950965447e-07 1.44748737342 2.87982723577e-07 1.2 2.88014481707e-07 0.952512626585 2.88046239837e-07 0.85 2.88077997967e-07 0.952512626585 2.88109756098e-07 1.2 2.88141514228e-07 1.44748737342 2.88173272358e-07 1.55 2.88205030488e-07 1.44748737342 2.88236788618e-07 1.2 2.88268546748e-07 0.952512626585 2.88300304878e-07 0.85 2.88332063008e-07 0.952512626585 2.88363821138e-07 1.2 2.88395579268e-07 1.44748737342 2.88427337398e-07 1.55 2.88459095528e-07 1.44748737342 2.88490853659e-07 1.2 2.88522611789e-07 0.952512626585 2.88554369919e-07 0.85 2.88586128049e-07 0.952512626585 2.88617886179e-07 1.2 2.88649644309e-07 1.44748737342 2.88681402439e-07 1.55 2.88713160569e-07 1.44748737342 2.88744918699e-07 1.2 2.88776676829e-07 0.952512626585 2.88808434959e-07 0.85 2.88840193089e-07 0.952512626585 2.8887195122e-07 1.2 2.8890370935e-07 1.44748737342 2.8893546748e-07 1.55 2.8896722561e-07 1.44748737342 2.8899898374e-07 1.2 2.8903074187e-07 0.952512626585 2.890625e-07 0.85 2.8909425813e-07 0.952512626585 2.8912601626e-07 1.2 2.8915777439e-07 1.44748737342 2.8918953252e-07 1.55 2.8922129065e-07 1.44748737342 2.8925304878e-07 1.2 2.89284806911e-07 0.952512626585 2.89316565041e-07 0.85 2.89348323171e-07 0.952512626585 2.89380081301e-07 1.2 2.89411839431e-07 1.44748737342 2.89443597561e-07 1.55 2.89475355691e-07 1.44748737342 2.89507113821e-07 1.2 2.89538871951e-07 0.952512626585 2.89570630081e-07 0.85 2.89602388211e-07 0.952512626585 2.89634146341e-07 1.2 2.89665904472e-07 1.44748737342 2.89697662602e-07 1.55 2.89729420732e-07 1.44748737342 2.89761178862e-07 1.2 2.89792936992e-07 0.952512626584 2.89824695122e-07 0.85 2.89856453252e-07 0.952512626585 2.89888211382e-07 1.2 2.89919969512e-07 1.44748737342 2.89951727642e-07 1.55 2.89983485772e-07 1.44748737342 2.90015243902e-07 1.2 2.90047002033e-07 0.952512626585 2.90078760163e-07 0.85 2.90110518293e-07 0.952512626585 2.90142276423e-07 1.2 2.90174034553e-07 1.44748737342 2.90205792683e-07 1.55 2.90237550813e-07 1.44748737342 2.90269308943e-07 1.2 2.90301067073e-07 0.952512626585 2.90332825203e-07 0.85 2.90364583333e-07 0.952512626585 2.90396341463e-07 1.2 2.90428099593e-07 1.44748737342 2.90459857724e-07 1.55 2.90491615854e-07 1.44748737342 2.90523373984e-07 1.2 2.90555132114e-07 0.952512626585 2.90586890244e-07 0.85 2.90618648374e-07 0.952512626585 2.90650406504e-07 1.2 2.90682164634e-07 1.44748737342 2.90713922764e-07 1.55 2.90745680894e-07 1.44748737342 2.90777439024e-07 1.2 2.90809197154e-07 0.952512626585 2.90840955285e-07 0.85 2.90872713415e-07 0.952512626585 2.90904471545e-07 1.2 2.90936229675e-07 1.44748737342 2.90967987805e-07 1.55 2.90999745935e-07 1.44748737342 2.91031504065e-07 1.2 2.91063262195e-07 0.952512626585 2.91095020325e-07 0.85 2.91126778455e-07 0.952512626585 2.91158536585e-07 1.2 2.91190294715e-07 1.44748737342 2.91222052846e-07 1.55 2.91253810976e-07 1.44748737342 2.91285569106e-07 1.2 2.91317327236e-07 0.952512626585 2.91349085366e-07 0.85 2.91380843496e-07 0.952512626585 2.91412601626e-07 1.2 2.91444359756e-07 1.44748737342 2.91476117886e-07 1.55 2.91507876016e-07 1.44748737342 2.91539634146e-07 1.2 2.91571392276e-07 0.952512626585 2.91603150407e-07 0.85 2.91634908537e-07 0.952512626585 2.91666666667e-07 1.2 2.91698424797e-07 1.44748737342 2.91730182927e-07 1.55 2.91761941057e-07 1.44748737342 2.91793699187e-07 1.2 2.91825457317e-07 0.952512626585 2.91857215447e-07 0.85 2.91888973577e-07 0.952512626585 2.91920731707e-07 1.2 2.91952489837e-07 1.44748737342 2.91984247967e-07 1.55 2.92016006098e-07 1.44748737342 2.92047764228e-07 1.2 2.92079522358e-07 0.952512626585 2.92111280488e-07 0.85 2.92143038618e-07 0.952512626585 2.92174796748e-07 1.2 2.92206554878e-07 1.44748737342 2.92238313008e-07 1.55 2.92270071138e-07 1.44748737342 2.92301829268e-07 1.2 2.92333587398e-07 0.952512626585 2.92365345528e-07 0.85 2.92397103659e-07 0.952512626585 2.92428861789e-07 1.2 2.92460619919e-07 1.44748737342 2.92492378049e-07 1.55 2.92524136179e-07 1.44748737342 2.92555894309e-07 1.2 2.92587652439e-07 0.952512626585 2.92619410569e-07 0.85 2.92651168699e-07 0.952512626585 2.92682926829e-07 1.2 2.92714684959e-07 1.44748737342 2.92746443089e-07 1.55 2.9277820122e-07 1.44748737342 2.9280995935e-07 1.2 2.9284171748e-07 0.952512626585 2.9287347561e-07 0.85 2.9290523374e-07 0.952512626585 2.9293699187e-07 1.2 2.9296875e-07 1.44748737342 2.9300050813e-07 1.55 2.9303226626e-07 1.44748737342 2.9306402439e-07 1.2 2.9309578252e-07 0.952512626585 2.9312754065e-07 0.85 2.9315929878e-07 0.952512626585 2.93191056911e-07 1.2 2.93222815041e-07 1.44748737342 2.93254573171e-07 1.55 2.93286331301e-07 1.44748737342 2.93318089431e-07 1.2 2.93349847561e-07 0.952512626585 2.93381605691e-07 0.85 2.93413363821e-07 0.952512626585 2.93445121951e-07 1.2 2.93476880081e-07 1.44748737342 2.93508638211e-07 1.55 2.93540396341e-07 1.44748737342 2.93572154472e-07 1.2 2.93603912602e-07 0.952512626585 2.93635670732e-07 0.85 2.93667428862e-07 0.952512626585 2.93699186992e-07 1.2 2.93730945122e-07 1.44748737342 2.93762703252e-07 1.55 2.93794461382e-07 1.44748737342 2.93826219512e-07 1.2 2.93857977642e-07 0.952512626585 2.93889735772e-07 0.85 2.93921493902e-07 0.952512626585 2.93953252033e-07 1.2 2.93985010163e-07 1.44748737342 2.94016768293e-07 1.55 2.94048526423e-07 1.44748737342 2.94080284553e-07 1.2 2.94112042683e-07 0.952512626585 2.94143800813e-07 0.85 2.94175558943e-07 0.952512626585 2.94207317073e-07 1.2 2.94239075203e-07 1.44748737342 2.94270833333e-07 1.55 2.94302591463e-07 1.44748737342 2.94334349593e-07 1.2 2.94366107724e-07 0.952512626585 2.94397865854e-07 0.85 2.94429623984e-07 0.952512626585 2.94461382114e-07 1.2 2.94493140244e-07 1.44748737342 2.94524898374e-07 1.55 2.94556656504e-07 1.44748737342 2.94588414634e-07 1.2 2.94620172764e-07 0.952512626585 2.94651930894e-07 0.85 2.94683689024e-07 0.952512626585 2.94715447154e-07 1.2 2.94747205285e-07 1.44748737342 2.94778963415e-07 1.55 2.94810721545e-07 1.44748737342 2.94842479675e-07 1.2 2.94874237805e-07 0.952512626585 2.94905995935e-07 0.85 2.94937754065e-07 0.952512626585 2.94969512195e-07 1.2 2.95001270325e-07 1.44748737342 2.95033028455e-07 1.55 2.95064786585e-07 1.44748737342 2.95096544715e-07 1.2 2.95128302846e-07 0.952512626585 2.95160060976e-07 0.85 2.95191819106e-07 0.952512626585 2.95223577236e-07 1.2 2.95255335366e-07 1.44748737342 2.95287093496e-07 1.55 2.95318851626e-07 1.44748737342 2.95350609756e-07 1.2 2.95382367886e-07 0.952512626585 2.95414126016e-07 0.85 2.95445884146e-07 0.952512626585 2.95477642276e-07 1.2 2.95509400407e-07 1.44748737342 2.95541158537e-07 1.55 2.95572916667e-07 1.44748737342 2.95604674797e-07 1.2 2.95636432927e-07 0.952512626585 2.95668191057e-07 0.85 2.95699949187e-07 0.952512626585 2.95731707317e-07 1.2 2.95763465447e-07 1.44748737342 2.95795223577e-07 1.55 2.95826981707e-07 1.44748737342 2.95858739837e-07 1.2 2.95890497967e-07 0.952512626585 2.95922256098e-07 0.85 2.95954014228e-07 0.952512626585 2.95985772358e-07 1.2 2.96017530488e-07 1.44748737342 2.96049288618e-07 1.55 2.96081046748e-07 1.44748737342 2.96112804878e-07 1.2 2.96144563008e-07 0.952512626585 2.96176321138e-07 0.85 2.96208079268e-07 0.952512626585 2.96239837398e-07 1.2 2.96271595528e-07 1.44748737342 2.96303353659e-07 1.55 2.96335111789e-07 1.44748737342 2.96366869919e-07 1.2 2.96398628049e-07 0.952512626585 2.96430386179e-07 0.85 2.96462144309e-07 0.952512626585 2.96493902439e-07 1.2 2.96525660569e-07 1.44748737342 2.96557418699e-07 1.55 2.96589176829e-07 1.44748737342 2.96620934959e-07 1.2 2.96652693089e-07 0.952512626585 2.9668445122e-07 0.85 2.9671620935e-07 0.952512626585 2.9674796748e-07 1.2 2.9677972561e-07 1.44748737342 2.9681148374e-07 1.55 2.9684324187e-07 1.44748737342 2.96875e-07 1.2 2.9690675813e-07 0.952512626585 2.9693851626e-07 0.85 2.9697027439e-07 0.952512626585 2.9700203252e-07 1.2 2.9703379065e-07 1.44748737342 2.9706554878e-07 1.55 2.97097306911e-07 1.44748737342 2.97129065041e-07 1.2 2.97160823171e-07 0.952512626585 2.97192581301e-07 0.85 2.97224339431e-07 0.952512626585 2.97256097561e-07 1.2 2.97287855691e-07 1.44748737342 2.97319613821e-07 1.55 2.97351371951e-07 1.44748737342 2.97383130081e-07 1.2 2.97414888211e-07 0.952512626585 2.97446646341e-07 0.85 2.97478404472e-07 0.952512626585 2.97510162602e-07 1.2 2.97541920732e-07 1.44748737342 2.97573678862e-07 1.55 2.97605436992e-07 1.44748737342 2.97637195122e-07 1.2 2.97668953252e-07 0.952512626585 2.97700711382e-07 0.85 2.97732469512e-07 0.952512626585 2.97764227642e-07 1.2 2.97795985772e-07 1.44748737342 2.97827743902e-07 1.55 2.97859502033e-07 1.44748737342 2.97891260163e-07 1.2 2.97923018293e-07 0.952512626585 2.97954776423e-07 0.85 2.97986534553e-07 0.952512626585 2.98018292683e-07 1.2 2.98050050813e-07 1.44748737342 2.98081808943e-07 1.55 2.98113567073e-07 1.44748737342 2.98145325203e-07 1.2 2.98177083333e-07 0.952512626585 2.98208841463e-07 0.85 2.98240599593e-07 0.952512626585 2.98272357724e-07 1.2 2.98304115854e-07 1.44748737342 2.98335873984e-07 1.55 2.98367632114e-07 1.44748737342 2.98399390244e-07 1.2 2.98431148374e-07 0.952512626585 2.98462906504e-07 0.85 2.98494664634e-07 0.952512626585 2.98526422764e-07 1.2 2.98558180894e-07 1.44748737342 2.98589939024e-07 1.55 2.98621697154e-07 1.44748737342 2.98653455285e-07 1.2 2.98685213415e-07 0.952512626585 2.98716971545e-07 0.85 2.98748729675e-07 0.952512626585 2.98780487805e-07 1.2 2.98812245935e-07 1.44748737342 2.98844004065e-07 1.55 2.98875762195e-07 1.44748737342 2.98907520325e-07 1.2 2.98939278455e-07 0.952512626585 2.98971036585e-07 0.85 2.99002794715e-07 0.952512626585 2.99034552846e-07 1.2 2.99066310976e-07 1.44748737342 2.99098069106e-07 1.55 2.99129827236e-07 1.44748737342 2.99161585366e-07 1.2 2.99193343496e-07 0.952512626585 2.99225101626e-07 0.85 2.99256859756e-07 0.952512626585 2.99288617886e-07 1.2 2.99320376016e-07 1.44748737342 2.99352134146e-07 1.55 2.99383892276e-07 1.44748737342 2.99415650407e-07 1.2 2.99447408537e-07 0.952512626585 2.99479166667e-07 0.85 2.99510924797e-07 0.952512626585 2.99542682927e-07 1.2 2.99574441057e-07 1.44748737342 2.99606199187e-07 1.55 2.99637957317e-07 1.44748737342 2.99669715447e-07 1.2 2.99701473577e-07 0.952512626585 2.99733231707e-07 0.85 2.99764989837e-07 0.952512626585 2.99796747967e-07 1.2 2.99828506098e-07 1.44748737342 2.99860264228e-07 1.55 2.99892022358e-07 1.44748737342 2.99923780488e-07 1.2 2.99955538618e-07 0.952512626584 2.99987296748e-07 0.85 3.00019054878e-07 0.952512626585 3.00050813008e-07 1.2 3.00082571138e-07 1.44748737342 3.00114329268e-07 1.55 3.00146087398e-07 1.44748737342 3.00177845528e-07 1.2 3.00209603659e-07 0.952512626585 3.00241361789e-07 0.85 3.00273119919e-07 0.952512626585 3.00304878049e-07 1.2 3.00336636179e-07 1.44748737342 3.00368394309e-07 1.55 3.00400152439e-07 1.44748737342 3.00431910569e-07 1.2 3.00463668699e-07 0.952512626585 3.00495426829e-07 0.85 3.00527184959e-07 0.952512626585 3.00558943089e-07 1.2 3.0059070122e-07 1.44748737342 3.0062245935e-07 1.55 3.0065421748e-07 1.44748737342 3.0068597561e-07 1.2 3.0071773374e-07 0.952512626585 3.0074949187e-07 0.85 3.0078125e-07 0.952512626585 3.0081300813e-07 1.2 3.0084476626e-07 1.44748737342 3.0087652439e-07 1.55 3.0090828252e-07 1.44748737342 3.0094004065e-07 1.2 3.0097179878e-07 0.952512626585 3.01003556911e-07 0.85 3.01035315041e-07 0.952512626585 3.01067073171e-07 1.2 3.01098831301e-07 1.44748737342 3.01130589431e-07 1.55 3.01162347561e-07 1.44748737342 3.01194105691e-07 1.2 3.01225863821e-07 0.952512626585 3.01257621951e-07 0.85 3.01289380081e-07 0.952512626585 3.01321138211e-07 1.2 3.01352896341e-07 1.44748737342 3.01384654472e-07 1.55 3.01416412602e-07 1.44748737342 3.01448170732e-07 1.2 3.01479928862e-07 0.952512626585 3.01511686992e-07 0.85 3.01543445122e-07 0.952512626585 3.01575203252e-07 1.2 3.01606961382e-07 1.44748737342 3.01638719512e-07 1.55 3.01670477642e-07 1.44748737342 3.01702235772e-07 1.2 3.01733993902e-07 0.952512626585 3.01765752033e-07 0.85 3.01797510163e-07 0.952512626585 3.01829268293e-07 1.2 3.01861026423e-07 1.44748737342 3.01892784553e-07 1.55 3.01924542683e-07 1.44748737342 3.01956300813e-07 1.2 3.01988058943e-07 0.952512626585 3.02019817073e-07 0.85 3.02051575203e-07 0.952512626585 3.02083333333e-07 1.2 3.02115091463e-07 1.44748737342 3.02146849593e-07 1.55 3.02178607724e-07 1.44748737342 3.02210365854e-07 1.2 3.02242123984e-07 0.952512626585 3.02273882114e-07 0.85 3.02305640244e-07 0.952512626585 3.02337398374e-07 1.2 3.02369156504e-07 1.44748737342 3.02400914634e-07 1.55 3.02432672764e-07 1.44748737342 3.02464430894e-07 1.2 3.02496189024e-07 0.952512626585 3.02527947154e-07 0.85 3.02559705285e-07 0.952512626585 3.02591463415e-07 1.2 3.02623221545e-07 1.44748737342 3.02654979675e-07 1.55 3.02686737805e-07 1.44748737342 3.02718495935e-07 1.2 3.02750254065e-07 0.952512626585 3.02782012195e-07 0.85 3.02813770325e-07 0.952512626585 3.02845528455e-07 1.2 3.02877286585e-07 1.44748737342 3.02909044715e-07 1.55 3.02940802846e-07 1.44748737342 3.02972560976e-07 1.2 3.03004319106e-07 0.952512626585 3.03036077236e-07 0.85 3.03067835366e-07 0.952512626585 3.03099593496e-07 1.2 3.03131351626e-07 1.44748737342 3.03163109756e-07 1.55 3.03194867886e-07 1.44748737342 3.03226626016e-07 1.2 3.03258384146e-07 0.952512626585 3.03290142276e-07 0.85 3.03321900407e-07 0.952512626585 3.03353658537e-07 1.2 3.03385416667e-07 1.44748737342 3.03417174797e-07 1.55 3.03448932927e-07 1.44748737342 3.03480691057e-07 1.2 3.03512449187e-07 0.952512626585 3.03544207317e-07 0.85 3.03575965447e-07 0.952512626585 3.03607723577e-07 1.2 3.03639481707e-07 1.44748737342 3.03671239837e-07 1.55 3.03702997967e-07 1.44748737342 3.03734756098e-07 1.2 3.03766514228e-07 0.952512626585 3.03798272358e-07 0.85 3.03830030488e-07 0.952512626585 3.03861788618e-07 1.2 3.03893546748e-07 1.44748737342 3.03925304878e-07 1.55 3.03957063008e-07 1.44748737342 3.03988821138e-07 1.2 3.04020579268e-07 0.952512626585 3.04052337398e-07 0.85 3.04084095528e-07 0.952512626585 3.04115853659e-07 1.2 3.04147611789e-07 1.44748737342 3.04179369919e-07 1.55 3.04211128049e-07 1.44748737342 3.04242886179e-07 1.2 3.04274644309e-07 0.952512626585 3.04306402439e-07 0.85 3.04338160569e-07 0.952512626585 3.04369918699e-07 1.2 3.04401676829e-07 1.44748737342 3.04433434959e-07 1.55 3.04465193089e-07 1.44748737342 3.0449695122e-07 1.2 3.0452870935e-07 0.952512626585 3.0456046748e-07 0.85 3.0459222561e-07 0.952512626585 3.0462398374e-07 1.2 3.0465574187e-07 1.44748737342 3.046875e-07 1.55 3.0471925813e-07 1.44748737342 3.0475101626e-07 1.2 3.0478277439e-07 0.952512626585 3.0481453252e-07 0.85 3.0484629065e-07 0.952512626585 3.0487804878e-07 1.2 3.04909806911e-07 1.44748737342 3.04941565041e-07 1.55 3.04973323171e-07 1.44748737342 3.05005081301e-07 1.2 3.05036839431e-07 0.952512626585 3.05068597561e-07 0.85 3.05100355691e-07 0.952512626585 3.05132113821e-07 1.2 3.05163871951e-07 1.44748737342 3.05195630081e-07 1.55 3.05227388211e-07 1.44748737342 3.05259146341e-07 1.2 3.05290904472e-07 0.952512626585 3.05322662602e-07 0.85 3.05354420732e-07 0.952512626585 3.05386178862e-07 1.2 3.05417936992e-07 1.44748737342 3.05449695122e-07 1.55 3.05481453252e-07 1.44748737342 3.05513211382e-07 1.2 3.05544969512e-07 0.952512626585 3.05576727642e-07 0.85 3.05608485772e-07 0.952512626585 3.05640243902e-07 1.2 3.05672002033e-07 1.44748737342 3.05703760163e-07 1.55 3.05735518293e-07 1.44748737342 3.05767276423e-07 1.2 3.05799034553e-07 0.952512626585 3.05830792683e-07 0.85 3.05862550813e-07 0.952512626585 3.05894308943e-07 1.2 3.05926067073e-07 1.44748737342 3.05957825203e-07 1.55 3.05989583333e-07 1.44748737342 3.06021341463e-07 1.2 3.06053099593e-07 0.952512626585 3.06084857724e-07 0.85 3.06116615854e-07 0.952512626585 3.06148373984e-07 1.2 3.06180132114e-07 1.44748737342 3.06211890244e-07 1.55 3.06243648374e-07 1.44748737342 3.06275406504e-07 1.2 3.06307164634e-07 0.952512626585 3.06338922764e-07 0.85 3.06370680894e-07 0.952512626585 3.06402439024e-07 1.2 3.06434197154e-07 1.44748737342 3.06465955285e-07 1.55 3.06497713415e-07 1.44748737342 3.06529471545e-07 1.2 3.06561229675e-07 0.952512626585 3.06592987805e-07 0.85 3.06624745935e-07 0.952512626585 3.06656504065e-07 1.2 3.06688262195e-07 1.44748737342 3.06720020325e-07 1.55 3.06751778455e-07 1.44748737342 3.06783536585e-07 1.2 3.06815294715e-07 0.952512626585 3.06847052846e-07 0.85 3.06878810976e-07 0.952512626585 3.06910569106e-07 1.2 3.06942327236e-07 1.44748737342 3.06974085366e-07 1.55 3.07005843496e-07 1.44748737342 3.07037601626e-07 1.2 3.07069359756e-07 0.952512626585 3.07101117886e-07 0.85 3.07132876016e-07 0.952512626585 3.07164634146e-07 1.2 3.07196392276e-07 1.44748737342 3.07228150407e-07 1.55 3.07259908537e-07 1.44748737342 3.07291666667e-07 1.2 3.07323424797e-07 0.952512626585 3.07355182927e-07 0.85 3.07386941057e-07 0.952512626585 3.07418699187e-07 1.2 3.07450457317e-07 1.44748737342 3.07482215447e-07 1.55 3.07513973577e-07 1.44748737342 3.07545731707e-07 1.2 3.07577489837e-07 0.952512626585 3.07609247967e-07 0.85 3.07641006098e-07 0.952512626585 3.07672764228e-07 1.2 3.07704522358e-07 1.44748737342 3.07736280488e-07 1.55 3.07768038618e-07 1.44748737342 3.07799796748e-07 1.2 3.07831554878e-07 0.952512626585 3.07863313008e-07 0.85 3.07895071138e-07 0.952512626585 3.07926829268e-07 1.2 3.07958587398e-07 1.44748737342 3.07990345528e-07 1.55 3.08022103659e-07 1.44748737342 3.08053861789e-07 1.2 3.08085619919e-07 0.952512626585 3.08117378049e-07 0.85 3.08149136179e-07 0.952512626585 3.08180894309e-07 1.2 3.08212652439e-07 1.44748737342 3.08244410569e-07 1.55 3.08276168699e-07 1.44748737342 3.08307926829e-07 1.2 3.08339684959e-07 0.952512626584 3.08371443089e-07 0.85 3.0840320122e-07 0.952512626585 3.0843495935e-07 1.2 3.0846671748e-07 1.44748737342 3.0849847561e-07 1.55 3.0853023374e-07 1.44748737342 3.0856199187e-07 1.2 3.0859375e-07 0.952512626585 3.0862550813e-07 0.85 3.0865726626e-07 0.952512626584 3.0868902439e-07 1.2 3.0872078252e-07 1.44748737342 3.0875254065e-07 1.55 3.0878429878e-07 1.44748737342 3.08816056911e-07 1.2 3.08847815041e-07 0.952512626585 3.08879573171e-07 0.85 3.08911331301e-07 0.952512626585 3.08943089431e-07 1.2 3.08974847561e-07 1.44748737342 3.09006605691e-07 1.55 3.09038363821e-07 1.44748737342 3.09070121951e-07 1.2 3.09101880081e-07 0.952512626585 3.09133638211e-07 0.85 3.09165396341e-07 0.952512626585 3.09197154472e-07 1.2 3.09228912602e-07 1.44748737342 3.09260670732e-07 1.55 3.09292428862e-07 1.44748737342 3.09324186992e-07 1.2 3.09355945122e-07 0.952512626585 3.09387703252e-07 0.85 3.09419461382e-07 0.952512626585 3.09451219512e-07 1.2 3.09482977642e-07 1.44748737342 3.09514735772e-07 1.55 3.09546493902e-07 1.44748737342 3.09578252033e-07 1.2 3.09610010163e-07 0.952512626585 3.09641768293e-07 0.85 3.09673526423e-07 0.952512626585 3.09705284553e-07 1.2 3.09737042683e-07 1.44748737342 3.09768800813e-07 1.55 3.09800558943e-07 1.44748737342 3.09832317073e-07 1.2 3.09864075203e-07 0.952512626585 3.09895833333e-07 0.85 3.09927591463e-07 0.952512626585 3.09959349593e-07 1.2 3.09991107724e-07 1.44748737342 3.10022865854e-07 1.55 3.10054623984e-07 1.44748737342 3.10086382114e-07 1.2 3.10118140244e-07 0.952512626584 3.10149898374e-07 0.85 3.10181656504e-07 0.952512626585 3.10213414634e-07 1.2 3.10245172764e-07 1.44748737342 3.10276930894e-07 1.55 3.10308689024e-07 1.44748737342 3.10340447154e-07 1.2 3.10372205285e-07 0.952512626585 3.10403963415e-07 0.85 3.10435721545e-07 0.952512626584 3.10467479675e-07 1.2 3.10499237805e-07 1.44748737342 3.10530995935e-07 1.55 3.10562754065e-07 1.44748737342 3.10594512195e-07 1.2 3.10626270325e-07 0.952512626585 3.10658028455e-07 0.85 3.10689786585e-07 0.952512626585 3.10721544715e-07 1.2 3.10753302846e-07 1.44748737342 3.10785060976e-07 1.55 3.10816819106e-07 1.44748737342 3.10848577236e-07 1.2 3.10880335366e-07 0.952512626585 3.10912093496e-07 0.85 3.10943851626e-07 0.952512626585 3.10975609756e-07 1.2 3.11007367886e-07 1.44748737342 3.11039126016e-07 1.55 3.11070884146e-07 1.44748737342 3.11102642276e-07 1.2 3.11134400407e-07 0.952512626585 3.11166158537e-07 0.85 3.11197916667e-07 0.952512626585 3.11229674797e-07 1.2 3.11261432927e-07 1.44748737342 3.11293191057e-07 1.55 3.11324949187e-07 1.44748737342 3.11356707317e-07 1.2 3.11388465447e-07 0.952512626585 3.11420223577e-07 0.85 3.11451981707e-07 0.952512626585 3.11483739837e-07 1.2 3.11515497967e-07 1.44748737342 3.11547256098e-07 1.55 3.11579014228e-07 1.44748737342 3.11610772358e-07 1.2 3.11642530488e-07 0.952512626585 3.11674288618e-07 0.85 3.11706046748e-07 0.952512626585 3.11737804878e-07 1.2 3.11769563008e-07 1.44748737342 3.11801321138e-07 1.55 3.11833079268e-07 1.44748737342 3.11864837398e-07 1.2 3.11896595528e-07 0.952512626585 3.11928353659e-07 0.85 3.11960111789e-07 0.952512626585 3.11991869919e-07 1.2 3.12023628049e-07 1.44748737342 3.12055386179e-07 1.55 3.12087144309e-07 1.44748737342 3.12118902439e-07 1.2 3.12150660569e-07 0.952512626585 3.12182418699e-07 0.85 3.12214176829e-07 0.952512626585 3.12245934959e-07 1.2 3.12277693089e-07 1.44748737342 3.1230945122e-07 1.55 3.1234120935e-07 1.44748737342 3.1237296748e-07 1.2 3.1240472561e-07 0.952512626585 3.1243648374e-07 0.85 3.1246824187e-07 0.952512626585 3.125e-07 1.2 3.1253175813e-07 1.44748737342 3.1256351626e-07 1.55 3.1259527439e-07 1.44748737342 3.1262703252e-07 1.2 3.1265879065e-07 0.952512626585 3.1269054878e-07 0.85 3.12722306911e-07 0.952512626585 3.12754065041e-07 1.2 3.12785823171e-07 1.44748737342 3.12817581301e-07 1.55 3.12849339431e-07 1.44748737342 3.12881097561e-07 1.2 3.12912855691e-07 0.952512626585 3.12944613821e-07 0.85 3.12976371951e-07 0.952512626585 3.13008130081e-07 1.2 3.13039888211e-07 1.44748737342 3.13071646341e-07 1.55 3.13103404472e-07 1.44748737342 3.13135162602e-07 1.2 3.13166920732e-07 0.952512626585 3.13198678862e-07 0.85 3.13230436992e-07 0.952512626585 3.13262195122e-07 1.2 3.13293953252e-07 1.44748737342 3.13325711382e-07 1.55 3.13357469512e-07 1.44748737342 3.13389227642e-07 1.2 3.13420985772e-07 0.952512626585 3.13452743902e-07 0.85 3.13484502033e-07 0.952512626585 3.13516260163e-07 1.2 3.13548018293e-07 1.44748737342 3.13579776423e-07 1.55 3.13611534553e-07 1.44748737342 3.13643292683e-07 1.2 3.13675050813e-07 0.952512626585 3.13706808943e-07 0.85 3.13738567073e-07 0.952512626585 3.13770325203e-07 1.2 3.13802083333e-07 1.44748737342 3.13833841463e-07 1.55 3.13865599593e-07 1.44748737342 3.13897357724e-07 1.2 3.13929115854e-07 0.952512626585 3.13960873984e-07 0.85 3.13992632114e-07 0.952512626585 3.14024390244e-07 1.2 3.14056148374e-07 1.44748737342 3.14087906504e-07 1.55 3.14119664634e-07 1.44748737342 3.14151422764e-07 1.2 3.14183180894e-07 0.952512626585 3.14214939024e-07 0.85 3.14246697154e-07 0.952512626585 3.14278455285e-07 1.2 3.14310213415e-07 1.44748737342 3.14341971545e-07 1.55 3.14373729675e-07 1.44748737342 3.14405487805e-07 1.2 3.14437245935e-07 0.952512626585 3.14469004065e-07 0.85 3.14500762195e-07 0.952512626585 3.14532520325e-07 1.2 3.14564278455e-07 1.44748737342 3.14596036585e-07 1.55 3.14627794715e-07 1.44748737342 3.14659552846e-07 1.2 3.14691310976e-07 0.952512626585 3.14723069106e-07 0.85 3.14754827236e-07 0.952512626585 3.14786585366e-07 1.2 3.14818343496e-07 1.44748737342 3.14850101626e-07 1.55 3.14881859756e-07 1.44748737342 3.14913617886e-07 1.2 3.14945376016e-07 0.952512626585 3.14977134146e-07 0.85 3.15008892276e-07 0.952512626585 3.15040650407e-07 1.2 3.15072408537e-07 1.44748737342 3.15104166667e-07 1.55 3.15135924797e-07 1.44748737342 3.15167682927e-07 1.2 3.15199441057e-07 0.952512626585 3.15231199187e-07 0.85 3.15262957317e-07 0.952512626585 3.15294715447e-07 1.2 3.15326473577e-07 1.44748737342 3.15358231707e-07 1.55 3.15389989837e-07 1.44748737342 3.15421747967e-07 1.2 3.15453506098e-07 0.952512626585 3.15485264228e-07 0.85 3.15517022358e-07 0.952512626585 3.15548780488e-07 1.2 3.15580538618e-07 1.44748737342 3.15612296748e-07 1.55 3.15644054878e-07 1.44748737342 3.15675813008e-07 1.2 3.15707571138e-07 0.952512626585 3.15739329268e-07 0.85 3.15771087398e-07 0.952512626585 3.15802845528e-07 1.2 3.15834603659e-07 1.44748737342 3.15866361789e-07 1.55 3.15898119919e-07 1.44748737342 3.15929878049e-07 1.2 3.15961636179e-07 0.952512626585 3.15993394309e-07 0.85 3.16025152439e-07 0.952512626585 3.16056910569e-07 1.2 3.16088668699e-07 1.44748737342 3.16120426829e-07 1.55 3.16152184959e-07 1.44748737342 3.16183943089e-07 1.2 3.1621570122e-07 0.952512626585 3.1624745935e-07 0.85 3.1627921748e-07 0.952512626585 3.1631097561e-07 1.2 3.1634273374e-07 1.44748737342 3.1637449187e-07 1.55 3.1640625e-07 1.44748737342 3.1643800813e-07 1.2 3.1646976626e-07 0.952512626585 3.1650152439e-07 0.85 3.1653328252e-07 0.952512626585 3.1656504065e-07 1.2 3.1659679878e-07 1.44748737342 3.16628556911e-07 1.55 3.16660315041e-07 1.44748737342 3.16692073171e-07 1.2 3.16723831301e-07 0.952512626585 3.16755589431e-07 0.85 3.16787347561e-07 0.952512626585 3.16819105691e-07 1.2 3.16850863821e-07 1.44748737342 3.16882621951e-07 1.55 3.16914380081e-07 1.44748737342 3.16946138211e-07 1.2 3.16977896341e-07 0.952512626585 3.17009654472e-07 0.85 3.17041412602e-07 0.952512626584 3.17073170732e-07 1.2 3.17104928862e-07 1.44748737342 3.17136686992e-07 1.55 3.17168445122e-07 1.44748737342 3.17200203252e-07 1.2 3.17231961382e-07 0.952512626585 3.17263719512e-07 0.85 3.17295477642e-07 0.952512626585 3.17327235772e-07 1.2 3.17358993902e-07 1.44748737342 3.17390752033e-07 1.55 3.17422510163e-07 1.44748737342 3.17454268293e-07 1.2 3.17486026423e-07 0.952512626585 3.17517784553e-07 0.85 3.17549542683e-07 0.952512626585 3.17581300813e-07 1.2 3.17613058943e-07 1.44748737342 3.17644817073e-07 1.55 3.17676575203e-07 1.44748737342 3.17708333333e-07 1.2 3.17740091463e-07 0.952512626585 3.17771849593e-07 0.85 3.17803607724e-07 0.952512626585 3.17835365854e-07 1.2 3.17867123984e-07 1.44748737342 3.17898882114e-07 1.55 3.17930640244e-07 1.44748737342 3.17962398374e-07 1.2 3.17994156504e-07 0.952512626585 3.18025914634e-07 0.85 3.18057672764e-07 0.952512626585 3.18089430894e-07 1.2 3.18121189024e-07 1.44748737342 3.18152947154e-07 1.55 3.18184705285e-07 1.44748737342 3.18216463415e-07 1.2 3.18248221545e-07 0.952512626585 3.18279979675e-07 0.85 3.18311737805e-07 0.952512626585 3.18343495935e-07 1.2 3.18375254065e-07 1.44748737342 3.18407012195e-07 1.55 3.18438770325e-07 1.44748737342 3.18470528455e-07 1.2 3.18502286585e-07 0.952512626585 3.18534044715e-07 0.85 3.18565802846e-07 0.952512626585 3.18597560976e-07 1.2 3.18629319106e-07 1.44748737342 3.18661077236e-07 1.55 3.18692835366e-07 1.44748737342 3.18724593496e-07 1.2 3.18756351626e-07 0.952512626585 3.18788109756e-07 0.85 3.18819867886e-07 0.952512626584 3.18851626016e-07 1.2 3.18883384146e-07 1.44748737342 3.18915142276e-07 1.55 3.18946900407e-07 1.44748737342 3.18978658537e-07 1.2 3.19010416667e-07 0.952512626585 3.19042174797e-07 0.85 3.19073932927e-07 0.952512626585 3.19105691057e-07 1.2 3.19137449187e-07 1.44748737342 3.19169207317e-07 1.55 3.19200965447e-07 1.44748737342 3.19232723577e-07 1.2 3.19264481707e-07 0.952512626585 3.19296239837e-07 0.85 3.19327997967e-07 0.952512626585 3.19359756098e-07 1.2 3.19391514228e-07 1.44748737342 3.19423272358e-07 1.55 3.19455030488e-07 1.44748737342 3.19486788618e-07 1.2 3.19518546748e-07 0.952512626585 3.19550304878e-07 0.85 3.19582063008e-07 0.952512626585 3.19613821138e-07 1.2 3.19645579268e-07 1.44748737342 3.19677337398e-07 1.55 3.19709095528e-07 1.44748737342 3.19740853659e-07 1.2 3.19772611789e-07 0.952512626585 3.19804369919e-07 0.85 3.19836128049e-07 0.952512626585 3.19867886179e-07 1.2 3.19899644309e-07 1.44748737342 3.19931402439e-07 1.55 3.19963160569e-07 1.44748737342 3.19994918699e-07 1.2 3.20026676829e-07 0.952512626585 3.20058434959e-07 0.85 3.20090193089e-07 0.952512626585 3.2012195122e-07 1.2 3.2015370935e-07 1.44748737342 3.2018546748e-07 1.55 3.2021722561e-07 1.44748737342 3.2024898374e-07 1.2 3.2028074187e-07 0.952512626585 3.203125e-07 0.85 3.2034425813e-07 0.952512626585 3.2037601626e-07 1.2 3.2040777439e-07 1.44748737342 3.2043953252e-07 1.55 3.2047129065e-07 1.44748737342 3.2050304878e-07 1.2 3.20534806911e-07 0.952512626585 3.20566565041e-07 0.85 3.20598323171e-07 0.952512626584 3.20630081301e-07 1.2 3.20661839431e-07 1.44748737342 3.20693597561e-07 1.55 3.20725355691e-07 1.44748737342 3.20757113821e-07 1.2 3.20788871951e-07 0.952512626585 3.20820630081e-07 0.85 3.20852388211e-07 0.952512626585 3.20884146341e-07 1.2 3.20915904472e-07 1.44748737342 3.20947662602e-07 1.55 3.20979420732e-07 1.44748737342 3.21011178862e-07 1.2 3.21042936992e-07 0.952512626585 3.21074695122e-07 0.85 3.21106453252e-07 0.952512626585 3.21138211382e-07 1.2 3.21169969512e-07 1.44748737342 3.21201727642e-07 1.55 3.21233485772e-07 1.44748737342 3.21265243902e-07 1.2 3.21297002033e-07 0.952512626585 3.21328760163e-07 0.85 3.21360518293e-07 0.952512626585 3.21392276423e-07 1.2 3.21424034553e-07 1.44748737342 3.21455792683e-07 1.55 3.21487550813e-07 1.44748737342 3.21519308943e-07 1.2 3.21551067073e-07 0.952512626585 3.21582825203e-07 0.85 3.21614583333e-07 0.952512626585 3.21646341463e-07 1.2 3.21678099593e-07 1.44748737342 3.21709857724e-07 1.55 3.21741615854e-07 1.44748737342 3.21773373984e-07 1.2 3.21805132114e-07 0.952512626585 3.21836890244e-07 0.85 3.21868648374e-07 0.952512626585 3.21900406504e-07 1.2 3.21932164634e-07 1.44748737342 3.21963922764e-07 1.55 3.21995680894e-07 1.44748737342 3.22027439024e-07 1.2 3.22059197154e-07 0.952512626585 3.22090955285e-07 0.85 3.22122713415e-07 0.952512626585 3.22154471545e-07 1.2 3.22186229675e-07 1.44748737342 3.22217987805e-07 1.55 3.22249745935e-07 1.44748737342 3.22281504065e-07 1.2 3.22313262195e-07 0.952512626585 3.22345020325e-07 0.85 3.22376778455e-07 0.952512626585 3.22408536585e-07 1.2 3.22440294715e-07 1.44748737342 3.22472052846e-07 1.55 3.22503810976e-07 1.44748737342 3.22535569106e-07 1.2 3.22567327236e-07 0.952512626585 3.22599085366e-07 0.85 3.22630843496e-07 0.952512626585 3.22662601626e-07 1.2 3.22694359756e-07 1.44748737342 3.22726117886e-07 1.55 3.22757876016e-07 1.44748737342 3.22789634146e-07 1.2 3.22821392276e-07 0.952512626585 3.22853150407e-07 0.85 3.22884908537e-07 0.952512626585 3.22916666667e-07 1.2 3.22948424797e-07 1.44748737342 3.22980182927e-07 1.55 3.23011941057e-07 1.44748737342 3.23043699187e-07 1.2 3.23075457317e-07 0.952512626585 3.23107215447e-07 0.85 3.23138973577e-07 0.952512626585 3.23170731707e-07 1.2 3.23202489837e-07 1.44748737342 3.23234247967e-07 1.55 3.23266006098e-07 1.44748737342 3.23297764228e-07 1.2 3.23329522358e-07 0.952512626585 3.23361280488e-07 0.85 3.23393038618e-07 0.952512626585 3.23424796748e-07 1.2 3.23456554878e-07 1.44748737342 3.23488313008e-07 1.55 3.23520071138e-07 1.44748737342 3.23551829268e-07 1.2 3.23583587398e-07 0.952512626585 3.23615345528e-07 0.85 3.23647103659e-07 0.952512626585 3.23678861789e-07 1.2 3.23710619919e-07 1.44748737342 3.23742378049e-07 1.55 3.23774136179e-07 1.44748737342 3.23805894309e-07 1.2 3.23837652439e-07 0.952512626585 3.23869410569e-07 0.85 3.23901168699e-07 0.952512626585 3.23932926829e-07 1.2 3.23964684959e-07 1.44748737342 3.23996443089e-07 1.55 3.2402820122e-07 1.44748737342 3.2405995935e-07 1.2 3.2409171748e-07 0.952512626585 3.2412347561e-07 0.85 3.2415523374e-07 0.952512626585 3.2418699187e-07 1.2 3.2421875e-07 1.44748737342 3.2425050813e-07 1.55 3.2428226626e-07 1.44748737342 3.2431402439e-07 1.2 3.2434578252e-07 0.952512626585 3.2437754065e-07 0.85 3.2440929878e-07 0.952512626585 3.24441056911e-07 1.2 3.24472815041e-07 1.44748737342 3.24504573171e-07 1.55 3.24536331301e-07 1.44748737342 3.24568089431e-07 1.2 3.24599847561e-07 0.952512626585 3.24631605691e-07 0.85 3.24663363821e-07 0.952512626585 3.24695121951e-07 1.2 3.24726880081e-07 1.44748737342 3.24758638211e-07 1.55 3.24790396341e-07 1.44748737342 3.24822154472e-07 1.2 3.24853912602e-07 0.952512626585 3.24885670732e-07 0.85 3.24917428862e-07 0.952512626585 3.24949186992e-07 1.2 3.24980945122e-07 1.44748737342 3.25012703252e-07 1.55 3.25044461382e-07 1.44748737342 3.25076219512e-07 1.2 3.25107977642e-07 0.952512626585 3.25139735772e-07 0.85 3.25171493902e-07 0.952512626585 3.25203252033e-07 1.2 3.25235010163e-07 1.44748737342 3.25266768293e-07 1.55 3.25298526423e-07 1.44748737342 3.25330284553e-07 1.2 3.25362042683e-07 0.952512626585 3.25393800813e-07 0.85 3.25425558943e-07 0.952512626585 3.25457317073e-07 1.2 3.25489075203e-07 1.44748737342 3.25520833333e-07 1.55 3.25552591463e-07 1.44748737342 3.25584349593e-07 1.2 3.25616107724e-07 0.952512626585 3.25647865854e-07 0.85 3.25679623984e-07 0.952512626585 3.25711382114e-07 1.2 3.25743140244e-07 1.44748737342 3.25774898374e-07 1.55 3.25806656504e-07 1.44748737342 3.25838414634e-07 1.2 3.25870172764e-07 0.952512626585 3.25901930894e-07 0.85 3.25933689024e-07 0.952512626585 3.25965447154e-07 1.2 3.25997205285e-07 1.44748737342 3.26028963415e-07 1.55 3.26060721545e-07 1.44748737342 3.26092479675e-07 1.2 3.26124237805e-07 0.952512626585 3.26155995935e-07 0.85 3.26187754065e-07 0.952512626585 3.26219512195e-07 1.2 3.26251270325e-07 1.44748737342 3.26283028455e-07 1.55 3.26314786585e-07 1.44748737342 3.26346544715e-07 1.2 3.26378302846e-07 0.952512626585 3.26410060976e-07 0.85 3.26441819106e-07 0.952512626585 3.26473577236e-07 1.2 3.26505335366e-07 1.44748737342 3.26537093496e-07 1.55 3.26568851626e-07 1.44748737342 3.26600609756e-07 1.2 3.26632367886e-07 0.952512626585 3.26664126016e-07 0.85 3.26695884146e-07 0.952512626585 3.26727642276e-07 1.2 3.26759400407e-07 1.44748737342 3.26791158537e-07 1.55 3.26822916667e-07 1.44748737342 3.26854674797e-07 1.2 3.26886432927e-07 0.952512626585 3.26918191057e-07 0.85 3.26949949187e-07 0.952512626585 3.26981707317e-07 1.2 3.27013465447e-07 1.44748737342 3.27045223577e-07 1.55 3.27076981707e-07 1.44748737342 3.27108739837e-07 1.2 3.27140497967e-07 0.952512626585 3.27172256098e-07 0.85 3.27204014228e-07 0.952512626584 3.27235772358e-07 1.2 3.27267530488e-07 1.44748737342 3.27299288618e-07 1.55 3.27331046748e-07 1.44748737342 3.27362804878e-07 1.2 3.27394563008e-07 0.952512626585 3.27426321138e-07 0.85 3.27458079268e-07 0.952512626585 3.27489837398e-07 1.2 3.27521595528e-07 1.44748737342 3.27553353659e-07 1.55 3.27585111789e-07 1.44748737342 3.27616869919e-07 1.2 3.27648628049e-07 0.952512626585 3.27680386179e-07 0.85 3.27712144309e-07 0.952512626585 3.27743902439e-07 1.2 3.27775660569e-07 1.44748737342 3.27807418699e-07 1.55 3.27839176829e-07 1.44748737342 3.27870934959e-07 1.2 3.27902693089e-07 0.952512626585 3.2793445122e-07 0.85 3.2796620935e-07 0.952512626585 3.2799796748e-07 1.2 3.2802972561e-07 1.44748737342 3.2806148374e-07 1.55 3.2809324187e-07 1.44748737342 3.28125e-07 1.2 3.2815675813e-07 0.952512626585 3.2818851626e-07 0.85 3.2822027439e-07 0.952512626585 3.2825203252e-07 1.2 3.2828379065e-07 1.44748737342 3.2831554878e-07 1.55 3.28347306911e-07 1.44748737342 3.28379065041e-07 1.2 3.28410823171e-07 0.952512626585 3.28442581301e-07 0.85 3.28474339431e-07 0.952512626585 3.28506097561e-07 1.2 3.28537855691e-07 1.44748737342 3.28569613821e-07 1.55 3.28601371951e-07 1.44748737342 3.28633130081e-07 1.2 3.28664888211e-07 0.952512626585 3.28696646341e-07 0.85 3.28728404472e-07 0.952512626585 3.28760162602e-07 1.2 3.28791920732e-07 1.44748737342 3.28823678862e-07 1.55 3.28855436992e-07 1.44748737342 3.28887195122e-07 1.2 3.28918953252e-07 0.952512626585 3.28950711382e-07 0.85 3.28982469512e-07 0.952512626584 3.29014227642e-07 1.2 3.29045985772e-07 1.44748737342 3.29077743902e-07 1.55 3.29109502033e-07 1.44748737342 3.29141260163e-07 1.2 3.29173018293e-07 0.952512626585 3.29204776423e-07 0.85 3.29236534553e-07 0.952512626585 3.29268292683e-07 1.2 3.29300050813e-07 1.44748737342 3.29331808943e-07 1.55 3.29363567073e-07 1.44748737342 3.29395325203e-07 1.2 3.29427083333e-07 0.952512626585 3.29458841463e-07 0.85 3.29490599593e-07 0.952512626585 3.29522357724e-07 1.2 3.29554115854e-07 1.44748737342 3.29585873984e-07 1.55 3.29617632114e-07 1.44748737342 3.29649390244e-07 1.2 3.29681148374e-07 0.952512626585 3.29712906504e-07 0.85 3.29744664634e-07 0.952512626585 3.29776422764e-07 1.2 3.29808180894e-07 1.44748737342 3.29839939024e-07 1.55 3.29871697154e-07 1.44748737342 3.29903455285e-07 1.2 3.29935213415e-07 0.952512626585 3.29966971545e-07 0.85 3.29998729675e-07 0.952512626585 3.30030487805e-07 1.2 3.30062245935e-07 1.44748737342 3.30094004065e-07 1.55 3.30125762195e-07 1.44748737342 3.30157520325e-07 1.2 3.30189278455e-07 0.952512626585 3.30221036585e-07 0.85 3.30252794715e-07 0.952512626585 3.30284552846e-07 1.2 3.30316310976e-07 1.44748737342 3.30348069106e-07 1.55 3.30379827236e-07 1.44748737342 3.30411585366e-07 1.2 3.30443343496e-07 0.952512626585 3.30475101626e-07 0.85 3.30506859756e-07 0.952512626585 3.30538617886e-07 1.2 3.30570376016e-07 1.44748737342 3.30602134146e-07 1.55 3.30633892276e-07 1.44748737342 3.30665650407e-07 1.2 3.30697408537e-07 0.952512626585 3.30729166667e-07 0.85 3.30760924797e-07 0.952512626584 3.30792682927e-07 1.2 3.30824441057e-07 1.44748737342 3.30856199187e-07 1.55 3.30887957317e-07 1.44748737342 3.30919715447e-07 1.2 3.30951473577e-07 0.952512626585 3.30983231707e-07 0.85 3.31014989837e-07 0.952512626585 3.31046747967e-07 1.2 3.31078506098e-07 1.44748737342 3.31110264228e-07 1.55 3.31142022358e-07 1.44748737342 3.31173780488e-07 1.2 3.31205538618e-07 0.952512626585 3.31237296748e-07 0.85 3.31269054878e-07 0.952512626585 3.31300813008e-07 1.2 3.31332571138e-07 1.44748737342 3.31364329268e-07 1.55 3.31396087398e-07 1.44748737342 3.31427845528e-07 1.2 3.31459603659e-07 0.952512626585 3.31491361789e-07 0.85 3.31523119919e-07 0.952512626585 3.31554878049e-07 1.2 3.31586636179e-07 1.44748737342 3.31618394309e-07 1.55 3.31650152439e-07 1.44748737342 3.31681910569e-07 1.2 3.31713668699e-07 0.952512626585 3.31745426829e-07 0.85 3.31777184959e-07 0.952512626585 3.31808943089e-07 1.2 3.3184070122e-07 1.44748737342 3.3187245935e-07 1.55 3.3190421748e-07 1.44748737342 3.3193597561e-07 1.2 3.3196773374e-07 0.952512626585 3.3199949187e-07 0.85 3.3203125e-07 0.952512626584 3.3206300813e-07 1.2 3.3209476626e-07 1.44748737342 3.3212652439e-07 1.55 3.3215828252e-07 1.44748737342 3.3219004065e-07 1.2 3.3222179878e-07 0.952512626585 3.32253556911e-07 0.85 3.32285315041e-07 0.952512626585 3.32317073171e-07 1.2 3.32348831301e-07 1.44748737341 3.32380589431e-07 1.55 3.32412347561e-07 1.44748737342 3.32444105691e-07 1.2 3.32475863821e-07 0.952512626585 3.32507621951e-07 0.85 3.32539380081e-07 0.952512626585 3.32571138211e-07 1.2 3.32602896341e-07 1.44748737342 3.32634654472e-07 1.55 3.32666412602e-07 1.44748737342 3.32698170732e-07 1.2 3.32729928862e-07 0.952512626585 3.32761686992e-07 0.85 3.32793445122e-07 0.952512626585 3.32825203252e-07 1.2 3.32856961382e-07 1.44748737342 3.32888719512e-07 1.55 3.32920477642e-07 1.44748737342 3.32952235772e-07 1.2 3.32983993902e-07 0.952512626585 3.33015752033e-07 0.85 3.33047510163e-07 0.952512626585 3.33079268293e-07 1.2 3.33111026423e-07 1.44748737342 3.33142784553e-07 1.55 3.33174542683e-07 1.44748737342 3.33206300813e-07 1.2 3.33238058943e-07 0.952512626584 3.33269817073e-07 0.85 3.33301575203e-07 0.952512626585 3.33333333333e-07 1.2 3.33365091463e-07 1.44748737342 3.33396849593e-07 1.55 3.33428607724e-07 1.44748737342 3.33460365854e-07 1.2 3.33492123984e-07 0.952512626585 3.33523882114e-07 0.85 3.33555640244e-07 0.952512626585 3.33587398374e-07 1.2 3.33619156504e-07 1.44748737342 3.33650914634e-07 1.55 3.33682672764e-07 1.44748737341 3.33714430894e-07 1.2 3.33746189024e-07 0.952512626585 3.33777947154e-07 0.85 3.33809705285e-07 0.952512626585 3.33841463415e-07 1.2 3.33873221545e-07 1.44748737342 3.33904979675e-07 1.55 3.33936737805e-07 1.44748737342 3.33968495935e-07 1.2 3.34000254065e-07 0.952512626584 3.34032012195e-07 0.85 3.34063770325e-07 0.952512626585 3.34095528455e-07 1.2 3.34127286585e-07 1.44748737342 3.34159044715e-07 1.55 3.34190802846e-07 1.44748737342 3.34222560976e-07 1.2 3.34254319106e-07 0.952512626585 3.34286077236e-07 0.85 3.34317835366e-07 0.952512626585 3.34349593496e-07 1.2 3.34381351626e-07 1.44748737342 3.34413109756e-07 1.55 3.34444867886e-07 1.44748737342 3.34476626016e-07 1.2 3.34508384146e-07 0.952512626585 3.34540142276e-07 0.85 3.34571900407e-07 0.952512626585 3.34603658537e-07 1.2 3.34635416667e-07 1.44748737342 3.34667174797e-07 1.55 3.34698932927e-07 1.44748737342 3.34730691057e-07 1.2 3.34762449187e-07 0.952512626585 3.34794207317e-07 0.85 3.34825965447e-07 0.952512626585 3.34857723577e-07 1.2 3.34889481707e-07 1.44748737342 3.34921239837e-07 1.55 3.34952997967e-07 1.44748737342 3.34984756098e-07 1.2 3.35016514228e-07 0.952512626585 3.35048272358e-07 0.85 3.35080030488e-07 0.952512626585 3.35111788618e-07 1.2 3.35143546748e-07 1.44748737342 3.35175304878e-07 1.55 3.35207063008e-07 1.44748737342 3.35238821138e-07 1.2 3.35270579268e-07 0.952512626585 3.35302337398e-07 0.85 3.35334095528e-07 0.952512626585 3.35365853659e-07 1.2 3.35397611789e-07 1.44748737342 3.35429369919e-07 1.55 3.35461128049e-07 1.44748737342 3.35492886179e-07 1.2 3.35524644309e-07 0.952512626585 3.35556402439e-07 0.85 3.35588160569e-07 0.952512626584 3.35619918699e-07 1.2 3.35651676829e-07 1.44748737342 3.35683434959e-07 1.55 3.35715193089e-07 1.44748737342 3.3574695122e-07 1.2 3.3577870935e-07 0.952512626585 3.3581046748e-07 0.85 3.3584222561e-07 0.952512626585 3.3587398374e-07 1.2 3.3590574187e-07 1.44748737342 3.359375e-07 1.55 3.3596925813e-07 1.44748737342 3.3600101626e-07 1.2 3.3603277439e-07 0.952512626585 3.3606453252e-07 0.85 3.3609629065e-07 0.952512626584 3.3612804878e-07 1.2 3.36159806911e-07 1.44748737342 3.36191565041e-07 1.55 3.36223323171e-07 1.44748737342 3.36255081301e-07 1.2 3.36286839431e-07 0.952512626585 3.36318597561e-07 0.85 3.36350355691e-07 0.952512626584 3.36382113821e-07 1.2 3.36413871951e-07 1.44748737342 3.36445630081e-07 1.55 3.36477388211e-07 1.44748737342 3.36509146341e-07 1.2 3.36540904472e-07 0.952512626585 3.36572662602e-07 0.85 3.36604420732e-07 0.952512626585 3.36636178862e-07 1.2 3.36667936992e-07 1.44748737342 3.36699695122e-07 1.55 3.36731453252e-07 1.44748737342 3.36763211382e-07 1.2 3.36794969512e-07 0.952512626585 3.36826727642e-07 0.85 3.36858485772e-07 0.952512626585 3.36890243902e-07 1.2 3.36922002033e-07 1.44748737342 3.36953760163e-07 1.55 3.36985518293e-07 1.44748737342 3.37017276423e-07 1.2 3.37049034553e-07 0.952512626585 3.37080792683e-07 0.85 3.37112550813e-07 0.952512626585 3.37144308943e-07 1.2 3.37176067073e-07 1.44748737342 3.37207825203e-07 1.55 3.37239583333e-07 1.44748737342 3.37271341463e-07 1.2 3.37303099593e-07 0.952512626585 3.37334857724e-07 0.85 3.37366615854e-07 0.952512626585 3.37398373984e-07 1.2 3.37430132114e-07 1.44748737342 3.37461890244e-07 1.55 3.37493648374e-07 1.44748737342 3.37525406504e-07 1.2 3.37557164634e-07 0.952512626584 3.37588922764e-07 0.85 3.37620680894e-07 0.952512626585 3.37652439024e-07 1.2 3.37684197154e-07 1.44748737342 3.37715955285e-07 1.55 3.37747713415e-07 1.44748737342 3.37779471545e-07 1.2 3.37811229675e-07 0.952512626585 3.37842987805e-07 0.85 3.37874745935e-07 0.952512626585 3.37906504065e-07 1.2 3.37938262195e-07 1.44748737342 3.37970020325e-07 1.55 3.38001778455e-07 1.44748737342 3.38033536585e-07 1.2 3.38065294715e-07 0.952512626585 3.38097052846e-07 0.85 3.38128810976e-07 0.952512626585 3.38160569106e-07 1.2 3.38192327236e-07 1.44748737342 3.38224085366e-07 1.55 3.38255843496e-07 1.44748737342 3.38287601626e-07 1.2 3.38319359756e-07 0.952512626585 3.38351117886e-07 0.85 3.38382876016e-07 0.952512626585 3.38414634146e-07 1.2 3.38446392276e-07 1.44748737342 3.38478150407e-07 1.55 3.38509908537e-07 1.44748737342 3.38541666667e-07 1.2 3.38573424797e-07 0.952512626585 3.38605182927e-07 0.85 3.38636941057e-07 0.952512626585 3.38668699187e-07 1.2 3.38700457317e-07 1.44748737342 3.38732215447e-07 1.55 3.38763973577e-07 1.44748737342 3.38795731707e-07 1.2 3.38827489837e-07 0.952512626585 3.38859247967e-07 0.85 3.38891006098e-07 0.952512626585 3.38922764228e-07 1.2 3.38954522358e-07 1.44748737342 3.38986280488e-07 1.55 3.39018038618e-07 1.44748737342 3.39049796748e-07 1.2 3.39081554878e-07 0.952512626585 3.39113313008e-07 0.85 3.39145071138e-07 0.952512626584 3.39176829268e-07 1.2 3.39208587398e-07 1.44748737342 3.39240345528e-07 1.55 3.39272103659e-07 1.44748737342 3.39303861789e-07 1.2 3.39335619919e-07 0.952512626585 3.39367378049e-07 0.85 3.39399136179e-07 0.952512626585 3.39430894309e-07 1.2 3.39462652439e-07 1.44748737342 3.39494410569e-07 1.55 3.39526168699e-07 1.44748737342 3.39557926829e-07 1.2 3.39589684959e-07 0.952512626585 3.39621443089e-07 0.85 3.3965320122e-07 0.952512626585 3.3968495935e-07 1.2 3.3971671748e-07 1.44748737342 3.3974847561e-07 1.55 3.3978023374e-07 1.44748737342 3.3981199187e-07 1.2 3.3984375e-07 0.952512626585 3.3987550813e-07 0.85 3.3990726626e-07 0.952512626585 3.3993902439e-07 1.2 3.3997078252e-07 1.44748737342 3.4000254065e-07 1.55 3.4003429878e-07 1.44748737342 3.40066056911e-07 1.2 3.40097815041e-07 0.952512626585 3.40129573171e-07 0.85 3.40161331301e-07 0.952512626585 3.40193089431e-07 1.2 3.40224847561e-07 1.44748737342 3.40256605691e-07 1.55 3.40288363821e-07 1.44748737342 3.40320121951e-07 1.2 3.40351880081e-07 0.952512626585 3.40383638211e-07 0.85 3.40415396341e-07 0.952512626584 3.40447154472e-07 1.2 3.40478912602e-07 1.44748737342 3.40510670732e-07 1.55 3.40542428862e-07 1.44748737342 3.40574186992e-07 1.2 3.40605945122e-07 0.952512626585 3.40637703252e-07 0.85 3.40669461382e-07 0.952512626585 3.40701219512e-07 1.2 3.40732977642e-07 1.44748737342 3.40764735772e-07 1.55 3.40796493902e-07 1.44748737342 3.40828252033e-07 1.2 3.40860010163e-07 0.952512626585 3.40891768293e-07 0.85 3.40923526423e-07 0.952512626585 3.40955284553e-07 1.2 3.40987042683e-07 1.44748737342 3.41018800813e-07 1.55 3.41050558943e-07 1.44748737342 3.41082317073e-07 1.2 3.41114075203e-07 0.952512626585 3.41145833333e-07 0.85 3.41177591463e-07 0.952512626585 3.41209349593e-07 1.2 3.41241107724e-07 1.44748737342 3.41272865854e-07 1.55 3.41304623984e-07 1.44748737342 3.41336382114e-07 1.2 3.41368140244e-07 0.952512626585 3.41399898374e-07 0.85 3.41431656504e-07 0.952512626585 3.41463414634e-07 1.2 3.41495172764e-07 1.44748737342 3.41526930894e-07 1.55 3.41558689024e-07 1.44748737342 3.41590447154e-07 1.2 3.41622205285e-07 0.952512626584 3.41653963415e-07 0.85 3.41685721545e-07 0.952512626585 3.41717479675e-07 1.2 3.41749237805e-07 1.44748737342 3.41780995935e-07 1.55 3.41812754065e-07 1.44748737342 3.41844512195e-07 1.2 3.41876270325e-07 0.952512626585 3.41908028455e-07 0.85 3.41939786585e-07 0.952512626585 3.41971544715e-07 1.2 3.42003302846e-07 1.44748737342 3.42035060976e-07 1.55 3.42066819106e-07 1.44748737342 3.42098577236e-07 1.2 3.42130335366e-07 0.952512626585 3.42162093496e-07 0.85 3.42193851626e-07 0.952512626585 3.42225609756e-07 1.2 3.42257367886e-07 1.44748737342 3.42289126016e-07 1.55 3.42320884146e-07 1.44748737342 3.42352642276e-07 1.2 3.42384400407e-07 0.952512626585 3.42416158537e-07 0.85 3.42447916667e-07 0.952512626585 3.42479674797e-07 1.2 3.42511432927e-07 1.44748737342 3.42543191057e-07 1.55 3.42574949187e-07 1.44748737342 3.42606707317e-07 1.2 3.42638465447e-07 0.952512626585 3.42670223577e-07 0.85 3.42701981707e-07 0.952512626585 3.42733739837e-07 1.2 3.42765497967e-07 1.44748737342 3.42797256098e-07 1.55 3.42829014228e-07 1.44748737342 3.42860772358e-07 1.2 3.42892530488e-07 0.952512626585 3.42924288618e-07 0.85 3.42956046748e-07 0.952512626585 3.42987804878e-07 1.2 3.43019563008e-07 1.44748737342 3.43051321138e-07 1.55 3.43083079268e-07 1.44748737342 3.43114837398e-07 1.2 3.43146595528e-07 0.952512626585 3.43178353659e-07 0.85 3.43210111789e-07 0.952512626585 3.43241869919e-07 1.2 3.43273628049e-07 1.44748737342 3.43305386179e-07 1.55 3.43337144309e-07 1.44748737342 3.43368902439e-07 1.2 3.43400660569e-07 0.952512626585 3.43432418699e-07 0.85 3.43464176829e-07 0.952512626585 3.43495934959e-07 1.2 3.43527693089e-07 1.44748737342 3.4355945122e-07 1.55 3.4359120935e-07 1.44748737342 3.4362296748e-07 1.2 3.4365472561e-07 0.952512626585 3.4368648374e-07 0.85 3.4371824187e-07 0.952512626585 3.4375e-07 1.2 3.4378175813e-07 1.44748737342 3.4381351626e-07 1.55 3.4384527439e-07 1.44748737342 3.4387703252e-07 1.2 3.4390879065e-07 0.952512626585 3.4394054878e-07 0.85 3.43972306911e-07 0.952512626584 3.44004065041e-07 1.2 3.44035823171e-07 1.44748737342 3.44067581301e-07 1.55 3.44099339431e-07 1.44748737342 3.44131097561e-07 1.2 3.44162855691e-07 0.952512626585 3.44194613821e-07 0.85 3.44226371951e-07 0.952512626585 3.44258130081e-07 1.2 3.44289888211e-07 1.44748737342 3.44321646341e-07 1.55 3.44353404472e-07 1.44748737342 3.44385162602e-07 1.2 3.44416920732e-07 0.952512626585 3.44448678862e-07 0.85 3.44480436992e-07 0.952512626585 3.44512195122e-07 1.2 3.44543953252e-07 1.44748737342 3.44575711382e-07 1.55 3.44607469512e-07 1.44748737342 3.44639227642e-07 1.2 3.44670985772e-07 0.952512626585 3.44702743902e-07 0.85 3.44734502033e-07 0.952512626584 3.44766260163e-07 1.2 3.44798018293e-07 1.44748737342 3.44829776423e-07 1.55 3.44861534553e-07 1.44748737342 3.44893292683e-07 1.2 3.44925050813e-07 0.952512626585 3.44956808943e-07 0.85 3.44988567073e-07 0.952512626585 3.45020325203e-07 1.2 3.45052083333e-07 1.44748737342 3.45083841463e-07 1.55 3.45115599593e-07 1.44748737342 3.45147357724e-07 1.2 3.45179115854e-07 0.952512626585 3.45210873984e-07 0.85 3.45242632114e-07 0.952512626585 3.45274390244e-07 1.2 3.45306148374e-07 1.44748737342 3.45337906504e-07 1.55 3.45369664634e-07 1.44748737342 3.45401422764e-07 1.2 3.45433180894e-07 0.952512626585 3.45464939024e-07 0.85 3.45496697154e-07 0.952512626585 3.45528455285e-07 1.2 3.45560213415e-07 1.44748737342 3.45591971545e-07 1.55 3.45623729675e-07 1.44748737341 3.45655487805e-07 1.2 3.45687245935e-07 0.952512626585 3.45719004065e-07 0.85 3.45750762195e-07 0.952512626585 3.45782520325e-07 1.2 3.45814278455e-07 1.44748737342 3.45846036585e-07 1.55 3.45877794715e-07 1.44748737342 3.45909552846e-07 1.2 3.45941310976e-07 0.952512626585 3.45973069106e-07 0.85 3.46004827236e-07 0.952512626585 3.46036585366e-07 1.2 3.46068343496e-07 1.44748737342 3.46100101626e-07 1.55 3.46131859756e-07 1.44748737342 3.46163617886e-07 1.2 3.46195376016e-07 0.952512626585 3.46227134146e-07 0.85 3.46258892276e-07 0.952512626585 3.46290650407e-07 1.2 3.46322408537e-07 1.44748737342 3.46354166667e-07 1.55 3.46385924797e-07 1.44748737342 3.46417682927e-07 1.2 3.46449441057e-07 0.952512626585 3.46481199187e-07 0.85 3.46512957317e-07 0.952512626585 3.46544715447e-07 1.2 3.46576473577e-07 1.44748737342 3.46608231707e-07 1.55 3.46639989837e-07 1.44748737342 3.46671747967e-07 1.2 3.46703506098e-07 0.952512626585 3.46735264228e-07 0.85 3.46767022358e-07 0.952512626585 3.46798780488e-07 1.2 3.46830538618e-07 1.44748737342 3.46862296748e-07 1.55 3.46894054878e-07 1.44748737342 3.46925813008e-07 1.2 3.46957571138e-07 0.952512626585 3.46989329268e-07 0.85 3.47021087398e-07 0.952512626585 3.47052845528e-07 1.2 3.47084603659e-07 1.44748737342 3.47116361789e-07 1.55 3.47148119919e-07 1.44748737342 3.47179878049e-07 1.2 3.47211636179e-07 0.952512626585 3.47243394309e-07 0.85 3.47275152439e-07 0.952512626585 3.47306910569e-07 1.2 3.47338668699e-07 1.44748737342 3.47370426829e-07 1.55 3.47402184959e-07 1.44748737342 3.47433943089e-07 1.2 3.4746570122e-07 0.952512626585 3.4749745935e-07 0.85 3.4752921748e-07 0.952512626584 3.4756097561e-07 1.2 3.4759273374e-07 1.44748737342 3.4762449187e-07 1.55 3.4765625e-07 1.44748737342 3.4768800813e-07 1.2 3.4771976626e-07 0.952512626585 3.4775152439e-07 0.85 3.4778328252e-07 0.952512626585 3.4781504065e-07 1.2 3.4784679878e-07 1.44748737342 3.47878556911e-07 1.55 3.47910315041e-07 1.44748737342 3.47942073171e-07 1.2 3.47973831301e-07 0.952512626585 3.48005589431e-07 0.85 3.48037347561e-07 0.952512626584 3.48069105691e-07 1.2 3.48100863821e-07 1.44748737342 3.48132621951e-07 1.55 3.48164380081e-07 1.44748737342 3.48196138211e-07 1.2 3.48227896341e-07 0.952512626585 3.48259654472e-07 0.85 3.48291412602e-07 0.952512626585 3.48323170732e-07 1.2 3.48354928862e-07 1.44748737341 3.48386686992e-07 1.55 3.48418445122e-07 1.44748737342 3.48450203252e-07 1.2 3.48481961382e-07 0.952512626585 3.48513719512e-07 0.85 3.48545477642e-07 0.952512626585 3.48577235772e-07 1.2 3.48608993902e-07 1.44748737342 3.48640752033e-07 1.55 3.48672510163e-07 1.44748737342 3.48704268293e-07 1.2 3.48736026423e-07 0.952512626585 3.48767784553e-07 0.85 3.48799542683e-07 0.952512626585 3.48831300813e-07 1.2 3.48863058943e-07 1.44748737342 3.48894817073e-07 1.55 3.48926575203e-07 1.44748737342 3.48958333333e-07 1.2 3.48990091463e-07 0.952512626585 3.49021849593e-07 0.85 3.49053607724e-07 0.952512626585 3.49085365854e-07 1.2 3.49117123984e-07 1.44748737342 3.49148882114e-07 1.55 3.49180640244e-07 1.44748737342 3.49212398374e-07 1.2 3.49244156504e-07 0.952512626585 3.49275914634e-07 0.85 3.49307672764e-07 0.952512626585 3.49339430894e-07 1.2 3.49371189024e-07 1.44748737342 3.49402947154e-07 1.55 3.49434705285e-07 1.44748737342 3.49466463415e-07 1.2 3.49498221545e-07 0.952512626585 3.49529979675e-07 0.85 3.49561737805e-07 0.952512626585 3.49593495935e-07 1.2 3.49625254065e-07 1.44748737342 3.49657012195e-07 1.55 3.49688770325e-07 1.44748737342 3.49720528455e-07 1.2 3.49752286585e-07 0.952512626585 3.49784044715e-07 0.85 3.49815802846e-07 0.952512626585 3.49847560976e-07 1.2 3.49879319106e-07 1.44748737342 3.49911077236e-07 1.55 3.49942835366e-07 1.44748737342 3.49974593496e-07 1.2 3.50006351626e-07 0.952512626584 3.50038109756e-07 0.85 3.50069867886e-07 0.952512626585 3.50101626016e-07 1.2 3.50133384146e-07 1.44748737342 3.50165142276e-07 1.55 3.50196900407e-07 1.44748737342 3.50228658537e-07 1.2 3.50260416667e-07 0.952512626585 3.50292174797e-07 0.85 3.50323932927e-07 0.952512626585 3.50355691057e-07 1.2 3.50387449187e-07 1.44748737342 3.50419207317e-07 1.55 3.50450965447e-07 1.44748737342 3.50482723577e-07 1.2 3.50514481707e-07 0.952512626585 3.50546239837e-07 0.85 3.50577997967e-07 0.952512626585 3.50609756098e-07 1.2 3.50641514228e-07 1.44748737342 3.50673272358e-07 1.55 3.50705030488e-07 1.44748737342 3.50736788618e-07 1.2 3.50768546748e-07 0.952512626585 3.50800304878e-07 0.85 3.50832063008e-07 0.952512626585 3.50863821138e-07 1.2 3.50895579268e-07 1.44748737342 3.50927337398e-07 1.55 3.50959095528e-07 1.44748737342 3.50990853659e-07 1.2 3.51022611789e-07 0.952512626585 3.51054369919e-07 0.85 3.51086128049e-07 0.952512626585 3.51117886179e-07 1.2 3.51149644309e-07 1.44748737342 3.51181402439e-07 1.55 3.51213160569e-07 1.44748737342 3.51244918699e-07 1.2 3.51276676829e-07 0.952512626585 3.51308434959e-07 0.85 3.51340193089e-07 0.952512626585 3.5137195122e-07 1.2 3.5140370935e-07 1.44748737342 3.5143546748e-07 1.55 3.5146722561e-07 1.44748737342 3.5149898374e-07 1.2 3.5153074187e-07 0.952512626585 3.515625e-07 0.85 3.5159425813e-07 0.952512626585 3.5162601626e-07 1.2 3.5165777439e-07 1.44748737342 3.5168953252e-07 1.55 3.5172129065e-07 1.44748737342 3.5175304878e-07 1.2 3.51784806911e-07 0.952512626585 3.51816565041e-07 0.85 3.51848323171e-07 0.952512626585 3.51880081301e-07 1.2 3.51911839431e-07 1.44748737341 3.51943597561e-07 1.55 3.51975355691e-07 1.44748737342 3.52007113821e-07 1.2 3.52038871951e-07 0.952512626585 3.52070630081e-07 0.85 3.52102388211e-07 0.952512626585 3.52134146341e-07 1.2 3.52165904472e-07 1.44748737342 3.52197662602e-07 1.55 3.52229420732e-07 1.44748737342 3.52261178862e-07 1.2 3.52292936992e-07 0.952512626585 3.52324695122e-07 0.85 3.52356453252e-07 0.952512626584 3.52388211382e-07 1.2 3.52419969512e-07 1.44748737342 3.52451727642e-07 1.55 3.52483485772e-07 1.44748737342 3.52515243902e-07 1.2 3.52547002033e-07 0.952512626585 3.52578760163e-07 0.85 3.52610518293e-07 0.952512626585 3.52642276423e-07 1.2 3.52674034553e-07 1.44748737341 3.52705792683e-07 1.55 3.52737550813e-07 1.44748737342 3.52769308943e-07 1.2 3.52801067073e-07 0.952512626585 3.52832825203e-07 0.85 3.52864583333e-07 0.952512626585 3.52896341463e-07 1.2 3.52928099593e-07 1.44748737342 3.52959857724e-07 1.55 3.52991615854e-07 1.44748737342 3.53023373984e-07 1.2 3.53055132114e-07 0.952512626585 3.53086890244e-07 0.85 3.53118648374e-07 0.952512626585 3.53150406504e-07 1.2 3.53182164634e-07 1.44748737342 3.53213922764e-07 1.55 3.53245680894e-07 1.44748737342 3.53277439024e-07 1.2 3.53309197154e-07 0.952512626585 3.53340955285e-07 0.85 3.53372713415e-07 0.952512626585 3.53404471545e-07 1.2 3.53436229675e-07 1.44748737342 3.53467987805e-07 1.55 3.53499745935e-07 1.44748737342 3.53531504065e-07 1.2 3.53563262195e-07 0.952512626584 3.53595020325e-07 0.85 3.53626778455e-07 0.952512626585 3.53658536585e-07 1.2 3.53690294715e-07 1.44748737342 3.53722052846e-07 1.55 3.53753810976e-07 1.44748737342 3.53785569106e-07 1.2 3.53817327236e-07 0.952512626585 3.53849085366e-07 0.85 3.53880843496e-07 0.952512626585 3.53912601626e-07 1.2 3.53944359756e-07 1.44748737342 3.53976117886e-07 1.55 3.54007876016e-07 1.44748737342 3.54039634146e-07 1.2 3.54071392276e-07 0.952512626585 3.54103150407e-07 0.85 3.54134908537e-07 0.952512626585 3.54166666667e-07 1.2 3.54198424797e-07 1.44748737342 3.54230182927e-07 1.55 3.54261941057e-07 1.44748737342 3.54293699187e-07 1.2 3.54325457317e-07 0.952512626585 3.54357215447e-07 0.85 3.54388973577e-07 0.952512626585 3.54420731707e-07 1.2 3.54452489837e-07 1.44748737342 3.54484247967e-07 1.55 3.54516006098e-07 1.44748737342 3.54547764228e-07 1.2 3.54579522358e-07 0.952512626585 3.54611280488e-07 0.85 3.54643038618e-07 0.952512626585 3.54674796748e-07 1.2 3.54706554878e-07 1.44748737342 3.54738313008e-07 1.55 3.54770071138e-07 1.44748737342 3.54801829268e-07 1.2 3.54833587398e-07 0.952512626585 3.54865345528e-07 0.85 3.54897103659e-07 0.952512626585 3.54928861789e-07 1.2 3.54960619919e-07 1.44748737342 3.54992378049e-07 1.55 3.55024136179e-07 1.44748737342 3.55055894309e-07 1.2 3.55087652439e-07 0.952512626585 3.55119410569e-07 0.85 3.55151168699e-07 0.952512626585 3.55182926829e-07 1.2 3.55214684959e-07 1.44748737342 3.55246443089e-07 1.55 3.5527820122e-07 1.44748737342 3.5530995935e-07 1.2 3.5534171748e-07 0.952512626585 3.5537347561e-07 0.85 3.5540523374e-07 0.952512626585 3.5543699187e-07 1.2 3.5546875e-07 1.44748737342 3.5550050813e-07 1.55 3.5553226626e-07 1.44748737342 3.5556402439e-07 1.2 3.5559578252e-07 0.952512626585 3.5562754065e-07 0.85 3.5565929878e-07 0.952512626585 3.55691056911e-07 1.2 3.55722815041e-07 1.44748737342 3.55754573171e-07 1.55 3.55786331301e-07 1.44748737342 3.55818089431e-07 1.2 3.55849847561e-07 0.952512626585 3.55881605691e-07 0.85 3.55913363821e-07 0.952512626584 3.55945121951e-07 1.2 3.55976880081e-07 1.44748737342 3.56008638211e-07 1.55 3.56040396341e-07 1.44748737342 3.56072154472e-07 1.2 3.56103912602e-07 0.952512626585 3.56135670732e-07 0.85 3.56167428862e-07 0.952512626585 3.56199186992e-07 1.2 3.56230945122e-07 1.44748737342 3.56262703252e-07 1.55 3.56294461382e-07 1.44748737342 3.56326219512e-07 1.2 3.56357977642e-07 0.952512626585 3.56389735772e-07 0.85 3.56421493902e-07 0.952512626584 3.56453252033e-07 1.2 3.56485010163e-07 1.44748737342 3.56516768293e-07 1.55 3.56548526423e-07 1.44748737342 3.56580284553e-07 1.2 3.56612042683e-07 0.952512626585 3.56643800813e-07 0.85 3.56675558943e-07 0.952512626585 3.56707317073e-07 1.2 3.56739075203e-07 1.44748737342 3.56770833333e-07 1.55 3.56802591463e-07 1.44748737342 3.56834349593e-07 1.2 3.56866107724e-07 0.952512626585 3.56897865854e-07 0.85 3.56929623984e-07 0.952512626585 3.56961382114e-07 1.2 3.56993140244e-07 1.44748737342 3.57024898374e-07 1.55 3.57056656504e-07 1.44748737342 3.57088414634e-07 1.2 3.57120172764e-07 0.952512626585 3.57151930894e-07 0.85 3.57183689024e-07 0.952512626585 3.57215447154e-07 1.2 3.57247205285e-07 1.44748737342 3.57278963415e-07 1.55 3.57310721545e-07 1.44748737342 3.57342479675e-07 1.2 3.57374237805e-07 0.952512626585 3.57405995935e-07 0.85 3.57437754065e-07 0.952512626585 3.57469512195e-07 1.2 3.57501270325e-07 1.44748737342 3.57533028455e-07 1.55 3.57564786585e-07 1.44748737342 3.57596544715e-07 1.2 3.57628302846e-07 0.952512626585 3.57660060976e-07 0.85 3.57691819106e-07 0.952512626585 3.57723577236e-07 1.2 3.57755335366e-07 1.44748737342 3.57787093496e-07 1.55 3.57818851626e-07 1.44748737342 3.57850609756e-07 1.2 3.57882367886e-07 0.952512626585 3.57914126016e-07 0.85 3.57945884146e-07 0.952512626585 3.57977642276e-07 1.2 3.58009400407e-07 1.44748737342 3.58041158537e-07 1.55 3.58072916667e-07 1.44748737342 3.58104674797e-07 1.2 3.58136432927e-07 0.952512626585 3.58168191057e-07 0.85 3.58199949187e-07 0.952512626585 3.58231707317e-07 1.2 3.58263465447e-07 1.44748737342 3.58295223577e-07 1.55 3.58326981707e-07 1.44748737342 3.58358739837e-07 1.2 3.58390497967e-07 0.952512626584 3.58422256098e-07 0.85 3.58454014228e-07 0.952512626585 3.58485772358e-07 1.2 3.58517530488e-07 1.44748737342 3.58549288618e-07 1.55 3.58581046748e-07 1.44748737342 3.58612804878e-07 1.2 3.58644563008e-07 0.952512626585 3.58676321138e-07 0.85 3.58708079268e-07 0.952512626585 3.58739837398e-07 1.2 3.58771595528e-07 1.44748737342 3.58803353659e-07 1.55 3.58835111789e-07 1.44748737342 3.58866869919e-07 1.2 3.58898628049e-07 0.952512626585 3.58930386179e-07 0.85 3.58962144309e-07 0.952512626585 3.58993902439e-07 1.2 3.59025660569e-07 1.44748737342 3.59057418699e-07 1.55 3.59089176829e-07 1.44748737342 3.59120934959e-07 1.2 3.59152693089e-07 0.952512626585 3.5918445122e-07 0.85 3.5921620935e-07 0.952512626585 3.5924796748e-07 1.2 3.5927972561e-07 1.44748737342 3.5931148374e-07 1.55 3.5934324187e-07 1.44748737342 3.59375e-07 1.2 3.5940675813e-07 0.952512626585 3.5943851626e-07 0.85 3.5947027439e-07 0.952512626585 3.5950203252e-07 1.2 3.5953379065e-07 1.44748737342 3.5956554878e-07 1.55 3.59597306911e-07 1.44748737342 3.59629065041e-07 1.2 3.59660823171e-07 0.952512626585 3.59692581301e-07 0.85 3.59724339431e-07 0.952512626585 3.59756097561e-07 1.2 3.59787855691e-07 1.44748737342 3.59819613821e-07 1.55 3.59851371951e-07 1.44748737342 3.59883130081e-07 1.2 3.59914888211e-07 0.952512626585 3.59946646341e-07 0.85 3.59978404472e-07 0.952512626584 3.60010162602e-07 1.2 3.60041920732e-07 1.44748737342 3.60073678862e-07 1.55 3.60105436992e-07 1.44748737342 3.60137195122e-07 1.2 3.60168953252e-07 0.952512626585 3.60200711382e-07 0.85 3.60232469512e-07 0.952512626585 3.60264227642e-07 1.2 3.60295985772e-07 1.44748737341 3.60327743902e-07 1.55 3.60359502033e-07 1.44748737342 3.60391260163e-07 1.2 3.60423018293e-07 0.952512626585 3.60454776423e-07 0.85 3.60486534553e-07 0.952512626585 3.60518292683e-07 1.2 3.60550050813e-07 1.44748737342 3.60581808943e-07 1.55 3.60613567073e-07 1.44748737342 3.60645325203e-07 1.2 3.60677083333e-07 0.952512626585 3.60708841463e-07 0.85 3.60740599593e-07 0.952512626584 3.60772357724e-07 1.2 3.60804115854e-07 1.44748737342 3.60835873984e-07 1.55 3.60867632114e-07 1.44748737342 3.60899390244e-07 1.2 3.60931148374e-07 0.952512626585 3.60962906504e-07 0.85 3.60994664634e-07 0.952512626585 3.61026422764e-07 1.2 3.61058180894e-07 1.44748737342 3.61089939024e-07 1.55 3.61121697154e-07 1.44748737342 3.61153455285e-07 1.2 3.61185213415e-07 0.952512626585 3.61216971545e-07 0.85 3.61248729675e-07 0.952512626585 3.61280487805e-07 1.2 3.61312245935e-07 1.44748737342 3.61344004065e-07 1.55 3.61375762195e-07 1.44748737342 3.61407520325e-07 1.2 3.61439278455e-07 0.952512626585 3.61471036585e-07 0.85 3.61502794715e-07 0.952512626585 3.61534552846e-07 1.2 3.61566310976e-07 1.44748737342 3.61598069106e-07 1.55 3.61629827236e-07 1.44748737342 3.61661585366e-07 1.2 3.61693343496e-07 0.952512626585 3.61725101626e-07 0.85 3.61756859756e-07 0.952512626585 3.61788617886e-07 1.2 3.61820376016e-07 1.44748737342 3.61852134146e-07 1.55 3.61883892276e-07 1.44748737342 3.61915650407e-07 1.2 3.61947408537e-07 0.952512626584 3.61979166667e-07 0.85 3.62010924797e-07 0.952512626585 3.62042682927e-07 1.2 3.62074441057e-07 1.44748737342 3.62106199187e-07 1.55 3.62137957317e-07 1.44748737342 3.62169715447e-07 1.2 3.62201473577e-07 0.952512626585 3.62233231707e-07 0.85 3.62264989837e-07 0.952512626585 3.62296747967e-07 1.2 3.62328506098e-07 1.44748737342 3.62360264228e-07 1.55 3.62392022358e-07 1.44748737342 3.62423780488e-07 1.2 3.62455538618e-07 0.952512626585 3.62487296748e-07 0.85 3.62519054878e-07 0.952512626585 3.62550813008e-07 1.2 3.62582571138e-07 1.44748737342 3.62614329268e-07 1.55 3.62646087398e-07 1.44748737342 3.62677845528e-07 1.2 3.62709603659e-07 0.952512626585 3.62741361789e-07 0.85 3.62773119919e-07 0.952512626585 3.62804878049e-07 1.2 3.62836636179e-07 1.44748737342 3.62868394309e-07 1.55 3.62900152439e-07 1.44748737342 3.62931910569e-07 1.2 3.62963668699e-07 0.952512626585 3.62995426829e-07 0.85 3.63027184959e-07 0.952512626585 3.63058943089e-07 1.2 3.6309070122e-07 1.44748737342 3.6312245935e-07 1.55 3.6315421748e-07 1.44748737342 3.6318597561e-07 1.2 3.6321773374e-07 0.952512626585 3.6324949187e-07 0.85 3.6328125e-07 0.952512626585 3.6331300813e-07 1.2 3.6334476626e-07 1.44748737342 3.6337652439e-07 1.55 3.6340828252e-07 1.44748737342 3.6344004065e-07 1.2 3.6347179878e-07 0.952512626585 3.63503556911e-07 0.85 3.63535315041e-07 0.952512626585 3.63567073171e-07 1.2 3.63598831301e-07 1.44748737342 3.63630589431e-07 1.55 3.63662347561e-07 1.44748737342 3.63694105691e-07 1.2 3.63725863821e-07 0.952512626585 3.63757621951e-07 0.85 3.63789380081e-07 0.952512626585 3.63821138211e-07 1.2 3.63852896341e-07 1.44748737341 3.63884654472e-07 1.55 3.63916412602e-07 1.44748737342 3.63948170732e-07 1.2 3.63979928862e-07 0.952512626585 3.64011686992e-07 0.85 3.64043445122e-07 0.952512626585 3.64075203252e-07 1.2 3.64106961382e-07 1.44748737342 3.64138719512e-07 1.55 3.64170477642e-07 1.44748737342 3.64202235772e-07 1.2 3.64233993902e-07 0.952512626585 3.64265752033e-07 0.85 3.64297510163e-07 0.952512626584 3.64329268293e-07 1.2 3.64361026423e-07 1.44748737342 3.64392784553e-07 1.55 3.64424542683e-07 1.44748737342 3.64456300813e-07 1.2 3.64488058943e-07 0.952512626585 3.64519817073e-07 0.85 3.64551575203e-07 0.952512626585 3.64583333333e-07 1.2 3.64615091463e-07 1.44748737342 3.64646849593e-07 1.55 3.64678607724e-07 1.44748737342 3.64710365854e-07 1.2 3.64742123984e-07 0.952512626585 3.64773882114e-07 0.85 3.64805640244e-07 0.952512626585 3.64837398374e-07 1.2 3.64869156504e-07 1.44748737342 3.64900914634e-07 1.55 3.64932672764e-07 1.44748737342 3.64964430894e-07 1.2 3.64996189024e-07 0.952512626585 3.65027947154e-07 0.85 3.65059705285e-07 0.952512626585 3.65091463415e-07 1.2 3.65123221545e-07 1.44748737342 3.65154979675e-07 1.55 3.65186737805e-07 1.44748737342 3.65218495935e-07 1.2 3.65250254065e-07 0.952512626585 3.65282012195e-07 0.85 3.65313770325e-07 0.952512626585 3.65345528455e-07 1.2 3.65377286585e-07 1.44748737342 3.65409044715e-07 1.55 3.65440802846e-07 1.44748737342 3.65472560976e-07 1.2 3.65504319106e-07 0.952512626585 3.65536077236e-07 0.85 3.65567835366e-07 0.952512626585 3.65599593496e-07 1.2 3.65631351626e-07 1.44748737342 3.65663109756e-07 1.55 3.65694867886e-07 1.44748737342 3.65726626016e-07 1.2 3.65758384146e-07 0.952512626585 3.65790142276e-07 0.85 3.65821900407e-07 0.952512626585 3.65853658537e-07 1.2 3.65885416667e-07 1.44748737342 3.65917174797e-07 1.55 3.65948932927e-07 1.44748737342 3.65980691057e-07 1.2 3.66012449187e-07 0.952512626585 3.66044207317e-07 0.85 3.66075965447e-07 0.952512626585 3.66107723577e-07 1.2 3.66139481707e-07 1.44748737342 3.66171239837e-07 1.55 3.66202997967e-07 1.44748737342 3.66234756098e-07 1.2 3.66266514228e-07 0.952512626585 3.66298272358e-07 0.85 3.66330030488e-07 0.952512626585 3.66361788618e-07 1.2 3.66393546748e-07 1.44748737342 3.66425304878e-07 1.55 3.66457063008e-07 1.44748737342 3.66488821138e-07 1.2 3.66520579268e-07 0.952512626585 3.66552337398e-07 0.85 3.66584095528e-07 0.952512626585 3.66615853659e-07 1.2 3.66647611789e-07 1.44748737342 3.66679369919e-07 1.55 3.66711128049e-07 1.44748737342 3.66742886179e-07 1.2 3.66774644309e-07 0.952512626584 3.66806402439e-07 0.85 3.66838160569e-07 0.952512626585 3.66869918699e-07 1.2 3.66901676829e-07 1.44748737342 3.66933434959e-07 1.55 3.66965193089e-07 1.44748737342 3.6699695122e-07 1.2 3.6702870935e-07 0.952512626585 3.6706046748e-07 0.85 3.6709222561e-07 0.952512626585 3.6712398374e-07 1.2 3.6715574187e-07 1.44748737342 3.671875e-07 1.55 3.6721925813e-07 1.44748737342 3.6725101626e-07 1.2 3.6728277439e-07 0.952512626585 3.6731453252e-07 0.85 3.6734629065e-07 0.952512626585 3.6737804878e-07 1.2 3.67409806911e-07 1.44748737342 3.67441565041e-07 1.55 3.67473323171e-07 1.44748737342 3.67505081301e-07 1.2 3.67536839431e-07 0.952512626585 3.67568597561e-07 0.85 3.67600355691e-07 0.952512626585 3.67632113821e-07 1.2 3.67663871951e-07 1.44748737342 3.67695630081e-07 1.55 3.67727388211e-07 1.44748737342 3.67759146341e-07 1.2 3.67790904472e-07 0.952512626585 3.67822662602e-07 0.85 3.67854420732e-07 0.952512626585 3.67886178862e-07 1.2 3.67917936992e-07 1.44748737342 3.67949695122e-07 1.55 3.67981453252e-07 1.44748737342 3.68013211382e-07 1.2 3.68044969512e-07 0.952512626585 3.68076727642e-07 0.85 3.68108485772e-07 0.952512626585 3.68140243902e-07 1.2 3.68172002033e-07 1.44748737342 3.68203760163e-07 1.55 3.68235518293e-07 1.44748737342 3.68267276423e-07 1.2 3.68299034553e-07 0.952512626585 3.68330792683e-07 0.85 3.68362550813e-07 0.952512626584 3.68394308943e-07 1.2 3.68426067073e-07 1.44748737342 3.68457825203e-07 1.55 3.68489583333e-07 1.44748737342 3.68521341463e-07 1.2 3.68553099593e-07 0.952512626585 3.68584857724e-07 0.85 3.68616615854e-07 0.952512626585 3.68648373984e-07 1.2 3.68680132114e-07 1.44748737341 3.68711890244e-07 1.55 3.68743648374e-07 1.44748737342 3.68775406504e-07 1.2 3.68807164634e-07 0.952512626585 3.68838922764e-07 0.85 3.68870680894e-07 0.952512626585 3.68902439024e-07 1.2 3.68934197154e-07 1.44748737342 3.68965955285e-07 1.55 3.68997713415e-07 1.44748737342 3.69029471545e-07 1.2 3.69061229675e-07 0.952512626585 3.69092987805e-07 0.85 3.69124745935e-07 0.952512626585 3.69156504065e-07 1.2 3.69188262195e-07 1.44748737342 3.69220020325e-07 1.55 3.69251778455e-07 1.44748737342 3.69283536585e-07 1.2 3.69315294715e-07 0.952512626585 3.69347052846e-07 0.85 3.69378810976e-07 0.952512626585 3.69410569106e-07 1.2 3.69442327236e-07 1.44748737342 3.69474085366e-07 1.55 3.69505843496e-07 1.44748737342 3.69537601626e-07 1.2 3.69569359756e-07 0.952512626584 3.69601117886e-07 0.85 3.69632876016e-07 0.952512626585 3.69664634146e-07 1.2 3.69696392276e-07 1.44748737342 3.69728150407e-07 1.55 3.69759908537e-07 1.44748737342 3.69791666667e-07 1.2 3.69823424797e-07 0.952512626585 3.69855182927e-07 0.85 3.69886941057e-07 0.952512626585 3.69918699187e-07 1.2 3.69950457317e-07 1.44748737342 3.69982215447e-07 1.55 3.70013973577e-07 1.44748737342 3.70045731707e-07 1.2 3.70077489837e-07 0.952512626585 3.70109247967e-07 0.85 3.70141006098e-07 0.952512626585 3.70172764228e-07 1.2 3.70204522358e-07 1.44748737342 3.70236280488e-07 1.55 3.70268038618e-07 1.44748737342 3.70299796748e-07 1.2 3.70331554878e-07 0.952512626584 3.70363313008e-07 0.85 3.70395071138e-07 0.952512626585 3.70426829268e-07 1.2 3.70458587398e-07 1.44748737342 3.70490345528e-07 1.55 3.70522103659e-07 1.44748737342 3.70553861789e-07 1.2 3.70585619919e-07 0.952512626585 3.70617378049e-07 0.85 3.70649136179e-07 0.952512626585 3.70680894309e-07 1.2 3.70712652439e-07 1.44748737342 3.70744410569e-07 1.55 3.70776168699e-07 1.44748737342 3.70807926829e-07 1.2 3.70839684959e-07 0.952512626585 3.70871443089e-07 0.85 3.7090320122e-07 0.952512626585 3.7093495935e-07 1.2 3.7096671748e-07 1.44748737342 3.7099847561e-07 1.55 3.7103023374e-07 1.44748737342 3.7106199187e-07 1.2 3.7109375e-07 0.952512626585 3.7112550813e-07 0.85 3.7115726626e-07 0.952512626585 3.7118902439e-07 1.2 3.7122078252e-07 1.44748737342 3.7125254065e-07 1.55 3.7128429878e-07 1.44748737342 3.71316056911e-07 1.2 3.71347815041e-07 0.952512626585 3.71379573171e-07 0.85 3.71411331301e-07 0.952512626585 3.71443089431e-07 1.2 3.71474847561e-07 1.44748737342 3.71506605691e-07 1.55 3.71538363821e-07 1.44748737342 3.71570121951e-07 1.2 3.71601880081e-07 0.952512626585 3.71633638211e-07 0.85 3.71665396341e-07 0.952512626585 3.71697154472e-07 1.2 3.71728912602e-07 1.44748737342 3.71760670732e-07 1.55 3.71792428862e-07 1.44748737342 3.71824186992e-07 1.2 3.71855945122e-07 0.952512626585 3.71887703252e-07 0.85 3.71919461382e-07 0.952512626584 3.71951219512e-07 1.2 3.71982977642e-07 1.44748737342 3.72014735772e-07 1.55 3.72046493902e-07 1.44748737342 3.72078252033e-07 1.2 3.72110010163e-07 0.952512626585 3.72141768293e-07 0.85 3.72173526423e-07 0.952512626585 3.72205284553e-07 1.2 3.72237042683e-07 1.44748737341 3.72268800813e-07 1.55 3.72300558943e-07 1.44748737342 3.72332317073e-07 1.2 3.72364075203e-07 0.952512626585 3.72395833333e-07 0.85 3.72427591463e-07 0.952512626585 3.72459349593e-07 1.2 3.72491107724e-07 1.44748737342 3.72522865854e-07 1.55 3.72554623984e-07 1.44748737342 3.72586382114e-07 1.2 3.72618140244e-07 0.952512626585 3.72649898374e-07 0.85 3.72681656504e-07 0.952512626584 3.72713414634e-07 1.2 3.72745172764e-07 1.44748737342 3.72776930894e-07 1.55 3.72808689024e-07 1.44748737342 3.72840447154e-07 1.2 3.72872205285e-07 0.952512626585 3.72903963415e-07 0.85 3.72935721545e-07 0.952512626585 3.72967479675e-07 1.2 3.72999237805e-07 1.44748737342 3.73030995935e-07 1.55 3.73062754065e-07 1.44748737342 3.73094512195e-07 1.2 3.73126270325e-07 0.952512626585 3.73158028455e-07 0.85 3.73189786585e-07 0.952512626585 3.73221544715e-07 1.2 3.73253302846e-07 1.44748737342 3.73285060976e-07 1.55 3.73316819106e-07 1.44748737342 3.73348577236e-07 1.2 3.73380335366e-07 0.952512626585 3.73412093496e-07 0.85 3.73443851626e-07 0.952512626585 3.73475609756e-07 1.2 3.73507367886e-07 1.44748737342 3.73539126016e-07 1.55 3.73570884146e-07 1.44748737342 3.73602642276e-07 1.2 3.73634400407e-07 0.952512626585 3.73666158537e-07 0.85 3.73697916667e-07 0.952512626585 3.73729674797e-07 1.2 3.73761432927e-07 1.44748737342 3.73793191057e-07 1.55 3.73824949187e-07 1.44748737342 3.73856707317e-07 1.2 3.73888465447e-07 0.952512626584 3.73920223577e-07 0.85 3.73951981707e-07 0.952512626585 3.73983739837e-07 1.2 3.74015497967e-07 1.44748737342 3.74047256098e-07 1.55 3.74079014228e-07 1.44748737342 3.74110772358e-07 1.2 3.74142530488e-07 0.952512626585 3.74174288618e-07 0.85 3.74206046748e-07 0.952512626585 3.74237804878e-07 1.2 3.74269563008e-07 1.44748737342 3.74301321138e-07 1.55 3.74333079268e-07 1.44748737342 3.74364837398e-07 1.2 3.74396595528e-07 0.952512626585 3.74428353659e-07 0.85 3.74460111789e-07 0.952512626585 3.74491869919e-07 1.2 3.74523628049e-07 1.44748737342 3.74555386179e-07 1.55 3.74587144309e-07 1.44748737342 3.74618902439e-07 1.2 3.74650660569e-07 0.952512626585 3.74682418699e-07 0.85 3.74714176829e-07 0.952512626585 3.74745934959e-07 1.2 3.74777693089e-07 1.44748737342 3.7480945122e-07 1.55 3.7484120935e-07 1.44748737342 3.7487296748e-07 1.2 3.7490472561e-07 0.952512626585 3.7493648374e-07 0.85 3.7496824187e-07 0.952512626585 3.75e-07 1.2 3.7503175813e-07 1.44748737342 3.7506351626e-07 1.55 3.7509527439e-07 1.44748737342 3.7512703252e-07 1.2 3.7515879065e-07 0.952512626584 3.7519054878e-07 0.85 3.75222306911e-07 0.952512626585 3.75254065041e-07 1.2 3.75285823171e-07 1.44748737342 3.75317581301e-07 1.55 3.75349339431e-07 1.44748737342 3.75381097561e-07 1.2 3.75412855691e-07 0.952512626585 3.75444613821e-07 0.85 3.75476371951e-07 0.952512626584 3.75508130081e-07 1.2 3.75539888211e-07 1.44748737342 3.75571646341e-07 1.55 3.75603404472e-07 1.44748737342 3.75635162602e-07 1.2 3.75666920732e-07 0.952512626585 3.75698678862e-07 0.85 3.75730436992e-07 0.952512626585 3.75762195122e-07 1.2 3.75793953252e-07 1.44748737342 3.75825711382e-07 1.55 3.75857469512e-07 1.44748737342 3.75889227642e-07 1.2 3.75920985772e-07 0.952512626585 3.75952743902e-07 0.85 3.75984502033e-07 0.952512626585 3.76016260163e-07 1.2 3.76048018293e-07 1.44748737342 3.76079776423e-07 1.55 3.76111534553e-07 1.44748737342 3.76143292683e-07 1.2 3.76175050813e-07 0.952512626585 3.76206808943e-07 0.85 3.76238567073e-07 0.952512626584 3.76270325203e-07 1.2 3.76302083333e-07 1.44748737342 3.76333841463e-07 1.55 3.76365599593e-07 1.44748737342 3.76397357724e-07 1.2 3.76429115854e-07 0.952512626585 3.76460873984e-07 0.85 3.76492632114e-07 0.952512626585 3.76524390244e-07 1.2 3.76556148374e-07 1.44748737342 3.76587906504e-07 1.55 3.76619664634e-07 1.44748737342 3.76651422764e-07 1.2 3.76683180894e-07 0.952512626585 3.76714939024e-07 0.85 3.76746697154e-07 0.952512626584 3.76778455285e-07 1.2 3.76810213415e-07 1.44748737342 3.76841971545e-07 1.55 3.76873729675e-07 1.44748737342 3.76905487805e-07 1.2 3.76937245935e-07 0.952512626585 3.76969004065e-07 0.85 3.77000762195e-07 0.952512626585 3.77032520325e-07 1.2 3.77064278455e-07 1.44748737342 3.77096036585e-07 1.55 3.77127794715e-07 1.44748737342 3.77159552846e-07 1.2 3.77191310976e-07 0.952512626585 3.77223069106e-07 0.85 3.77254827236e-07 0.952512626585 3.77286585366e-07 1.2 3.77318343496e-07 1.44748737342 3.77350101626e-07 1.55 3.77381859756e-07 1.44748737342 3.77413617886e-07 1.2 3.77445376016e-07 0.952512626585 3.77477134146e-07 0.85 3.77508892276e-07 0.952512626585 3.77540650407e-07 1.2 3.77572408537e-07 1.44748737342 3.77604166667e-07 1.55 3.77635924797e-07 1.44748737342 3.77667682927e-07 1.2 3.77699441057e-07 0.952512626585 3.77731199187e-07 0.85 3.77762957317e-07 0.952512626585 3.77794715447e-07 1.2 3.77826473577e-07 1.44748737342 3.77858231707e-07 1.55 3.77889989837e-07 1.44748737342 3.77921747967e-07 1.2 3.77953506098e-07 0.952512626584 3.77985264228e-07 0.85 3.78017022358e-07 0.952512626585 3.78048780488e-07 1.2 3.78080538618e-07 1.44748737342 3.78112296748e-07 1.55 3.78144054878e-07 1.44748737342 3.78175813008e-07 1.2 3.78207571138e-07 0.952512626585 3.78239329268e-07 0.85 3.78271087398e-07 0.952512626585 3.78302845528e-07 1.2 3.78334603659e-07 1.44748737342 3.78366361789e-07 1.55 3.78398119919e-07 1.44748737342 3.78429878049e-07 1.2 3.78461636179e-07 0.952512626585 3.78493394309e-07 0.85 3.78525152439e-07 0.952512626585 3.78556910569e-07 1.2 3.78588668699e-07 1.44748737342 3.78620426829e-07 1.55 3.78652184959e-07 1.44748737342 3.78683943089e-07 1.2 3.7871570122e-07 0.952512626584 3.7874745935e-07 0.85 3.7877921748e-07 0.952512626585 3.7881097561e-07 1.2 3.7884273374e-07 1.44748737342 3.7887449187e-07 1.55 3.7890625e-07 1.44748737342 3.7893800813e-07 1.2 3.7896976626e-07 0.952512626585 3.7900152439e-07 0.85 3.7903328252e-07 0.952512626585 3.7906504065e-07 1.2 3.7909679878e-07 1.44748737342 3.79128556911e-07 1.55 3.79160315041e-07 1.44748737342 3.79192073171e-07 1.2 3.79223831301e-07 0.952512626585 3.79255589431e-07 0.85 3.79287347561e-07 0.952512626585 3.79319105691e-07 1.2 3.79350863821e-07 1.44748737342 3.79382621951e-07 1.55 3.79414380081e-07 1.44748737342 3.79446138211e-07 1.2 3.79477896341e-07 0.952512626585 3.79509654472e-07 0.85 3.79541412602e-07 0.952512626585 3.79573170732e-07 1.2 3.79604928862e-07 1.44748737342 3.79636686992e-07 1.55 3.79668445122e-07 1.44748737342 3.79700203252e-07 1.2 3.79731961382e-07 0.952512626585 3.79763719512e-07 0.85 3.79795477642e-07 0.952512626585 3.79827235772e-07 1.2 3.79858993902e-07 1.44748737342 3.79890752033e-07 1.55 3.79922510163e-07 1.44748737342 3.79954268293e-07 1.2 3.79986026423e-07 0.952512626585 3.80017784553e-07 0.85 3.80049542683e-07 0.952512626585 3.80081300813e-07 1.2 3.80113058943e-07 1.44748737342 3.80144817073e-07 1.55 3.80176575203e-07 1.44748737342 3.80208333333e-07 1.2 3.80240091463e-07 0.952512626585 3.80271849593e-07 0.85 3.80303607724e-07 0.952512626584 3.80335365854e-07 1.2 3.80367123984e-07 1.44748737342 3.80398882114e-07 1.55 3.80430640244e-07 1.44748737342 3.80462398374e-07 1.2 3.80494156504e-07 0.952512626585 3.80525914634e-07 0.85 3.80557672764e-07 0.952512626585 3.80589430894e-07 1.2 3.80621189024e-07 1.44748737341 3.80652947154e-07 1.55 3.80684705285e-07 1.44748737342 3.80716463415e-07 1.2 3.80748221545e-07 0.952512626585 3.80779979675e-07 0.85 3.80811737805e-07 0.952512626585 3.80843495935e-07 1.2 3.80875254065e-07 1.44748737342 3.80907012195e-07 1.55 3.80938770325e-07 1.44748737342 3.80970528455e-07 1.2 3.81002286585e-07 0.952512626585 3.81034044715e-07 0.85 3.81065802846e-07 0.952512626584 3.81097560976e-07 1.2 3.81129319106e-07 1.44748737342 3.81161077236e-07 1.55 3.81192835366e-07 1.44748737342 3.81224593496e-07 1.2 3.81256351626e-07 0.952512626585 3.81288109756e-07 0.85 3.81319867886e-07 0.952512626585 3.81351626016e-07 1.2 3.81383384146e-07 1.44748737342 3.81415142276e-07 1.55 3.81446900407e-07 1.44748737342 3.81478658537e-07 1.2 3.81510416667e-07 0.952512626585 3.81542174797e-07 0.85 3.81573932927e-07 0.952512626585 3.81605691057e-07 1.2 3.81637449187e-07 1.44748737342 3.81669207317e-07 1.55 3.81700965447e-07 1.44748737342 3.81732723577e-07 1.2 3.81764481707e-07 0.952512626585 3.81796239837e-07 0.85 3.81827997967e-07 0.952512626585 3.81859756098e-07 1.2 3.81891514228e-07 1.44748737342 3.81923272358e-07 1.55 3.81955030488e-07 1.44748737341 3.81986788618e-07 1.2 3.82018546748e-07 0.952512626585 3.82050304878e-07 0.85 3.82082063008e-07 0.952512626585 3.82113821138e-07 1.2 3.82145579268e-07 1.44748737342 3.82177337398e-07 1.55 3.82209095528e-07 1.44748737342 3.82240853659e-07 1.2 3.82272611789e-07 0.952512626584 3.82304369919e-07 0.85 3.82336128049e-07 0.952512626585 3.82367886179e-07 1.2 3.82399644309e-07 1.44748737342 3.82431402439e-07 1.55 3.82463160569e-07 1.44748737342 3.82494918699e-07 1.2 3.82526676829e-07 0.952512626585 3.82558434959e-07 0.85 3.82590193089e-07 0.952512626585 3.8262195122e-07 1.2 3.8265370935e-07 1.44748737342 3.8268546748e-07 1.55 3.8271722561e-07 1.44748737342 3.8274898374e-07 1.2 3.8278074187e-07 0.952512626585 3.828125e-07 0.85 3.8284425813e-07 0.952512626585 3.8287601626e-07 1.2 3.8290777439e-07 1.44748737342 3.8293953252e-07 1.55 3.8297129065e-07 1.44748737342 3.8300304878e-07 1.2 3.83034806911e-07 0.952512626585 3.83066565041e-07 0.85 3.83098323171e-07 0.952512626585 3.83130081301e-07 1.2 3.83161839431e-07 1.44748737342 3.83193597561e-07 1.55 3.83225355691e-07 1.44748737342 3.83257113821e-07 1.2 3.83288871951e-07 0.952512626585 3.83320630081e-07 0.85 3.83352388211e-07 0.952512626585 3.83384146341e-07 1.2 3.83415904472e-07 1.44748737342 3.83447662602e-07 1.55 3.83479420732e-07 1.44748737342 3.83511178862e-07 1.2 3.83542936992e-07 0.952512626585 3.83574695122e-07 0.85 3.83606453252e-07 0.952512626585 3.83638211382e-07 1.2 3.83669969512e-07 1.44748737342 3.83701727642e-07 1.55 3.83733485772e-07 1.44748737342 3.83765243902e-07 1.2 3.83797002033e-07 0.952512626585 3.83828760163e-07 0.85 3.83860518293e-07 0.952512626584 3.83892276423e-07 1.2 3.83924034553e-07 1.44748737342 3.83955792683e-07 1.55 3.83987550813e-07 1.44748737342 3.84019308943e-07 1.2 3.84051067073e-07 0.952512626585 3.84082825203e-07 0.85 3.84114583333e-07 0.952512626585 3.84146341463e-07 1.2 3.84178099593e-07 1.44748737342 3.84209857724e-07 1.55 3.84241615854e-07 1.44748737342 3.84273373984e-07 1.2 3.84305132114e-07 0.952512626585 3.84336890244e-07 0.85 3.84368648374e-07 0.952512626585 3.84400406504e-07 1.2 3.84432164634e-07 1.44748737342 3.84463922764e-07 1.55 3.84495680894e-07 1.44748737342 3.84527439024e-07 1.2 3.84559197154e-07 0.952512626585 3.84590955285e-07 0.85 3.84622713415e-07 0.952512626584 3.84654471545e-07 1.2 3.84686229675e-07 1.44748737342 3.84717987805e-07 1.55 3.84749745935e-07 1.44748737342 3.84781504065e-07 1.2 3.84813262195e-07 0.952512626585 3.84845020325e-07 0.85 3.84876778455e-07 0.952512626585 3.84908536585e-07 1.2 3.84940294715e-07 1.44748737342 3.84972052846e-07 1.55 3.85003810976e-07 1.44748737342 3.85035569106e-07 1.2 3.85067327236e-07 0.952512626585 3.85099085366e-07 0.85 3.85130843496e-07 0.952512626584 3.85162601626e-07 1.2 3.85194359756e-07 1.44748737342 3.85226117886e-07 1.55 3.85257876016e-07 1.44748737342 3.85289634146e-07 1.2 3.85321392276e-07 0.952512626585 3.85353150407e-07 0.85 3.85384908537e-07 0.952512626585 3.85416666667e-07 1.2 3.85448424797e-07 1.44748737342 3.85480182927e-07 1.55 3.85511941057e-07 1.44748737342 3.85543699187e-07 1.2 3.85575457317e-07 0.952512626585 3.85607215447e-07 0.85 3.85638973577e-07 0.952512626585 3.85670731707e-07 1.2 3.85702489837e-07 1.44748737342 3.85734247967e-07 1.55 3.85766006098e-07 1.44748737342 3.85797764228e-07 1.2 3.85829522358e-07 0.952512626585 3.85861280488e-07 0.85 3.85893038618e-07 0.952512626585 3.85924796748e-07 1.2 3.85956554878e-07 1.44748737342 3.85988313008e-07 1.55 3.86020071138e-07 1.44748737342 3.86051829268e-07 1.2 3.86083587398e-07 0.952512626585 3.86115345528e-07 0.85 3.86147103659e-07 0.952512626585 3.86178861789e-07 1.2 3.86210619919e-07 1.44748737342 3.86242378049e-07 1.55 3.86274136179e-07 1.44748737342 3.86305894309e-07 1.2 3.86337652439e-07 0.952512626585 3.86369410569e-07 0.85 3.86401168699e-07 0.952512626585 3.86432926829e-07 1.2 3.86464684959e-07 1.44748737342 3.86496443089e-07 1.55 3.8652820122e-07 1.44748737342 3.8655995935e-07 1.2 3.8659171748e-07 0.952512626585 3.8662347561e-07 0.85 3.8665523374e-07 0.952512626585 3.8668699187e-07 1.2 3.8671875e-07 1.44748737342 3.8675050813e-07 1.55 3.8678226626e-07 1.44748737342 3.8681402439e-07 1.2 3.8684578252e-07 0.952512626585 3.8687754065e-07 0.85 3.8690929878e-07 0.952512626585 3.86941056911e-07 1.2 3.86972815041e-07 1.44748737342 3.87004573171e-07 1.55 3.87036331301e-07 1.44748737342 3.87068089431e-07 1.2 3.87099847561e-07 0.952512626584 3.87131605691e-07 0.85 3.87163363821e-07 0.952512626585 3.87195121951e-07 1.2 3.87226880081e-07 1.44748737342 3.87258638211e-07 1.55 3.87290396341e-07 1.44748737342 3.87322154472e-07 1.2 3.87353912602e-07 0.952512626585 3.87385670732e-07 0.85 3.87417428862e-07 0.952512626584 3.87449186992e-07 1.2 3.87480945122e-07 1.44748737342 3.87512703252e-07 1.55 3.87544461382e-07 1.44748737342 3.87576219512e-07 1.2 3.87607977642e-07 0.952512626585 3.87639735772e-07 0.85 3.87671493902e-07 0.952512626585 3.87703252033e-07 1.2 3.87735010163e-07 1.44748737342 3.87766768293e-07 1.55 3.87798526423e-07 1.44748737342 3.87830284553e-07 1.2 3.87862042683e-07 0.952512626585 3.87893800813e-07 0.85 3.87925558943e-07 0.952512626585 3.87957317073e-07 1.2 3.87989075203e-07 1.44748737342 3.88020833333e-07 1.55 3.88052591463e-07 1.44748737342 3.88084349593e-07 1.2 3.88116107724e-07 0.952512626585 3.88147865854e-07 0.85 3.88179623984e-07 0.952512626585 3.88211382114e-07 1.2 3.88243140244e-07 1.44748737342 3.88274898374e-07 1.55 3.88306656504e-07 1.44748737342 3.88338414634e-07 1.2 3.88370172764e-07 0.952512626585 3.88401930894e-07 0.85 3.88433689024e-07 0.952512626585 3.88465447154e-07 1.2 3.88497205285e-07 1.44748737342 3.88528963415e-07 1.55 3.88560721545e-07 1.44748737342 3.88592479675e-07 1.2 3.88624237805e-07 0.952512626585 3.88655995935e-07 0.85 3.88687754065e-07 0.952512626584 3.88719512195e-07 1.2 3.88751270325e-07 1.44748737342 3.88783028455e-07 1.55 3.88814786585e-07 1.44748737342 3.88846544715e-07 1.2 3.88878302846e-07 0.952512626585 3.88910060976e-07 0.85 3.88941819106e-07 0.952512626585 3.88973577236e-07 1.2 3.89005335366e-07 1.44748737341 3.89037093496e-07 1.55 3.89068851626e-07 1.44748737342 3.89100609756e-07 1.2 3.89132367886e-07 0.952512626585 3.89164126016e-07 0.85 3.89195884146e-07 0.952512626585 3.89227642276e-07 1.2 3.89259400407e-07 1.44748737342 3.89291158537e-07 1.55 3.89322916667e-07 1.44748737342 3.89354674797e-07 1.2 3.89386432927e-07 0.952512626585 3.89418191057e-07 0.85 3.89449949187e-07 0.952512626584 3.89481707317e-07 1.2 3.89513465447e-07 1.44748737342 3.89545223577e-07 1.55 3.89576981707e-07 1.44748737342 3.89608739837e-07 1.2 3.89640497967e-07 0.952512626585 3.89672256098e-07 0.85 3.89704014228e-07 0.952512626585 3.89735772358e-07 1.2 3.89767530488e-07 1.44748737342 3.89799288618e-07 1.55 3.89831046748e-07 1.44748737342 3.89862804878e-07 1.2 3.89894563008e-07 0.952512626584 3.89926321138e-07 0.85 3.89958079268e-07 0.952512626585 3.89989837398e-07 1.2 3.90021595528e-07 1.44748737342 3.90053353659e-07 1.55 3.90085111789e-07 1.44748737342 3.90116869919e-07 1.2 3.90148628049e-07 0.952512626585 3.90180386179e-07 0.85 3.90212144309e-07 0.952512626585 3.90243902439e-07 1.2 3.90275660569e-07 1.44748737342 3.90307418699e-07 1.55 3.90339176829e-07 1.44748737341 3.90370934959e-07 1.2 3.90402693089e-07 0.952512626585 3.9043445122e-07 0.85 3.9046620935e-07 0.952512626585 3.9049796748e-07 1.2 3.9052972561e-07 1.44748737342 3.9056148374e-07 1.55 3.9059324187e-07 1.44748737342 3.90625e-07 1.2 3.9065675813e-07 0.952512626584 3.9068851626e-07 0.85 3.9072027439e-07 0.952512626585 3.9075203252e-07 1.2 3.9078379065e-07 1.44748737342 3.9081554878e-07 1.55 3.90847306911e-07 1.44748737342 3.90879065041e-07 1.2 3.90910823171e-07 0.952512626585 3.90942581301e-07 0.85 3.90974339431e-07 0.952512626585 3.91006097561e-07 1.2 3.91037855691e-07 1.44748737342 3.91069613821e-07 1.55 3.91101371951e-07 1.44748737342 3.91133130081e-07 1.2 3.91164888211e-07 0.952512626585 3.91196646341e-07 0.85 3.91228404472e-07 0.952512626585 3.91260162602e-07 1.2 3.91291920732e-07 1.44748737342 3.91323678862e-07 1.55 3.91355436992e-07 1.44748737342 3.91387195122e-07 1.2 3.91418953252e-07 0.952512626585 3.91450711382e-07 0.85 3.91482469512e-07 0.952512626585 3.91514227642e-07 1.2 3.91545985772e-07 1.44748737342 3.91577743902e-07 1.55 3.91609502033e-07 1.44748737342 3.91641260163e-07 1.2 3.91673018293e-07 0.952512626585 3.91704776423e-07 0.85 3.91736534553e-07 0.952512626585 3.91768292683e-07 1.2 3.91800050813e-07 1.44748737342 3.91831808943e-07 1.55 3.91863567073e-07 1.44748737342 3.91895325203e-07 1.2 3.91927083333e-07 0.952512626585 3.91958841463e-07 0.85 3.91990599593e-07 0.952512626585 3.92022357724e-07 1.2 3.92054115854e-07 1.44748737342 3.92085873984e-07 1.55 3.92117632114e-07 1.44748737342 3.92149390244e-07 1.2 3.92181148374e-07 0.952512626585 3.92212906504e-07 0.85 3.92244664634e-07 0.952512626584 3.92276422764e-07 1.2 3.92308180894e-07 1.44748737342 3.92339939024e-07 1.55 3.92371697154e-07 1.44748737342 3.92403455285e-07 1.2 3.92435213415e-07 0.952512626585 3.92466971545e-07 0.85 3.92498729675e-07 0.952512626585 3.92530487805e-07 1.2 3.92562245935e-07 1.44748737342 3.92594004065e-07 1.55 3.92625762195e-07 1.44748737342 3.92657520325e-07 1.2 3.92689278455e-07 0.952512626585 3.92721036585e-07 0.85 3.92752794715e-07 0.952512626585 3.92784552846e-07 1.2 3.92816310976e-07 1.44748737342 3.92848069106e-07 1.55 3.92879827236e-07 1.44748737342 3.92911585366e-07 1.2 3.92943343496e-07 0.952512626585 3.92975101626e-07 0.85 3.93006859756e-07 0.952512626584 3.93038617886e-07 1.2 3.93070376016e-07 1.44748737342 3.93102134146e-07 1.55 3.93133892276e-07 1.44748737342 3.93165650407e-07 1.2 3.93197408537e-07 0.952512626585 3.93229166667e-07 0.85 3.93260924797e-07 0.952512626585 3.93292682927e-07 1.2 3.93324441057e-07 1.44748737342 3.93356199187e-07 1.55 3.93387957317e-07 1.44748737342 3.93419715447e-07 1.2 3.93451473577e-07 0.952512626585 3.93483231707e-07 0.85 3.93514989837e-07 0.952512626585 3.93546747967e-07 1.2 3.93578506098e-07 1.44748737342 3.93610264228e-07 1.55 3.93642022358e-07 1.44748737342 3.93673780488e-07 1.2 3.93705538618e-07 0.952512626585 3.93737296748e-07 0.85 3.93769054878e-07 0.952512626585 3.93800813008e-07 1.2 3.93832571138e-07 1.44748737342 3.93864329268e-07 1.55 3.93896087398e-07 1.44748737342 3.93927845528e-07 1.2 3.93959603659e-07 0.952512626585 3.93991361789e-07 0.85 3.94023119919e-07 0.952512626585 3.94054878049e-07 1.2 3.94086636179e-07 1.44748737342 3.94118394309e-07 1.55 3.94150152439e-07 1.44748737342 3.94181910569e-07 1.2 3.94213668699e-07 0.952512626584 3.94245426829e-07 0.85 3.94277184959e-07 0.952512626585 3.94308943089e-07 1.2 3.9434070122e-07 1.44748737342 3.9437245935e-07 1.55 3.9440421748e-07 1.44748737342 3.9443597561e-07 1.2 3.9446773374e-07 0.952512626585 3.9449949187e-07 0.85 3.9453125e-07 0.952512626585 3.9456300813e-07 1.2 3.9459476626e-07 1.44748737342 3.9462652439e-07 1.55 3.9465828252e-07 1.44748737342 3.9469004065e-07 1.2 3.9472179878e-07 0.952512626585 3.94753556911e-07 0.85 3.94785315041e-07 0.952512626585 3.94817073171e-07 1.2 3.94848831301e-07 1.44748737342 3.94880589431e-07 1.55 3.94912347561e-07 1.44748737342 3.94944105691e-07 1.2 3.94975863821e-07 0.952512626585 3.95007621951e-07 0.85 3.95039380081e-07 0.952512626585 3.95071138211e-07 1.2 3.95102896341e-07 1.44748737342 3.95134654472e-07 1.55 3.95166412602e-07 1.44748737342 3.95198170732e-07 1.2 3.95229928862e-07 0.952512626585 3.95261686992e-07 0.85 3.95293445122e-07 0.952512626585 3.95325203252e-07 1.2 3.95356961382e-07 1.44748737342 3.95388719512e-07 1.55 3.95420477642e-07 1.44748737342 3.95452235772e-07 1.2 3.95483993902e-07 0.952512626585 3.95515752033e-07 0.85 3.95547510163e-07 0.952512626585 3.95579268293e-07 1.2 3.95611026423e-07 1.44748737342 3.95642784553e-07 1.55 3.95674542683e-07 1.44748737342 3.95706300813e-07 1.2 3.95738058943e-07 0.952512626585 3.95769817073e-07 0.85 3.95801575203e-07 0.952512626584 3.95833333333e-07 1.2 3.95865091463e-07 1.44748737342 3.95896849593e-07 1.55 3.95928607724e-07 1.44748737342 3.95960365854e-07 1.2 3.95992123984e-07 0.952512626585 3.96023882114e-07 0.85 3.96055640244e-07 0.952512626585 3.96087398374e-07 1.2 3.96119156504e-07 1.44748737342 3.96150914634e-07 1.55 3.96182672764e-07 1.44748737342 3.96214430894e-07 1.2 3.96246189024e-07 0.952512626585 3.96277947154e-07 0.85 3.96309705285e-07 0.952512626585 3.96341463415e-07 1.2 3.96373221545e-07 1.44748737342 3.96404979675e-07 1.55 3.96436737805e-07 1.44748737342 3.96468495935e-07 1.2 3.96500254065e-07 0.952512626585 3.96532012195e-07 0.85 3.96563770325e-07 0.952512626585 3.96595528455e-07 1.2 3.96627286585e-07 1.44748737342 3.96659044715e-07 1.55 3.96690802846e-07 1.44748737342 3.96722560976e-07 1.2 3.96754319106e-07 0.952512626585 3.96786077236e-07 0.85 3.96817835366e-07 0.952512626585 3.96849593496e-07 1.2 3.96881351626e-07 1.44748737342 3.96913109756e-07 1.55 3.96944867886e-07 1.44748737342 3.96976626016e-07 1.2 3.97008384146e-07 0.952512626585 3.97040142276e-07 0.85 3.97071900407e-07 0.952512626584 3.97103658537e-07 1.2 3.97135416667e-07 1.44748737342 3.97167174797e-07 1.55 3.97198932927e-07 1.44748737342 3.97230691057e-07 1.2 3.97262449187e-07 0.952512626585 3.97294207317e-07 0.85 3.97325965447e-07 0.952512626585 3.97357723577e-07 1.2 3.97389481707e-07 1.44748737342 3.97421239837e-07 1.55 3.97452997967e-07 1.44748737342 3.97484756098e-07 1.2 3.97516514228e-07 0.952512626585 3.97548272358e-07 0.85 3.97580030488e-07 0.952512626585 3.97611788618e-07 1.2 3.97643546748e-07 1.44748737342 3.97675304878e-07 1.55 3.97707063008e-07 1.44748737342 3.97738821138e-07 1.2 3.97770579268e-07 0.952512626585 3.97802337398e-07 0.85 3.97834095528e-07 0.952512626585 3.97865853659e-07 1.2 3.97897611789e-07 1.44748737342 3.97929369919e-07 1.55 3.97961128049e-07 1.44748737342 3.97992886179e-07 1.2 3.98024644309e-07 0.952512626585 3.98056402439e-07 0.85 3.98088160569e-07 0.952512626585 3.98119918699e-07 1.2 3.98151676829e-07 1.44748737342 3.98183434959e-07 1.55 3.98215193089e-07 1.44748737342 3.9824695122e-07 1.2 3.9827870935e-07 0.952512626584 3.9831046748e-07 0.85 3.9834222561e-07 0.952512626585 3.9837398374e-07 1.2 3.9840574187e-07 1.44748737342 3.984375e-07 1.55 3.9846925813e-07 1.44748737342 3.9850101626e-07 1.2 3.9853277439e-07 0.952512626585 3.9856453252e-07 0.85 3.9859629065e-07 0.952512626585 3.9862804878e-07 1.2 3.98659806911e-07 1.44748737342 3.98691565041e-07 1.55 3.98723323171e-07 1.44748737341 3.98755081301e-07 1.2 3.98786839431e-07 0.952512626585 3.98818597561e-07 0.85 3.98850355691e-07 0.952512626585 3.98882113821e-07 1.2 3.98913871951e-07 1.44748737342 3.98945630081e-07 1.55 3.98977388211e-07 1.44748737342 3.99009146341e-07 1.2 3.99040904472e-07 0.952512626584 3.99072662602e-07 0.85 3.99104420732e-07 0.952512626585 3.99136178862e-07 1.2 3.99167936992e-07 1.44748737342 3.99199695122e-07 1.55 3.99231453252e-07 1.44748737342 3.99263211382e-07 1.2 3.99294969512e-07 0.952512626585 3.99326727642e-07 0.85 3.99358485772e-07 0.952512626585 3.99390243902e-07 1.2 3.99422002033e-07 1.44748737342 3.99453760163e-07 1.55 3.99485518293e-07 1.44748737342 3.99517276423e-07 1.2 3.99549034553e-07 0.952512626585 3.99580792683e-07 0.85 3.99612550813e-07 0.952512626585 3.99644308943e-07 1.2 3.99676067073e-07 1.44748737342 3.99707825203e-07 1.55 3.99739583333e-07 1.44748737342 3.99771341463e-07 1.2 3.99803099593e-07 0.952512626585 3.99834857724e-07 0.85 3.99866615854e-07 0.952512626585 3.99898373984e-07 1.2 3.99930132114e-07 1.44748737342 3.99961890244e-07 1.55 3.99993648374e-07 1.44748737342 4.00025406504e-07 1.2 4.00057164634e-07 0.952512626585 4.00088922764e-07 0.85 4.00120680894e-07 0.952512626585 4.00152439024e-07 1.2 4.00184197154e-07 1.44748737342 4.00215955285e-07 1.55 4.00247713415e-07 1.44748737342 4.00279471545e-07 1.2 4.00311229675e-07 0.952512626585 4.00342987805e-07 0.85 4.00374745935e-07 0.952512626585 4.00406504065e-07 1.2 4.00438262195e-07 1.44748737342 4.00470020325e-07 1.55 4.00501778455e-07 1.44748737342 4.00533536585e-07 1.2 4.00565294715e-07 0.952512626585 4.00597052846e-07 0.85 4.00628810976e-07 0.952512626584 4.00660569106e-07 1.2 4.00692327236e-07 1.44748737342 4.00724085366e-07 1.55 4.00755843496e-07 1.44748737342 4.00787601626e-07 1.2 4.00819359756e-07 0.952512626585 4.00851117886e-07 0.85 4.00882876016e-07 0.952512626585 4.00914634146e-07 1.2 4.00946392276e-07 1.44748737341 4.00978150407e-07 1.55 4.01009908537e-07 1.44748737342 4.01041666667e-07 1.2 4.01073424797e-07 0.952512626585 4.01105182927e-07 0.85 4.01136941057e-07 0.952512626584 4.01168699187e-07 1.2 4.01200457317e-07 1.44748737342 4.01232215447e-07 1.55 4.01263973577e-07 1.44748737342 4.01295731707e-07 1.2 4.01327489837e-07 0.952512626585 4.01359247967e-07 0.85 4.01391006098e-07 0.952512626584 4.01422764228e-07 1.2 4.01454522358e-07 1.44748737342 4.01486280488e-07 1.55 4.01518038618e-07 1.44748737342 4.01549796748e-07 1.2 4.01581554878e-07 0.952512626585 4.01613313008e-07 0.85 4.01645071138e-07 0.952512626585 4.01676829268e-07 1.2 4.01708587398e-07 1.44748737342 4.01740345528e-07 1.55 4.01772103659e-07 1.44748737342 4.01803861789e-07 1.2 4.01835619919e-07 0.952512626585 4.01867378049e-07 0.85 4.01899136179e-07 0.952512626585 4.01930894309e-07 1.2 4.01962652439e-07 1.44748737342 4.01994410569e-07 1.55 4.02026168699e-07 1.44748737342 4.02057926829e-07 1.2 4.02089684959e-07 0.952512626585 4.02121443089e-07 0.85 4.0215320122e-07 0.952512626585 4.0218495935e-07 1.2 4.0221671748e-07 1.44748737342 4.0224847561e-07 1.55 4.0228023374e-07 1.44748737341 4.0231199187e-07 1.2 4.0234375e-07 0.952512626585 4.0237550813e-07 0.85 4.0240726626e-07 0.952512626585 4.0243902439e-07 1.2 4.0247078252e-07 1.44748737342 4.0250254065e-07 1.55 4.0253429878e-07 1.44748737342 4.02566056911e-07 1.2 4.02597815041e-07 0.952512626584 4.02629573171e-07 0.85 4.02661331301e-07 0.952512626585 4.02693089431e-07 1.2 4.02724847561e-07 1.44748737342 4.02756605691e-07 1.55 4.02788363821e-07 1.44748737342 4.02820121951e-07 1.2 4.02851880081e-07 0.952512626585 4.02883638211e-07 0.85 4.02915396341e-07 0.952512626585 4.02947154472e-07 1.2 4.02978912602e-07 1.44748737342 4.03010670732e-07 1.55 4.03042428862e-07 1.44748737342 4.03074186992e-07 1.2 4.03105945122e-07 0.952512626585 4.03137703252e-07 0.85 4.03169461382e-07 0.952512626585 4.03201219512e-07 1.2 4.03232977642e-07 1.44748737342 4.03264735772e-07 1.55 4.03296493902e-07 1.44748737342 4.03328252033e-07 1.2 4.03360010163e-07 0.952512626585 4.03391768293e-07 0.85 4.03423526423e-07 0.952512626585 4.03455284553e-07 1.2 4.03487042683e-07 1.44748737342 4.03518800813e-07 1.55 4.03550558943e-07 1.44748737342 4.03582317073e-07 1.2 4.03614075203e-07 0.952512626585 4.03645833333e-07 0.85 4.03677591463e-07 0.952512626585 4.03709349593e-07 1.2 4.03741107724e-07 1.44748737342 4.03772865854e-07 1.55 4.03804623984e-07 1.44748737342 4.03836382114e-07 1.2 4.03868140244e-07 0.952512626585 4.03899898374e-07 0.85 4.03931656504e-07 0.952512626585 4.03963414634e-07 1.2 4.03995172764e-07 1.44748737342 4.04026930894e-07 1.55 4.04058689024e-07 1.44748737342 4.04090447154e-07 1.2 4.04122205285e-07 0.952512626585 4.04153963415e-07 0.85 4.04185721545e-07 0.952512626584 4.04217479675e-07 1.2 4.04249237805e-07 1.44748737342 4.04280995935e-07 1.55 4.04312754065e-07 1.44748737342 4.04344512195e-07 1.2 4.04376270325e-07 0.952512626585 4.04408028455e-07 0.85 4.04439786585e-07 0.952512626585 4.04471544715e-07 1.2 4.04503302846e-07 1.44748737342 4.04535060976e-07 1.55 4.04566819106e-07 1.44748737342 4.04598577236e-07 1.2 4.04630335366e-07 0.952512626585 4.04662093496e-07 0.85 4.04693851626e-07 0.952512626585 4.04725609756e-07 1.2 4.04757367886e-07 1.44748737342 4.04789126016e-07 1.55 4.04820884146e-07 1.44748737342 4.04852642276e-07 1.2 4.04884400407e-07 0.952512626585 4.04916158537e-07 0.85 4.04947916667e-07 0.952512626585 4.04979674797e-07 1.2 4.05011432927e-07 1.44748737342 4.05043191057e-07 1.55 4.05074949187e-07 1.44748737342 4.05106707317e-07 1.2 4.05138465447e-07 0.952512626585 4.05170223577e-07 0.85 4.05201981707e-07 0.952512626585 4.05233739837e-07 1.2 4.05265497967e-07 1.44748737342 4.05297256098e-07 1.55 4.05329014228e-07 1.44748737342 4.05360772358e-07 1.2 4.05392530488e-07 0.952512626585 4.05424288618e-07 0.85 4.05456046748e-07 0.952512626584 4.05487804878e-07 1.2 4.05519563008e-07 1.44748737342 4.05551321138e-07 1.55 4.05583079268e-07 1.44748737342 4.05614837398e-07 1.2 4.05646595528e-07 0.952512626585 4.05678353659e-07 0.85 4.05710111789e-07 0.952512626585 4.05741869919e-07 1.2 4.05773628049e-07 1.44748737342 4.05805386179e-07 1.55 4.05837144309e-07 1.44748737342 4.05868902439e-07 1.2 4.05900660569e-07 0.952512626585 4.05932418699e-07 0.85 4.05964176829e-07 0.952512626585 4.05995934959e-07 1.2 4.06027693089e-07 1.44748737342 4.0605945122e-07 1.55 4.0609120935e-07 1.44748737342 4.0612296748e-07 1.2 4.0615472561e-07 0.952512626585 4.0618648374e-07 0.85 4.0621824187e-07 0.952512626585 4.0625e-07 1.2 4.0628175813e-07 1.44748737342 4.0631351626e-07 1.55 4.0634527439e-07 1.44748737342 4.0637703252e-07 1.2 4.0640879065e-07 0.952512626585 4.0644054878e-07 0.85 4.06472306911e-07 0.952512626585 4.06504065041e-07 1.2 4.06535823171e-07 1.44748737342 4.06567581301e-07 1.55 4.06599339431e-07 1.44748737342 4.06631097561e-07 1.2 4.06662855691e-07 0.952512626584 4.06694613821e-07 0.85 4.06726371951e-07 0.952512626585 4.06758130081e-07 1.2 4.06789888211e-07 1.44748737342 4.06821646341e-07 1.55 4.06853404472e-07 1.44748737342 4.06885162602e-07 1.2 4.06916920732e-07 0.952512626585 4.06948678862e-07 0.85 4.06980436992e-07 0.952512626585 4.07012195122e-07 1.2 4.07043953252e-07 1.44748737342 4.07075711382e-07 1.55 4.07107469512e-07 1.44748737342 4.07139227642e-07 1.2 4.07170985772e-07 0.952512626585 4.07202743902e-07 0.85 4.07234502033e-07 0.952512626585 4.07266260163e-07 1.2 4.07298018293e-07 1.44748737342 4.07329776423e-07 1.55 4.07361534553e-07 1.44748737342 4.07393292683e-07 1.2 4.07425050813e-07 0.952512626585 4.07456808943e-07 0.85 4.07488567073e-07 0.952512626585 4.07520325203e-07 1.2 4.07552083333e-07 1.44748737342 4.07583841463e-07 1.55 4.07615599593e-07 1.44748737342 4.07647357724e-07 1.2 4.07679115854e-07 0.952512626585 4.07710873984e-07 0.85 4.07742632114e-07 0.952512626585 4.07774390244e-07 1.2 4.07806148374e-07 1.44748737342 4.07837906504e-07 1.55 4.07869664634e-07 1.44748737342 4.07901422764e-07 1.2 4.07933180894e-07 0.952512626585 4.07964939024e-07 0.85 4.07996697154e-07 0.952512626585 4.08028455285e-07 1.2 4.08060213415e-07 1.44748737342 4.08091971545e-07 1.55 4.08123729675e-07 1.44748737342 4.08155487805e-07 1.2 4.08187245935e-07 0.952512626585 4.08219004065e-07 0.85 4.08250762195e-07 0.952512626585 4.08282520325e-07 1.2 4.08314278455e-07 1.44748737342 4.08346036585e-07 1.55 4.08377794715e-07 1.44748737342 4.08409552846e-07 1.2 4.08441310976e-07 0.952512626585 4.08473069106e-07 0.85 4.08504827236e-07 0.952512626585 4.08536585366e-07 1.2 4.08568343496e-07 1.44748737342 4.08600101626e-07 1.55 4.08631859756e-07 1.44748737342 4.08663617886e-07 1.2 4.08695376016e-07 0.952512626585 4.08727134146e-07 0.85 4.08758892276e-07 0.952512626585 4.08790650407e-07 1.2 4.08822408537e-07 1.44748737342 4.08854166667e-07 1.55 4.08885924797e-07 1.44748737342 4.08917682927e-07 1.2 4.08949441057e-07 0.952512626585 4.08981199187e-07 0.85 4.09012957317e-07 0.952512626584 4.09044715447e-07 1.2 4.09076473577e-07 1.44748737342 4.09108231707e-07 1.55 4.09139989837e-07 1.44748737342 4.09171747967e-07 1.2 4.09203506098e-07 0.952512626585 4.09235264228e-07 0.85 4.09267022358e-07 0.952512626585 4.09298780488e-07 1.2 4.09330538618e-07 1.44748737341 4.09362296748e-07 1.55 4.09394054878e-07 1.44748737342 4.09425813008e-07 1.2 4.09457571138e-07 0.952512626585 4.09489329268e-07 0.85 4.09521087398e-07 0.952512626585 4.09552845528e-07 1.2 4.09584603659e-07 1.44748737342 4.09616361789e-07 1.55 4.09648119919e-07 1.44748737342 4.09679878049e-07 1.2 4.09711636179e-07 0.952512626585 4.09743394309e-07 0.85 4.09775152439e-07 0.952512626584 4.09806910569e-07 1.2 4.09838668699e-07 1.44748737342 4.09870426829e-07 1.55 4.09902184959e-07 1.44748737342 4.09933943089e-07 1.2 4.0996570122e-07 0.952512626585 4.0999745935e-07 0.85 4.1002921748e-07 0.952512626585 4.1006097561e-07 1.2 4.1009273374e-07 1.44748737342 4.1012449187e-07 1.55 4.1015625e-07 1.44748737342 4.1018800813e-07 1.2 4.1021976626e-07 0.952512626584 4.1025152439e-07 0.85 4.1028328252e-07 0.952512626585 4.1031504065e-07 1.2 4.1034679878e-07 1.44748737342 4.10378556911e-07 1.55 4.10410315041e-07 1.44748737342 4.10442073171e-07 1.2 4.10473831301e-07 0.952512626585 4.10505589431e-07 0.85 4.10537347561e-07 0.952512626585 4.10569105691e-07 1.2 4.10600863821e-07 1.44748737342 4.10632621951e-07 1.55 4.10664380081e-07 1.44748737341 4.10696138211e-07 1.2 4.10727896341e-07 0.952512626585 4.10759654472e-07 0.85 4.10791412602e-07 0.952512626585 4.10823170732e-07 1.2 4.10854928862e-07 1.44748737342 4.10886686992e-07 1.55 4.10918445122e-07 1.44748737342 4.10950203252e-07 1.2 4.10981961382e-07 0.952512626585 4.11013719512e-07 0.85 4.11045477642e-07 0.952512626585 4.11077235772e-07 1.2 4.11108993902e-07 1.44748737342 4.11140752033e-07 1.55 4.11172510163e-07 1.44748737342 4.11204268293e-07 1.2 4.11236026423e-07 0.952512626585 4.11267784553e-07 0.85 4.11299542683e-07 0.952512626585 4.11331300813e-07 1.2 4.11363058943e-07 1.44748737342 4.11394817073e-07 1.55 4.11426575203e-07 1.44748737342 4.11458333333e-07 1.2 4.11490091463e-07 0.952512626585 4.11521849593e-07 0.85 4.11553607724e-07 0.952512626585 4.11585365854e-07 1.2 4.11617123984e-07 1.44748737342 4.11648882114e-07 1.55 4.11680640244e-07 1.44748737342 4.11712398374e-07 1.2 4.11744156504e-07 0.952512626585 4.11775914634e-07 0.85 4.11807672764e-07 0.952512626585 4.11839430894e-07 1.2 4.11871189024e-07 1.44748737342 4.11902947154e-07 1.55 4.11934705285e-07 1.44748737342 4.11966463415e-07 1.2 4.11998221545e-07 0.952512626585 4.12029979675e-07 0.85 4.12061737805e-07 0.952512626585 4.12093495935e-07 1.2 4.12125254065e-07 1.44748737342 4.12157012195e-07 1.55 4.12188770325e-07 1.44748737342 4.12220528455e-07 1.2 4.12252286585e-07 0.952512626585 4.12284044715e-07 0.85 4.12315802846e-07 0.952512626585 4.12347560976e-07 1.2 4.12379319106e-07 1.44748737342 4.12411077236e-07 1.55 4.12442835366e-07 1.44748737342 4.12474593496e-07 1.2 4.12506351626e-07 0.952512626585 4.12538109756e-07 0.85 4.12569867886e-07 0.952512626584 4.12601626016e-07 1.2 4.12633384146e-07 1.44748737342 4.12665142276e-07 1.55 4.12696900407e-07 1.44748737342 4.12728658537e-07 1.2 4.12760416667e-07 0.952512626585 4.12792174797e-07 0.85 4.12823932927e-07 0.952512626585 4.12855691057e-07 1.2 4.12887449187e-07 1.44748737342 4.12919207317e-07 1.55 4.12950965447e-07 1.44748737342 4.12982723577e-07 1.2 4.13014481707e-07 0.952512626585 4.13046239837e-07 0.85 4.13077997967e-07 0.952512626584 4.13109756098e-07 1.2 4.13141514228e-07 1.44748737342 4.13173272358e-07 1.55 4.13205030488e-07 1.44748737342 4.13236788618e-07 1.2 4.13268546748e-07 0.952512626585 4.13300304878e-07 0.85 4.13332063008e-07 0.952512626585 4.13363821138e-07 1.2 4.13395579268e-07 1.44748737341 4.13427337398e-07 1.55 4.13459095528e-07 1.44748737342 4.13490853659e-07 1.2 4.13522611789e-07 0.952512626585 4.13554369919e-07 0.85 4.13586128049e-07 0.952512626585 4.13617886179e-07 1.2 4.13649644309e-07 1.44748737342 4.13681402439e-07 1.55 4.13713160569e-07 1.44748737342 4.13744918699e-07 1.2 4.13776676829e-07 0.952512626585 4.13808434959e-07 0.85 4.13840193089e-07 0.952512626585 4.1387195122e-07 1.2 4.1390370935e-07 1.44748737342 4.1393546748e-07 1.55 4.1396722561e-07 1.44748737342 4.1399898374e-07 1.2 4.1403074187e-07 0.952512626585 4.140625e-07 0.85 4.1409425813e-07 0.952512626585 4.1412601626e-07 1.2 4.1415777439e-07 1.44748737342 4.1418953252e-07 1.55 4.1422129065e-07 1.44748737342 4.1425304878e-07 1.2 4.14284806911e-07 0.952512626585 4.14316565041e-07 0.85 4.14348323171e-07 0.952512626585 4.14380081301e-07 1.2 4.14411839431e-07 1.44748737342 4.14443597561e-07 1.55 4.14475355691e-07 1.44748737342 4.14507113821e-07 1.2 4.14538871951e-07 0.952512626584 4.14570630081e-07 0.85 4.14602388211e-07 0.952512626585 4.14634146341e-07 1.2 4.14665904472e-07 1.44748737342 4.14697662602e-07 1.55 4.14729420732e-07 1.44748737342 4.14761178862e-07 1.2 4.14792936992e-07 0.952512626585 4.14824695122e-07 0.85 4.14856453252e-07 0.952512626585 4.14888211382e-07 1.2 4.14919969512e-07 1.44748737342 4.14951727642e-07 1.55 4.14983485772e-07 1.44748737342 4.15015243902e-07 1.2 4.15047002033e-07 0.952512626584 4.15078760163e-07 0.85 4.15110518293e-07 0.952512626585 4.15142276423e-07 1.2 4.15174034553e-07 1.44748737342 4.15205792683e-07 1.55 4.15237550813e-07 1.44748737342 4.15269308943e-07 1.2 4.15301067073e-07 0.952512626585 4.15332825203e-07 0.85 4.15364583333e-07 0.952512626585 4.15396341463e-07 1.2 4.15428099593e-07 1.44748737342 4.15459857724e-07 1.55 4.15491615854e-07 1.44748737342 4.15523373984e-07 1.2 4.15555132114e-07 0.952512626585 4.15586890244e-07 0.85 4.15618648374e-07 0.952512626585 4.15650406504e-07 1.2 4.15682164634e-07 1.44748737342 4.15713922764e-07 1.55 4.15745680894e-07 1.44748737342 4.15777439024e-07 1.2 4.15809197154e-07 0.952512626585 4.15840955285e-07 0.85 4.15872713415e-07 0.952512626585 4.15904471545e-07 1.2 4.15936229675e-07 1.44748737342 4.15967987805e-07 1.55 4.15999745935e-07 1.44748737342 4.16031504065e-07 1.2 4.16063262195e-07 0.952512626585 4.16095020325e-07 0.85 4.16126778455e-07 0.952512626585 4.16158536585e-07 1.2 4.16190294715e-07 1.44748737342 4.16222052846e-07 1.55 4.16253810976e-07 1.44748737342 4.16285569106e-07 1.2 4.16317327236e-07 0.952512626585 4.16349085366e-07 0.85 4.16380843496e-07 0.952512626585 4.16412601626e-07 1.2 4.16444359756e-07 1.44748737342 4.16476117886e-07 1.55 4.16507876016e-07 1.44748737342 4.16539634146e-07 1.2 4.16571392276e-07 0.952512626585 4.16603150407e-07 0.85 4.16634908537e-07 0.952512626585 4.16666666667e-07 1.2 4.16698424797e-07 1.44748737342 4.16730182927e-07 1.55 4.16761941057e-07 1.44748737342 4.16793699187e-07 1.2 4.16825457317e-07 0.952512626585 4.16857215447e-07 0.85 4.16888973577e-07 0.952512626585 4.16920731707e-07 1.2 4.16952489837e-07 1.44748737341 4.16984247967e-07 1.55 4.17016006098e-07 1.44748737342 4.17047764228e-07 1.2 4.17079522358e-07 0.952512626585 4.17111280488e-07 0.85 4.17143038618e-07 0.952512626585 4.17174796748e-07 1.2 4.17206554878e-07 1.44748737342 4.17238313008e-07 1.55 4.17270071138e-07 1.44748737342 4.17301829268e-07 1.2 4.17333587398e-07 0.952512626585 4.17365345528e-07 0.85 4.17397103659e-07 0.952512626584 4.17428861789e-07 1.2 4.17460619919e-07 1.44748737342 4.17492378049e-07 1.55 4.17524136179e-07 1.44748737342 4.17555894309e-07 1.2 4.17587652439e-07 0.952512626585 4.17619410569e-07 0.85 4.17651168699e-07 0.952512626585 4.17682926829e-07 1.2 4.17714684959e-07 1.44748737341 4.17746443089e-07 1.55 4.1777820122e-07 1.44748737342 4.1780995935e-07 1.2 4.1784171748e-07 0.952512626585 4.1787347561e-07 0.85 4.1790523374e-07 0.952512626585 4.1793699187e-07 1.2 4.1796875e-07 1.44748737342 4.1800050813e-07 1.55 4.1803226626e-07 1.44748737342 4.1806402439e-07 1.2 4.1809578252e-07 0.952512626585 4.1812754065e-07 0.85 4.1815929878e-07 0.952512626585 4.18191056911e-07 1.2 4.18222815041e-07 1.44748737342 4.18254573171e-07 1.55 4.18286331301e-07 1.44748737342 4.18318089431e-07 1.2 4.18349847561e-07 0.952512626585 4.18381605691e-07 0.85 4.18413363821e-07 0.952512626585 4.18445121951e-07 1.2 4.18476880081e-07 1.44748737342 4.18508638211e-07 1.55 4.18540396341e-07 1.44748737342 4.18572154472e-07 1.2 4.18603912602e-07 0.952512626584 4.18635670732e-07 0.85 4.18667428862e-07 0.952512626585 4.18699186992e-07 1.2 4.18730945122e-07 1.44748737342 4.18762703252e-07 1.55 4.18794461382e-07 1.44748737342 4.18826219512e-07 1.2 4.18857977642e-07 0.952512626585 4.18889735772e-07 0.85 4.18921493902e-07 0.952512626585 4.18953252033e-07 1.2 4.18985010163e-07 1.44748737342 4.19016768293e-07 1.55 4.19048526423e-07 1.44748737342 4.19080284553e-07 1.2 4.19112042683e-07 0.952512626585 4.19143800813e-07 0.85 4.19175558943e-07 0.952512626585 4.19207317073e-07 1.2 4.19239075203e-07 1.44748737342 4.19270833333e-07 1.55 4.19302591463e-07 1.44748737342 4.19334349593e-07 1.2 4.19366107724e-07 0.952512626585 4.19397865854e-07 0.85 4.19429623984e-07 0.952512626585 4.19461382114e-07 1.2 4.19493140244e-07 1.44748737342 4.19524898374e-07 1.55 4.19556656504e-07 1.44748737342 4.19588414634e-07 1.2 4.19620172764e-07 0.952512626585 4.19651930894e-07 0.85 4.19683689024e-07 0.952512626585 4.19715447154e-07 1.2 4.19747205285e-07 1.44748737342 4.19778963415e-07 1.55 4.19810721545e-07 1.44748737342 4.19842479675e-07 1.2 4.19874237805e-07 0.952512626585 4.19905995935e-07 0.85 4.19937754065e-07 0.952512626585 4.19969512195e-07 1.2 4.20001270325e-07 1.44748737342 4.20033028455e-07 1.55 4.20064786585e-07 1.44748737342 4.20096544715e-07 1.2 4.20128302846e-07 0.952512626585 4.20160060976e-07 0.85 4.20191819106e-07 0.952512626585 4.20223577236e-07 1.2 4.20255335366e-07 1.44748737342 4.20287093496e-07 1.55 4.20318851626e-07 1.44748737342 4.20350609756e-07 1.2 4.20382367886e-07 0.952512626585 4.20414126016e-07 0.85 4.20445884146e-07 0.952512626585 4.20477642276e-07 1.2 4.20509400407e-07 1.44748737342 4.20541158537e-07 1.55 4.20572916667e-07 1.44748737342 4.20604674797e-07 1.2 4.20636432927e-07 0.952512626585 4.20668191057e-07 0.85 4.20699949187e-07 0.952512626585 4.20731707317e-07 1.2 4.20763465447e-07 1.44748737342 4.20795223577e-07 1.55 4.20826981707e-07 1.44748737342 4.20858739837e-07 1.2 4.20890497967e-07 0.952512626585 4.20922256098e-07 0.85 4.20954014228e-07 0.952512626584 4.20985772358e-07 1.2 4.21017530488e-07 1.44748737342 4.21049288618e-07 1.55 4.21081046748e-07 1.44748737342 4.21112804878e-07 1.2 4.21144563008e-07 0.952512626585 4.21176321138e-07 0.85 4.21208079268e-07 0.952512626585 4.21239837398e-07 1.2 4.21271595528e-07 1.44748737342 4.21303353659e-07 1.55 4.21335111789e-07 1.44748737342 4.21366869919e-07 1.2 4.21398628049e-07 0.952512626585 4.21430386179e-07 0.85 4.21462144309e-07 0.952512626584 4.21493902439e-07 1.2 4.21525660569e-07 1.44748737342 4.21557418699e-07 1.55 4.21589176829e-07 1.44748737342 4.21620934959e-07 1.2 4.21652693089e-07 0.952512626585 4.2168445122e-07 0.85 4.2171620935e-07 0.952512626584 4.2174796748e-07 1.2 4.2177972561e-07 1.44748737342 4.2181148374e-07 1.55 4.2184324187e-07 1.44748737342 4.21875e-07 1.2 4.2190675813e-07 0.952512626585 4.2193851626e-07 0.85 4.2197027439e-07 0.952512626585 4.2200203252e-07 1.2 4.2203379065e-07 1.44748737342 4.2206554878e-07 1.55 4.22097306911e-07 1.44748737342 4.22129065041e-07 1.2 4.22160823171e-07 0.952512626585 4.22192581301e-07 0.85 4.22224339431e-07 0.952512626585 4.22256097561e-07 1.2 4.22287855691e-07 1.44748737342 4.22319613821e-07 1.55 4.22351371951e-07 1.44748737342 4.22383130081e-07 1.2 4.22414888211e-07 0.952512626585 4.22446646341e-07 0.85 4.22478404472e-07 0.952512626585 4.22510162602e-07 1.2 4.22541920732e-07 1.44748737342 4.22573678862e-07 1.55 4.22605436992e-07 1.44748737341 4.22637195122e-07 1.2 4.22668953252e-07 0.952512626585 4.22700711382e-07 0.85 4.22732469512e-07 0.952512626585 4.22764227642e-07 1.2 4.22795985772e-07 1.44748737342 4.22827743902e-07 1.55 4.22859502033e-07 1.44748737342 4.22891260163e-07 1.2 4.22923018293e-07 0.952512626585 4.22954776423e-07 0.85 4.22986534553e-07 0.952512626585 4.23018292683e-07 1.2 4.23050050813e-07 1.44748737342 4.23081808943e-07 1.55 4.23113567073e-07 1.44748737342 4.23145325203e-07 1.2 4.23177083333e-07 0.952512626585 4.23208841463e-07 0.85 4.23240599593e-07 0.952512626585 4.23272357724e-07 1.2 4.23304115854e-07 1.44748737342 4.23335873984e-07 1.55 4.23367632114e-07 1.44748737342 4.23399390244e-07 1.2 4.23431148374e-07 0.952512626584 4.23462906504e-07 0.85 4.23494664634e-07 0.952512626585 4.23526422764e-07 1.2 4.23558180894e-07 1.44748737342 4.23589939024e-07 1.55 4.23621697154e-07 1.44748737342 4.23653455285e-07 1.2 4.23685213415e-07 0.952512626585 4.23716971545e-07 0.85 4.23748729675e-07 0.952512626585 4.23780487805e-07 1.2 4.23812245935e-07 1.44748737342 4.23844004065e-07 1.55 4.23875762195e-07 1.44748737342 4.23907520325e-07 1.2 4.23939278455e-07 0.952512626585 4.23971036585e-07 0.85 4.24002794715e-07 0.952512626585 4.24034552846e-07 1.2 4.24066310976e-07 1.44748737342 4.24098069106e-07 1.55 4.24129827236e-07 1.44748737342 4.24161585366e-07 1.2 4.24193343496e-07 0.952512626585 4.24225101626e-07 0.85 4.24256859756e-07 0.952512626585 4.24288617886e-07 1.2 4.24320376016e-07 1.44748737342 4.24352134146e-07 1.55 4.24383892276e-07 1.44748737342 4.24415650407e-07 1.2 4.24447408537e-07 0.952512626585 4.24479166667e-07 0.85 4.24510924797e-07 0.952512626584 4.24542682927e-07 1.2 4.24574441057e-07 1.44748737342 4.24606199187e-07 1.55 4.24637957317e-07 1.44748737342 4.24669715447e-07 1.2 4.24701473577e-07 0.952512626585 4.24733231707e-07 0.85 4.24764989837e-07 0.952512626585 4.24796747967e-07 1.2 4.24828506098e-07 1.44748737342 4.24860264228e-07 1.55 4.24892022358e-07 1.44748737342 4.24923780488e-07 1.2 4.24955538618e-07 0.952512626585 4.24987296748e-07 0.85 4.25019054878e-07 0.952512626584 4.25050813008e-07 1.2 4.25082571138e-07 1.44748737342 4.25114329268e-07 1.55 4.25146087398e-07 1.44748737342 4.25177845528e-07 1.2 4.25209603659e-07 0.952512626585 4.25241361789e-07 0.85 4.25273119919e-07 0.952512626585 4.25304878049e-07 1.2 4.25336636179e-07 1.44748737341 4.25368394309e-07 1.55 4.25400152439e-07 1.44748737342 4.25431910569e-07 1.2 4.25463668699e-07 0.952512626585 4.25495426829e-07 0.85 4.25527184959e-07 0.952512626585 4.25558943089e-07 1.2 4.2559070122e-07 1.44748737342 4.2562245935e-07 1.55 4.2565421748e-07 1.44748737342 4.2568597561e-07 1.2 4.2571773374e-07 0.952512626585 4.2574949187e-07 0.85 4.2578125e-07 0.952512626584 4.2581300813e-07 1.2 4.2584476626e-07 1.44748737342 4.2587652439e-07 1.55 4.2590828252e-07 1.44748737342 4.2594004065e-07 1.2 4.2597179878e-07 0.952512626585 4.26003556911e-07 0.85 4.26035315041e-07 0.952512626585 4.26067073171e-07 1.2 4.26098831301e-07 1.44748737342 4.26130589431e-07 1.55 4.26162347561e-07 1.44748737342 4.26194105691e-07 1.2 4.26225863821e-07 0.952512626584 4.26257621951e-07 0.85 4.26289380081e-07 0.952512626585 4.26321138211e-07 1.2 4.26352896341e-07 1.44748737342 4.26384654472e-07 1.55 4.26416412602e-07 1.44748737342 4.26448170732e-07 1.2 4.26479928862e-07 0.952512626585 4.26511686992e-07 0.85 4.26543445122e-07 0.952512626585 4.26575203252e-07 1.2 4.26606961382e-07 1.44748737342 4.26638719512e-07 1.55 4.26670477642e-07 1.44748737342 4.26702235772e-07 1.2 4.26733993902e-07 0.952512626585 4.26765752033e-07 0.85 4.26797510163e-07 0.952512626585 4.26829268293e-07 1.2 4.26861026423e-07 1.44748737342 4.26892784553e-07 1.55 4.26924542683e-07 1.44748737342 4.26956300813e-07 1.2 4.26988058943e-07 0.952512626584 4.27019817073e-07 0.85 4.27051575203e-07 0.952512626585 4.27083333333e-07 1.2 4.27115091463e-07 1.44748737342 4.27146849593e-07 1.55 4.27178607724e-07 1.44748737342 4.27210365854e-07 1.2 4.27242123984e-07 0.952512626585 4.27273882114e-07 0.85 4.27305640244e-07 0.952512626585 4.27337398374e-07 1.2 4.27369156504e-07 1.44748737342 4.27400914634e-07 1.55 4.27432672764e-07 1.44748737342 4.27464430894e-07 1.2 4.27496189024e-07 0.952512626585 4.27527947154e-07 0.85 4.27559705285e-07 0.952512626585 4.27591463415e-07 1.2 4.27623221545e-07 1.44748737342 4.27654979675e-07 1.55 4.27686737805e-07 1.44748737342 4.27718495935e-07 1.2 4.27750254065e-07 0.952512626585 4.27782012195e-07 0.85 4.27813770325e-07 0.952512626585 4.27845528455e-07 1.2 4.27877286585e-07 1.44748737342 4.27909044715e-07 1.55 4.27940802846e-07 1.44748737342 4.27972560976e-07 1.2 4.28004319106e-07 0.952512626585 4.28036077236e-07 0.85 4.28067835366e-07 0.952512626585 4.28099593496e-07 1.2 4.28131351626e-07 1.44748737342 4.28163109756e-07 1.55 4.28194867886e-07 1.44748737342 4.28226626016e-07 1.2 4.28258384146e-07 0.952512626585 4.28290142276e-07 0.85 4.28321900407e-07 0.952512626585 4.28353658537e-07 1.2 4.28385416667e-07 1.44748737342 4.28417174797e-07 1.55 4.28448932927e-07 1.44748737342 4.28480691057e-07 1.2 4.28512449187e-07 0.952512626585 4.28544207317e-07 0.85 4.28575965447e-07 0.952512626585 4.28607723577e-07 1.2 4.28639481707e-07 1.44748737342 4.28671239837e-07 1.55 4.28702997967e-07 1.44748737342 4.28734756098e-07 1.2 4.28766514228e-07 0.952512626585 4.28798272358e-07 0.85 4.28830030488e-07 0.952512626585 4.28861788618e-07 1.2 4.28893546748e-07 1.44748737341 4.28925304878e-07 1.55 4.28957063008e-07 1.44748737342 4.28988821138e-07 1.2 4.29020579268e-07 0.952512626585 4.29052337398e-07 0.85 4.29084095528e-07 0.952512626585 4.29115853659e-07 1.2 4.29147611789e-07 1.44748737342 4.29179369919e-07 1.55 4.29211128049e-07 1.44748737342 4.29242886179e-07 1.2 4.29274644309e-07 0.952512626585 4.29306402439e-07 0.85 4.29338160569e-07 0.952512626584 4.29369918699e-07 1.2 4.29401676829e-07 1.44748737342 4.29433434959e-07 1.55 4.29465193089e-07 1.44748737342 4.2949695122e-07 1.2 4.2952870935e-07 0.952512626585 4.2956046748e-07 0.85 4.2959222561e-07 0.952512626585 4.2962398374e-07 1.2 4.2965574187e-07 1.44748737342 4.296875e-07 1.55 4.2971925813e-07 1.44748737342 4.2975101626e-07 1.2 4.2978277439e-07 0.952512626585 4.2981453252e-07 0.85 4.2984629065e-07 0.952512626585 4.2987804878e-07 1.2 4.29909806911e-07 1.44748737342 4.29941565041e-07 1.55 4.29973323171e-07 1.44748737342 4.30005081301e-07 1.2 4.30036839431e-07 0.952512626585 4.30068597561e-07 0.85 4.30100355691e-07 0.952512626584 4.30132113821e-07 1.2 4.30163871951e-07 1.44748737342 4.30195630081e-07 1.55 4.30227388211e-07 1.44748737342 4.30259146341e-07 1.2 4.30290904472e-07 0.952512626585 4.30322662602e-07 0.85 4.30354420732e-07 0.952512626585 4.30386178862e-07 1.2 4.30417936992e-07 1.44748737342 4.30449695122e-07 1.55 4.30481453252e-07 1.44748737342 4.30513211382e-07 1.2 4.30544969512e-07 0.952512626584 4.30576727642e-07 0.85 4.30608485772e-07 0.952512626585 4.30640243902e-07 1.2 4.30672002033e-07 1.44748737342 4.30703760163e-07 1.55 4.30735518293e-07 1.44748737342 4.30767276423e-07 1.2 4.30799034553e-07 0.952512626585 4.30830792683e-07 0.85 4.30862550813e-07 0.952512626585 4.30894308943e-07 1.2 4.30926067073e-07 1.44748737342 4.30957825203e-07 1.55 4.30989583333e-07 1.44748737342 4.31021341463e-07 1.2 4.31053099593e-07 0.952512626585 4.31084857724e-07 0.85 4.31116615854e-07 0.952512626585 4.31148373984e-07 1.2 4.31180132114e-07 1.44748737342 4.31211890244e-07 1.55 4.31243648374e-07 1.44748737342 4.31275406504e-07 1.2 4.31307164634e-07 0.952512626585 4.31338922764e-07 0.85 4.31370680894e-07 0.952512626585 4.31402439024e-07 1.2 4.31434197154e-07 1.44748737342 4.31465955285e-07 1.55 4.31497713415e-07 1.44748737342 4.31529471545e-07 1.2 4.31561229675e-07 0.952512626585 4.31592987805e-07 0.85 4.31624745935e-07 0.952512626585 4.31656504065e-07 1.2 4.31688262195e-07 1.44748737342 4.31720020325e-07 1.55 4.31751778455e-07 1.44748737342 4.31783536585e-07 1.2 4.31815294715e-07 0.952512626584 4.31847052846e-07 0.85 4.31878810976e-07 0.952512626585 4.31910569106e-07 1.2 4.31942327236e-07 1.44748737342 4.31974085366e-07 1.55 4.32005843496e-07 1.44748737342 4.32037601626e-07 1.2 4.32069359756e-07 0.952512626585 4.32101117886e-07 0.85 4.32132876016e-07 0.952512626585 4.32164634146e-07 1.2 4.32196392276e-07 1.44748737342 4.32228150407e-07 1.55 4.32259908537e-07 1.44748737342 4.32291666667e-07 1.2 4.32323424797e-07 0.952512626585 4.32355182927e-07 0.85 4.32386941057e-07 0.952512626585 4.32418699187e-07 1.2 4.32450457317e-07 1.44748737342 4.32482215447e-07 1.55 4.32513973577e-07 1.44748737342 4.32545731707e-07 1.2 4.32577489837e-07 0.952512626585 4.32609247967e-07 0.85 4.32641006098e-07 0.952512626585 4.32672764228e-07 1.2 4.32704522358e-07 1.44748737342 4.32736280488e-07 1.55 4.32768038618e-07 1.44748737342 4.32799796748e-07 1.2 4.32831554878e-07 0.952512626585 4.32863313008e-07 0.85 4.32895071138e-07 0.952512626584 4.32926829268e-07 1.2 4.32958587398e-07 1.44748737342 4.32990345528e-07 1.55 4.33022103659e-07 1.44748737342 4.33053861789e-07 1.2 4.33085619919e-07 0.952512626585 4.33117378049e-07 0.85 4.33149136179e-07 0.952512626585 4.33180894309e-07 1.2 4.33212652439e-07 1.44748737342 4.33244410569e-07 1.55 4.33276168699e-07 1.44748737342 4.33307926829e-07 1.2 4.33339684959e-07 0.952512626585 4.33371443089e-07 0.85 4.3340320122e-07 0.952512626584 4.3343495935e-07 1.2 4.3346671748e-07 1.44748737342 4.3349847561e-07 1.55 4.3353023374e-07 1.44748737342 4.3356199187e-07 1.2 4.3359375e-07 0.952512626585 4.3362550813e-07 0.85 4.3365726626e-07 0.952512626585 4.3368902439e-07 1.2 4.3372078252e-07 1.44748737341 4.3375254065e-07 1.55 4.3378429878e-07 1.44748737342 4.33816056911e-07 1.2 4.33847815041e-07 0.952512626585 4.33879573171e-07 0.85 4.33911331301e-07 0.952512626585 4.33943089431e-07 1.2 4.33974847561e-07 1.44748737342 4.34006605691e-07 1.55 4.34038363821e-07 1.44748737342 4.34070121951e-07 1.2 4.34101880081e-07 0.952512626585 4.34133638211e-07 0.85 4.34165396341e-07 0.952512626585 4.34197154472e-07 1.2 4.34228912602e-07 1.44748737342 4.34260670732e-07 1.55 4.34292428862e-07 1.44748737342 4.34324186992e-07 1.2 4.34355945122e-07 0.952512626585 4.34387703252e-07 0.85 4.34419461382e-07 0.952512626585 4.34451219512e-07 1.2 4.34482977642e-07 1.44748737342 4.34514735772e-07 1.55 4.34546493902e-07 1.44748737342 4.34578252033e-07 1.2 4.34610010163e-07 0.952512626585 4.34641768293e-07 0.85 4.34673526423e-07 0.952512626585 4.34705284553e-07 1.2 4.34737042683e-07 1.44748737342 4.34768800813e-07 1.55 4.34800558943e-07 1.44748737342 4.34832317073e-07 1.2 4.34864075203e-07 0.952512626585 4.34895833333e-07 0.85 4.34927591463e-07 0.952512626585 4.34959349593e-07 1.2 4.34991107724e-07 1.44748737342 4.35022865854e-07 1.55 4.35054623984e-07 1.44748737342 4.35086382114e-07 1.2 4.35118140244e-07 0.952512626585 4.35149898374e-07 0.85 4.35181656504e-07 0.952512626585 4.35213414634e-07 1.2 4.35245172764e-07 1.44748737342 4.35276930894e-07 1.55 4.35308689024e-07 1.44748737342 4.35340447154e-07 1.2 4.35372205285e-07 0.952512626584 4.35403963415e-07 0.85 4.35435721545e-07 0.952512626585 4.35467479675e-07 1.2 4.35499237805e-07 1.44748737342 4.35530995935e-07 1.55 4.35562754065e-07 1.44748737342 4.35594512195e-07 1.2 4.35626270325e-07 0.952512626585 4.35658028455e-07 0.85 4.35689786585e-07 0.952512626585 4.35721544715e-07 1.2 4.35753302846e-07 1.44748737342 4.35785060976e-07 1.55 4.35816819106e-07 1.44748737342 4.35848577236e-07 1.2 4.35880335366e-07 0.952512626585 4.35912093496e-07 0.85 4.35943851626e-07 0.952512626585 4.35975609756e-07 1.2 4.36007367886e-07 1.44748737342 4.36039126016e-07 1.55 4.36070884146e-07 1.44748737342 4.36102642276e-07 1.2 4.36134400407e-07 0.952512626585 4.36166158537e-07 0.85 4.36197916667e-07 0.952512626585 4.36229674797e-07 1.2 4.36261432927e-07 1.44748737342 4.36293191057e-07 1.55 4.36324949187e-07 1.44748737342 4.36356707317e-07 1.2 4.36388465447e-07 0.952512626585 4.36420223577e-07 0.85 4.36451981707e-07 0.952512626585 4.36483739837e-07 1.2 4.36515497967e-07 1.44748737342 4.36547256098e-07 1.55 4.36579014228e-07 1.44748737342 4.36610772358e-07 1.2 4.36642530488e-07 0.952512626585 4.36674288618e-07 0.85 4.36706046748e-07 0.952512626585 4.36737804878e-07 1.2 4.36769563008e-07 1.44748737342 4.36801321138e-07 1.55 4.36833079268e-07 1.44748737342 4.36864837398e-07 1.2 4.36896595528e-07 0.952512626585 4.36928353659e-07 0.85 4.36960111789e-07 0.952512626584 4.36991869919e-07 1.2 4.37023628049e-07 1.44748737342 4.37055386179e-07 1.55 4.37087144309e-07 1.44748737342 4.37118902439e-07 1.2 4.37150660569e-07 0.952512626585 4.37182418699e-07 0.85 4.37214176829e-07 0.952512626585 4.37245934959e-07 1.2 4.37277693089e-07 1.44748737341 4.3730945122e-07 1.55 4.3734120935e-07 1.44748737342 4.3737296748e-07 1.2 4.3740472561e-07 0.952512626585 4.3743648374e-07 0.85 4.3746824187e-07 0.952512626585 4.375e-07 1.2 4.3753175813e-07 1.44748737342 4.3756351626e-07 1.55 4.3759527439e-07 1.44748737342 4.3762703252e-07 1.2 4.3765879065e-07 0.952512626585 4.3769054878e-07 0.85 4.37722306911e-07 0.952512626584 4.37754065041e-07 1.2 4.37785823171e-07 1.44748737342 4.37817581301e-07 1.55 4.37849339431e-07 1.44748737342 4.37881097561e-07 1.2 4.37912855691e-07 0.952512626585 4.37944613821e-07 0.85 4.37976371951e-07 0.952512626585 4.38008130081e-07 1.2 4.38039888211e-07 1.44748737342 4.38071646341e-07 1.55 4.38103404472e-07 1.44748737342 4.38135162602e-07 1.2 4.38166920732e-07 0.952512626585 4.38198678862e-07 0.85 4.38230436992e-07 0.952512626585 4.38262195122e-07 1.2 4.38293953252e-07 1.44748737342 4.38325711382e-07 1.55 4.38357469512e-07 1.44748737342 4.38389227642e-07 1.2 4.38420985772e-07 0.952512626585 4.38452743902e-07 0.85 4.38484502033e-07 0.952512626585 4.38516260163e-07 1.2 4.38548018293e-07 1.44748737342 4.38579776423e-07 1.55 4.38611534553e-07 1.44748737341 4.38643292683e-07 1.2 4.38675050813e-07 0.952512626585 4.38706808943e-07 0.85 4.38738567073e-07 0.952512626585 4.38770325203e-07 1.2 4.38802083333e-07 1.44748737342 4.38833841463e-07 1.55 4.38865599593e-07 1.44748737342 4.38897357724e-07 1.2 4.38929115854e-07 0.952512626584 4.38960873984e-07 0.85 4.38992632114e-07 0.952512626585 4.39024390244e-07 1.2 4.39056148374e-07 1.44748737342 4.39087906504e-07 1.55 4.39119664634e-07 1.44748737342 4.39151422764e-07 1.2 4.39183180894e-07 0.952512626585 4.39214939024e-07 0.85 4.39246697154e-07 0.952512626585 4.39278455285e-07 1.2 4.39310213415e-07 1.44748737342 4.39341971545e-07 1.55 4.39373729675e-07 1.44748737342 4.39405487805e-07 1.2 4.39437245935e-07 0.952512626585 4.39469004065e-07 0.85 4.39500762195e-07 0.952512626585 4.39532520325e-07 1.2 4.39564278455e-07 1.44748737342 4.39596036585e-07 1.55 4.39627794715e-07 1.44748737342 4.39659552846e-07 1.2 4.39691310976e-07 0.952512626585 4.39723069106e-07 0.85 4.39754827236e-07 0.952512626585 4.39786585366e-07 1.2 4.39818343496e-07 1.44748737342 4.39850101626e-07 1.55 4.39881859756e-07 1.44748737342 4.39913617886e-07 1.2 4.39945376016e-07 0.952512626585 4.39977134146e-07 0.85 4.40008892276e-07 0.952512626585 4.40040650407e-07 1.2 4.40072408537e-07 1.44748737342 4.40104166667e-07 1.55 4.40135924797e-07 1.44748737342 4.40167682927e-07 1.2 4.40199441057e-07 0.952512626585 4.40231199187e-07 0.85 4.40262957317e-07 0.952512626585 4.40294715447e-07 1.2 4.40326473577e-07 1.44748737342 4.40358231707e-07 1.55 4.40389989837e-07 1.44748737342 4.40421747967e-07 1.2 4.40453506098e-07 0.952512626585 4.40485264228e-07 0.85 4.40517022358e-07 0.952512626584 4.40548780488e-07 1.2 4.40580538618e-07 1.44748737342 4.40612296748e-07 1.55 4.40644054878e-07 1.44748737342 4.40675813008e-07 1.2 4.40707571138e-07 0.952512626585 4.40739329268e-07 0.85 4.40771087398e-07 0.952512626585 4.40802845528e-07 1.2 4.40834603659e-07 1.44748737342 4.40866361789e-07 1.55 4.40898119919e-07 1.44748737342 4.40929878049e-07 1.2 4.40961636179e-07 0.952512626585 4.40993394309e-07 0.85 4.41025152439e-07 0.952512626585 4.41056910569e-07 1.2 4.41088668699e-07 1.44748737342 4.41120426829e-07 1.55 4.41152184959e-07 1.44748737342 4.41183943089e-07 1.2 4.4121570122e-07 0.952512626585 4.4124745935e-07 0.85 4.4127921748e-07 0.952512626584 4.4131097561e-07 1.2 4.4134273374e-07 1.44748737342 4.4137449187e-07 1.55 4.4140625e-07 1.44748737342 4.4143800813e-07 1.2 4.4146976626e-07 0.952512626585 4.4150152439e-07 0.85 4.4153328252e-07 0.952512626585 4.4156504065e-07 1.2 4.4159679878e-07 1.44748737342 4.41628556911e-07 1.55 4.41660315041e-07 1.44748737342 4.41692073171e-07 1.2 4.41723831301e-07 0.952512626585 4.41755589431e-07 0.85 4.41787347561e-07 0.952512626584 4.41819105691e-07 1.2 4.41850863821e-07 1.44748737342 4.41882621951e-07 1.55 4.41914380081e-07 1.44748737342 4.41946138211e-07 1.2 4.41977896341e-07 0.952512626585 4.42009654472e-07 0.85 4.42041412602e-07 0.952512626585 4.42073170732e-07 1.2 4.42104928862e-07 1.44748737342 4.42136686992e-07 1.55 4.42168445122e-07 1.44748737342 4.42200203252e-07 1.2 4.42231961382e-07 0.952512626585 4.42263719512e-07 0.85 4.42295477642e-07 0.952512626585 4.42327235772e-07 1.2 4.42358993902e-07 1.44748737342 4.42390752033e-07 1.55 4.42422510163e-07 1.44748737342 4.42454268293e-07 1.2 4.42486026423e-07 0.952512626585 4.42517784553e-07 0.85 4.42549542683e-07 0.952512626585 4.42581300813e-07 1.2 4.42613058943e-07 1.44748737342 4.42644817073e-07 1.55 4.42676575203e-07 1.44748737342 4.42708333333e-07 1.2 4.42740091463e-07 0.952512626585 4.42771849593e-07 0.85 4.42803607724e-07 0.952512626585 4.42835365854e-07 1.2 4.42867123984e-07 1.44748737342 4.42898882114e-07 1.55 4.42930640244e-07 1.44748737342 4.42962398374e-07 1.2 4.42994156504e-07 0.952512626585 4.43025914634e-07 0.85 4.43057672764e-07 0.952512626585 4.43089430894e-07 1.2 4.43121189024e-07 1.44748737342 4.43152947154e-07 1.55 4.43184705285e-07 1.44748737342 4.43216463415e-07 1.2 4.43248221545e-07 0.952512626585 4.43279979675e-07 0.85 4.43311737805e-07 0.952512626585 4.43343495935e-07 1.2 4.43375254065e-07 1.44748737342 4.43407012195e-07 1.55 4.43438770325e-07 1.44748737342 4.43470528455e-07 1.2 4.43502286585e-07 0.952512626585 4.43534044715e-07 0.85 4.43565802846e-07 0.952512626585 4.43597560976e-07 1.2 4.43629319106e-07 1.44748737342 4.43661077236e-07 1.55 4.43692835366e-07 1.44748737342 4.43724593496e-07 1.2 4.43756351626e-07 0.952512626584 4.43788109756e-07 0.85 4.43819867886e-07 0.952512626585 4.43851626016e-07 1.2 4.43883384146e-07 1.44748737342 4.43915142276e-07 1.55 4.43946900407e-07 1.44748737342 4.43978658537e-07 1.2 4.44010416667e-07 0.952512626585 4.44042174797e-07 0.85 4.44073932927e-07 0.952512626585 4.44105691057e-07 1.2 4.44137449187e-07 1.44748737342 4.44169207317e-07 1.55 4.44200965447e-07 1.44748737342 4.44232723577e-07 1.2 4.44264481707e-07 0.952512626585 4.44296239837e-07 0.85 4.44327997967e-07 0.952512626585 4.44359756098e-07 1.2 4.44391514228e-07 1.44748737342 4.44423272358e-07 1.55 4.44455030488e-07 1.44748737342 4.44486788618e-07 1.2 4.44518546748e-07 0.952512626585 4.44550304878e-07 0.85 4.44582063008e-07 0.952512626585 4.44613821138e-07 1.2 4.44645579268e-07 1.44748737342 4.44677337398e-07 1.55 4.44709095528e-07 1.44748737342 4.44740853659e-07 1.2 4.44772611789e-07 0.952512626585 4.44804369919e-07 0.85 4.44836128049e-07 0.952512626585 4.44867886179e-07 1.2 4.44899644309e-07 1.44748737342 4.44931402439e-07 1.55 4.44963160569e-07 1.44748737342 4.44994918699e-07 1.2 4.45026676829e-07 0.952512626585 4.45058434959e-07 0.85 4.45090193089e-07 0.952512626585 4.4512195122e-07 1.2 4.4515370935e-07 1.44748737342 4.4518546748e-07 1.55 4.4521722561e-07 1.44748737342 4.4524898374e-07 1.2 4.4528074187e-07 0.952512626585 4.453125e-07 0.85 4.4534425813e-07 0.952512626584 4.4537601626e-07 1.2 4.4540777439e-07 1.44748737342 4.4543953252e-07 1.55 4.4547129065e-07 1.44748737342 4.4550304878e-07 1.2 4.45534806911e-07 0.952512626585 4.45566565041e-07 0.85 4.45598323171e-07 0.952512626585 4.45630081301e-07 1.2 4.45661839431e-07 1.44748737341 4.45693597561e-07 1.55 4.45725355691e-07 1.44748737342 4.45757113821e-07 1.2 4.45788871951e-07 0.952512626585 4.45820630081e-07 0.85 4.45852388211e-07 0.952512626585 4.45884146341e-07 1.2 4.45915904472e-07 1.44748737342 4.45947662602e-07 1.55 4.45979420732e-07 1.44748737342 4.46011178862e-07 1.2 4.46042936992e-07 0.952512626585 4.46074695122e-07 0.85 4.46106453252e-07 0.952512626584 4.46138211382e-07 1.2 4.46169969512e-07 1.44748737342 4.46201727642e-07 1.55 4.46233485772e-07 1.44748737342 4.46265243902e-07 1.2 4.46297002033e-07 0.952512626585 4.46328760163e-07 0.85 4.46360518293e-07 0.952512626585 4.46392276423e-07 1.2 4.46424034553e-07 1.44748737342 4.46455792683e-07 1.55 4.46487550813e-07 1.44748737342 4.46519308943e-07 1.2 4.46551067073e-07 0.952512626584 4.46582825203e-07 0.85 4.46614583333e-07 0.952512626585 4.46646341463e-07 1.2 4.46678099593e-07 1.44748737342 4.46709857724e-07 1.55 4.46741615854e-07 1.44748737342 4.46773373984e-07 1.2 4.46805132114e-07 0.952512626585 4.46836890244e-07 0.85 4.46868648374e-07 0.952512626585 4.46900406504e-07 1.2 4.46932164634e-07 1.44748737342 4.46963922764e-07 1.55 4.46995680894e-07 1.44748737341 4.47027439024e-07 1.2 4.47059197154e-07 0.952512626585 4.47090955285e-07 0.85 4.47122713415e-07 0.952512626585 4.47154471545e-07 1.2 4.47186229675e-07 1.44748737342 4.47217987805e-07 1.55 4.47249745935e-07 1.44748737342 4.47281504065e-07 1.2 4.47313262195e-07 0.952512626584 4.47345020325e-07 0.85 4.47376778455e-07 0.952512626585 4.47408536585e-07 1.2 4.47440294715e-07 1.44748737342 4.47472052846e-07 1.55 4.47503810976e-07 1.44748737342 4.47535569106e-07 1.2 4.47567327236e-07 0.952512626585 4.47599085366e-07 0.85 4.47630843496e-07 0.952512626585 4.47662601626e-07 1.2 4.47694359756e-07 1.44748737342 4.47726117886e-07 1.55 4.47757876016e-07 1.44748737342 4.47789634146e-07 1.2 4.47821392276e-07 0.952512626585 4.47853150407e-07 0.85 4.47884908537e-07 0.952512626585 4.47916666667e-07 1.2 4.47948424797e-07 1.44748737342 4.47980182927e-07 1.55 4.48011941057e-07 1.44748737342 4.48043699187e-07 1.2 4.48075457317e-07 0.952512626585 4.48107215447e-07 0.85 4.48138973577e-07 0.952512626585 4.48170731707e-07 1.2 4.48202489837e-07 1.44748737342 4.48234247967e-07 1.55 4.48266006098e-07 1.44748737342 4.48297764228e-07 1.2 4.48329522358e-07 0.952512626585 4.48361280488e-07 0.85 4.48393038618e-07 0.952512626585 4.48424796748e-07 1.2 4.48456554878e-07 1.44748737342 4.48488313008e-07 1.55 4.48520071138e-07 1.44748737342 4.48551829268e-07 1.2 4.48583587398e-07 0.952512626585 4.48615345528e-07 0.85 4.48647103659e-07 0.952512626585 4.48678861789e-07 1.2 4.48710619919e-07 1.44748737342 4.48742378049e-07 1.55 4.48774136179e-07 1.44748737342 4.48805894309e-07 1.2 4.48837652439e-07 0.952512626585 4.48869410569e-07 0.85 4.48901168699e-07 0.952512626584 4.48932926829e-07 1.2 4.48964684959e-07 1.44748737342 4.48996443089e-07 1.55 4.4902820122e-07 1.44748737342 4.4905995935e-07 1.2 4.4909171748e-07 0.952512626585 4.4912347561e-07 0.85 4.4915523374e-07 0.952512626585 4.4918699187e-07 1.2 4.4921875e-07 1.44748737341 4.4925050813e-07 1.55 4.4928226626e-07 1.44748737342 4.4931402439e-07 1.2 4.4934578252e-07 0.952512626585 4.4937754065e-07 0.85 4.4940929878e-07 0.952512626585 4.49441056911e-07 1.2 4.49472815041e-07 1.44748737342 4.49504573171e-07 1.55 4.49536331301e-07 1.44748737342 4.49568089431e-07 1.2 4.49599847561e-07 0.952512626585 4.49631605691e-07 0.85 4.49663363821e-07 0.952512626584 4.49695121951e-07 1.2 4.49726880081e-07 1.44748737342 4.49758638211e-07 1.55 4.49790396341e-07 1.44748737342 4.49822154472e-07 1.2 4.49853912602e-07 0.952512626585 4.49885670732e-07 0.85 4.49917428862e-07 0.952512626585 4.49949186992e-07 1.2 4.49980945122e-07 1.44748737342 4.50012703252e-07 1.55 4.50044461382e-07 1.44748737342 4.50076219512e-07 1.2 4.50107977642e-07 0.952512626585 4.50139735772e-07 0.85 4.50171493902e-07 0.952512626585 4.50203252033e-07 1.2 4.50235010163e-07 1.44748737342 4.50266768293e-07 1.55 4.50298526423e-07 1.44748737342 4.50330284553e-07 1.2 4.50362042683e-07 0.952512626585 4.50393800813e-07 0.85 4.50425558943e-07 0.952512626585 4.50457317073e-07 1.2 4.50489075203e-07 1.44748737342 4.50520833333e-07 1.55 4.50552591463e-07 1.44748737342 4.50584349593e-07 1.2 4.50616107724e-07 0.952512626585 4.50647865854e-07 0.85 4.50679623984e-07 0.952512626585 4.50711382114e-07 1.2 4.50743140244e-07 1.44748737342 4.50774898374e-07 1.55 4.50806656504e-07 1.44748737342 4.50838414634e-07 1.2 4.50870172764e-07 0.952512626584 4.50901930894e-07 0.85 4.50933689024e-07 0.952512626585 4.50965447154e-07 1.2 4.50997205285e-07 1.44748737342 4.51028963415e-07 1.55 4.51060721545e-07 1.44748737342 4.51092479675e-07 1.2 4.51124237805e-07 0.952512626585 4.51155995935e-07 0.85 4.51187754065e-07 0.952512626585 4.51219512195e-07 1.2 4.51251270325e-07 1.44748737342 4.51283028455e-07 1.55 4.51314786585e-07 1.44748737342 4.51346544715e-07 1.2 4.51378302846e-07 0.952512626585 4.51410060976e-07 0.85 4.51441819106e-07 0.952512626585 4.51473577236e-07 1.2 4.51505335366e-07 1.44748737342 4.51537093496e-07 1.55 4.51568851626e-07 1.44748737342 4.51600609756e-07 1.2 4.51632367886e-07 0.952512626585 4.51664126016e-07 0.85 4.51695884146e-07 0.952512626585 4.51727642276e-07 1.2 4.51759400407e-07 1.44748737342 4.51791158537e-07 1.55 4.51822916667e-07 1.44748737342 4.51854674797e-07 1.2 4.51886432927e-07 0.952512626585 4.51918191057e-07 0.85 4.51949949187e-07 0.952512626585 4.51981707317e-07 1.2 4.52013465447e-07 1.44748737342 4.52045223577e-07 1.55 4.52076981707e-07 1.44748737342 4.52108739837e-07 1.2 4.52140497967e-07 0.952512626584 4.52172256098e-07 0.85 4.52204014228e-07 0.952512626585 4.52235772358e-07 1.2 4.52267530488e-07 1.44748737342 4.52299288618e-07 1.55 4.52331046748e-07 1.44748737342 4.52362804878e-07 1.2 4.52394563008e-07 0.952512626585 4.52426321138e-07 0.85 4.52458079268e-07 0.952512626584 4.52489837398e-07 1.2 4.52521595528e-07 1.44748737342 4.52553353659e-07 1.55 4.52585111789e-07 1.44748737342 4.52616869919e-07 1.2 4.52648628049e-07 0.952512626585 4.52680386179e-07 0.85 4.52712144309e-07 0.952512626585 4.52743902439e-07 1.2 4.52775660569e-07 1.44748737342 4.52807418699e-07 1.55 4.52839176829e-07 1.44748737342 4.52870934959e-07 1.2 4.52902693089e-07 0.952512626585 4.5293445122e-07 0.85 4.5296620935e-07 0.952512626585 4.5299796748e-07 1.2 4.5302972561e-07 1.44748737342 4.5306148374e-07 1.55 4.5309324187e-07 1.44748737342 4.53125e-07 1.2 4.5315675813e-07 0.952512626585 4.5318851626e-07 0.85 4.5322027439e-07 0.952512626585 4.5325203252e-07 1.2 4.5328379065e-07 1.44748737342 4.5331554878e-07 1.55 4.53347306911e-07 1.44748737342 4.53379065041e-07 1.2 4.53410823171e-07 0.952512626585 4.53442581301e-07 0.85 4.53474339431e-07 0.952512626585 4.53506097561e-07 1.2 4.53537855691e-07 1.44748737342 4.53569613821e-07 1.55 4.53601371951e-07 1.44748737342 4.53633130081e-07 1.2 4.53664888211e-07 0.952512626585 4.53696646341e-07 0.85 4.53728404472e-07 0.952512626584 4.53760162602e-07 1.2 4.53791920732e-07 1.44748737342 4.53823678862e-07 1.55 4.53855436992e-07 1.44748737342 4.53887195122e-07 1.2 4.53918953252e-07 0.952512626585 4.53950711382e-07 0.85 4.53982469512e-07 0.952512626585 4.54014227642e-07 1.2 4.54045985772e-07 1.44748737341 4.54077743902e-07 1.55 4.54109502033e-07 1.44748737342 4.54141260163e-07 1.2 4.54173018293e-07 0.952512626585 4.54204776423e-07 0.85 4.54236534553e-07 0.952512626585 4.54268292683e-07 1.2 4.54300050813e-07 1.44748737342 4.54331808943e-07 1.55 4.54363567073e-07 1.44748737342 4.54395325203e-07 1.2 4.54427083333e-07 0.952512626585 4.54458841463e-07 0.85 4.54490599593e-07 0.952512626585 4.54522357724e-07 1.2 4.54554115854e-07 1.44748737342 4.54585873984e-07 1.55 4.54617632114e-07 1.44748737342 4.54649390244e-07 1.2 4.54681148374e-07 0.952512626585 4.54712906504e-07 0.85 4.54744664634e-07 0.952512626585 4.54776422764e-07 1.2 4.54808180894e-07 1.44748737342 4.54839939024e-07 1.55 4.54871697154e-07 1.44748737342 4.54903455285e-07 1.2 4.54935213415e-07 0.952512626584 4.54966971545e-07 0.85 4.54998729675e-07 0.952512626585 4.55030487805e-07 1.2 4.55062245935e-07 1.44748737342 4.55094004065e-07 1.55 4.55125762195e-07 1.44748737342 4.55157520325e-07 1.2 4.55189278455e-07 0.952512626585 4.55221036585e-07 0.85 4.55252794715e-07 0.952512626585 4.55284552846e-07 1.2 4.55316310976e-07 1.44748737342 4.55348069106e-07 1.55 4.55379827236e-07 1.44748737342 4.55411585366e-07 1.2 4.55443343496e-07 0.952512626585 4.55475101626e-07 0.85 4.55506859756e-07 0.952512626585 4.55538617886e-07 1.2 4.55570376016e-07 1.44748737342 4.55602134146e-07 1.55 4.55633892276e-07 1.44748737342 4.55665650407e-07 1.2 4.55697408537e-07 0.952512626584 4.55729166667e-07 0.85 4.55760924797e-07 0.952512626585 4.55792682927e-07 1.2 4.55824441057e-07 1.44748737342 4.55856199187e-07 1.55 4.55887957317e-07 1.44748737342 4.55919715447e-07 1.2 4.55951473577e-07 0.952512626585 4.55983231707e-07 0.85 4.56014989837e-07 0.952512626585 4.56046747967e-07 1.2 4.56078506098e-07 1.44748737342 4.56110264228e-07 1.55 4.56142022358e-07 1.44748737342 4.56173780488e-07 1.2 4.56205538618e-07 0.952512626585 4.56237296748e-07 0.85 4.56269054878e-07 0.952512626585 4.56300813008e-07 1.2 4.56332571138e-07 1.44748737342 4.56364329268e-07 1.55 4.56396087398e-07 1.44748737342 4.56427845528e-07 1.2 4.56459603659e-07 0.952512626585 4.56491361789e-07 0.85 4.56523119919e-07 0.952512626585 4.56554878049e-07 1.2 4.56586636179e-07 1.44748737342 4.56618394309e-07 1.55 4.56650152439e-07 1.44748737342 4.56681910569e-07 1.2 4.56713668699e-07 0.952512626585 4.56745426829e-07 0.85 4.56777184959e-07 0.952512626585 4.56808943089e-07 1.2 4.5684070122e-07 1.44748737342 4.5687245935e-07 1.55 4.5690421748e-07 1.44748737342 4.5693597561e-07 1.2 4.5696773374e-07 0.952512626585 4.5699949187e-07 0.85 4.5703125e-07 0.952512626585 4.5706300813e-07 1.2 4.5709476626e-07 1.44748737342 4.5712652439e-07 1.55 4.5715828252e-07 1.44748737342 4.5719004065e-07 1.2 4.5722179878e-07 0.952512626585 4.57253556911e-07 0.85 4.57285315041e-07 0.952512626584 4.57317073171e-07 1.2 4.57348831301e-07 1.44748737342 4.57380589431e-07 1.55 4.57412347561e-07 1.44748737342 4.57444105691e-07 1.2 4.57475863821e-07 0.952512626585 4.57507621951e-07 0.85 4.57539380081e-07 0.952512626585 4.57571138211e-07 1.2 4.57602896341e-07 1.44748737341 4.57634654472e-07 1.55 4.57666412602e-07 1.44748737342 4.57698170732e-07 1.2 4.57729928862e-07 0.952512626585 4.57761686992e-07 0.85 4.57793445122e-07 0.952512626585 4.57825203252e-07 1.2 4.57856961382e-07 1.44748737342 4.57888719512e-07 1.55 4.57920477642e-07 1.44748737342 4.57952235772e-07 1.2 4.57983993902e-07 0.952512626585 4.58015752033e-07 0.85 4.58047510163e-07 0.952512626584 4.58079268293e-07 1.2 4.58111026423e-07 1.44748737342 4.58142784553e-07 1.55 4.58174542683e-07 1.44748737342 4.58206300813e-07 1.2 4.58238058943e-07 0.952512626585 4.58269817073e-07 0.85 4.58301575203e-07 0.952512626585 4.58333333333e-07 1.2 4.58365091463e-07 1.44748737342 4.58396849593e-07 1.55 4.58428607724e-07 1.44748737342 4.58460365854e-07 1.2 4.58492123984e-07 0.952512626585 4.58523882114e-07 0.85 4.58555640244e-07 0.952512626585 4.58587398374e-07 1.2 4.58619156504e-07 1.44748737342 4.58650914634e-07 1.55 4.58682672764e-07 1.44748737342 4.58714430894e-07 1.2 4.58746189024e-07 0.952512626585 4.58777947154e-07 0.85 4.58809705285e-07 0.952512626585 4.58841463415e-07 1.2 4.58873221545e-07 1.44748737342 4.58904979675e-07 1.55 4.58936737805e-07 1.44748737342 4.58968495935e-07 1.2 4.59000254065e-07 0.952512626585 4.59032012195e-07 0.85 4.59063770325e-07 0.952512626585 4.59095528455e-07 1.2 4.59127286585e-07 1.44748737342 4.59159044715e-07 1.55 4.59190802846e-07 1.44748737342 4.59222560976e-07 1.2 4.59254319106e-07 0.952512626584 4.59286077236e-07 0.85 4.59317835366e-07 0.952512626585 4.59349593496e-07 1.2 4.59381351626e-07 1.44748737342 4.59413109756e-07 1.55 4.59444867886e-07 1.44748737342 4.59476626016e-07 1.2 4.59508384146e-07 0.952512626585 4.59540142276e-07 0.85 4.59571900407e-07 0.952512626585 4.59603658537e-07 1.2 4.59635416667e-07 1.44748737342 4.59667174797e-07 1.55 4.59698932927e-07 1.44748737342 4.59730691057e-07 1.2 4.59762449187e-07 0.952512626585 4.59794207317e-07 0.85 4.59825965447e-07 0.952512626585 4.59857723577e-07 1.2 4.59889481707e-07 1.44748737342 4.59921239837e-07 1.55 4.59952997967e-07 1.44748737342 4.59984756098e-07 1.2 4.60016514228e-07 0.952512626585 4.60048272358e-07 0.85 4.60080030488e-07 0.952512626585 4.60111788618e-07 1.2 4.60143546748e-07 1.44748737342 4.60175304878e-07 1.55 4.60207063008e-07 1.44748737342 4.60238821138e-07 1.2 4.60270579268e-07 0.952512626585 4.60302337398e-07 0.85 4.60334095528e-07 0.952512626585 4.60365853659e-07 1.2 4.60397611789e-07 1.44748737342 4.60429369919e-07 1.55 4.60461128049e-07 1.44748737342 4.60492886179e-07 1.2 4.60524644309e-07 0.952512626585 4.60556402439e-07 0.85 4.60588160569e-07 0.952512626585 4.60619918699e-07 1.2 4.60651676829e-07 1.44748737342 4.60683434959e-07 1.55 4.60715193089e-07 1.44748737342 4.6074695122e-07 1.2 4.6077870935e-07 0.952512626585 4.6081046748e-07 0.85 4.6084222561e-07 0.952512626584 4.6087398374e-07 1.2 4.6090574187e-07 1.44748737342 4.609375e-07 1.55 4.6096925813e-07 1.44748737342 4.6100101626e-07 1.2 4.6103277439e-07 0.952512626585 4.6106453252e-07 0.85 4.6109629065e-07 0.952512626585 4.6112804878e-07 1.2 4.61159806911e-07 1.44748737342 4.61191565041e-07 1.55 4.61223323171e-07 1.44748737342 4.61255081301e-07 1.2 4.61286839431e-07 0.952512626585 4.61318597561e-07 0.85 4.61350355691e-07 0.952512626585 4.61382113821e-07 1.2 4.61413871951e-07 1.44748737342 4.61445630081e-07 1.55 4.61477388211e-07 1.44748737342 4.61509146341e-07 1.2 4.61540904472e-07 0.952512626585 4.61572662602e-07 0.85 4.61604420732e-07 0.952512626585 4.61636178862e-07 1.2 4.61667936992e-07 1.44748737342 4.61699695122e-07 1.55 4.61731453252e-07 1.44748737342 4.61763211382e-07 1.2 4.61794969512e-07 0.952512626585 4.61826727642e-07 0.85 4.61858485772e-07 0.952512626585 4.61890243902e-07 1.2 4.61922002033e-07 1.44748737342 4.61953760163e-07 1.55 4.61985518293e-07 1.44748737342 4.62017276423e-07 1.2 4.62049034553e-07 0.952512626585 4.62080792683e-07 0.85 4.62112550813e-07 0.952512626584 4.62144308943e-07 1.2 4.62176067073e-07 1.44748737342 4.62207825203e-07 1.55 4.62239583333e-07 1.44748737342 4.62271341463e-07 1.2 4.62303099593e-07 0.952512626585 4.62334857724e-07 0.85 4.62366615854e-07 0.952512626585 4.62398373984e-07 1.2 4.62430132114e-07 1.44748737342 4.62461890244e-07 1.55 4.62493648374e-07 1.44748737342 4.62525406504e-07 1.2 4.62557164634e-07 0.952512626585 4.62588922764e-07 0.85 4.62620680894e-07 0.952512626585 4.62652439024e-07 1.2 4.62684197154e-07 1.44748737342 4.62715955285e-07 1.55 4.62747713415e-07 1.44748737342 4.62779471545e-07 1.2 4.62811229675e-07 0.952512626585 4.62842987805e-07 0.85 4.62874745935e-07 0.952512626585 4.62906504065e-07 1.2 4.62938262195e-07 1.44748737342 4.62970020325e-07 1.55 4.63001778455e-07 1.44748737342 4.63033536585e-07 1.2 4.63065294715e-07 0.952512626585 4.63097052846e-07 0.85 4.63128810976e-07 0.952512626585 4.63160569106e-07 1.2 4.63192327236e-07 1.44748737342 4.63224085366e-07 1.55 4.63255843496e-07 1.44748737342 4.63287601626e-07 1.2 4.63319359756e-07 0.952512626584 4.63351117886e-07 0.85 4.63382876016e-07 0.952512626585 4.63414634146e-07 1.2 4.63446392276e-07 1.44748737342 4.63478150407e-07 1.55 4.63509908537e-07 1.44748737342 4.63541666667e-07 1.2 4.63573424797e-07 0.952512626585 4.63605182927e-07 0.85 4.63636941057e-07 0.952512626585 4.63668699187e-07 1.2 4.63700457317e-07 1.44748737342 4.63732215447e-07 1.55 4.63763973577e-07 1.44748737342 4.63795731707e-07 1.2 4.63827489837e-07 0.952512626585 4.63859247967e-07 0.85 4.63891006098e-07 0.952512626585 4.63922764228e-07 1.2 4.63954522358e-07 1.44748737342 4.63986280488e-07 1.55 4.64018038618e-07 1.44748737342 4.64049796748e-07 1.2 4.64081554878e-07 0.952512626584 4.64113313008e-07 0.85 4.64145071138e-07 0.952512626585 4.64176829268e-07 1.2 4.64208587398e-07 1.44748737342 4.64240345528e-07 1.55 4.64272103659e-07 1.44748737342 4.64303861789e-07 1.2 4.64335619919e-07 0.952512626585 4.64367378049e-07 0.85 4.64399136179e-07 0.952512626584 4.64430894309e-07 1.2 4.64462652439e-07 1.44748737342 4.64494410569e-07 1.55 4.64526168699e-07 1.44748737342 4.64557926829e-07 1.2 4.64589684959e-07 0.952512626585 4.64621443089e-07 0.85 4.6465320122e-07 0.952512626585 4.6468495935e-07 1.2 4.6471671748e-07 1.44748737342 4.6474847561e-07 1.55 4.6478023374e-07 1.44748737342 4.6481199187e-07 1.2 4.6484375e-07 0.952512626585 4.6487550813e-07 0.85 4.6490726626e-07 0.952512626585 4.6493902439e-07 1.2 4.6497078252e-07 1.44748737342 4.6500254065e-07 1.55 4.6503429878e-07 1.44748737342 4.65066056911e-07 1.2 4.65097815041e-07 0.952512626585 4.65129573171e-07 0.85 4.65161331301e-07 0.952512626585 4.65193089431e-07 1.2 4.65224847561e-07 1.44748737342 4.65256605691e-07 1.55 4.65288363821e-07 1.44748737342 4.65320121951e-07 1.2 4.65351880081e-07 0.952512626585 4.65383638211e-07 0.85 4.65415396341e-07 0.952512626585 4.65447154472e-07 1.2 4.65478912602e-07 1.44748737342 4.65510670732e-07 1.55 4.65542428862e-07 1.44748737342 4.65574186992e-07 1.2 4.65605945122e-07 0.952512626585 4.65637703252e-07 0.85 4.65669461382e-07 0.952512626584 4.65701219512e-07 1.2 4.65732977642e-07 1.44748737342 4.65764735772e-07 1.55 4.65796493902e-07 1.44748737342 4.65828252033e-07 1.2 4.65860010163e-07 0.952512626585 4.65891768293e-07 0.85 4.65923526423e-07 0.952512626585 4.65955284553e-07 1.2 4.65987042683e-07 1.44748737341 4.66018800813e-07 1.55 4.66050558943e-07 1.44748737342 4.66082317073e-07 1.2 4.66114075203e-07 0.952512626585 4.66145833333e-07 0.85 4.66177591463e-07 0.952512626585 4.66209349593e-07 1.2 4.66241107724e-07 1.44748737342 4.66272865854e-07 1.55 4.66304623984e-07 1.44748737342 4.66336382114e-07 1.2 4.66368140244e-07 0.952512626585 4.66399898374e-07 0.85 4.66431656504e-07 0.952512626584 4.66463414634e-07 1.2 4.66495172764e-07 1.44748737342 4.66526930894e-07 1.55 4.66558689024e-07 1.44748737342 4.66590447154e-07 1.2 4.66622205285e-07 0.952512626585 4.66653963415e-07 0.85 4.66685721545e-07 0.952512626585 4.66717479675e-07 1.2 4.66749237805e-07 1.44748737342 4.66780995935e-07 1.55 4.66812754065e-07 1.44748737342 4.66844512195e-07 1.2 4.66876270325e-07 0.952512626584 4.66908028455e-07 0.85 4.66939786585e-07 0.952512626585 4.66971544715e-07 1.2 4.67003302846e-07 1.44748737342 4.67035060976e-07 1.55 4.67066819106e-07 1.44748737342 4.67098577236e-07 1.2 4.67130335366e-07 0.952512626585 4.67162093496e-07 0.85 4.67193851626e-07 0.952512626585 4.67225609756e-07 1.2 4.67257367886e-07 1.44748737342 4.67289126016e-07 1.55 4.67320884146e-07 1.44748737341 4.67352642276e-07 1.2 4.67384400407e-07 0.952512626585 4.67416158537e-07 0.85 4.67447916667e-07 0.952512626585 4.67479674797e-07 1.2 4.67511432927e-07 1.44748737342 4.67543191057e-07 1.55 4.67574949187e-07 1.44748737342 4.67606707317e-07 1.2 4.67638465447e-07 0.952512626584 4.67670223577e-07 0.85 4.67701981707e-07 0.952512626585 4.67733739837e-07 1.2 4.67765497967e-07 1.44748737342 4.67797256098e-07 1.55 4.67829014228e-07 1.44748737342 4.67860772358e-07 1.2 4.67892530488e-07 0.952512626585 4.67924288618e-07 0.85 4.67956046748e-07 0.952512626585 4.67987804878e-07 1.2 4.68019563008e-07 1.44748737342 4.68051321138e-07 1.55 4.68083079268e-07 1.44748737342 4.68114837398e-07 1.2 4.68146595528e-07 0.952512626585 4.68178353659e-07 0.85 4.68210111789e-07 0.952512626585 4.68241869919e-07 1.2 4.68273628049e-07 1.44748737342 4.68305386179e-07 1.55 4.68337144309e-07 1.44748737342 4.68368902439e-07 1.2 4.68400660569e-07 0.952512626585 4.68432418699e-07 0.85 4.68464176829e-07 0.952512626585 4.68495934959e-07 1.2 4.68527693089e-07 1.44748737342 4.6855945122e-07 1.55 4.6859120935e-07 1.44748737342 4.6862296748e-07 1.2 4.6865472561e-07 0.952512626585 4.6868648374e-07 0.85 4.6871824187e-07 0.952512626585 4.6875e-07 1.2 4.6878175813e-07 1.44748737342 4.6881351626e-07 1.55 4.6884527439e-07 1.44748737342 4.6887703252e-07 1.2 4.6890879065e-07 0.952512626585 4.6894054878e-07 0.85 4.68972306911e-07 0.952512626585 4.69004065041e-07 1.2 4.69035823171e-07 1.44748737342 4.69067581301e-07 1.55 4.69099339431e-07 1.44748737342 4.69131097561e-07 1.2 4.69162855691e-07 0.952512626585 4.69194613821e-07 0.85 4.69226371951e-07 0.952512626584 4.69258130081e-07 1.2 4.69289888211e-07 1.44748737342 4.69321646341e-07 1.55 4.69353404472e-07 1.44748737342 4.69385162602e-07 1.2 4.69416920732e-07 0.952512626585 4.69448678862e-07 0.85 4.69480436992e-07 0.952512626585 4.69512195122e-07 1.2 4.69543953252e-07 1.44748737342 4.69575711382e-07 1.55 4.69607469512e-07 1.44748737342 4.69639227642e-07 1.2 4.69670985772e-07 0.952512626585 4.69702743902e-07 0.85 4.69734502033e-07 0.952512626585 4.69766260163e-07 1.2 4.69798018293e-07 1.44748737342 4.69829776423e-07 1.55 4.69861534553e-07 1.44748737342 4.69893292683e-07 1.2 4.69925050813e-07 0.952512626585 4.69956808943e-07 0.85 4.69988567073e-07 0.952512626584 4.70020325203e-07 1.2 4.70052083333e-07 1.44748737342 4.70083841463e-07 1.55 4.70115599593e-07 1.44748737342 4.70147357724e-07 1.2 4.70179115854e-07 0.952512626585 4.70210873984e-07 0.85 4.70242632114e-07 0.952512626585 4.70274390244e-07 1.2 4.70306148374e-07 1.44748737342 4.70337906504e-07 1.55 4.70369664634e-07 1.44748737342 4.70401422764e-07 1.2 4.70433180894e-07 0.952512626585 4.70464939024e-07 0.85 4.70496697154e-07 0.952512626585 4.70528455285e-07 1.2 4.70560213415e-07 1.44748737342 4.70591971545e-07 1.55 4.70623729675e-07 1.44748737342 4.70655487805e-07 1.2 4.70687245935e-07 0.952512626585 4.70719004065e-07 0.85 4.70750762195e-07 0.952512626585 4.70782520325e-07 1.2 4.70814278455e-07 1.44748737342 4.70846036585e-07 1.55 4.70877794715e-07 1.44748737342 4.70909552846e-07 1.2 4.70941310976e-07 0.952512626585 4.70973069106e-07 0.85 4.71004827236e-07 0.952512626585 4.71036585366e-07 1.2 4.71068343496e-07 1.44748737342 4.71100101626e-07 1.55 4.71131859756e-07 1.44748737342 4.71163617886e-07 1.2 4.71195376016e-07 0.952512626584 4.71227134146e-07 0.85 4.71258892276e-07 0.952512626585 4.71290650407e-07 1.2 4.71322408537e-07 1.44748737342 4.71354166667e-07 1.55 4.71385924797e-07 1.44748737342 4.71417682927e-07 1.2 4.71449441057e-07 0.952512626585 4.71481199187e-07 0.85 4.71512957317e-07 0.952512626585 4.71544715447e-07 1.2 4.71576473577e-07 1.44748737342 4.71608231707e-07 1.55 4.71639989837e-07 1.44748737342 4.71671747967e-07 1.2 4.71703506098e-07 0.952512626584 4.71735264228e-07 0.85 4.71767022358e-07 0.952512626585 4.71798780488e-07 1.2 4.71830538618e-07 1.44748737342 4.71862296748e-07 1.55 4.71894054878e-07 1.44748737342 4.71925813008e-07 1.2 4.71957571138e-07 0.952512626585 4.71989329268e-07 0.85 4.72021087398e-07 0.952512626585 4.72052845528e-07 1.2 4.72084603659e-07 1.44748737342 4.72116361789e-07 1.55 4.72148119919e-07 1.44748737342 4.72179878049e-07 1.2 4.72211636179e-07 0.952512626585 4.72243394309e-07 0.85 4.72275152439e-07 0.952512626585 4.72306910569e-07 1.2 4.72338668699e-07 1.44748737342 4.72370426829e-07 1.55 4.72402184959e-07 1.44748737342 4.72433943089e-07 1.2 4.7246570122e-07 0.952512626585 4.7249745935e-07 0.85 4.7252921748e-07 0.952512626585 4.7256097561e-07 1.2 4.7259273374e-07 1.44748737342 4.7262449187e-07 1.55 4.7265625e-07 1.44748737342 4.7268800813e-07 1.2 4.7271976626e-07 0.952512626585 4.7275152439e-07 0.85 4.7278328252e-07 0.952512626584 4.7281504065e-07 1.2 4.7284679878e-07 1.44748737342 4.72878556911e-07 1.55 4.72910315041e-07 1.44748737342 4.72942073171e-07 1.2 4.72973831301e-07 0.952512626585 4.73005589431e-07 0.85 4.73037347561e-07 0.952512626585 4.73069105691e-07 1.2 4.73100863821e-07 1.44748737342 4.73132621951e-07 1.55 4.73164380081e-07 1.44748737342 4.73196138211e-07 1.2 4.73227896341e-07 0.952512626585 4.73259654472e-07 0.85 4.73291412602e-07 0.952512626585 4.73323170732e-07 1.2 4.73354928862e-07 1.44748737342 4.73386686992e-07 1.55 4.73418445122e-07 1.44748737342 4.73450203252e-07 1.2 4.73481961382e-07 0.952512626585 4.73513719512e-07 0.85 4.73545477642e-07 0.952512626585 4.73577235772e-07 1.2 4.73608993902e-07 1.44748737342 4.73640752033e-07 1.55 4.73672510163e-07 1.44748737342 4.73704268293e-07 1.2 4.73736026423e-07 0.952512626585 4.73767784553e-07 0.85 4.73799542683e-07 0.952512626585 4.73831300813e-07 1.2 4.73863058943e-07 1.44748737342 4.73894817073e-07 1.55 4.73926575203e-07 1.44748737342 4.73958333333e-07 1.2 4.73990091463e-07 0.952512626585 4.74021849593e-07 0.85 4.74053607724e-07 0.952512626584 4.74085365854e-07 1.2 4.74117123984e-07 1.44748737342 4.74148882114e-07 1.55 4.74180640244e-07 1.44748737342 4.74212398374e-07 1.2 4.74244156504e-07 0.952512626585 4.74275914634e-07 0.85 4.74307672764e-07 0.952512626585 4.74339430894e-07 1.2 4.74371189024e-07 1.44748737341 4.74402947154e-07 1.55 4.74434705285e-07 1.44748737342 4.74466463415e-07 1.2 4.74498221545e-07 0.952512626585 4.74529979675e-07 0.85 4.74561737805e-07 0.952512626585 4.74593495935e-07 1.2 4.74625254065e-07 1.44748737342 4.74657012195e-07 1.55 4.74688770325e-07 1.44748737342 4.74720528455e-07 1.2 4.74752286585e-07 0.952512626585 4.74784044715e-07 0.85 4.74815802846e-07 0.952512626585 4.74847560976e-07 1.2 4.74879319106e-07 1.44748737342 4.74911077236e-07 1.55 4.74942835366e-07 1.44748737342 4.74974593496e-07 1.2 4.75006351626e-07 0.952512626585 4.75038109756e-07 0.85 4.75069867886e-07 0.952512626585 4.75101626016e-07 1.2 4.75133384146e-07 1.44748737342 4.75165142276e-07 1.55 4.75196900407e-07 1.44748737342 4.75228658537e-07 1.2 4.75260416667e-07 0.952512626584 4.75292174797e-07 0.85 4.75323932927e-07 0.952512626585 4.75355691057e-07 1.2 4.75387449187e-07 1.44748737342 4.75419207317e-07 1.55 4.75450965447e-07 1.44748737342 4.75482723577e-07 1.2 4.75514481707e-07 0.952512626585 4.75546239837e-07 0.85 4.75577997967e-07 0.952512626585 4.75609756098e-07 1.2 4.75641514228e-07 1.44748737342 4.75673272358e-07 1.55 4.75705030488e-07 1.44748737341 4.75736788618e-07 1.2 4.75768546748e-07 0.952512626585 4.75800304878e-07 0.85 4.75832063008e-07 0.952512626585 4.75863821138e-07 1.2 4.75895579268e-07 1.44748737342 4.75927337398e-07 1.55 4.75959095528e-07 1.44748737342 4.75990853659e-07 1.2 4.76022611789e-07 0.952512626585 4.76054369919e-07 0.85 4.76086128049e-07 0.952512626585 4.76117886179e-07 1.2 4.76149644309e-07 1.44748737342 4.76181402439e-07 1.55 4.76213160569e-07 1.44748737342 4.76244918699e-07 1.2 4.76276676829e-07 0.952512626585 4.76308434959e-07 0.85 4.76340193089e-07 0.952512626585 4.7637195122e-07 1.2 4.7640370935e-07 1.44748737342 4.7643546748e-07 1.55 4.7646722561e-07 1.44748737342 4.7649898374e-07 1.2 4.7653074187e-07 0.952512626585 4.765625e-07 0.85 4.7659425813e-07 0.952512626585 4.7662601626e-07 1.2 4.7665777439e-07 1.44748737342 4.7668953252e-07 1.55 4.7672129065e-07 1.44748737342 4.7675304878e-07 1.2 4.76784806911e-07 0.952512626585 4.76816565041e-07 0.85 4.76848323171e-07 0.952512626584 4.76880081301e-07 1.2 4.76911839431e-07 1.44748737342 4.76943597561e-07 1.55 4.76975355691e-07 1.44748737342 4.77007113821e-07 1.2 4.77038871951e-07 0.952512626585 4.77070630081e-07 0.85 4.77102388211e-07 0.952512626585 4.77134146341e-07 1.2 4.77165904472e-07 1.44748737341 4.77197662602e-07 1.55 4.77229420732e-07 1.44748737342 4.77261178862e-07 1.2 4.77292936992e-07 0.952512626584 4.77324695122e-07 0.85 4.77356453252e-07 0.952512626585 4.77388211382e-07 1.2 4.77419969512e-07 1.44748737342 4.77451727642e-07 1.55 4.77483485772e-07 1.44748737342 4.77515243902e-07 1.2 4.77547002033e-07 0.952512626585 4.77578760163e-07 0.85 4.77610518293e-07 0.952512626585 4.77642276423e-07 1.2 4.77674034553e-07 1.44748737342 4.77705792683e-07 1.55 4.77737550813e-07 1.44748737342 4.77769308943e-07 1.2 4.77801067073e-07 0.952512626585 4.77832825203e-07 0.85 4.77864583333e-07 0.952512626585 4.77896341463e-07 1.2 4.77928099593e-07 1.44748737342 4.77959857724e-07 1.55 4.77991615854e-07 1.44748737342 4.78023373984e-07 1.2 4.78055132114e-07 0.952512626585 4.78086890244e-07 0.85 4.78118648374e-07 0.952512626584 4.78150406504e-07 1.2 4.78182164634e-07 1.44748737342 4.78213922764e-07 1.55 4.78245680894e-07 1.44748737342 4.78277439024e-07 1.2 4.78309197154e-07 0.952512626585 4.78340955285e-07 0.85 4.78372713415e-07 0.952512626584 4.78404471545e-07 1.2 4.78436229675e-07 1.44748737342 4.78467987805e-07 1.55 4.78499745935e-07 1.44748737342 4.78531504065e-07 1.2 4.78563262195e-07 0.952512626585 4.78595020325e-07 0.85 4.78626778455e-07 0.952512626585 4.78658536585e-07 1.2 4.78690294715e-07 1.44748737342 4.78722052846e-07 1.55 4.78753810976e-07 1.44748737342 4.78785569106e-07 1.2 4.78817327236e-07 0.952512626585 4.78849085366e-07 0.85 4.78880843496e-07 0.952512626585 4.78912601626e-07 1.2 4.78944359756e-07 1.44748737342 4.78976117886e-07 1.55 4.79007876016e-07 1.44748737342 4.79039634146e-07 1.2 4.79071392276e-07 0.952512626585 4.79103150407e-07 0.85 4.79134908537e-07 0.952512626585 4.79166666667e-07 1.2 4.79198424797e-07 1.44748737342 4.79230182927e-07 1.55 4.79261941057e-07 1.44748737342 4.79293699187e-07 1.2 4.79325457317e-07 0.952512626585 4.79357215447e-07 0.85 4.79388973577e-07 0.952512626585 4.79420731707e-07 1.2 4.79452489837e-07 1.44748737342 4.79484247967e-07 1.55 4.79516006098e-07 1.44748737342 4.79547764228e-07 1.2 4.79579522358e-07 0.952512626584 4.79611280488e-07 0.85 4.79643038618e-07 0.952512626585 4.79674796748e-07 1.2 4.79706554878e-07 1.44748737342 4.79738313008e-07 1.55 4.79770071138e-07 1.44748737342 4.79801829268e-07 1.2 4.79833587398e-07 0.952512626585 4.79865345528e-07 0.85 4.79897103659e-07 0.952512626585 4.79928861789e-07 1.2 4.79960619919e-07 1.44748737342 4.79992378049e-07 1.55 4.80024136179e-07 1.44748737342 4.80055894309e-07 1.2 4.80087652439e-07 0.952512626585 4.80119410569e-07 0.85 4.80151168699e-07 0.952512626585 4.80182926829e-07 1.2 4.80214684959e-07 1.44748737342 4.80246443089e-07 1.55 4.8027820122e-07 1.44748737342 4.8030995935e-07 1.2 4.8034171748e-07 0.952512626585 4.8037347561e-07 0.85 4.8040523374e-07 0.952512626584 4.8043699187e-07 1.2 4.8046875e-07 1.44748737342 4.8050050813e-07 1.55 4.8053226626e-07 1.44748737342 4.8056402439e-07 1.2 4.8059578252e-07 0.952512626585 4.8062754065e-07 0.85 4.8065929878e-07 0.952512626585 4.80691056911e-07 1.2 4.80722815041e-07 1.44748737342 4.80754573171e-07 1.55 4.80786331301e-07 1.44748737341 4.80818089431e-07 1.2 4.80849847561e-07 0.952512626584 4.80881605691e-07 0.85 4.80913363821e-07 0.952512626585 4.80945121951e-07 1.2 4.80976880081e-07 1.44748737342 4.81008638211e-07 1.55 4.81040396341e-07 1.44748737342 4.81072154472e-07 1.2 4.81103912602e-07 0.952512626585 4.81135670732e-07 0.85 4.81167428862e-07 0.952512626585 4.81199186992e-07 1.2 4.81230945122e-07 1.44748737342 4.81262703252e-07 1.55 4.81294461382e-07 1.44748737342 4.81326219512e-07 1.2 4.81357977642e-07 0.952512626585 4.81389735772e-07 0.85 4.81421493902e-07 0.952512626584 4.81453252033e-07 1.2 4.81485010163e-07 1.44748737342 4.81516768293e-07 1.55 4.81548526423e-07 1.44748737342 4.81580284553e-07 1.2 4.81612042683e-07 0.952512626585 4.81643800813e-07 0.85 4.81675558943e-07 0.952512626584 4.81707317073e-07 1.2 4.81739075203e-07 1.44748737341 4.81770833333e-07 1.55 4.81802591463e-07 1.44748737342 4.81834349593e-07 1.2 4.81866107724e-07 0.952512626585 4.81897865854e-07 0.85 4.81929623984e-07 0.952512626585 4.81961382114e-07 1.2 4.81993140244e-07 1.44748737341 4.82024898374e-07 1.55 4.82056656504e-07 1.44748737342 4.82088414634e-07 1.2 4.82120172764e-07 0.952512626585 4.82151930894e-07 0.85 4.82183689024e-07 0.952512626585 4.82215447154e-07 1.2 4.82247205285e-07 1.44748737342 4.82278963415e-07 1.55 4.82310721545e-07 1.44748737342 4.82342479675e-07 1.2 4.82374237805e-07 0.952512626585 4.82405995935e-07 0.85 4.82437754065e-07 0.952512626585 4.82469512195e-07 1.2 4.82501270325e-07 1.44748737342 4.82533028455e-07 1.55 4.82564786585e-07 1.44748737342 4.82596544715e-07 1.2 4.82628302846e-07 0.952512626585 4.82660060976e-07 0.85 4.82691819106e-07 0.952512626585 4.82723577236e-07 1.2 4.82755335366e-07 1.44748737342 4.82787093496e-07 1.55 4.82818851626e-07 1.44748737342 4.82850609756e-07 1.2 4.82882367886e-07 0.952512626585 4.82914126016e-07 0.85 4.82945884146e-07 0.952512626585 4.82977642276e-07 1.2 4.83009400407e-07 1.44748737342 4.83041158537e-07 1.55 4.83072916667e-07 1.44748737342 4.83104674797e-07 1.2 4.83136432927e-07 0.952512626585 4.83168191057e-07 0.85 4.83199949187e-07 0.952512626585 4.83231707317e-07 1.2 4.83263465447e-07 1.44748737342 4.83295223577e-07 1.55 4.83326981707e-07 1.44748737342 4.83358739837e-07 1.2 4.83390497967e-07 0.952512626585 4.83422256098e-07 0.85 4.83454014228e-07 0.952512626585 4.83485772358e-07 1.2 4.83517530488e-07 1.44748737342 4.83549288618e-07 1.55 4.83581046748e-07 1.44748737342 4.83612804878e-07 1.2 4.83644563008e-07 0.952512626585 4.83676321138e-07 0.85 4.83708079268e-07 0.952512626585 4.83739837398e-07 1.2 4.83771595528e-07 1.44748737342 4.83803353659e-07 1.55 4.83835111789e-07 1.44748737342 4.83866869919e-07 1.2 4.83898628049e-07 0.952512626585 4.83930386179e-07 0.85 4.83962144309e-07 0.952512626584 4.83993902439e-07 1.2 4.84025660569e-07 1.44748737342 4.84057418699e-07 1.55 4.84089176829e-07 1.44748737341 4.84120934959e-07 1.2 4.84152693089e-07 0.952512626585 4.8418445122e-07 0.85 4.8421620935e-07 0.952512626585 4.8424796748e-07 1.2 4.8427972561e-07 1.44748737342 4.8431148374e-07 1.55 4.8434324187e-07 1.44748737341 4.84375e-07 1.2 4.8440675813e-07 0.952512626584 4.8443851626e-07 0.85 4.8447027439e-07 0.952512626585 4.8450203252e-07 1.2 4.8453379065e-07 1.44748737342 4.8456554878e-07 1.55 4.84597306911e-07 1.44748737342 4.84629065041e-07 1.2 4.84660823171e-07 0.952512626584 4.84692581301e-07 0.85 4.84724339431e-07 0.952512626585 4.84756097561e-07 1.2 4.84787855691e-07 1.44748737342 4.84819613821e-07 1.55 4.84851371951e-07 1.44748737342 4.84883130081e-07 1.2 4.84914888211e-07 0.952512626585 4.84946646341e-07 0.85 4.84978404472e-07 0.952512626584 4.85010162602e-07 1.2 4.85041920732e-07 1.44748737342 4.85073678862e-07 1.55 4.85105436992e-07 1.44748737342 4.85137195122e-07 1.2 4.85168953252e-07 0.952512626585 4.85200711382e-07 0.85 4.85232469512e-07 0.952512626584 4.85264227642e-07 1.2 4.85295985772e-07 1.44748737341 4.85327743902e-07 1.55 4.85359502033e-07 1.44748737342 4.85391260163e-07 1.2 4.85423018293e-07 0.952512626585 4.85454776423e-07 0.85 4.85486534553e-07 0.952512626585 4.85518292683e-07 1.2 4.85550050813e-07 1.44748737341 4.85581808943e-07 1.55 4.85613567073e-07 1.44748737342 4.85645325203e-07 1.2 4.85677083333e-07 0.952512626585 4.85708841463e-07 0.85 4.85740599593e-07 0.952512626585 4.85772357724e-07 1.2 4.85804115854e-07 1.44748737342 4.85835873984e-07 1.55 4.85867632114e-07 1.44748737342 4.85899390244e-07 1.2 4.85931148374e-07 0.952512626585 4.85962906504e-07 0.85 4.85994664634e-07 0.952512626585 4.86026422764e-07 1.2 4.86058180894e-07 1.44748737342 4.86089939024e-07 1.55 4.86121697154e-07 1.44748737342 4.86153455285e-07 1.2 4.86185213415e-07 0.952512626585 4.86216971545e-07 0.85 4.86248729675e-07 0.952512626585 4.86280487805e-07 1.2 4.86312245935e-07 1.44748737342 4.86344004065e-07 1.55 4.86375762195e-07 1.44748737342 4.86407520325e-07 1.2 4.86439278455e-07 0.952512626585 4.86471036585e-07 0.85 4.86502794715e-07 0.952512626585 4.86534552846e-07 1.2 4.86566310976e-07 1.44748737342 4.86598069106e-07 1.55 4.86629827236e-07 1.44748737342 4.86661585366e-07 1.2 4.86693343496e-07 0.952512626585 4.86725101626e-07 0.85 4.86756859756e-07 0.952512626584 4.86788617886e-07 1.2 4.86820376016e-07 1.44748737342 4.86852134146e-07 1.55 4.86883892276e-07 1.44748737342 4.86915650407e-07 1.2 4.86947408537e-07 0.952512626585 4.86979166667e-07 0.85 4.87010924797e-07 0.952512626585 4.87042682927e-07 1.2 4.87074441057e-07 1.44748737342 4.87106199187e-07 1.55 4.87137957317e-07 1.44748737342 4.87169715447e-07 1.2 4.87201473577e-07 0.952512626585 4.87233231707e-07 0.85 4.87264989837e-07 0.952512626585 4.87296747967e-07 1.2 4.87328506098e-07 1.44748737342 4.87360264228e-07 1.55 4.87392022358e-07 1.44748737342 4.87423780488e-07 1.2 4.87455538618e-07 0.952512626585 4.87487296748e-07 0.85 4.87519054878e-07 0.952512626585 4.87550813008e-07 1.2 4.87582571138e-07 1.44748737342 4.87614329268e-07 1.55 4.87646087398e-07 1.44748737341 4.87677845528e-07 1.2 4.87709603659e-07 0.952512626585 4.87741361789e-07 0.85 4.87773119919e-07 0.952512626585 4.87804878049e-07 1.2 4.87836636179e-07 1.44748737342 4.87868394309e-07 1.55 4.87900152439e-07 1.44748737342 4.87931910569e-07 1.2 4.87963668699e-07 0.952512626584 4.87995426829e-07 0.85 4.88027184959e-07 0.952512626585 4.88058943089e-07 1.2 4.8809070122e-07 1.44748737342 4.8812245935e-07 1.55 4.8815421748e-07 1.44748737342 4.8818597561e-07 1.2 4.8821773374e-07 0.952512626584 4.8824949187e-07 0.85 4.8828125e-07 0.952512626585 4.8831300813e-07 1.2 4.8834476626e-07 1.44748737342 4.8837652439e-07 1.55 4.8840828252e-07 1.44748737342 4.8844004065e-07 1.2 4.8847179878e-07 0.952512626585 4.88503556911e-07 0.85 4.88535315041e-07 0.952512626585 4.88567073171e-07 1.2 4.88598831301e-07 1.44748737342 4.88630589431e-07 1.55 4.88662347561e-07 1.44748737342 4.88694105691e-07 1.2 4.88725863821e-07 0.952512626585 4.88757621951e-07 0.85 4.88789380081e-07 0.952512626584 4.88821138211e-07 1.2 4.88852896341e-07 1.44748737341 4.88884654472e-07 1.55 4.88916412602e-07 1.44748737342 4.88948170732e-07 1.2 4.88979928862e-07 0.952512626585 4.89011686992e-07 0.85 4.89043445122e-07 0.952512626585 4.89075203252e-07 1.2 4.89106961382e-07 1.44748737342 4.89138719512e-07 1.55 4.89170477642e-07 1.44748737342 4.89202235772e-07 1.2 4.89233993902e-07 0.952512626584 4.89265752033e-07 0.85 4.89297510163e-07 0.952512626585 4.89329268293e-07 1.2 4.89361026423e-07 1.44748737342 4.89392784553e-07 1.55 4.89424542683e-07 1.44748737342 4.89456300813e-07 1.2 4.89488058943e-07 0.952512626585 4.89519817073e-07 0.85 4.89551575203e-07 0.952512626585 4.89583333333e-07 1.2 4.89615091463e-07 1.44748737342 4.89646849593e-07 1.55 4.89678607724e-07 1.44748737342 4.89710365854e-07 1.2 4.89742123984e-07 0.952512626585 4.89773882114e-07 0.85 4.89805640244e-07 0.952512626584 4.89837398374e-07 1.2 4.89869156504e-07 1.44748737342 4.89900914634e-07 1.55 4.89932672764e-07 1.44748737342 4.89964430894e-07 1.2 4.89996189024e-07 0.952512626585 4.90027947154e-07 0.85 4.90059705285e-07 0.952512626584 4.90091463415e-07 1.2 4.90123221545e-07 1.44748737342 4.90154979675e-07 1.55 4.90186737805e-07 1.44748737342 4.90218495935e-07 1.2 4.90250254065e-07 0.952512626585 4.90282012195e-07 0.85 4.90313770325e-07 0.952512626585 4.90345528455e-07 1.2 4.90377286585e-07 1.44748737341 4.90409044715e-07 1.55 4.90440802846e-07 1.44748737342 4.90472560976e-07 1.2 4.90504319106e-07 0.952512626585 4.90536077236e-07 0.85 4.90567835366e-07 0.952512626585 4.90599593496e-07 1.2 4.90631351626e-07 1.44748737342 4.90663109756e-07 1.55 4.90694867886e-07 1.44748737342 4.90726626016e-07 1.2 4.90758384146e-07 0.952512626585 4.90790142276e-07 0.85 4.90821900407e-07 0.952512626585 4.90853658537e-07 1.2 4.90885416667e-07 1.44748737342 4.90917174797e-07 1.55 4.90948932927e-07 1.44748737342 4.90980691057e-07 1.2 4.91012449187e-07 0.952512626585 4.91044207317e-07 0.85 4.91075965447e-07 0.952512626585 4.91107723577e-07 1.2 4.91139481707e-07 1.44748737342 4.91171239837e-07 1.55 4.91202997967e-07 1.44748737342 4.91234756098e-07 1.2 4.91266514228e-07 0.952512626585 4.91298272358e-07 0.85 4.91330030488e-07 0.952512626585 4.91361788618e-07 1.2 4.91393546748e-07 1.44748737342 4.91425304878e-07 1.55 4.91457063008e-07 1.44748737342 4.91488821138e-07 1.2 4.91520579268e-07 0.952512626585 4.91552337398e-07 0.85 4.91584095528e-07 0.952512626585 4.91615853659e-07 1.2 4.91647611789e-07 1.44748737342 4.91679369919e-07 1.55 4.91711128049e-07 1.44748737342 4.91742886179e-07 1.2 4.91774644309e-07 0.952512626585 4.91806402439e-07 0.85 4.91838160569e-07 0.952512626585 4.91869918699e-07 1.2 4.91901676829e-07 1.44748737342 4.91933434959e-07 1.55 4.91965193089e-07 1.44748737342 4.9199695122e-07 1.2 4.9202870935e-07 0.952512626585 4.9206046748e-07 0.85 4.9209222561e-07 0.952512626585 4.9212398374e-07 1.2 4.9215574187e-07 1.44748737342 4.921875e-07 1.55 4.9221925813e-07 1.44748737342 4.9225101626e-07 1.2 4.9228277439e-07 0.952512626585 4.9231453252e-07 0.85 4.9234629065e-07 0.952512626584 4.9237804878e-07 1.2 4.92409806911e-07 1.44748737342 4.92441565041e-07 1.55 4.92473323171e-07 1.44748737341 4.92505081301e-07 1.2 4.92536839431e-07 0.952512626585 4.92568597561e-07 0.85 4.92600355691e-07 0.952512626585 4.92632113821e-07 1.2 4.92663871951e-07 1.44748737342 4.92695630081e-07 1.55 4.92727388211e-07 1.44748737341 4.92759146341e-07 1.2 4.92790904472e-07 0.952512626584 4.92822662602e-07 0.85 4.92854420732e-07 0.952512626585 4.92886178862e-07 1.2 4.92917936992e-07 1.44748737342 4.92949695122e-07 1.55 4.92981453252e-07 1.44748737342 4.93013211382e-07 1.2 4.93044969512e-07 0.952512626585 4.93076727642e-07 0.85 4.93108485772e-07 0.952512626585 4.93140243902e-07 1.2 4.93172002033e-07 1.44748737342 4.93203760163e-07 1.55 4.93235518293e-07 1.44748737342 4.93267276423e-07 1.2 4.93299034553e-07 0.952512626585 4.93330792683e-07 0.85 4.93362550813e-07 0.952512626584 4.93394308943e-07 1.2 4.93426067073e-07 1.44748737342 4.93457825203e-07 1.55 4.93489583333e-07 1.44748737342 4.93521341463e-07 1.2 4.93553099593e-07 0.952512626585 4.93584857724e-07 0.85 4.93616615854e-07 0.952512626584 4.93648373984e-07 1.2 4.93680132114e-07 1.44748737341 4.93711890244e-07 1.55 4.93743648374e-07 1.44748737342 4.93775406504e-07 1.2 4.93807164634e-07 0.952512626585 4.93838922764e-07 0.85 4.93870680894e-07 0.952512626585 4.93902439024e-07 1.2 4.93934197154e-07 1.44748737341 4.93965955285e-07 1.55 4.93997713415e-07 1.44748737342 4.94029471545e-07 1.2 4.94061229675e-07 0.952512626585 4.94092987805e-07 0.85 4.94124745935e-07 0.952512626585 4.94156504065e-07 1.2 4.94188262195e-07 1.44748737342 4.94220020325e-07 1.55 4.94251778455e-07 1.44748737342 4.94283536585e-07 1.2 4.94315294715e-07 0.952512626585 4.94347052846e-07 0.85 4.94378810976e-07 0.952512626585 4.94410569106e-07 1.2 4.94442327236e-07 1.44748737342 4.94474085366e-07 1.55 4.94505843496e-07 1.44748737342 4.94537601626e-07 1.2 4.94569359756e-07 0.952512626585 4.94601117886e-07 0.85 4.94632876016e-07 0.952512626585 4.94664634146e-07 1.2 4.94696392276e-07 1.44748737342 4.94728150407e-07 1.55 4.94759908537e-07 1.44748737342 4.94791666667e-07 1.2 4.94823424797e-07 0.952512626585 4.94855182927e-07 0.85 4.94886941057e-07 0.952512626585 4.94918699187e-07 1.2 4.94950457317e-07 1.44748737342 4.94982215447e-07 1.55 4.95013973577e-07 1.44748737342 4.95045731707e-07 1.2 4.95077489837e-07 0.952512626585 4.95109247967e-07 0.85 4.95141006098e-07 0.952512626585 4.95172764228e-07 1.2 4.95204522358e-07 1.44748737342 4.95236280488e-07 1.55 4.95268038618e-07 1.44748737342 4.95299796748e-07 1.2 4.95331554878e-07 0.952512626585 4.95363313008e-07 0.85 4.95395071138e-07 0.952512626585 4.95426829268e-07 1.2 4.95458587398e-07 1.44748737342 4.95490345528e-07 1.55 4.95522103659e-07 1.44748737342 4.95553861789e-07 1.2 4.95585619919e-07 0.952512626585 4.95617378049e-07 0.85 4.95649136179e-07 0.952512626585 4.95680894309e-07 1.2 4.95712652439e-07 1.44748737342 4.95744410569e-07 1.55 4.95776168699e-07 1.44748737342 4.95807926829e-07 1.2 4.95839684959e-07 0.952512626585 4.95871443089e-07 0.85 4.9590320122e-07 0.952512626585 4.9593495935e-07 1.2 4.9596671748e-07 1.44748737342 4.9599847561e-07 1.55 4.9603023374e-07 1.44748737341 4.9606199187e-07 1.2 4.9609375e-07 0.952512626585 4.9612550813e-07 0.85 4.9615726626e-07 0.952512626585 4.9618902439e-07 1.2 4.9622078252e-07 1.44748737342 4.9625254065e-07 1.55 4.9628429878e-07 1.44748737341 4.96316056911e-07 1.2 4.96347815041e-07 0.952512626584 4.96379573171e-07 0.85 4.96411331301e-07 0.952512626585 4.96443089431e-07 1.2 4.96474847561e-07 1.44748737342 4.96506605691e-07 1.55 4.96538363821e-07 1.44748737342 4.96570121951e-07 1.2 4.96601880081e-07 0.952512626584 4.96633638211e-07 0.85 4.96665396341e-07 0.952512626585 4.96697154472e-07 1.2 4.96728912602e-07 1.44748737342 4.96760670732e-07 1.55 4.96792428862e-07 1.44748737342 4.96824186992e-07 1.2 4.96855945122e-07 0.952512626585 4.96887703252e-07 0.85 4.96919461382e-07 0.952512626584 4.96951219512e-07 1.2 4.96982977642e-07 1.44748737342 4.97014735772e-07 1.55 4.97046493902e-07 1.44748737342 4.97078252033e-07 1.2 4.97110010163e-07 0.952512626585 4.97141768293e-07 0.85 4.97173526423e-07 0.952512626584 4.97205284553e-07 1.2 4.97237042683e-07 1.44748737341 4.97268800813e-07 1.55 4.97300558943e-07 1.44748737342 4.97332317073e-07 1.2 4.97364075203e-07 0.952512626585 4.97395833333e-07 0.85 4.97427591463e-07 0.952512626585 4.97459349593e-07 1.2 4.97491107724e-07 1.44748737341 4.97522865854e-07 1.55 4.97554623984e-07 1.44748737342 4.97586382114e-07 1.2 4.97618140244e-07 0.952512626584 4.97649898374e-07 0.85 4.97681656504e-07 0.952512626585 4.97713414634e-07 1.2 4.97745172764e-07 1.44748737342 4.97776930894e-07 1.55 4.97808689024e-07 1.44748737342 4.97840447154e-07 1.2 4.97872205285e-07 0.952512626585 4.97903963415e-07 0.85 4.97935721545e-07 0.952512626585 4.97967479675e-07 1.2 4.97999237805e-07 1.44748737342 4.98030995935e-07 1.55 4.98062754065e-07 1.44748737342 4.98094512195e-07 1.2 4.98126270325e-07 0.952512626585 4.98158028455e-07 0.85 4.98189786585e-07 0.952512626585 4.98221544715e-07 1.2 4.98253302846e-07 1.44748737342 4.98285060976e-07 1.55 4.98316819106e-07 1.44748737342 4.98348577236e-07 1.2 4.98380335366e-07 0.952512626585 4.98412093496e-07 0.85 4.98443851626e-07 0.952512626584 4.98475609756e-07 1.2 4.98507367886e-07 1.44748737342 4.98539126016e-07 1.55 4.98570884146e-07 1.44748737342 4.98602642276e-07 1.2 4.98634400407e-07 0.952512626585 4.98666158537e-07 0.85 4.98697916667e-07 0.952512626585 4.98729674797e-07 1.2 4.98761432927e-07 1.44748737342 4.98793191057e-07 1.55 4.98824949187e-07 1.44748737342 4.98856707317e-07 1.2 4.98888465447e-07 0.952512626585 4.98920223577e-07 0.85 4.98951981707e-07 0.952512626585 4.98983739837e-07 1.2 4.99015497967e-07 1.44748737342 4.99047256098e-07 1.55 4.99079014228e-07 1.44748737342 4.99110772358e-07 1.2 4.99142530488e-07 0.952512626585 4.99174288618e-07 0.85 4.99206046748e-07 0.952512626585 4.99237804878e-07 1.2 4.99269563008e-07 1.44748737342 4.99301321138e-07 1.55 4.99333079268e-07 1.44748737342 4.99364837398e-07 1.2 4.99396595528e-07 0.952512626585 4.99428353659e-07 0.85 4.99460111789e-07 0.952512626585 4.99491869919e-07 1.2 4.99523628049e-07 1.44748737342 4.99555386179e-07 1.55 4.99587144309e-07 1.44748737342 4.99618902439e-07 1.2 4.99650660569e-07 0.952512626585 4.99682418699e-07 0.85 4.99714176829e-07 0.952512626585 4.99745934959e-07 1.2 4.99777693089e-07 1.44748737342 4.9980945122e-07 1.55 4.9984120935e-07 1.44748737342 4.9987296748e-07 1.2 4.9990472561e-07 0.952512626584 4.9993648374e-07 0.85 4.9996824187e-07 0.952512626585 5e-07 1.2 5.0003175813e-07 1.44748737342 5.0006351626e-07 1.55 5.0009527439e-07 1.44748737342 5.0012703252e-07 1.2 5.0015879065e-07 0.952512626585 5.0019054878e-07 0.85 5.00222306911e-07 0.952512626585 5.00254065041e-07 1.2 5.00285823171e-07 1.44748737342 5.00317581301e-07 1.55 5.00349339431e-07 1.44748737342 5.00381097561e-07 1.2 5.00412855691e-07 0.952512626585 5.00444613821e-07 0.85 5.00476371951e-07 0.952512626585 5.00508130081e-07 1.2 5.00539888211e-07 1.44748737342 5.00571646341e-07 1.55 5.00603404472e-07 1.44748737342 5.00635162602e-07 1.2 5.00666920732e-07 0.952512626585 5.00698678862e-07 0.85 5.00730436992e-07 0.952512626584 5.00762195122e-07 1.2 5.00793953252e-07 1.44748737341 5.00825711382e-07 1.55 5.00857469512e-07 1.44748737341 5.00889227642e-07 1.2 5.00920985772e-07 0.952512626585 5.00952743902e-07 0.85 5.00984502033e-07 0.952512626585 5.01016260163e-07 1.2 5.01048018293e-07 1.44748737342 5.01079776423e-07 1.55 5.01111534553e-07 1.44748737342 5.01143292683e-07 1.2 5.01175050813e-07 0.952512626584 5.01206808943e-07 0.85 5.01238567073e-07 0.952512626585 5.01270325203e-07 1.2 5.01302083333e-07 1.44748737342 5.01333841463e-07 1.55 5.01365599593e-07 1.44748737342 5.01397357724e-07 1.2 5.01429115854e-07 0.952512626585 5.01460873984e-07 0.85 5.01492632114e-07 0.952512626585 5.01524390244e-07 1.2 5.01556148374e-07 1.44748737342 5.01587906504e-07 1.55 5.01619664634e-07 1.44748737342 5.01651422764e-07 1.2 5.01683180894e-07 0.952512626585 5.01714939024e-07 0.85 5.01746697154e-07 0.952512626584 5.01778455285e-07 1.2 5.01810213415e-07 1.44748737342 5.01841971545e-07 1.55 5.01873729675e-07 1.44748737342 5.01905487805e-07 1.2 5.01937245935e-07 0.952512626585 5.01969004065e-07 0.85 5.02000762195e-07 0.952512626584 5.02032520325e-07 1.2 5.02064278455e-07 1.44748737341 5.02096036585e-07 1.55 5.02127794715e-07 1.44748737342 5.02159552846e-07 1.2 5.02191310976e-07 0.952512626585 5.02223069106e-07 0.85 5.02254827236e-07 0.952512626585 5.02286585366e-07 1.2 5.02318343496e-07 1.44748737341 5.02350101626e-07 1.55 5.02381859756e-07 1.44748737342 5.02413617886e-07 1.2 5.02445376016e-07 0.952512626585 5.02477134146e-07 0.85 5.02508892276e-07 0.952512626585 5.02540650407e-07 1.2 5.02572408537e-07 1.44748737342 5.02604166667e-07 1.55 5.02635924797e-07 1.44748737342 5.02667682927e-07 1.2 5.02699441057e-07 0.952512626585 5.02731199187e-07 0.85 5.02762957317e-07 0.952512626585 5.02794715447e-07 1.2 5.02826473577e-07 1.44748737342 5.02858231707e-07 1.55 5.02889989837e-07 1.44748737342 5.02921747967e-07 1.2 5.02953506098e-07 0.952512626585 5.02985264228e-07 0.85 5.03017022358e-07 0.952512626585 5.03048780488e-07 1.2 5.03080538618e-07 1.44748737342 5.03112296748e-07 1.55 5.03144054878e-07 1.44748737342 5.03175813008e-07 1.2 5.03207571138e-07 0.952512626585 5.03239329268e-07 0.85 5.03271087398e-07 0.952512626585 5.03302845528e-07 1.2 5.03334603659e-07 1.44748737342 5.03366361789e-07 1.55 5.03398119919e-07 1.44748737342 5.03429878049e-07 1.2 5.03461636179e-07 0.952512626585 5.03493394309e-07 0.85 5.03525152439e-07 0.952512626585 5.03556910569e-07 1.2 5.03588668699e-07 1.44748737342 5.03620426829e-07 1.55 5.03652184959e-07 1.44748737342 5.03683943089e-07 1.2 5.0371570122e-07 0.952512626585 5.0374745935e-07 0.85 5.0377921748e-07 0.952512626585 5.0381097561e-07 1.2 5.0384273374e-07 1.44748737342 5.0387449187e-07 1.55 5.0390625e-07 1.44748737342 5.0393800813e-07 1.2 5.0396976626e-07 0.952512626585 5.0400152439e-07 0.85 5.0403328252e-07 0.952512626585 5.0406504065e-07 1.2 5.0409679878e-07 1.44748737342 5.04128556911e-07 1.55 5.04160315041e-07 1.44748737342 5.04192073171e-07 1.2 5.04223831301e-07 0.952512626585 5.04255589431e-07 0.85 5.04287347561e-07 0.952512626585 5.04319105691e-07 1.2 5.04350863821e-07 1.44748737342 5.04382621951e-07 1.55 5.04414380081e-07 1.44748737341 5.04446138211e-07 1.2 5.04477896341e-07 0.952512626585 5.04509654472e-07 0.85 5.04541412602e-07 0.952512626585 5.04573170732e-07 1.2 5.04604928862e-07 1.44748737342 5.04636686992e-07 1.55 5.04668445122e-07 1.44748737342 5.04700203252e-07 1.2 5.04731961382e-07 0.952512626584 5.04763719512e-07 0.85 5.04795477642e-07 0.952512626585 5.04827235772e-07 1.2 5.04858993902e-07 1.44748737342 5.04890752033e-07 1.55 5.04922510163e-07 1.44748737342 5.04954268293e-07 1.2 5.04986026423e-07 0.952512626585 5.05017784553e-07 0.85 5.05049542683e-07 0.952512626585 5.05081300813e-07 1.2 5.05113058943e-07 1.44748737342 5.05144817073e-07 1.55 5.05176575203e-07 1.44748737342 5.05208333333e-07 1.2 5.05240091463e-07 0.952512626585 5.05271849593e-07 0.85 5.05303607724e-07 0.952512626584 5.05335365854e-07 1.2 5.05367123984e-07 1.44748737342 5.05398882114e-07 1.55 5.05430640244e-07 1.44748737342 5.05462398374e-07 1.2 5.05494156504e-07 0.952512626585 5.05525914634e-07 0.85 5.05557672764e-07 0.952512626584 5.05589430894e-07 1.2 5.05621189024e-07 1.44748737341 5.05652947154e-07 1.55 5.05684705285e-07 1.44748737342 5.05716463415e-07 1.2 5.05748221545e-07 0.952512626585 5.05779979675e-07 0.85 5.05811737805e-07 0.952512626585 5.05843495935e-07 1.2 5.05875254065e-07 1.44748737341 5.05907012195e-07 1.55 5.05938770325e-07 1.44748737342 5.05970528455e-07 1.2 5.06002286585e-07 0.952512626584 5.06034044715e-07 0.85 5.06065802846e-07 0.952512626585 5.06097560976e-07 1.2 5.06129319106e-07 1.44748737342 5.06161077236e-07 1.55 5.06192835366e-07 1.44748737342 5.06224593496e-07 1.2 5.06256351626e-07 0.952512626585 5.06288109756e-07 0.85 5.06319867886e-07 0.952512626585 5.06351626016e-07 1.2 5.06383384146e-07 1.44748737342 5.06415142276e-07 1.55 5.06446900407e-07 1.44748737342 5.06478658537e-07 1.2 5.06510416667e-07 0.952512626585 5.06542174797e-07 0.85 5.06573932927e-07 0.952512626585 5.06605691057e-07 1.2 5.06637449187e-07 1.44748737342 5.06669207317e-07 1.55 5.06700965447e-07 1.44748737342 5.06732723577e-07 1.2 5.06764481707e-07 0.952512626585 5.06796239837e-07 0.85 5.06827997967e-07 0.952512626585 5.06859756098e-07 1.2 5.06891514228e-07 1.44748737342 5.06923272358e-07 1.55 5.06955030488e-07 1.44748737342 5.06986788618e-07 1.2 5.07018546748e-07 0.952512626585 5.07050304878e-07 0.85 5.07082063008e-07 0.952512626585 5.07113821138e-07 1.2 5.07145579268e-07 1.44748737342 5.07177337398e-07 1.55 5.07209095528e-07 1.44748737342 5.07240853659e-07 1.2 5.07272611789e-07 0.952512626585 5.07304369919e-07 0.85 5.07336128049e-07 0.952512626585 5.07367886179e-07 1.2 5.07399644309e-07 1.44748737342 5.07431402439e-07 1.55 5.07463160569e-07 1.44748737342 5.07494918699e-07 1.2 5.07526676829e-07 0.952512626585 5.07558434959e-07 0.85 5.07590193089e-07 0.952512626585 5.0762195122e-07 1.2 5.0765370935e-07 1.44748737342 5.0768546748e-07 1.55 5.0771722561e-07 1.44748737342 5.0774898374e-07 1.2 5.0778074187e-07 0.952512626585 5.078125e-07 0.85 5.0784425813e-07 0.952512626585 5.0787601626e-07 1.2 5.0790777439e-07 1.44748737342 5.0793953252e-07 1.55 5.0797129065e-07 1.44748737341 5.0800304878e-07 1.2 5.08034806911e-07 0.952512626585 5.08066565041e-07 0.85 5.08098323171e-07 0.952512626585 5.08130081301e-07 1.2 5.08161839431e-07 1.44748737342 5.08193597561e-07 1.55 5.08225355691e-07 1.44748737342 5.08257113821e-07 1.2 5.08288871951e-07 0.952512626584 5.08320630081e-07 0.85 5.08352388211e-07 0.952512626585 5.08384146341e-07 1.2 5.08415904472e-07 1.44748737342 5.08447662602e-07 1.55 5.08479420732e-07 1.44748737342 5.08511178862e-07 1.2 5.08542936992e-07 0.952512626585 5.08574695122e-07 0.85 5.08606453252e-07 0.952512626585 5.08638211382e-07 1.2 5.08669969512e-07 1.44748737342 5.08701727642e-07 1.55 5.08733485772e-07 1.44748737342 5.08765243902e-07 1.2 5.08797002033e-07 0.952512626585 5.08828760163e-07 0.85 5.08860518293e-07 0.952512626584 5.08892276423e-07 1.2 5.08924034553e-07 1.44748737342 5.08955792683e-07 1.55 5.08987550813e-07 1.44748737342 5.09019308943e-07 1.2 5.09051067073e-07 0.952512626585 5.09082825203e-07 0.85 5.09114583333e-07 0.952512626584 5.09146341463e-07 1.2 5.09178099593e-07 1.44748737341 5.09209857724e-07 1.55 5.09241615854e-07 1.44748737342 5.09273373984e-07 1.2 5.09305132114e-07 0.952512626585 5.09336890244e-07 0.85 5.09368648374e-07 0.952512626585 5.09400406504e-07 1.2 5.09432164634e-07 1.44748737342 5.09463922764e-07 1.55 5.09495680894e-07 1.44748737342 5.09527439024e-07 1.2 5.09559197154e-07 0.952512626584 5.09590955285e-07 0.85 5.09622713415e-07 0.952512626585 5.09654471545e-07 1.2 5.09686229675e-07 1.44748737342 5.09717987805e-07 1.55 5.09749745935e-07 1.44748737342 5.09781504065e-07 1.2 5.09813262195e-07 0.952512626585 5.09845020325e-07 0.85 5.09876778455e-07 0.952512626585 5.09908536585e-07 1.2 5.09940294715e-07 1.44748737342 5.09972052846e-07 1.55 5.10003810976e-07 1.44748737342 5.10035569106e-07 1.2 5.10067327236e-07 0.952512626585 5.10099085366e-07 0.85 5.10130843496e-07 0.952512626584 5.10162601626e-07 1.2 5.10194359756e-07 1.44748737342 5.10226117886e-07 1.55 5.10257876016e-07 1.44748737342 5.10289634146e-07 1.2 5.10321392276e-07 0.952512626585 5.10353150407e-07 0.85 5.10384908537e-07 0.952512626584 5.10416666667e-07 1.2 5.10448424797e-07 1.44748737342 5.10480182927e-07 1.55 5.10511941057e-07 1.44748737342 5.10543699187e-07 1.2 5.10575457317e-07 0.952512626585 5.10607215447e-07 0.85 5.10638973577e-07 0.952512626585 5.10670731707e-07 1.2 5.10702489837e-07 1.44748737341 5.10734247967e-07 1.55 5.10766006098e-07 1.44748737342 5.10797764228e-07 1.2 5.10829522358e-07 0.952512626585 5.10861280488e-07 0.85 5.10893038618e-07 0.952512626585 5.10924796748e-07 1.2 5.10956554878e-07 1.44748737342 5.10988313008e-07 1.55 5.11020071138e-07 1.44748737342 5.11051829268e-07 1.2 5.11083587398e-07 0.952512626585 5.11115345528e-07 0.85 5.11147103659e-07 0.952512626585 5.11178861789e-07 1.2 5.11210619919e-07 1.44748737342 5.11242378049e-07 1.55 5.11274136179e-07 1.44748737342 5.11305894309e-07 1.2 5.11337652439e-07 0.952512626585 5.11369410569e-07 0.85 5.11401168699e-07 0.952512626585 5.11432926829e-07 1.2 5.11464684959e-07 1.44748737342 5.11496443089e-07 1.55 5.1152820122e-07 1.44748737342 5.1155995935e-07 1.2 5.1159171748e-07 0.952512626584 5.1162347561e-07 0.85 5.1165523374e-07 0.952512626585 5.1168699187e-07 1.2 5.1171875e-07 1.44748737342 5.1175050813e-07 1.55 5.1178226626e-07 1.44748737342 5.1181402439e-07 1.2 5.1184578252e-07 0.952512626585 5.1187754065e-07 0.85 5.1190929878e-07 0.952512626585 5.11941056911e-07 1.2 5.11972815041e-07 1.44748737342 5.12004573171e-07 1.55 5.12036331301e-07 1.44748737342 5.12068089431e-07 1.2 5.12099847561e-07 0.952512626585 5.12131605691e-07 0.85 5.12163363821e-07 0.952512626585 5.12195121951e-07 1.2 5.12226880081e-07 1.44748737342 5.12258638211e-07 1.55 5.12290396341e-07 1.44748737342 5.12322154472e-07 1.2 5.12353912602e-07 0.952512626585 5.12385670732e-07 0.85 5.12417428862e-07 0.952512626585 5.12449186992e-07 1.2 5.12480945122e-07 1.44748737342 5.12512703252e-07 1.55 5.12544461382e-07 1.44748737342 5.12576219512e-07 1.2 5.12607977642e-07 0.952512626585 5.12639735772e-07 0.85 5.12671493902e-07 0.952512626584 5.12703252033e-07 1.2 5.12735010163e-07 1.44748737341 5.12766768293e-07 1.55 5.12798526423e-07 1.44748737341 5.12830284553e-07 1.2 5.12862042683e-07 0.952512626585 5.12893800813e-07 0.85 5.12925558943e-07 0.952512626585 5.12957317073e-07 1.2 5.12989075203e-07 1.44748737342 5.13020833333e-07 1.55 5.13052591463e-07 1.44748737342 5.13084349593e-07 1.2 5.13116107724e-07 0.952512626584 5.13147865854e-07 0.85 5.13179623984e-07 0.952512626585 5.13211382114e-07 1.2 5.13243140244e-07 1.44748737342 5.13274898374e-07 1.55 5.13306656504e-07 1.44748737342 5.13338414634e-07 1.2 5.13370172764e-07 0.952512626585 5.13401930894e-07 0.85 5.13433689024e-07 0.952512626585 5.13465447154e-07 1.2 5.13497205285e-07 1.44748737342 5.13528963415e-07 1.55 5.13560721545e-07 1.44748737342 5.13592479675e-07 1.2 5.13624237805e-07 0.952512626585 5.13655995935e-07 0.85 5.13687754065e-07 0.952512626584 5.13719512195e-07 1.2 5.13751270325e-07 1.44748737342 5.13783028455e-07 1.55 5.13814786585e-07 1.44748737342 5.13846544715e-07 1.2 5.13878302846e-07 0.952512626585 5.13910060976e-07 0.85 5.13941819106e-07 0.952512626584 5.13973577236e-07 1.2 5.14005335366e-07 1.44748737341 5.14037093496e-07 1.55 5.14068851626e-07 1.44748737342 5.14100609756e-07 1.2 5.14132367886e-07 0.952512626585 5.14164126016e-07 0.85 5.14195884146e-07 0.952512626585 5.14227642276e-07 1.2 5.14259400407e-07 1.44748737341 5.14291158537e-07 1.55 5.14322916667e-07 1.44748737342 5.14354674797e-07 1.2 5.14386432927e-07 0.952512626584 5.14418191057e-07 0.85 5.14449949187e-07 0.952512626585 5.14481707317e-07 1.2 5.14513465447e-07 1.44748737342 5.14545223577e-07 1.55 5.14576981707e-07 1.44748737342 5.14608739837e-07 1.2 5.14640497967e-07 0.952512626585 5.14672256098e-07 0.85 5.14704014228e-07 0.952512626585 5.14735772358e-07 1.2 5.14767530488e-07 1.44748737342 5.14799288618e-07 1.55 5.14831046748e-07 1.44748737342 5.14862804878e-07 1.2 5.14894563008e-07 0.952512626585 5.14926321138e-07 0.85 5.14958079268e-07 0.952512626585 5.14989837398e-07 1.2 5.15021595528e-07 1.44748737342 5.15053353659e-07 1.55 5.15085111789e-07 1.44748737342 5.15116869919e-07 1.2 5.15148628049e-07 0.952512626585 5.15180386179e-07 0.85 5.15212144309e-07 0.952512626585 5.15243902439e-07 1.2 5.15275660569e-07 1.44748737342 5.15307418699e-07 1.55 5.15339176829e-07 1.44748737342 5.15370934959e-07 1.2 5.15402693089e-07 0.952512626585 5.1543445122e-07 0.85 5.1546620935e-07 0.952512626584 5.1549796748e-07 1.2 5.1552972561e-07 1.44748737342 5.1556148374e-07 1.55 5.1559324187e-07 1.44748737342 5.15625e-07 1.2 5.1565675813e-07 0.952512626585 5.1568851626e-07 0.85 5.1572027439e-07 0.952512626585 5.1575203252e-07 1.2 5.1578379065e-07 1.44748737342 5.1581554878e-07 1.55 5.15847306911e-07 1.44748737342 5.15879065041e-07 1.2 5.15910823171e-07 0.952512626585 5.15942581301e-07 0.85 5.15974339431e-07 0.952512626585 5.16006097561e-07 1.2 5.16037855691e-07 1.44748737342 5.16069613821e-07 1.55 5.16101371951e-07 1.44748737342 5.16133130081e-07 1.2 5.16164888211e-07 0.952512626585 5.16196646341e-07 0.85 5.16228404472e-07 0.952512626585 5.16260162602e-07 1.2 5.16291920732e-07 1.44748737342 5.16323678862e-07 1.55 5.16355436992e-07 1.44748737341 5.16387195122e-07 1.2 5.16418953252e-07 0.952512626585 5.16450711382e-07 0.85 5.16482469512e-07 0.952512626585 5.16514227642e-07 1.2 5.16545985772e-07 1.44748737342 5.16577743902e-07 1.55 5.16609502033e-07 1.44748737342 5.16641260163e-07 1.2 5.16673018293e-07 0.952512626584 5.16704776423e-07 0.85 5.16736534553e-07 0.952512626585 5.16768292683e-07 1.2 5.16800050813e-07 1.44748737342 5.16831808943e-07 1.55 5.16863567073e-07 1.44748737342 5.16895325203e-07 1.2 5.16927083333e-07 0.952512626585 5.16958841463e-07 0.85 5.16990599593e-07 0.952512626585 5.17022357724e-07 1.2 5.17054115854e-07 1.44748737342 5.17085873984e-07 1.55 5.17117632114e-07 1.44748737342 5.17149390244e-07 1.2 5.17181148374e-07 0.952512626585 5.17212906504e-07 0.85 5.17244664634e-07 0.952512626584 5.17276422764e-07 1.2 5.17308180894e-07 1.44748737342 5.17339939024e-07 1.55 5.17371697154e-07 1.44748737342 5.17403455285e-07 1.2 5.17435213415e-07 0.952512626585 5.17466971545e-07 0.85 5.17498729675e-07 0.952512626584 5.17530487805e-07 1.2 5.17562245935e-07 1.44748737341 5.17594004065e-07 1.55 5.17625762195e-07 1.44748737342 5.17657520325e-07 1.2 5.17689278455e-07 0.952512626585 5.17721036585e-07 0.85 5.17752794715e-07 0.952512626585 5.17784552846e-07 1.2 5.17816310976e-07 1.44748737342 5.17848069106e-07 1.55 5.17879827236e-07 1.44748737342 5.17911585366e-07 1.2 5.17943343496e-07 0.952512626584 5.17975101626e-07 0.85 5.18006859756e-07 0.952512626585 5.18038617886e-07 1.2 5.18070376016e-07 1.44748737342 5.18102134146e-07 1.55 5.18133892276e-07 1.44748737342 5.18165650407e-07 1.2 5.18197408537e-07 0.952512626585 5.18229166667e-07 0.85 5.18260924797e-07 0.952512626585 5.18292682927e-07 1.2 5.18324441057e-07 1.44748737342 5.18356199187e-07 1.55 5.18387957317e-07 1.44748737342 5.18419715447e-07 1.2 5.18451473577e-07 0.952512626585 5.18483231707e-07 0.85 5.18514989837e-07 0.952512626584 5.18546747967e-07 1.2 5.18578506098e-07 1.44748737342 5.18610264228e-07 1.55 5.18642022358e-07 1.44748737342 5.18673780488e-07 1.2 5.18705538618e-07 0.952512626585 5.18737296748e-07 0.85 5.18769054878e-07 0.952512626584 5.18800813008e-07 1.2 5.18832571138e-07 1.44748737342 5.18864329268e-07 1.55 5.18896087398e-07 1.44748737342 5.18927845528e-07 1.2 5.18959603659e-07 0.952512626585 5.18991361789e-07 0.85 5.19023119919e-07 0.952512626585 5.19054878049e-07 1.2 5.19086636179e-07 1.44748737342 5.19118394309e-07 1.55 5.19150152439e-07 1.44748737342 5.19181910569e-07 1.2 5.19213668699e-07 0.952512626585 5.19245426829e-07 0.85 5.19277184959e-07 0.952512626585 5.19308943089e-07 1.2 5.1934070122e-07 1.44748737342 5.1937245935e-07 1.55 5.1940421748e-07 1.44748737342 5.1943597561e-07 1.2 5.1946773374e-07 0.952512626585 5.1949949187e-07 0.85 5.1953125e-07 0.952512626585 5.1956300813e-07 1.2 5.1959476626e-07 1.44748737342 5.1962652439e-07 1.55 5.1965828252e-07 1.44748737342 5.1969004065e-07 1.2 5.1972179878e-07 0.952512626585 5.19753556911e-07 0.85 5.19785315041e-07 0.952512626585 5.19817073171e-07 1.2 5.19848831301e-07 1.44748737342 5.19880589431e-07 1.55 5.19912347561e-07 1.44748737342 5.19944105691e-07 1.2 5.19975863821e-07 0.952512626584 5.20007621951e-07 0.85 5.20039380081e-07 0.952512626585 5.20071138211e-07 1.2 5.20102896341e-07 1.44748737342 5.20134654472e-07 1.55 5.20166412602e-07 1.44748737342 5.20198170732e-07 1.2 5.20229928862e-07 0.952512626584 5.20261686992e-07 0.85 5.20293445122e-07 0.952512626585 5.20325203252e-07 1.2 5.20356961382e-07 1.44748737342 5.20388719512e-07 1.55 5.20420477642e-07 1.44748737342 5.20452235772e-07 1.2 5.20483993902e-07 0.952512626585 5.20515752033e-07 0.85 5.20547510163e-07 0.952512626585 5.20579268293e-07 1.2 5.20611026423e-07 1.44748737342 5.20642784553e-07 1.55 5.20674542683e-07 1.44748737342 5.20706300813e-07 1.2 5.20738058943e-07 0.952512626585 5.20769817073e-07 0.85 5.20801575203e-07 0.952512626584 5.20833333333e-07 1.2 5.20865091463e-07 1.44748737342 5.20896849593e-07 1.55 5.20928607724e-07 1.44748737342 5.20960365854e-07 1.2 5.20992123984e-07 0.952512626585 5.21023882114e-07 0.85 5.21055640244e-07 0.952512626584 5.21087398374e-07 1.2 5.21119156504e-07 1.44748737341 5.21150914634e-07 1.55 5.21182672764e-07 1.44748737341 5.21214430894e-07 1.2 5.21246189024e-07 0.952512626585 5.21277947154e-07 0.85 5.21309705285e-07 0.952512626585 5.21341463415e-07 1.2 5.21373221545e-07 1.44748737342 5.21404979675e-07 1.55 5.21436737805e-07 1.44748737342 5.21468495935e-07 1.2 5.21500254065e-07 0.952512626584 5.21532012195e-07 0.85 5.21563770325e-07 0.952512626585 5.21595528455e-07 1.2 5.21627286585e-07 1.44748737342 5.21659044715e-07 1.55 5.21690802846e-07 1.44748737342 5.21722560976e-07 1.2 5.21754319106e-07 0.952512626585 5.21786077236e-07 0.85 5.21817835366e-07 0.952512626585 5.21849593496e-07 1.2 5.21881351626e-07 1.44748737342 5.21913109756e-07 1.55 5.21944867886e-07 1.44748737342 5.21976626016e-07 1.2 5.22008384146e-07 0.952512626585 5.22040142276e-07 0.85 5.22071900407e-07 0.952512626584 5.22103658537e-07 1.2 5.22135416667e-07 1.44748737342 5.22167174797e-07 1.55 5.22198932927e-07 1.44748737342 5.22230691057e-07 1.2 5.22262449187e-07 0.952512626585 5.22294207317e-07 0.85 5.22325965447e-07 0.952512626584 5.22357723577e-07 1.2 5.22389481707e-07 1.44748737341 5.22421239837e-07 1.55 5.22452997967e-07 1.44748737342 5.22484756098e-07 1.2 5.22516514228e-07 0.952512626585 5.22548272358e-07 0.85 5.22580030488e-07 0.952512626585 5.22611788618e-07 1.2 5.22643546748e-07 1.44748737341 5.22675304878e-07 1.55 5.22707063008e-07 1.44748737342 5.22738821138e-07 1.2 5.22770579268e-07 0.952512626584 5.22802337398e-07 0.85 5.22834095528e-07 0.952512626585 5.22865853659e-07 1.2 5.22897611789e-07 1.44748737342 5.22929369919e-07 1.55 5.22961128049e-07 1.44748737342 5.22992886179e-07 1.2 5.23024644309e-07 0.952512626585 5.23056402439e-07 0.85 5.23088160569e-07 0.952512626585 5.23119918699e-07 1.2 5.23151676829e-07 1.44748737342 5.23183434959e-07 1.55 5.23215193089e-07 1.44748737342 5.2324695122e-07 1.2 5.2327870935e-07 0.952512626585 5.2331046748e-07 0.85 5.2334222561e-07 0.952512626585 5.2337398374e-07 1.2 5.2340574187e-07 1.44748737342 5.234375e-07 1.55 5.2346925813e-07 1.44748737342 5.2350101626e-07 1.2 5.2353277439e-07 0.952512626585 5.2356453252e-07 0.85 5.2359629065e-07 0.952512626585 5.2362804878e-07 1.2 5.23659806911e-07 1.44748737342 5.23691565041e-07 1.55 5.23723323171e-07 1.44748737342 5.23755081301e-07 1.2 5.23786839431e-07 0.952512626585 5.23818597561e-07 0.85 5.23850355691e-07 0.952512626585 5.23882113821e-07 1.2 5.23913871951e-07 1.44748737342 5.23945630081e-07 1.55 5.23977388211e-07 1.44748737342 5.24009146341e-07 1.2 5.24040904472e-07 0.952512626585 5.24072662602e-07 0.85 5.24104420732e-07 0.952512626585 5.24136178862e-07 1.2 5.24167936992e-07 1.44748737342 5.24199695122e-07 1.55 5.24231453252e-07 1.44748737342 5.24263211382e-07 1.2 5.24294969512e-07 0.952512626585 5.24326727642e-07 0.85 5.24358485772e-07 0.952512626584 5.24390243902e-07 1.2 5.24422002033e-07 1.44748737342 5.24453760163e-07 1.55 5.24485518293e-07 1.44748737342 5.24517276423e-07 1.2 5.24549034553e-07 0.952512626585 5.24580792683e-07 0.85 5.24612550813e-07 0.952512626585 5.24644308943e-07 1.2 5.24676067073e-07 1.44748737341 5.24707825203e-07 1.55 5.24739583333e-07 1.44748737341 5.24771341463e-07 1.2 5.24803099593e-07 0.952512626585 5.24834857724e-07 0.85 5.24866615854e-07 0.952512626585 5.24898373984e-07 1.2 5.24930132114e-07 1.44748737342 5.24961890244e-07 1.55 5.24993648374e-07 1.44748737342 5.25025406504e-07 1.2 5.25057164634e-07 0.952512626584 5.25088922764e-07 0.85 5.25120680894e-07 0.952512626585 5.25152439024e-07 1.2 5.25184197154e-07 1.44748737342 5.25215955285e-07 1.55 5.25247713415e-07 1.44748737342 5.25279471545e-07 1.2 5.25311229675e-07 0.952512626585 5.25342987805e-07 0.85 5.25374745935e-07 0.952512626585 5.25406504065e-07 1.2 5.25438262195e-07 1.44748737342 5.25470020325e-07 1.55 5.25501778455e-07 1.44748737342 5.25533536585e-07 1.2 5.25565294715e-07 0.952512626585 5.25597052846e-07 0.85 5.25628810976e-07 0.952512626584 5.25660569106e-07 1.2 5.25692327236e-07 1.44748737342 5.25724085366e-07 1.55 5.25755843496e-07 1.44748737342 5.25787601626e-07 1.2 5.25819359756e-07 0.952512626585 5.25851117886e-07 0.85 5.25882876016e-07 0.952512626584 5.25914634146e-07 1.2 5.25946392276e-07 1.44748737341 5.25978150407e-07 1.55 5.26009908537e-07 1.44748737342 5.26041666667e-07 1.2 5.26073424797e-07 0.952512626585 5.26105182927e-07 0.85 5.26136941057e-07 0.952512626585 5.26168699187e-07 1.2 5.26200457317e-07 1.44748737342 5.26232215447e-07 1.55 5.26263973577e-07 1.44748737342 5.26295731707e-07 1.2 5.26327489837e-07 0.952512626584 5.26359247967e-07 0.85 5.26391006098e-07 0.952512626585 5.26422764228e-07 1.2 5.26454522358e-07 1.44748737342 5.26486280488e-07 1.55 5.26518038618e-07 1.44748737342 5.26549796748e-07 1.2 5.26581554878e-07 0.952512626585 5.26613313008e-07 0.85 5.26645071138e-07 0.952512626585 5.26676829268e-07 1.2 5.26708587398e-07 1.44748737342 5.26740345528e-07 1.55 5.26772103659e-07 1.44748737342 5.26803861789e-07 1.2 5.26835619919e-07 0.952512626585 5.26867378049e-07 0.85 5.26899136179e-07 0.952512626585 5.26930894309e-07 1.2 5.26962652439e-07 1.44748737342 5.26994410569e-07 1.55 5.27026168699e-07 1.44748737342 5.27057926829e-07 1.2 5.27089684959e-07 0.952512626585 5.27121443089e-07 0.85 5.2715320122e-07 0.952512626584 5.2718495935e-07 1.2 5.2721671748e-07 1.44748737342 5.2724847561e-07 1.55 5.2728023374e-07 1.44748737342 5.2731199187e-07 1.2 5.2734375e-07 0.952512626585 5.2737550813e-07 0.85 5.2740726626e-07 0.952512626585 5.2743902439e-07 1.2 5.2747078252e-07 1.44748737342 5.2750254065e-07 1.55 5.2753429878e-07 1.44748737342 5.27566056911e-07 1.2 5.27597815041e-07 0.952512626585 5.27629573171e-07 0.85 5.27661331301e-07 0.952512626585 5.27693089431e-07 1.2 5.27724847561e-07 1.44748737342 5.27756605691e-07 1.55 5.27788363821e-07 1.44748737342 5.27820121951e-07 1.2 5.27851880081e-07 0.952512626585 5.27883638211e-07 0.85 5.27915396341e-07 0.952512626585 5.27947154472e-07 1.2 5.27978912602e-07 1.44748737342 5.28010670732e-07 1.55 5.28042428862e-07 1.44748737342 5.28074186992e-07 1.2 5.28105945122e-07 0.952512626585 5.28137703252e-07 0.85 5.28169461382e-07 0.952512626585 5.28201219512e-07 1.2 5.28232977642e-07 1.44748737341 5.28264735772e-07 1.55 5.28296493902e-07 1.44748737341 5.28328252033e-07 1.2 5.28360010163e-07 0.952512626585 5.28391768293e-07 0.85 5.28423526423e-07 0.952512626585 5.28455284553e-07 1.2 5.28487042683e-07 1.44748737342 5.28518800813e-07 1.55 5.28550558943e-07 1.44748737342 5.28582317073e-07 1.2 5.28614075203e-07 0.952512626584 5.28645833333e-07 0.85 5.28677591463e-07 0.952512626585 5.28709349593e-07 1.2 5.28741107724e-07 1.44748737342 5.28772865854e-07 1.55 5.28804623984e-07 1.44748737342 5.28836382114e-07 1.2 5.28868140244e-07 0.952512626585 5.28899898374e-07 0.85 5.28931656504e-07 0.952512626585 5.28963414634e-07 1.2 5.28995172764e-07 1.44748737342 5.29026930894e-07 1.55 5.29058689024e-07 1.44748737342 5.29090447154e-07 1.2 5.29122205285e-07 0.952512626585 5.29153963415e-07 0.85 5.29185721545e-07 0.952512626584 5.29217479675e-07 1.2 5.29249237805e-07 1.44748737342 5.29280995935e-07 1.55 5.29312754065e-07 1.44748737342 5.29344512195e-07 1.2 5.29376270325e-07 0.952512626585 5.29408028455e-07 0.85 5.29439786585e-07 0.952512626584 5.29471544715e-07 1.2 5.29503302846e-07 1.44748737341 5.29535060976e-07 1.55 5.29566819106e-07 1.44748737341 5.29598577236e-07 1.2 5.29630335366e-07 0.952512626585 5.29662093496e-07 0.85 5.29693851626e-07 0.952512626585 5.29725609756e-07 1.2 5.29757367886e-07 1.44748737342 5.29789126016e-07 1.55 5.29820884146e-07 1.44748737342 5.29852642276e-07 1.2 5.29884400407e-07 0.952512626584 5.29916158537e-07 0.85 5.29947916667e-07 0.952512626585 5.29979674797e-07 1.2 5.30011432927e-07 1.44748737342 5.30043191057e-07 1.55 5.30074949187e-07 1.44748737342 5.30106707317e-07 1.2 5.30138465447e-07 0.952512626585 5.30170223577e-07 0.85 5.30201981707e-07 0.952512626585 5.30233739837e-07 1.2 5.30265497967e-07 1.44748737342 5.30297256098e-07 1.55 5.30329014228e-07 1.44748737342 5.30360772358e-07 1.2 5.30392530488e-07 0.952512626585 5.30424288618e-07 0.85 5.30456046748e-07 0.952512626584 5.30487804878e-07 1.2 5.30519563008e-07 1.44748737342 5.30551321138e-07 1.55 5.30583079268e-07 1.44748737342 5.30614837398e-07 1.2 5.30646595528e-07 0.952512626585 5.30678353659e-07 0.85 5.30710111789e-07 0.952512626584 5.30741869919e-07 1.2 5.30773628049e-07 1.44748737342 5.30805386179e-07 1.55 5.30837144309e-07 1.44748737342 5.30868902439e-07 1.2 5.30900660569e-07 0.952512626585 5.30932418699e-07 0.85 5.30964176829e-07 0.952512626585 5.30995934959e-07 1.2 5.31027693089e-07 1.44748737341 5.3105945122e-07 1.55 5.3109120935e-07 1.44748737342 5.3112296748e-07 1.2 5.3115472561e-07 0.952512626585 5.3118648374e-07 0.85 5.3121824187e-07 0.952512626585 5.3125e-07 1.2 5.3128175813e-07 1.44748737342 5.3131351626e-07 1.55 5.3134527439e-07 1.44748737342 5.3137703252e-07 1.2 5.3140879065e-07 0.952512626585 5.3144054878e-07 0.85 5.31472306911e-07 0.952512626585 5.31504065041e-07 1.2 5.31535823171e-07 1.44748737342 5.31567581301e-07 1.55 5.31599339431e-07 1.44748737342 5.31631097561e-07 1.2 5.31662855691e-07 0.952512626585 5.31694613821e-07 0.85 5.31726371951e-07 0.952512626585 5.31758130081e-07 1.2 5.31789888211e-07 1.44748737342 5.31821646341e-07 1.55 5.31853404472e-07 1.44748737342 5.31885162602e-07 1.2 5.31916920732e-07 0.952512626584 5.31948678862e-07 0.85 5.31980436992e-07 0.952512626585 5.32012195122e-07 1.2 5.32043953252e-07 1.44748737342 5.32075711382e-07 1.55 5.32107469512e-07 1.44748737342 5.32139227642e-07 1.2 5.32170985772e-07 0.952512626585 5.32202743902e-07 0.85 5.32234502033e-07 0.952512626585 5.32266260163e-07 1.2 5.32298018293e-07 1.44748737342 5.32329776423e-07 1.55 5.32361534553e-07 1.44748737342 5.32393292683e-07 1.2 5.32425050813e-07 0.952512626585 5.32456808943e-07 0.85 5.32488567073e-07 0.952512626585 5.32520325203e-07 1.2 5.32552083333e-07 1.44748737342 5.32583841463e-07 1.55 5.32615599593e-07 1.44748737342 5.32647357724e-07 1.2 5.32679115854e-07 0.952512626585 5.32710873984e-07 0.85 5.32742632114e-07 0.952512626584 5.32774390244e-07 1.2 5.32806148374e-07 1.44748737342 5.32837906504e-07 1.55 5.32869664634e-07 1.44748737342 5.32901422764e-07 1.2 5.32933180894e-07 0.952512626585 5.32964939024e-07 0.85 5.32996697154e-07 0.952512626585 5.33028455285e-07 1.2 5.33060213415e-07 1.44748737341 5.33091971545e-07 1.55 5.33123729675e-07 1.44748737341 5.33155487805e-07 1.2 5.33187245935e-07 0.952512626585 5.33219004065e-07 0.85 5.33250762195e-07 0.952512626585 5.33282520325e-07 1.2 5.33314278455e-07 1.44748737342 5.33346036585e-07 1.55 5.33377794715e-07 1.44748737342 5.33409552846e-07 1.2 5.33441310976e-07 0.952512626584 5.33473069106e-07 0.85 5.33504827236e-07 0.952512626585 5.33536585366e-07 1.2 5.33568343496e-07 1.44748737342 5.33600101626e-07 1.55 5.33631859756e-07 1.44748737342 5.33663617886e-07 1.2 5.33695376016e-07 0.952512626585 5.33727134146e-07 0.85 5.33758892276e-07 0.952512626585 5.33790650407e-07 1.2 5.33822408537e-07 1.44748737342 5.33854166667e-07 1.55 5.33885924797e-07 1.44748737342 5.33917682927e-07 1.2 5.33949441057e-07 0.952512626585 5.33981199187e-07 0.85 5.34012957317e-07 0.952512626584 5.34044715447e-07 1.2 5.34076473577e-07 1.44748737342 5.34108231707e-07 1.55 5.34139989837e-07 1.44748737342 5.34171747967e-07 1.2 5.34203506098e-07 0.952512626585 5.34235264228e-07 0.85 5.34267022358e-07 0.952512626584 5.34298780488e-07 1.2 5.34330538618e-07 1.44748737341 5.34362296748e-07 1.55 5.34394054878e-07 1.44748737342 5.34425813008e-07 1.2 5.34457571138e-07 0.952512626585 5.34489329268e-07 0.85 5.34521087398e-07 0.952512626585 5.34552845528e-07 1.2 5.34584603659e-07 1.44748737342 5.34616361789e-07 1.55 5.34648119919e-07 1.44748737342 5.34679878049e-07 1.2 5.34711636179e-07 0.952512626584 5.34743394309e-07 0.85 5.34775152439e-07 0.952512626585 5.34806910569e-07 1.2 5.34838668699e-07 1.44748737342 5.34870426829e-07 1.55 5.34902184959e-07 1.44748737342 5.34933943089e-07 1.2 5.3496570122e-07 0.952512626585 5.3499745935e-07 0.85 5.3502921748e-07 0.952512626585 5.3506097561e-07 1.2 5.3509273374e-07 1.44748737342 5.3512449187e-07 1.55 5.3515625e-07 1.44748737342 5.3518800813e-07 1.2 5.3521976626e-07 0.952512626585 5.3525152439e-07 0.85 5.3528328252e-07 0.952512626585 5.3531504065e-07 1.2 5.3534679878e-07 1.44748737342 5.35378556911e-07 1.55 5.35410315041e-07 1.44748737342 5.35442073171e-07 1.2 5.35473831301e-07 0.952512626585 5.35505589431e-07 0.85 5.35537347561e-07 0.952512626585 5.35569105691e-07 1.2 5.35600863821e-07 1.44748737342 5.35632621951e-07 1.55 5.35664380081e-07 1.44748737342 5.35696138211e-07 1.2 5.35727896341e-07 0.952512626585 5.35759654472e-07 0.85 5.35791412602e-07 0.952512626585 5.35823170732e-07 1.2 5.35854928862e-07 1.44748737342 5.35886686992e-07 1.55 5.35918445122e-07 1.44748737342 5.35950203252e-07 1.2 5.35981961382e-07 0.952512626585 5.36013719512e-07 0.85 5.36045477642e-07 0.952512626585 5.36077235772e-07 1.2 5.36108993902e-07 1.44748737342 5.36140752033e-07 1.55 5.36172510163e-07 1.44748737342 5.36204268293e-07 1.2 5.36236026423e-07 0.952512626585 5.36267784553e-07 0.85 5.36299542683e-07 0.952512626584 5.36331300813e-07 1.2 5.36363058943e-07 1.44748737342 5.36394817073e-07 1.55 5.36426575203e-07 1.44748737342 5.36458333333e-07 1.2 5.36490091463e-07 0.952512626585 5.36521849593e-07 0.85 5.36553607724e-07 0.952512626585 5.36585365854e-07 1.2 5.36617123984e-07 1.44748737341 5.36648882114e-07 1.55 5.36680640244e-07 1.44748737341 5.36712398374e-07 1.2 5.36744156504e-07 0.952512626585 5.36775914634e-07 0.85 5.36807672764e-07 0.952512626585 5.36839430894e-07 1.2 5.36871189024e-07 1.44748737342 5.36902947154e-07 1.55 5.36934705285e-07 1.44748737342 5.36966463415e-07 1.2 5.36998221545e-07 0.952512626584 5.37029979675e-07 0.85 5.37061737805e-07 0.952512626585 5.37093495935e-07 1.2 5.37125254065e-07 1.44748737342 5.37157012195e-07 1.55 5.37188770325e-07 1.44748737342 5.37220528455e-07 1.2 5.37252286585e-07 0.952512626585 5.37284044715e-07 0.85 5.37315802846e-07 0.952512626585 5.37347560976e-07 1.2 5.37379319106e-07 1.44748737342 5.37411077236e-07 1.55 5.37442835366e-07 1.44748737342 5.37474593496e-07 1.2 5.37506351626e-07 0.952512626585 5.37538109756e-07 0.85 5.37569867886e-07 0.952512626584 5.37601626016e-07 1.2 5.37633384146e-07 1.44748737342 5.37665142276e-07 1.55 5.37696900407e-07 1.44748737342 5.37728658537e-07 1.2 5.37760416667e-07 0.952512626585 5.37792174797e-07 0.85 5.37823932927e-07 0.952512626584 5.37855691057e-07 1.2 5.37887449187e-07 1.44748737341 5.37919207317e-07 1.55 5.37950965447e-07 1.44748737341 5.37982723577e-07 1.2 5.38014481707e-07 0.952512626585 5.38046239837e-07 0.85 5.38077997967e-07 0.952512626585 5.38109756098e-07 1.2 5.38141514228e-07 1.44748737342 5.38173272358e-07 1.55 5.38205030488e-07 1.44748737342 5.38236788618e-07 1.2 5.38268546748e-07 0.952512626584 5.38300304878e-07 0.85 5.38332063008e-07 0.952512626585 5.38363821138e-07 1.2 5.38395579268e-07 1.44748737342 5.38427337398e-07 1.55 5.38459095528e-07 1.44748737342 5.38490853659e-07 1.2 5.38522611789e-07 0.952512626585 5.38554369919e-07 0.85 5.38586128049e-07 0.952512626585 5.38617886179e-07 1.2 5.38649644309e-07 1.44748737342 5.38681402439e-07 1.55 5.38713160569e-07 1.44748737342 5.38744918699e-07 1.2 5.38776676829e-07 0.952512626585 5.38808434959e-07 0.85 5.38840193089e-07 0.952512626584 5.3887195122e-07 1.2 5.3890370935e-07 1.44748737342 5.3893546748e-07 1.55 5.3896722561e-07 1.44748737342 5.3899898374e-07 1.2 5.3903074187e-07 0.952512626585 5.390625e-07 0.85 5.3909425813e-07 0.952512626584 5.3912601626e-07 1.2 5.3915777439e-07 1.44748737342 5.3918953252e-07 1.55 5.3922129065e-07 1.44748737342 5.3925304878e-07 1.2 5.39284806911e-07 0.952512626585 5.39316565041e-07 0.85 5.39348323171e-07 0.952512626585 5.39380081301e-07 1.2 5.39411839431e-07 1.44748737342 5.39443597561e-07 1.55 5.39475355691e-07 1.44748737342 5.39507113821e-07 1.2 5.39538871951e-07 0.952512626585 5.39570630081e-07 0.85 5.39602388211e-07 0.952512626585 5.39634146341e-07 1.2 5.39665904472e-07 1.44748737342 5.39697662602e-07 1.55 5.39729420732e-07 1.44748737342 5.39761178862e-07 1.2 5.39792936992e-07 0.952512626585 5.39824695122e-07 0.85 5.39856453252e-07 0.952512626585 5.39888211382e-07 1.2 5.39919969512e-07 1.44748737342 5.39951727642e-07 1.55 5.39983485772e-07 1.44748737342 5.40015243902e-07 1.2 5.40047002033e-07 0.952512626585 5.40078760163e-07 0.85 5.40110518293e-07 0.952512626585 5.40142276423e-07 1.2 5.40174034553e-07 1.44748737341 5.40205792683e-07 1.55 5.40237550813e-07 1.44748737342 5.40269308943e-07 1.2 5.40301067073e-07 0.952512626584 5.40332825203e-07 0.85 5.40364583333e-07 0.952512626585 5.40396341463e-07 1.2 5.40428099593e-07 1.44748737342 5.40459857724e-07 1.55 5.40491615854e-07 1.44748737342 5.40523373984e-07 1.2 5.40555132114e-07 0.952512626584 5.40586890244e-07 0.85 5.40618648374e-07 0.952512626585 5.40650406504e-07 1.2 5.40682164634e-07 1.44748737342 5.40713922764e-07 1.55 5.40745680894e-07 1.44748737342 5.40777439024e-07 1.2 5.40809197154e-07 0.952512626585 5.40840955285e-07 0.85 5.40872713415e-07 0.952512626585 5.40904471545e-07 1.2 5.40936229675e-07 1.44748737342 5.40967987805e-07 1.55 5.40999745935e-07 1.44748737342 5.41031504065e-07 1.2 5.41063262195e-07 0.952512626585 5.41095020325e-07 0.85 5.41126778455e-07 0.952512626584 5.41158536585e-07 1.2 5.41190294715e-07 1.44748737342 5.41222052846e-07 1.55 5.41253810976e-07 1.44748737342 5.41285569106e-07 1.2 5.41317327236e-07 0.952512626585 5.41349085366e-07 0.85 5.41380843496e-07 0.952512626585 5.41412601626e-07 1.2 5.41444359756e-07 1.44748737341 5.41476117886e-07 1.55 5.41507876016e-07 1.44748737341 5.41539634146e-07 1.2 5.41571392276e-07 0.952512626585 5.41603150407e-07 0.85 5.41634908537e-07 0.952512626585 5.41666666667e-07 1.2 5.41698424797e-07 1.44748737342 5.41730182927e-07 1.55 5.41761941057e-07 1.44748737342 5.41793699187e-07 1.2 5.41825457317e-07 0.952512626584 5.41857215447e-07 0.85 5.41888973577e-07 0.952512626585 5.41920731707e-07 1.2 5.41952489837e-07 1.44748737342 5.41984247967e-07 1.55 5.42016006098e-07 1.44748737342 5.42047764228e-07 1.2 5.42079522358e-07 0.952512626585 5.42111280488e-07 0.85 5.42143038618e-07 0.952512626585 5.42174796748e-07 1.2 5.42206554878e-07 1.44748737342 5.42238313008e-07 1.55 5.42270071138e-07 1.44748737342 5.42301829268e-07 1.2 5.42333587398e-07 0.952512626585 5.42365345528e-07 0.85 5.42397103659e-07 0.952512626584 5.42428861789e-07 1.2 5.42460619919e-07 1.44748737342 5.42492378049e-07 1.55 5.42524136179e-07 1.44748737342 5.42555894309e-07 1.2 5.42587652439e-07 0.952512626585 5.42619410569e-07 0.85 5.42651168699e-07 0.952512626584 5.42682926829e-07 1.2 5.42714684959e-07 1.44748737341 5.42746443089e-07 1.55 5.4277820122e-07 1.44748737342 5.4280995935e-07 1.2 5.4284171748e-07 0.952512626585 5.4287347561e-07 0.85 5.4290523374e-07 0.952512626585 5.4293699187e-07 1.2 5.4296875e-07 1.44748737341 5.4300050813e-07 1.55 5.4303226626e-07 1.44748737342 5.4306402439e-07 1.2 5.4309578252e-07 0.952512626584 5.4312754065e-07 0.85 5.4315929878e-07 0.952512626585 5.43191056911e-07 1.2 5.43222815041e-07 1.44748737342 5.43254573171e-07 1.55 5.43286331301e-07 1.44748737342 5.43318089431e-07 1.2 5.43349847561e-07 0.952512626585 5.43381605691e-07 0.85 5.43413363821e-07 0.952512626585 5.43445121951e-07 1.2 5.43476880081e-07 1.44748737342 5.43508638211e-07 1.55 5.43540396341e-07 1.44748737342 5.43572154472e-07 1.2 5.43603912602e-07 0.952512626585 5.43635670732e-07 0.85 5.43667428862e-07 0.952512626585 5.43699186992e-07 1.2 5.43730945122e-07 1.44748737342 5.43762703252e-07 1.55 5.43794461382e-07 1.44748737342 5.43826219512e-07 1.2 5.43857977642e-07 0.952512626585 5.43889735772e-07 0.85 5.43921493902e-07 0.952512626585 5.43953252033e-07 1.2 5.43985010163e-07 1.44748737342 5.44016768293e-07 1.55 5.44048526423e-07 1.44748737342 5.44080284553e-07 1.2 5.44112042683e-07 0.952512626585 5.44143800813e-07 0.85 5.44175558943e-07 0.952512626585 5.44207317073e-07 1.2 5.44239075203e-07 1.44748737342 5.44270833333e-07 1.55 5.44302591463e-07 1.44748737342 5.44334349593e-07 1.2 5.44366107724e-07 0.952512626585 5.44397865854e-07 0.85 5.44429623984e-07 0.952512626585 5.44461382114e-07 1.2 5.44493140244e-07 1.44748737342 5.44524898374e-07 1.55 5.44556656504e-07 1.44748737342 5.44588414634e-07 1.2 5.44620172764e-07 0.952512626585 5.44651930894e-07 0.85 5.44683689024e-07 0.952512626584 5.44715447154e-07 1.2 5.44747205285e-07 1.44748737342 5.44778963415e-07 1.55 5.44810721545e-07 1.44748737342 5.44842479675e-07 1.2 5.44874237805e-07 0.952512626585 5.44905995935e-07 0.85 5.44937754065e-07 0.952512626585 5.44969512195e-07 1.2 5.45001270325e-07 1.44748737341 5.45033028455e-07 1.55 5.45064786585e-07 1.44748737341 5.45096544715e-07 1.2 5.45128302846e-07 0.952512626585 5.45160060976e-07 0.85 5.45191819106e-07 0.952512626585 5.45223577236e-07 1.2 5.45255335366e-07 1.44748737342 5.45287093496e-07 1.55 5.45318851626e-07 1.44748737342 5.45350609756e-07 1.2 5.45382367886e-07 0.952512626584 5.45414126016e-07 0.85 5.45445884146e-07 0.952512626585 5.45477642276e-07 1.2 5.45509400407e-07 1.44748737342 5.45541158537e-07 1.55 5.45572916667e-07 1.44748737342 5.45604674797e-07 1.2 5.45636432927e-07 0.952512626585 5.45668191057e-07 0.85 5.45699949187e-07 0.952512626585 5.45731707317e-07 1.2 5.45763465447e-07 1.44748737342 5.45795223577e-07 1.55 5.45826981707e-07 1.44748737342 5.45858739837e-07 1.2 5.45890497967e-07 0.952512626585 5.45922256098e-07 0.85 5.45954014228e-07 0.952512626584 5.45985772358e-07 1.2 5.46017530488e-07 1.44748737342 5.46049288618e-07 1.55 5.46081046748e-07 1.44748737342 5.46112804878e-07 1.2 5.46144563008e-07 0.952512626585 5.46176321138e-07 0.85 5.46208079268e-07 0.952512626584 5.46239837398e-07 1.2 5.46271595528e-07 1.44748737341 5.46303353659e-07 1.55 5.46335111789e-07 1.44748737341 5.46366869919e-07 1.2 5.46398628049e-07 0.952512626585 5.46430386179e-07 0.85 5.46462144309e-07 0.952512626585 5.46493902439e-07 1.2 5.46525660569e-07 1.44748737342 5.46557418699e-07 1.55 5.46589176829e-07 1.44748737342 5.46620934959e-07 1.2 5.46652693089e-07 0.952512626584 5.4668445122e-07 0.85 5.4671620935e-07 0.952512626585 5.4674796748e-07 1.2 5.4677972561e-07 1.44748737342 5.4681148374e-07 1.55 5.4684324187e-07 1.44748737342 5.46875e-07 1.2 5.4690675813e-07 0.952512626585 5.4693851626e-07 0.85 5.4697027439e-07 0.952512626585 5.4700203252e-07 1.2 5.4703379065e-07 1.44748737342 5.4706554878e-07 1.55 5.47097306911e-07 1.44748737342 5.47129065041e-07 1.2 5.47160823171e-07 0.952512626585 5.47192581301e-07 0.85 5.47224339431e-07 0.952512626585 5.47256097561e-07 1.2 5.47287855691e-07 1.44748737342 5.47319613821e-07 1.55 5.47351371951e-07 1.44748737342 5.47383130081e-07 1.2 5.47414888211e-07 0.952512626585 5.47446646341e-07 0.85 5.47478404472e-07 0.952512626584 5.47510162602e-07 1.2 5.47541920732e-07 1.44748737342 5.47573678862e-07 1.55 5.47605436992e-07 1.44748737342 5.47637195122e-07 1.2 5.47668953252e-07 0.952512626585 5.47700711382e-07 0.85 5.47732469512e-07 0.952512626585 5.47764227642e-07 1.2 5.47795985772e-07 1.44748737342 5.47827743902e-07 1.55 5.47859502033e-07 1.44748737342 5.47891260163e-07 1.2 5.47923018293e-07 0.952512626585 5.47954776423e-07 0.85 5.47986534553e-07 0.952512626585 5.48018292683e-07 1.2 5.48050050813e-07 1.44748737342 5.48081808943e-07 1.55 5.48113567073e-07 1.44748737342 5.48145325203e-07 1.2 5.48177083333e-07 0.952512626585 5.48208841463e-07 0.85 5.48240599593e-07 0.952512626584 5.48272357724e-07 1.2 5.48304115854e-07 1.44748737342 5.48335873984e-07 1.55 5.48367632114e-07 1.44748737342 5.48399390244e-07 1.2 5.48431148374e-07 0.952512626585 5.48462906504e-07 0.85 5.48494664634e-07 0.952512626585 5.48526422764e-07 1.2 5.48558180894e-07 1.44748737341 5.48589939024e-07 1.55 5.48621697154e-07 1.44748737341 5.48653455285e-07 1.2 5.48685213415e-07 0.952512626584 5.48716971545e-07 0.85 5.48748729675e-07 0.952512626585 5.48780487805e-07 1.2 5.48812245935e-07 1.44748737342 5.48844004065e-07 1.55 5.48875762195e-07 1.44748737342 5.48907520325e-07 1.2 5.48939278455e-07 0.952512626584 5.48971036585e-07 0.85 5.49002794715e-07 0.952512626585 5.49034552846e-07 1.2 5.49066310976e-07 1.44748737342 5.49098069106e-07 1.55 5.49129827236e-07 1.44748737342 5.49161585366e-07 1.2 5.49193343496e-07 0.952512626585 5.49225101626e-07 0.85 5.49256859756e-07 0.952512626585 5.49288617886e-07 1.2 5.49320376016e-07 1.44748737342 5.49352134146e-07 1.55 5.49383892276e-07 1.44748737342 5.49415650407e-07 1.2 5.49447408537e-07 0.952512626585 5.49479166667e-07 0.85 5.49510924797e-07 0.952512626584 5.49542682927e-07 1.2 5.49574441057e-07 1.44748737342 5.49606199187e-07 1.55 5.49637957317e-07 1.44748737342 5.49669715447e-07 1.2 5.49701473577e-07 0.952512626585 5.49733231707e-07 0.85 5.49764989837e-07 0.952512626585 5.49796747967e-07 1.2 5.49828506098e-07 1.44748737341 5.49860264228e-07 1.55 5.49892022358e-07 1.44748737341 5.49923780488e-07 1.2 5.49955538618e-07 0.952512626585 5.49987296748e-07 0.85 5.50019054878e-07 0.952512626585 5.50050813008e-07 1.2 5.50082571138e-07 1.44748737342 5.50114329268e-07 1.55 5.50146087398e-07 1.44748737342 5.50177845528e-07 1.2 5.50209603659e-07 0.952512626584 5.50241361789e-07 0.85 5.50273119919e-07 0.952512626585 5.50304878049e-07 1.2 5.50336636179e-07 1.44748737342 5.50368394309e-07 1.55 5.50400152439e-07 1.44748737342 5.50431910569e-07 1.2 5.50463668699e-07 0.952512626585 5.50495426829e-07 0.85 5.50527184959e-07 0.952512626585 5.50558943089e-07 1.2 5.5059070122e-07 1.44748737342 5.5062245935e-07 1.55 5.5065421748e-07 1.44748737342 5.5068597561e-07 1.2 5.5071773374e-07 0.952512626585 5.5074949187e-07 0.85 5.5078125e-07 0.952512626584 5.5081300813e-07 1.2 5.5084476626e-07 1.44748737342 5.5087652439e-07 1.55 5.5090828252e-07 1.44748737342 5.5094004065e-07 1.2 5.5097179878e-07 0.952512626585 5.51003556911e-07 0.85 5.51035315041e-07 0.952512626584 5.51067073171e-07 1.2 5.51098831301e-07 1.44748737341 5.51130589431e-07 1.55 5.51162347561e-07 1.44748737342 5.51194105691e-07 1.2 5.51225863821e-07 0.952512626585 5.51257621951e-07 0.85 5.51289380081e-07 0.952512626585 5.51321138211e-07 1.2 5.51352896341e-07 1.44748737341 5.51384654472e-07 1.55 5.51416412602e-07 1.44748737342 5.51448170732e-07 1.2 5.51479928862e-07 0.952512626584 5.51511686992e-07 0.85 5.51543445122e-07 0.952512626585 5.51575203252e-07 1.2 5.51606961382e-07 1.44748737342 5.51638719512e-07 1.55 5.51670477642e-07 1.44748737342 5.51702235772e-07 1.2 5.51733993902e-07 0.952512626585 5.51765752033e-07 0.85 5.51797510163e-07 0.952512626585 5.51829268293e-07 1.2 5.51861026423e-07 1.44748737342 5.51892784553e-07 1.55 5.51924542683e-07 1.44748737342 5.51956300813e-07 1.2 5.51988058943e-07 0.952512626585 5.52019817073e-07 0.85 5.52051575203e-07 0.952512626585 5.52083333333e-07 1.2 5.52115091463e-07 1.44748737342 5.52146849593e-07 1.55 5.52178607724e-07 1.44748737342 5.52210365854e-07 1.2 5.52242123984e-07 0.952512626584 5.52273882114e-07 0.85 5.52305640244e-07 0.952512626585 5.52337398374e-07 1.2 5.52369156504e-07 1.44748737342 5.52400914634e-07 1.55 5.52432672764e-07 1.44748737342 5.52464430894e-07 1.2 5.52496189024e-07 0.952512626585 5.52527947154e-07 0.85 5.52559705285e-07 0.952512626585 5.52591463415e-07 1.2 5.52623221545e-07 1.44748737342 5.52654979675e-07 1.55 5.52686737805e-07 1.44748737342 5.52718495935e-07 1.2 5.52750254065e-07 0.952512626585 5.52782012195e-07 0.85 5.52813770325e-07 0.952512626585 5.52845528455e-07 1.2 5.52877286585e-07 1.44748737342 5.52909044715e-07 1.55 5.52940802846e-07 1.44748737342 5.52972560976e-07 1.2 5.53004319106e-07 0.952512626585 5.53036077236e-07 0.85 5.53067835366e-07 0.952512626584 5.53099593496e-07 1.2 5.53131351626e-07 1.44748737342 5.53163109756e-07 1.55 5.53194867886e-07 1.44748737342 5.53226626016e-07 1.2 5.53258384146e-07 0.952512626585 5.53290142276e-07 0.85 5.53321900407e-07 0.952512626585 5.53353658537e-07 1.2 5.53385416667e-07 1.44748737341 5.53417174797e-07 1.55 5.53448932927e-07 1.44748737341 5.53480691057e-07 1.2 5.53512449187e-07 0.952512626585 5.53544207317e-07 0.85 5.53575965447e-07 0.952512626585 5.53607723577e-07 1.2 5.53639481707e-07 1.44748737342 5.53671239837e-07 1.55 5.53702997967e-07 1.44748737342 5.53734756098e-07 1.2 5.53766514228e-07 0.952512626584 5.53798272358e-07 0.85 5.53830030488e-07 0.952512626585 5.53861788618e-07 1.2 5.53893546748e-07 1.44748737342 5.53925304878e-07 1.55 5.53957063008e-07 1.44748737342 5.53988821138e-07 1.2 5.54020579268e-07 0.952512626585 5.54052337398e-07 0.85 5.54084095528e-07 0.952512626585 5.54115853659e-07 1.2 5.54147611789e-07 1.44748737342 5.54179369919e-07 1.55 5.54211128049e-07 1.44748737342 5.54242886179e-07 1.2 5.54274644309e-07 0.952512626585 5.54306402439e-07 0.85 5.54338160569e-07 0.952512626584 5.54369918699e-07 1.2 5.54401676829e-07 1.44748737342 5.54433434959e-07 1.55 5.54465193089e-07 1.44748737342 5.5449695122e-07 1.2 5.5452870935e-07 0.952512626585 5.5456046748e-07 0.85 5.5459222561e-07 0.952512626584 5.5462398374e-07 1.2 5.5465574187e-07 1.44748737341 5.546875e-07 1.55 5.5471925813e-07 1.44748737342 5.5475101626e-07 1.2 5.5478277439e-07 0.952512626585 5.5481453252e-07 0.85 5.5484629065e-07 0.952512626585 5.5487804878e-07 1.2 5.54909806911e-07 1.44748737342 5.54941565041e-07 1.55 5.54973323171e-07 1.44748737342 5.55005081301e-07 1.2 5.55036839431e-07 0.952512626584 5.55068597561e-07 0.85 5.55100355691e-07 0.952512626585 5.55132113821e-07 1.2 5.55163871951e-07 1.44748737342 5.55195630081e-07 1.55 5.55227388211e-07 1.44748737342 5.55259146341e-07 1.2 5.55290904472e-07 0.952512626585 5.55322662602e-07 0.85 5.55354420732e-07 0.952512626585 5.55386178862e-07 1.2 5.55417936992e-07 1.44748737342 5.55449695122e-07 1.55 5.55481453252e-07 1.44748737342 5.55513211382e-07 1.2 5.55544969512e-07 0.952512626585 5.55576727642e-07 0.85 5.55608485772e-07 0.952512626585 5.55640243902e-07 1.2 5.55672002033e-07 1.44748737342 5.55703760163e-07 1.55 5.55735518293e-07 1.44748737342 5.55767276423e-07 1.2 5.55799034553e-07 0.952512626585 5.55830792683e-07 0.85 5.55862550813e-07 0.952512626585 5.55894308943e-07 1.2 5.55926067073e-07 1.44748737342 5.55957825203e-07 1.55 5.55989583333e-07 1.44748737342 5.56021341463e-07 1.2 5.56053099593e-07 0.952512626585 5.56084857724e-07 0.85 5.56116615854e-07 0.952512626585 5.56148373984e-07 1.2 5.56180132114e-07 1.44748737342 5.56211890244e-07 1.55 5.56243648374e-07 1.44748737342 5.56275406504e-07 1.2 5.56307164634e-07 0.952512626585 5.56338922764e-07 0.85 5.56370680894e-07 0.952512626585 5.56402439024e-07 1.2 5.56434197154e-07 1.44748737342 5.56465955285e-07 1.55 5.56497713415e-07 1.44748737342 5.56529471545e-07 1.2 5.56561229675e-07 0.952512626585 5.56592987805e-07 0.85 5.56624745935e-07 0.952512626584 5.56656504065e-07 1.2 5.56688262195e-07 1.44748737342 5.56720020325e-07 1.55 5.56751778455e-07 1.44748737342 5.56783536585e-07 1.2 5.56815294715e-07 0.952512626585 5.56847052846e-07 0.85 5.56878810976e-07 0.952512626585 5.56910569106e-07 1.2 5.56942327236e-07 1.44748737341 5.56974085366e-07 1.55 5.57005843496e-07 1.44748737341 5.57037601626e-07 1.2 5.57069359756e-07 0.952512626584 5.57101117886e-07 0.85 5.57132876016e-07 0.952512626585 5.57164634146e-07 1.2 5.57196392276e-07 1.44748737342 5.57228150407e-07 1.55 5.57259908537e-07 1.44748737342 5.57291666667e-07 1.2 5.57323424797e-07 0.952512626584 5.57355182927e-07 0.85 5.57386941057e-07 0.952512626585 5.57418699187e-07 1.2 5.57450457317e-07 1.44748737342 5.57482215447e-07 1.55 5.57513973577e-07 1.44748737342 5.57545731707e-07 1.2 5.57577489837e-07 0.952512626585 5.57609247967e-07 0.85 5.57641006098e-07 0.952512626585 5.57672764228e-07 1.2 5.57704522358e-07 1.44748737342 5.57736280488e-07 1.55 5.57768038618e-07 1.44748737342 5.57799796748e-07 1.2 5.57831554878e-07 0.952512626585 5.57863313008e-07 0.85 5.57895071138e-07 0.952512626584 5.57926829268e-07 1.2 5.57958587398e-07 1.44748737342 5.57990345528e-07 1.55 5.58022103659e-07 1.44748737342 5.58053861789e-07 1.2 5.58085619919e-07 0.952512626585 5.58117378049e-07 0.85 5.58149136179e-07 0.952512626585 5.58180894309e-07 1.2 5.58212652439e-07 1.44748737341 5.58244410569e-07 1.55 5.58276168699e-07 1.44748737341 5.58307926829e-07 1.2 5.58339684959e-07 0.952512626585 5.58371443089e-07 0.85 5.5840320122e-07 0.952512626585 5.5843495935e-07 1.2 5.5846671748e-07 1.44748737342 5.5849847561e-07 1.55 5.5853023374e-07 1.44748737342 5.5856199187e-07 1.2 5.5859375e-07 0.952512626584 5.5862550813e-07 0.85 5.5865726626e-07 0.952512626585 5.5868902439e-07 1.2 5.5872078252e-07 1.44748737342 5.5875254065e-07 1.55 5.5878429878e-07 1.44748737342 5.58816056911e-07 1.2 5.58847815041e-07 0.952512626585 5.58879573171e-07 0.85 5.58911331301e-07 0.952512626585 5.58943089431e-07 1.2 5.58974847561e-07 1.44748737342 5.59006605691e-07 1.55 5.59038363821e-07 1.44748737342 5.59070121951e-07 1.2 5.59101880081e-07 0.952512626585 5.59133638211e-07 0.85 5.59165396341e-07 0.952512626584 5.59197154472e-07 1.2 5.59228912602e-07 1.44748737342 5.59260670732e-07 1.55 5.59292428862e-07 1.44748737342 5.59324186992e-07 1.2 5.59355945122e-07 0.952512626585 5.59387703252e-07 0.85 5.59419461382e-07 0.952512626584 5.59451219512e-07 1.2 5.59482977642e-07 1.44748737342 5.59514735772e-07 1.55 5.59546493902e-07 1.44748737342 5.59578252033e-07 1.2 5.59610010163e-07 0.952512626585 5.59641768293e-07 0.85 5.59673526423e-07 0.952512626585 5.59705284553e-07 1.2 5.59737042683e-07 1.44748737341 5.59768800813e-07 1.55 5.59800558943e-07 1.44748737342 5.59832317073e-07 1.2 5.59864075203e-07 0.952512626585 5.59895833333e-07 0.85 5.59927591463e-07 0.952512626585 5.59959349593e-07 1.2 5.59991107724e-07 1.44748737342 5.60022865854e-07 1.55 5.60054623984e-07 1.44748737342 5.60086382114e-07 1.2 5.60118140244e-07 0.952512626585 5.60149898374e-07 0.85 5.60181656504e-07 0.952512626584 5.60213414634e-07 1.2 5.60245172764e-07 1.44748737342 5.60276930894e-07 1.55 5.60308689024e-07 1.44748737342 5.60340447154e-07 1.2 5.60372205285e-07 0.952512626585 5.60403963415e-07 0.85 5.60435721545e-07 0.952512626585 5.60467479675e-07 1.2 5.60499237805e-07 1.44748737342 5.60530995935e-07 1.55 5.60562754065e-07 1.44748737342 5.60594512195e-07 1.2 5.60626270325e-07 0.952512626584 5.60658028455e-07 0.85 5.60689786585e-07 0.952512626585 5.60721544715e-07 1.2 5.60753302846e-07 1.44748737342 5.60785060976e-07 1.55 5.60816819106e-07 1.44748737342 5.60848577236e-07 1.2 5.60880335366e-07 0.952512626584 5.60912093496e-07 0.85 5.60943851626e-07 0.952512626585 5.60975609756e-07 1.2 5.61007367886e-07 1.44748737342 5.61039126016e-07 1.55 5.61070884146e-07 1.44748737342 5.61102642276e-07 1.2 5.61134400407e-07 0.952512626585 5.61166158537e-07 0.85 5.61197916667e-07 0.952512626585 5.61229674797e-07 1.2 5.61261432927e-07 1.44748737342 5.61293191057e-07 1.55 5.61324949187e-07 1.44748737342 5.61356707317e-07 1.2 5.61388465447e-07 0.952512626585 5.61420223577e-07 0.85 5.61451981707e-07 0.952512626584 5.61483739837e-07 1.2 5.61515497967e-07 1.44748737342 5.61547256098e-07 1.55 5.61579014228e-07 1.44748737342 5.61610772358e-07 1.2 5.61642530488e-07 0.952512626585 5.61674288618e-07 0.85 5.61706046748e-07 0.952512626585 5.61737804878e-07 1.2 5.61769563008e-07 1.44748737341 5.61801321138e-07 1.55 5.61833079268e-07 1.44748737341 5.61864837398e-07 1.2 5.61896595528e-07 0.952512626585 5.61928353659e-07 0.85 5.61960111789e-07 0.952512626585 5.61991869919e-07 1.2 5.62023628049e-07 1.44748737342 5.62055386179e-07 1.55 5.62087144309e-07 1.44748737342 5.62118902439e-07 1.2 5.62150660569e-07 0.952512626584 5.62182418699e-07 0.85 5.62214176829e-07 0.952512626585 5.62245934959e-07 1.2 5.62277693089e-07 1.44748737342 5.6230945122e-07 1.55 5.6234120935e-07 1.44748737342 5.6237296748e-07 1.2 5.6240472561e-07 0.952512626585 5.6243648374e-07 0.85 5.6246824187e-07 0.952512626585 5.625e-07 1.2 5.6253175813e-07 1.44748737342 5.6256351626e-07 1.55 5.6259527439e-07 1.44748737342 5.6262703252e-07 1.2 5.6265879065e-07 0.952512626585 5.6269054878e-07 0.85 5.62722306911e-07 0.952512626584 5.62754065041e-07 1.2 5.62785823171e-07 1.44748737342 5.62817581301e-07 1.55 5.62849339431e-07 1.44748737342 5.62881097561e-07 1.2 5.62912855691e-07 0.952512626585 5.62944613821e-07 0.85 5.62976371951e-07 0.952512626584 5.63008130081e-07 1.2 5.63039888211e-07 1.44748737341 5.63071646341e-07 1.55 5.63103404472e-07 1.44748737342 5.63135162602e-07 1.2 5.63166920732e-07 0.952512626585 5.63198678862e-07 0.85 5.63230436992e-07 0.952512626585 5.63262195122e-07 1.2 5.63293953252e-07 1.44748737342 5.63325711382e-07 1.55 5.63357469512e-07 1.44748737342 5.63389227642e-07 1.2 5.63420985772e-07 0.952512626584 5.63452743902e-07 0.85 5.63484502033e-07 0.952512626585 5.63516260163e-07 1.2 5.63548018293e-07 1.44748737342 5.63579776423e-07 1.55 5.63611534553e-07 1.44748737342 5.63643292683e-07 1.2 5.63675050813e-07 0.952512626585 5.63706808943e-07 0.85 5.63738567073e-07 0.952512626584 5.63770325203e-07 1.2 5.63802083333e-07 1.44748737342 5.63833841463e-07 1.55 5.63865599593e-07 1.44748737342 5.63897357724e-07 1.2 5.63929115854e-07 0.952512626585 5.63960873984e-07 0.85 5.63992632114e-07 0.952512626585 5.64024390244e-07 1.2 5.64056148374e-07 1.44748737342 5.64087906504e-07 1.55 5.64119664634e-07 1.44748737342 5.64151422764e-07 1.2 5.64183180894e-07 0.952512626585 5.64214939024e-07 0.85 5.64246697154e-07 0.952512626585 5.64278455285e-07 1.2 5.64310213415e-07 1.44748737342 5.64341971545e-07 1.55 5.64373729675e-07 1.44748737342 5.64405487805e-07 1.2 5.64437245935e-07 0.952512626585 5.64469004065e-07 0.85 5.64500762195e-07 0.952512626585 5.64532520325e-07 1.2 5.64564278455e-07 1.44748737342 5.64596036585e-07 1.55 5.64627794715e-07 1.44748737342 5.64659552846e-07 1.2 5.64691310976e-07 0.952512626585 5.64723069106e-07 0.85 5.64754827236e-07 0.952512626585 5.64786585366e-07 1.2 5.64818343496e-07 1.44748737342 5.64850101626e-07 1.55 5.64881859756e-07 1.44748737342 5.64913617886e-07 1.2 5.64945376016e-07 0.952512626585 5.64977134146e-07 0.85 5.65008892276e-07 0.952512626584 5.65040650407e-07 1.2 5.65072408537e-07 1.44748737342 5.65104166667e-07 1.55 5.65135924797e-07 1.44748737342 5.65167682927e-07 1.2 5.65199441057e-07 0.952512626585 5.65231199187e-07 0.85 5.65262957317e-07 0.952512626585 5.65294715447e-07 1.2 5.65326473577e-07 1.44748737341 5.65358231707e-07 1.55 5.65389989837e-07 1.44748737341 5.65421747967e-07 1.2 5.65453506098e-07 0.952512626584 5.65485264228e-07 0.85 5.65517022358e-07 0.952512626585 5.65548780488e-07 1.2 5.65580538618e-07 1.44748737342 5.65612296748e-07 1.55 5.65644054878e-07 1.44748737342 5.65675813008e-07 1.2 5.65707571138e-07 0.952512626584 5.65739329268e-07 0.85 5.65771087398e-07 0.952512626585 5.65802845528e-07 1.2 5.65834603659e-07 1.44748737342 5.65866361789e-07 1.55 5.65898119919e-07 1.44748737342 5.65929878049e-07 1.2 5.65961636179e-07 0.952512626585 5.65993394309e-07 0.85 5.66025152439e-07 0.952512626585 5.66056910569e-07 1.2 5.66088668699e-07 1.44748737342 5.66120426829e-07 1.55 5.66152184959e-07 1.44748737342 5.66183943089e-07 1.2 5.6621570122e-07 0.952512626585 5.6624745935e-07 0.85 5.6627921748e-07 0.952512626584 5.6631097561e-07 1.2 5.6634273374e-07 1.44748737342 5.6637449187e-07 1.55 5.6640625e-07 1.44748737342 5.6643800813e-07 1.2 5.6646976626e-07 0.952512626585 5.6650152439e-07 0.85 5.6653328252e-07 0.952512626584 5.6656504065e-07 1.2 5.6659679878e-07 1.44748737341 5.66628556911e-07 1.55 5.66660315041e-07 1.44748737341 5.66692073171e-07 1.2 5.66723831301e-07 0.952512626585 5.66755589431e-07 0.85 5.66787347561e-07 0.952512626585 5.66819105691e-07 1.2 5.66850863821e-07 1.44748737342 5.66882621951e-07 1.55 5.66914380081e-07 1.44748737342 5.66946138211e-07 1.2 5.66977896341e-07 0.952512626584 5.67009654472e-07 0.85 5.67041412602e-07 0.952512626585 5.67073170732e-07 1.2 5.67104928862e-07 1.44748737342 5.67136686992e-07 1.55 5.67168445122e-07 1.44748737342 5.67200203252e-07 1.2 5.67231961382e-07 0.952512626585 5.67263719512e-07 0.85 5.67295477642e-07 0.952512626585 5.67327235772e-07 1.2 5.67358993902e-07 1.44748737342 5.67390752033e-07 1.55 5.67422510163e-07 1.44748737342 5.67454268293e-07 1.2 5.67486026423e-07 0.952512626585 5.67517784553e-07 0.85 5.67549542683e-07 0.952512626585 5.67581300813e-07 1.2 5.67613058943e-07 1.44748737342 5.67644817073e-07 1.55 5.67676575203e-07 1.44748737342 5.67708333333e-07 1.2 5.67740091463e-07 0.952512626585 5.67771849593e-07 0.85 5.67803607724e-07 0.952512626584 5.67835365854e-07 1.2 5.67867123984e-07 1.44748737342 5.67898882114e-07 1.55 5.67930640244e-07 1.44748737342 5.67962398374e-07 1.2 5.67994156504e-07 0.952512626585 5.68025914634e-07 0.85 5.68057672764e-07 0.952512626585 5.68089430894e-07 1.2 5.68121189024e-07 1.44748737342 5.68152947154e-07 1.55 5.68184705285e-07 1.44748737342 5.68216463415e-07 1.2 5.68248221545e-07 0.952512626585 5.68279979675e-07 0.85 5.68311737805e-07 0.952512626585 5.68343495935e-07 1.2 5.68375254065e-07 1.44748737342 5.68407012195e-07 1.55 5.68438770325e-07 1.44748737342 5.68470528455e-07 1.2 5.68502286585e-07 0.952512626585 5.68534044715e-07 0.85 5.68565802846e-07 0.952512626584 5.68597560976e-07 1.2 5.68629319106e-07 1.44748737342 5.68661077236e-07 1.55 5.68692835366e-07 1.44748737342 5.68724593496e-07 1.2 5.68756351626e-07 0.952512626585 5.68788109756e-07 0.85 5.68819867886e-07 0.952512626585 5.68851626016e-07 1.2 5.68883384146e-07 1.44748737342 5.68915142276e-07 1.55 5.68946900407e-07 1.44748737341 5.68978658537e-07 1.2 5.69010416667e-07 0.952512626584 5.69042174797e-07 0.85 5.69073932927e-07 0.952512626585 5.69105691057e-07 1.2 5.69137449187e-07 1.44748737342 5.69169207317e-07 1.55 5.69200965447e-07 1.44748737342 5.69232723577e-07 1.2 5.69264481707e-07 0.952512626584 5.69296239837e-07 0.85 5.69327997967e-07 0.952512626585 5.69359756098e-07 1.2 5.69391514228e-07 1.44748737342 5.69423272358e-07 1.55 5.69455030488e-07 1.44748737342 5.69486788618e-07 1.2 5.69518546748e-07 0.952512626585 5.69550304878e-07 0.85 5.69582063008e-07 0.952512626585 5.69613821138e-07 1.2 5.69645579268e-07 1.44748737342 5.69677337398e-07 1.55 5.69709095528e-07 1.44748737342 5.69740853659e-07 1.2 5.69772611789e-07 0.952512626585 5.69804369919e-07 0.85 5.69836128049e-07 0.952512626584 5.69867886179e-07 1.2 5.69899644309e-07 1.44748737342 5.69931402439e-07 1.55 5.69963160569e-07 1.44748737342 5.69994918699e-07 1.2 5.70026676829e-07 0.952512626585 5.70058434959e-07 0.85 5.70090193089e-07 0.952512626585 5.7012195122e-07 1.2 5.7015370935e-07 1.44748737341 5.7018546748e-07 1.55 5.7021722561e-07 1.44748737341 5.7024898374e-07 1.2 5.7028074187e-07 0.952512626585 5.703125e-07 0.85 5.7034425813e-07 0.952512626585 5.7037601626e-07 1.2 5.7040777439e-07 1.44748737342 5.7043953252e-07 1.55 5.7047129065e-07 1.44748737342 5.7050304878e-07 1.2 5.70534806911e-07 0.952512626584 5.70566565041e-07 0.85 5.70598323171e-07 0.952512626585 5.70630081301e-07 1.2 5.70661839431e-07 1.44748737342 5.70693597561e-07 1.55 5.70725355691e-07 1.44748737342 5.70757113821e-07 1.2 5.70788871951e-07 0.952512626585 5.70820630081e-07 0.85 5.70852388211e-07 0.952512626585 5.70884146341e-07 1.2 5.70915904472e-07 1.44748737342 5.70947662602e-07 1.55 5.70979420732e-07 1.44748737342 5.71011178862e-07 1.2 5.71042936992e-07 0.952512626585 5.71074695122e-07 0.85 5.71106453252e-07 0.952512626584 5.71138211382e-07 1.2 5.71169969512e-07 1.44748737342 5.71201727642e-07 1.55 5.71233485772e-07 1.44748737342 5.71265243902e-07 1.2 5.71297002033e-07 0.952512626585 5.71328760163e-07 0.85 5.71360518293e-07 0.952512626584 5.71392276423e-07 1.2 5.71424034553e-07 1.44748737341 5.71455792683e-07 1.55 5.71487550813e-07 1.44748737342 5.71519308943e-07 1.2 5.71551067073e-07 0.952512626585 5.71582825203e-07 0.85 5.71614583333e-07 0.952512626585 5.71646341463e-07 1.2 5.71678099593e-07 1.44748737342 5.71709857724e-07 1.55 5.71741615854e-07 1.44748737342 5.71773373984e-07 1.2 5.71805132114e-07 0.952512626585 5.71836890244e-07 0.85 5.71868648374e-07 0.952512626585 5.71900406504e-07 1.2 5.71932164634e-07 1.44748737342 5.71963922764e-07 1.55 5.71995680894e-07 1.44748737342 5.72027439024e-07 1.2 5.72059197154e-07 0.952512626585 5.72090955285e-07 0.85 5.72122713415e-07 0.952512626584 5.72154471545e-07 1.2 5.72186229675e-07 1.44748737342 5.72217987805e-07 1.55 5.72249745935e-07 1.44748737342 5.72281504065e-07 1.2 5.72313262195e-07 0.952512626585 5.72345020325e-07 0.85 5.72376778455e-07 0.952512626585 5.72408536585e-07 1.2 5.72440294715e-07 1.44748737342 5.72472052846e-07 1.55 5.72503810976e-07 1.44748737342 5.72535569106e-07 1.2 5.72567327236e-07 0.952512626584 5.72599085366e-07 0.85 5.72630843496e-07 0.952512626585 5.72662601626e-07 1.2 5.72694359756e-07 1.44748737342 5.72726117886e-07 1.55 5.72757876016e-07 1.44748737342 5.72789634146e-07 1.2 5.72821392276e-07 0.952512626585 5.72853150407e-07 0.85 5.72884908537e-07 0.952512626585 5.72916666667e-07 1.2 5.72948424797e-07 1.44748737342 5.72980182927e-07 1.55 5.73011941057e-07 1.44748737342 5.73043699187e-07 1.2 5.73075457317e-07 0.952512626585 5.73107215447e-07 0.85 5.73138973577e-07 0.952512626585 5.73170731707e-07 1.2 5.73202489837e-07 1.44748737342 5.73234247967e-07 1.55 5.73266006098e-07 1.44748737342 5.73297764228e-07 1.2 5.73329522358e-07 0.952512626585 5.73361280488e-07 0.85 5.73393038618e-07 0.952512626584 5.73424796748e-07 1.2 5.73456554878e-07 1.44748737342 5.73488313008e-07 1.55 5.73520071138e-07 1.44748737342 5.73551829268e-07 1.2 5.73583587398e-07 0.952512626585 5.73615345528e-07 0.85 5.73647103659e-07 0.952512626585 5.73678861789e-07 1.2 5.73710619919e-07 1.44748737341 5.73742378049e-07 1.55 5.73774136179e-07 1.44748737341 5.73805894309e-07 1.2 5.73837652439e-07 0.952512626585 5.73869410569e-07 0.85 5.73901168699e-07 0.952512626585 5.73932926829e-07 1.2 5.73964684959e-07 1.44748737342 5.73996443089e-07 1.55 5.7402820122e-07 1.44748737342 5.7405995935e-07 1.2 5.7409171748e-07 0.952512626584 5.7412347561e-07 0.85 5.7415523374e-07 0.952512626585 5.7418699187e-07 1.2 5.7421875e-07 1.44748737342 5.7425050813e-07 1.55 5.7428226626e-07 1.44748737342 5.7431402439e-07 1.2 5.7434578252e-07 0.952512626585 5.7437754065e-07 0.85 5.7440929878e-07 0.952512626585 5.74441056911e-07 1.2 5.74472815041e-07 1.44748737342 5.74504573171e-07 1.55 5.74536331301e-07 1.44748737342 5.74568089431e-07 1.2 5.74599847561e-07 0.952512626585 5.74631605691e-07 0.85 5.74663363821e-07 0.952512626584 5.74695121951e-07 1.2 5.74726880081e-07 1.44748737342 5.74758638211e-07 1.55 5.74790396341e-07 1.44748737342 5.74822154472e-07 1.2 5.74853912602e-07 0.952512626585 5.74885670732e-07 0.85 5.74917428862e-07 0.952512626584 5.74949186992e-07 1.2 5.74980945122e-07 1.44748737341 5.75012703252e-07 1.55 5.75044461382e-07 1.44748737341 5.75076219512e-07 1.2 5.75107977642e-07 0.952512626585 5.75139735772e-07 0.85 5.75171493902e-07 0.952512626585 5.75203252033e-07 1.2 5.75235010163e-07 1.44748737342 5.75266768293e-07 1.55 5.75298526423e-07 1.44748737342 5.75330284553e-07 1.2 5.75362042683e-07 0.952512626584 5.75393800813e-07 0.85 5.75425558943e-07 0.952512626585 5.75457317073e-07 1.2 5.75489075203e-07 1.44748737342 5.75520833333e-07 1.55 5.75552591463e-07 1.44748737342 5.75584349593e-07 1.2 5.75616107724e-07 0.952512626585 5.75647865854e-07 0.85 5.75679623984e-07 0.952512626585 5.75711382114e-07 1.2 5.75743140244e-07 1.44748737342 5.75774898374e-07 1.55 5.75806656504e-07 1.44748737342 5.75838414634e-07 1.2 5.75870172764e-07 0.952512626585 5.75901930894e-07 0.85 5.75933689024e-07 0.952512626585 5.75965447154e-07 1.2 5.75997205285e-07 1.44748737342 5.76028963415e-07 1.55 5.76060721545e-07 1.44748737342 5.76092479675e-07 1.2 5.76124237805e-07 0.952512626585 5.76155995935e-07 0.85 5.76187754065e-07 0.952512626585 5.76219512195e-07 1.2 5.76251270325e-07 1.44748737342 5.76283028455e-07 1.55 5.76314786585e-07 1.44748737342 5.76346544715e-07 1.2 5.76378302846e-07 0.952512626585 5.76410060976e-07 0.85 5.76441819106e-07 0.952512626585 5.76473577236e-07 1.2 5.76505335366e-07 1.44748737342 5.76537093496e-07 1.55 5.76568851626e-07 1.44748737342 5.76600609756e-07 1.2 5.76632367886e-07 0.952512626585 5.76664126016e-07 0.85 5.76695884146e-07 0.952512626585 5.76727642276e-07 1.2 5.76759400407e-07 1.44748737342 5.76791158537e-07 1.55 5.76822916667e-07 1.44748737342 5.76854674797e-07 1.2 5.76886432927e-07 0.952512626585 5.76918191057e-07 0.85 5.76949949187e-07 0.952512626584 5.76981707317e-07 1.2 5.77013465447e-07 1.44748737342 5.77045223577e-07 1.55 5.77076981707e-07 1.44748737342 5.77108739837e-07 1.2 5.77140497967e-07 0.952512626585 5.77172256098e-07 0.85 5.77204014228e-07 0.952512626585 5.77235772358e-07 1.2 5.77267530488e-07 1.44748737342 5.77299288618e-07 1.55 5.77331046748e-07 1.44748737341 5.77362804878e-07 1.2 5.77394563008e-07 0.952512626584 5.77426321138e-07 0.85 5.77458079268e-07 0.952512626585 5.77489837398e-07 1.2 5.77521595528e-07 1.44748737342 5.77553353659e-07 1.55 5.77585111789e-07 1.44748737342 5.77616869919e-07 1.2 5.77648628049e-07 0.952512626584 5.77680386179e-07 0.85 5.77712144309e-07 0.952512626585 5.77743902439e-07 1.2 5.77775660569e-07 1.44748737342 5.77807418699e-07 1.55 5.77839176829e-07 1.44748737342 5.77870934959e-07 1.2 5.77902693089e-07 0.952512626585 5.7793445122e-07 0.85 5.7796620935e-07 0.952512626585 5.7799796748e-07 1.2 5.7802972561e-07 1.44748737342 5.7806148374e-07 1.55 5.7809324187e-07 1.44748737342 5.78125e-07 1.2 5.7815675813e-07 0.952512626585 5.7818851626e-07 0.85 5.7822027439e-07 0.952512626584 5.7825203252e-07 1.2 5.7828379065e-07 1.44748737342 5.7831554878e-07 1.55 5.78347306911e-07 1.44748737342 5.78379065041e-07 1.2 5.78410823171e-07 0.952512626585 5.78442581301e-07 0.85 5.78474339431e-07 0.952512626585 5.78506097561e-07 1.2 5.78537855691e-07 1.44748737341 5.78569613821e-07 1.55 5.78601371951e-07 1.44748737341 5.78633130081e-07 1.2 5.78664888211e-07 0.952512626585 5.78696646341e-07 0.85 5.78728404472e-07 0.952512626585 5.78760162602e-07 1.2 5.78791920732e-07 1.44748737342 5.78823678862e-07 1.55 5.78855436992e-07 1.44748737342 5.78887195122e-07 1.2 5.78918953252e-07 0.952512626584 5.78950711382e-07 0.85 5.78982469512e-07 0.952512626585 5.79014227642e-07 1.2 5.79045985772e-07 1.44748737342 5.79077743902e-07 1.55 5.79109502033e-07 1.44748737342 5.79141260163e-07 1.2 5.79173018293e-07 0.952512626585 5.79204776423e-07 0.85 5.79236534553e-07 0.952512626585 5.79268292683e-07 1.2 5.79300050813e-07 1.44748737342 5.79331808943e-07 1.55 5.79363567073e-07 1.44748737342 5.79395325203e-07 1.2 5.79427083333e-07 0.952512626585 5.79458841463e-07 0.85 5.79490599593e-07 0.952512626584 5.79522357724e-07 1.2 5.79554115854e-07 1.44748737342 5.79585873984e-07 1.55 5.79617632114e-07 1.44748737342 5.79649390244e-07 1.2 5.79681148374e-07 0.952512626585 5.79712906504e-07 0.85 5.79744664634e-07 0.952512626584 5.79776422764e-07 1.2 5.79808180894e-07 1.44748737342 5.79839939024e-07 1.55 5.79871697154e-07 1.44748737342 5.79903455285e-07 1.2 5.79935213415e-07 0.952512626585 5.79966971545e-07 0.85 5.79998729675e-07 0.952512626585 5.80030487805e-07 1.2 5.80062245935e-07 1.44748737342 5.80094004065e-07 1.55 5.80125762195e-07 1.44748737342 5.80157520325e-07 1.2 5.80189278455e-07 0.952512626585 5.80221036585e-07 0.85 5.80252794715e-07 0.952512626585 5.80284552846e-07 1.2 5.80316310976e-07 1.44748737342 5.80348069106e-07 1.55 5.80379827236e-07 1.44748737342 5.80411585366e-07 1.2 5.80443343496e-07 0.952512626585 5.80475101626e-07 0.85 5.80506859756e-07 0.952512626584 5.80538617886e-07 1.2 5.80570376016e-07 1.44748737342 5.80602134146e-07 1.55 5.80633892276e-07 1.44748737342 5.80665650407e-07 1.2 5.80697408537e-07 0.952512626585 5.80729166667e-07 0.85 5.80760924797e-07 0.952512626585 5.80792682927e-07 1.2 5.80824441057e-07 1.44748737342 5.80856199187e-07 1.55 5.80887957317e-07 1.44748737342 5.80919715447e-07 1.2 5.80951473577e-07 0.952512626584 5.80983231707e-07 0.85 5.81014989837e-07 0.952512626585 5.81046747967e-07 1.2 5.81078506098e-07 1.44748737342 5.81110264228e-07 1.55 5.81142022358e-07 1.44748737342 5.81173780488e-07 1.2 5.81205538618e-07 0.952512626584 5.81237296748e-07 0.85 5.81269054878e-07 0.952512626585 5.81300813008e-07 1.2 5.81332571138e-07 1.44748737342 5.81364329268e-07 1.55 5.81396087398e-07 1.44748737342 5.81427845528e-07 1.2 5.81459603659e-07 0.952512626585 5.81491361789e-07 0.85 5.81523119919e-07 0.952512626585 5.81554878049e-07 1.2 5.81586636179e-07 1.44748737342 5.81618394309e-07 1.55 5.81650152439e-07 1.44748737342 5.81681910569e-07 1.2 5.81713668699e-07 0.952512626585 5.81745426829e-07 0.85 5.81777184959e-07 0.952512626584 5.81808943089e-07 1.2 5.8184070122e-07 1.44748737342 5.8187245935e-07 1.55 5.8190421748e-07 1.44748737342 5.8193597561e-07 1.2 5.8196773374e-07 0.952512626585 5.8199949187e-07 0.85 5.8203125e-07 0.952512626585 5.8206300813e-07 1.2 5.8209476626e-07 1.44748737341 5.8212652439e-07 1.55 5.8215828252e-07 1.44748737341 5.8219004065e-07 1.2 5.8222179878e-07 0.952512626585 5.82253556911e-07 0.85 5.82285315041e-07 0.952512626585 5.82317073171e-07 1.2 5.82348831301e-07 1.44748737342 5.82380589431e-07 1.55 5.82412347561e-07 1.44748737342 5.82444105691e-07 1.2 5.82475863821e-07 0.952512626584 5.82507621951e-07 0.85 5.82539380081e-07 0.952512626585 5.82571138211e-07 1.2 5.82602896341e-07 1.44748737342 5.82634654472e-07 1.55 5.82666412602e-07 1.44748737342 5.82698170732e-07 1.2 5.82729928862e-07 0.952512626585 5.82761686992e-07 0.85 5.82793445122e-07 0.952512626585 5.82825203252e-07 1.2 5.82856961382e-07 1.44748737342 5.82888719512e-07 1.55 5.82920477642e-07 1.44748737342 5.82952235772e-07 1.2 5.82983993902e-07 0.952512626585 5.83015752033e-07 0.85 5.83047510163e-07 0.952512626584 5.83079268293e-07 1.2 5.83111026423e-07 1.44748737342 5.83142784553e-07 1.55 5.83174542683e-07 1.44748737342 5.83206300813e-07 1.2 5.83238058943e-07 0.952512626585 5.83269817073e-07 0.85 5.83301575203e-07 0.952512626584 5.83333333333e-07 1.2 5.83365091463e-07 1.44748737341 5.83396849593e-07 1.55 5.83428607724e-07 1.44748737342 5.83460365854e-07 1.2 5.83492123984e-07 0.952512626585 5.83523882114e-07 0.85 5.83555640244e-07 0.952512626585 5.83587398374e-07 1.2 5.83619156504e-07 1.44748737342 5.83650914634e-07 1.55 5.83682672764e-07 1.44748737342 5.83714430894e-07 1.2 5.83746189024e-07 0.952512626585 5.83777947154e-07 0.85 5.83809705285e-07 0.952512626585 5.83841463415e-07 1.2 5.83873221545e-07 1.44748737342 5.83904979675e-07 1.55 5.83936737805e-07 1.44748737342 5.83968495935e-07 1.2 5.84000254065e-07 0.952512626585 5.84032012195e-07 0.85 5.84063770325e-07 0.952512626585 5.84095528455e-07 1.2 5.84127286585e-07 1.44748737342 5.84159044715e-07 1.55 5.84190802846e-07 1.44748737342 5.84222560976e-07 1.2 5.84254319106e-07 0.952512626585 5.84286077236e-07 0.85 5.84317835366e-07 0.952512626585 5.84349593496e-07 1.2 5.84381351626e-07 1.44748737342 5.84413109756e-07 1.55 5.84444867886e-07 1.44748737342 5.84476626016e-07 1.2 5.84508384146e-07 0.952512626585 5.84540142276e-07 0.85 5.84571900407e-07 0.952512626585 5.84603658537e-07 1.2 5.84635416667e-07 1.44748737342 5.84667174797e-07 1.55 5.84698932927e-07 1.44748737342 5.84730691057e-07 1.2 5.84762449187e-07 0.952512626585 5.84794207317e-07 0.85 5.84825965447e-07 0.952512626585 5.84857723577e-07 1.2 5.84889481707e-07 1.44748737342 5.84921239837e-07 1.55 5.84952997967e-07 1.44748737342 5.84984756098e-07 1.2 5.85016514228e-07 0.952512626585 5.85048272358e-07 0.85 5.85080030488e-07 0.952512626585 5.85111788618e-07 1.2 5.85143546748e-07 1.44748737342 5.85175304878e-07 1.55 5.85207063008e-07 1.44748737342 5.85238821138e-07 1.2 5.85270579268e-07 0.952512626585 5.85302337398e-07 0.85 5.85334095528e-07 0.952512626584 5.85365853659e-07 1.2 5.85397611789e-07 1.44748737342 5.85429369919e-07 1.55 5.85461128049e-07 1.44748737342 5.85492886179e-07 1.2 5.85524644309e-07 0.952512626585 5.85556402439e-07 0.85 5.85588160569e-07 0.952512626585 5.85619918699e-07 1.2 5.85651676829e-07 1.44748737341 5.85683434959e-07 1.55 5.85715193089e-07 1.44748737341 5.8574695122e-07 1.2 5.8577870935e-07 0.952512626584 5.8581046748e-07 0.85 5.8584222561e-07 0.952512626585 5.8587398374e-07 1.2 5.8590574187e-07 1.44748737342 5.859375e-07 1.55 5.8596925813e-07 1.44748737342 5.8600101626e-07 1.2 5.8603277439e-07 0.952512626584 5.8606453252e-07 0.85 5.8609629065e-07 0.952512626585 5.8612804878e-07 1.2 5.86159806911e-07 1.44748737342 5.86191565041e-07 1.55 5.86223323171e-07 1.44748737342 5.86255081301e-07 1.2 5.86286839431e-07 0.952512626585 5.86318597561e-07 0.85 5.86350355691e-07 0.952512626585 5.86382113821e-07 1.2 5.86413871951e-07 1.44748737342 5.86445630081e-07 1.55 5.86477388211e-07 1.44748737342 5.86509146341e-07 1.2 5.86540904472e-07 0.952512626585 5.86572662602e-07 0.85 5.86604420732e-07 0.952512626584 5.86636178862e-07 1.2 5.86667936992e-07 1.44748737342 5.86699695122e-07 1.55 5.86731453252e-07 1.44748737342 5.86763211382e-07 1.2 5.86794969512e-07 0.952512626585 5.86826727642e-07 0.85 5.86858485772e-07 0.952512626585 5.86890243902e-07 1.2 5.86922002033e-07 1.44748737341 5.86953760163e-07 1.55 5.86985518293e-07 1.44748737341 5.87017276423e-07 1.2 5.87049034553e-07 0.952512626585 5.87080792683e-07 0.85 5.87112550813e-07 0.952512626585 5.87144308943e-07 1.2 5.87176067073e-07 1.44748737342 5.87207825203e-07 1.55 5.87239583333e-07 1.44748737342 5.87271341463e-07 1.2 5.87303099593e-07 0.952512626584 5.87334857724e-07 0.85 5.87366615854e-07 0.952512626585 5.87398373984e-07 1.2 5.87430132114e-07 1.44748737342 5.87461890244e-07 1.55 5.87493648374e-07 1.44748737342 5.87525406504e-07 1.2 5.87557164634e-07 0.952512626585 5.87588922764e-07 0.85 5.87620680894e-07 0.952512626585 5.87652439024e-07 1.2 5.87684197154e-07 1.44748737342 5.87715955285e-07 1.55 5.87747713415e-07 1.44748737342 5.87779471545e-07 1.2 5.87811229675e-07 0.952512626585 5.87842987805e-07 0.85 5.87874745935e-07 0.952512626585 5.87906504065e-07 1.2 5.87938262195e-07 1.44748737342 5.87970020325e-07 1.55 5.88001778455e-07 1.44748737342 5.88033536585e-07 1.2 5.88065294715e-07 0.952512626585 5.88097052846e-07 0.85 5.88128810976e-07 0.952512626584 5.88160569106e-07 1.2 5.88192327236e-07 1.44748737342 5.88224085366e-07 1.55 5.88255843496e-07 1.44748737342 5.88287601626e-07 1.2 5.88319359756e-07 0.952512626585 5.88351117886e-07 0.85 5.88382876016e-07 0.952512626585 5.88414634146e-07 1.2 5.88446392276e-07 1.44748737342 5.88478150407e-07 1.55 5.88509908537e-07 1.44748737342 5.88541666667e-07 1.2 5.88573424797e-07 0.952512626585 5.88605182927e-07 0.85 5.88636941057e-07 0.952512626585 5.88668699187e-07 1.2 5.88700457317e-07 1.44748737342 5.88732215447e-07 1.55 5.88763973577e-07 1.44748737342 5.88795731707e-07 1.2 5.88827489837e-07 0.952512626585 5.88859247967e-07 0.85 5.88891006098e-07 0.952512626584 5.88922764228e-07 1.2 5.88954522358e-07 1.44748737342 5.88986280488e-07 1.55 5.89018038618e-07 1.44748737341 5.89049796748e-07 1.2 5.89081554878e-07 0.952512626585 5.89113313008e-07 0.85 5.89145071138e-07 0.952512626585 5.89176829268e-07 1.2 5.89208587398e-07 1.44748737342 5.89240345528e-07 1.55 5.89272103659e-07 1.44748737342 5.89303861789e-07 1.2 5.89335619919e-07 0.952512626584 5.89367378049e-07 0.85 5.89399136179e-07 0.952512626585 5.89430894309e-07 1.2 5.89462652439e-07 1.44748737342 5.89494410569e-07 1.55 5.89526168699e-07 1.44748737342 5.89557926829e-07 1.2 5.89589684959e-07 0.952512626584 5.89621443089e-07 0.85 5.8965320122e-07 0.952512626585 5.8968495935e-07 1.2 5.8971671748e-07 1.44748737342 5.8974847561e-07 1.55 5.8978023374e-07 1.44748737342 5.8981199187e-07 1.2 5.8984375e-07 0.952512626585 5.8987550813e-07 0.85 5.8990726626e-07 0.952512626585 5.8993902439e-07 1.2 5.8997078252e-07 1.44748737342 5.9000254065e-07 1.55 5.9003429878e-07 1.44748737342 5.90066056911e-07 1.2 5.90097815041e-07 0.952512626585 5.90129573171e-07 0.85 5.90161331301e-07 0.952512626584 5.90193089431e-07 1.2 5.90224847561e-07 1.44748737342 5.90256605691e-07 1.55 5.90288363821e-07 1.44748737342 5.90320121951e-07 1.2 5.90351880081e-07 0.952512626585 5.90383638211e-07 0.85 5.90415396341e-07 0.952512626585 5.90447154472e-07 1.2 5.90478912602e-07 1.44748737341 5.90510670732e-07 1.55 5.90542428862e-07 1.44748737341 5.90574186992e-07 1.2 5.90605945122e-07 0.952512626585 5.90637703252e-07 0.85 5.90669461382e-07 0.952512626585 5.90701219512e-07 1.2 5.90732977642e-07 1.44748737342 5.90764735772e-07 1.55 5.90796493902e-07 1.44748737342 5.90828252033e-07 1.2 5.90860010163e-07 0.952512626584 5.90891768293e-07 0.85 5.90923526423e-07 0.952512626585 5.90955284553e-07 1.2 5.90987042683e-07 1.44748737342 5.91018800813e-07 1.55 5.91050558943e-07 1.44748737342 5.91082317073e-07 1.2 5.91114075203e-07 0.952512626585 5.91145833333e-07 0.85 5.91177591463e-07 0.952512626585 5.91209349593e-07 1.2 5.91241107724e-07 1.44748737342 5.91272865854e-07 1.55 5.91304623984e-07 1.44748737342 5.91336382114e-07 1.2 5.91368140244e-07 0.952512626585 5.91399898374e-07 0.85 5.91431656504e-07 0.952512626584 5.91463414634e-07 1.2 5.91495172764e-07 1.44748737342 5.91526930894e-07 1.55 5.91558689024e-07 1.44748737342 5.91590447154e-07 1.2 5.91622205285e-07 0.952512626585 5.91653963415e-07 0.85 5.91685721545e-07 0.952512626584 5.91717479675e-07 1.2 5.91749237805e-07 1.44748737341 5.91780995935e-07 1.55 5.91812754065e-07 1.44748737342 5.91844512195e-07 1.2 5.91876270325e-07 0.952512626585 5.91908028455e-07 0.85 5.91939786585e-07 0.952512626585 5.91971544715e-07 1.2 5.92003302846e-07 1.44748737342 5.92035060976e-07 1.55 5.92066819106e-07 1.44748737342 5.92098577236e-07 1.2 5.92130335366e-07 0.952512626585 5.92162093496e-07 0.85 5.92193851626e-07 0.952512626585 5.92225609756e-07 1.2 5.92257367886e-07 1.44748737342 5.92289126016e-07 1.55 5.92320884146e-07 1.44748737342 5.92352642276e-07 1.2 5.92384400407e-07 0.952512626585 5.92416158537e-07 0.85 5.92447916667e-07 0.952512626585 5.92479674797e-07 1.2 5.92511432927e-07 1.44748737342 5.92543191057e-07 1.55 5.92574949187e-07 1.44748737342 5.92606707317e-07 1.2 5.92638465447e-07 0.952512626585 5.92670223577e-07 0.85 5.92701981707e-07 0.952512626585 5.92733739837e-07 1.2 5.92765497967e-07 1.44748737342 5.92797256098e-07 1.55 5.92829014228e-07 1.44748737342 5.92860772358e-07 1.2 5.92892530488e-07 0.952512626584 5.92924288618e-07 0.85 5.92956046748e-07 0.952512626585 5.92987804878e-07 1.2 5.93019563008e-07 1.44748737342 5.93051321138e-07 1.55 5.93083079268e-07 1.44748737342 5.93114837398e-07 1.2 5.93146595528e-07 0.952512626585 5.93178353659e-07 0.85 5.93210111789e-07 0.952512626585 5.93241869919e-07 1.2 5.93273628049e-07 1.44748737342 5.93305386179e-07 1.55 5.93337144309e-07 1.44748737342 5.93368902439e-07 1.2 5.93400660569e-07 0.952512626585 5.93432418699e-07 0.85 5.93464176829e-07 0.952512626585 5.93495934959e-07 1.2 5.93527693089e-07 1.44748737342 5.9355945122e-07 1.55 5.9359120935e-07 1.44748737342 5.9362296748e-07 1.2 5.9365472561e-07 0.952512626585 5.9368648374e-07 0.85 5.9371824187e-07 0.952512626584 5.9375e-07 1.2 5.9378175813e-07 1.44748737342 5.9381351626e-07 1.55 5.9384527439e-07 1.44748737342 5.9387703252e-07 1.2 5.9390879065e-07 0.952512626585 5.9394054878e-07 0.85 5.93972306911e-07 0.952512626585 5.94004065041e-07 1.2 5.94035823171e-07 1.44748737341 5.94067581301e-07 1.55 5.94099339431e-07 1.44748737341 5.94131097561e-07 1.2 5.94162855691e-07 0.952512626584 5.94194613821e-07 0.85 5.94226371951e-07 0.952512626585 5.94258130081e-07 1.2 5.94289888211e-07 1.44748737342 5.94321646341e-07 1.55 5.94353404472e-07 1.44748737342 5.94385162602e-07 1.2 5.94416920732e-07 0.952512626584 5.94448678862e-07 0.85 5.94480436992e-07 0.952512626585 5.94512195122e-07 1.2 5.94543953252e-07 1.44748737342 5.94575711382e-07 1.55 5.94607469512e-07 1.44748737342 5.94639227642e-07 1.2 5.94670985772e-07 0.952512626585 5.94702743902e-07 0.85 5.94734502033e-07 0.952512626585 5.94766260163e-07 1.2 5.94798018293e-07 1.44748737342 5.94829776423e-07 1.55 5.94861534553e-07 1.44748737342 5.94893292683e-07 1.2 5.94925050813e-07 0.952512626585 5.94956808943e-07 0.85 5.94988567073e-07 0.952512626584 5.95020325203e-07 1.2 5.95052083333e-07 1.44748737342 5.95083841463e-07 1.55 5.95115599593e-07 1.44748737342 5.95147357724e-07 1.2 5.95179115854e-07 0.952512626585 5.95210873984e-07 0.85 5.95242632114e-07 0.952512626585 5.95274390244e-07 1.2 5.95306148374e-07 1.44748737341 5.95337906504e-07 1.55 5.95369664634e-07 1.44748737342 5.95401422764e-07 1.2 5.95433180894e-07 0.952512626585 5.95464939024e-07 0.85 5.95496697154e-07 0.952512626585 5.95528455285e-07 1.2 5.95560213415e-07 1.44748737342 5.95591971545e-07 1.55 5.95623729675e-07 1.44748737342 5.95655487805e-07 1.2 5.95687245935e-07 0.952512626585 5.95719004065e-07 0.85 5.95750762195e-07 0.952512626585 5.95782520325e-07 1.2 5.95814278455e-07 1.44748737342 5.95846036585e-07 1.55 5.95877794715e-07 1.44748737342 5.95909552846e-07 1.2 5.95941310976e-07 0.952512626585 5.95973069106e-07 0.85 5.96004827236e-07 0.952512626585 5.96036585366e-07 1.2 5.96068343496e-07 1.44748737342 5.96100101626e-07 1.55 5.96131859756e-07 1.44748737342 5.96163617886e-07 1.2 5.96195376016e-07 0.952512626585 5.96227134146e-07 0.85 5.96258892276e-07 0.952512626585 5.96290650407e-07 1.2 5.96322408537e-07 1.44748737342 5.96354166667e-07 1.55 5.96385924797e-07 1.44748737342 5.96417682927e-07 1.2 5.96449441057e-07 0.952512626585 5.96481199187e-07 0.85 5.96512957317e-07 0.952512626585 5.96544715447e-07 1.2 5.96576473577e-07 1.44748737342 5.96608231707e-07 1.55 5.96639989837e-07 1.44748737342 5.96671747967e-07 1.2 5.96703506098e-07 0.952512626585 5.96735264228e-07 0.85 5.96767022358e-07 0.952512626585 5.96798780488e-07 1.2 5.96830538618e-07 1.44748737342 5.96862296748e-07 1.55 5.96894054878e-07 1.44748737342 5.96925813008e-07 1.2 5.96957571138e-07 0.952512626585 5.96989329268e-07 0.85 5.97021087398e-07 0.952512626585 5.97052845528e-07 1.2 5.97084603659e-07 1.44748737342 5.97116361789e-07 1.55 5.97148119919e-07 1.44748737342 5.97179878049e-07 1.2 5.97211636179e-07 0.952512626585 5.97243394309e-07 0.85 5.97275152439e-07 0.952512626584 5.97306910569e-07 1.2 5.97338668699e-07 1.44748737342 5.97370426829e-07 1.55 5.97402184959e-07 1.44748737342 5.97433943089e-07 1.2 5.9746570122e-07 0.952512626585 5.9749745935e-07 0.85 5.9752921748e-07 0.952512626585 5.9756097561e-07 1.2 5.9759273374e-07 1.44748737342 5.9762449187e-07 1.55 5.9765625e-07 1.44748737341 5.9768800813e-07 1.2 5.9771976626e-07 0.952512626584 5.9775152439e-07 0.85 5.9778328252e-07 0.952512626585 5.9781504065e-07 1.2 5.9784679878e-07 1.44748737342 5.97878556911e-07 1.55 5.97910315041e-07 1.44748737342 5.97942073171e-07 1.2 5.97973831301e-07 0.952512626584 5.98005589431e-07 0.85 5.98037347561e-07 0.952512626585 5.98069105691e-07 1.2 5.98100863821e-07 1.44748737342 5.98132621951e-07 1.55 5.98164380081e-07 1.44748737342 5.98196138211e-07 1.2 5.98227896341e-07 0.952512626585 5.98259654472e-07 0.85 5.98291412602e-07 0.952512626585 5.98323170732e-07 1.2 5.98354928862e-07 1.44748737342 5.98386686992e-07 1.55 5.98418445122e-07 1.44748737342 5.98450203252e-07 1.2 5.98481961382e-07 0.952512626585 5.98513719512e-07 0.85 5.98545477642e-07 0.952512626584 5.98577235772e-07 1.2 5.98608993902e-07 1.44748737342 5.98640752033e-07 1.55 5.98672510163e-07 1.44748737342 5.98704268293e-07 1.2 5.98736026423e-07 0.952512626585 5.98767784553e-07 0.85 5.98799542683e-07 0.952512626585 5.98831300813e-07 1.2 5.98863058943e-07 1.44748737341 5.98894817073e-07 1.55 5.98926575203e-07 1.44748737341 5.98958333333e-07 1.2 5.98990091463e-07 0.952512626585 5.99021849593e-07 0.85 5.99053607724e-07 0.952512626585 5.99085365854e-07 1.2 5.99117123984e-07 1.44748737342 5.99148882114e-07 1.55 5.99180640244e-07 1.44748737342 5.99212398374e-07 1.2 5.99244156504e-07 0.952512626585 5.99275914634e-07 0.85 5.99307672764e-07 0.952512626585 5.99339430894e-07 1.2 5.99371189024e-07 1.44748737342 5.99402947154e-07 1.55 5.99434705285e-07 1.44748737342 5.99466463415e-07 1.2 5.99498221545e-07 0.952512626585 5.99529979675e-07 0.85 5.99561737805e-07 0.952512626585 5.99593495935e-07 1.2 5.99625254065e-07 1.44748737342 5.99657012195e-07 1.55 5.99688770325e-07 1.44748737342 5.99720528455e-07 1.2 5.99752286585e-07 0.952512626585 5.99784044715e-07 0.85 5.99815802846e-07 0.952512626584 5.99847560976e-07 1.2 5.99879319106e-07 1.44748737342 5.99911077236e-07 1.55 5.99942835366e-07 1.44748737342 5.99974593496e-07 1.2 6.00006351626e-07 0.952512626585 6.00038109756e-07 0.85 6.00069867886e-07 0.952512626584 6.00101626016e-07 1.2 6.00133384146e-07 1.44748737342 6.00165142276e-07 1.55 6.00196900407e-07 1.44748737342 6.00228658537e-07 1.2 6.00260416667e-07 0.952512626585 6.00292174797e-07 0.85 6.00323932927e-07 0.952512626585 6.00355691057e-07 1.2 6.00387449187e-07 1.44748737342 6.00419207317e-07 1.55 6.00450965447e-07 1.44748737342 6.00482723577e-07 1.2 6.00514481707e-07 0.952512626585 6.00546239837e-07 0.85 6.00577997967e-07 0.952512626585 6.00609756098e-07 1.2 6.00641514228e-07 1.44748737342 6.00673272358e-07 1.55 6.00705030488e-07 1.44748737342 6.00736788618e-07 1.2 6.00768546748e-07 0.952512626585 6.00800304878e-07 0.85 6.00832063008e-07 0.952512626585 6.00863821138e-07 1.2 6.00895579268e-07 1.44748737342 6.00927337398e-07 1.55 6.00959095528e-07 1.44748737342 6.00990853659e-07 1.2 6.01022611789e-07 0.952512626585 6.01054369919e-07 0.85 6.01086128049e-07 0.952512626585 6.01117886179e-07 1.2 6.01149644309e-07 1.44748737342 6.01181402439e-07 1.55 6.01213160569e-07 1.44748737342 6.01244918699e-07 1.2 6.01276676829e-07 0.952512626584 6.01308434959e-07 0.85 6.01340193089e-07 0.952512626585 6.0137195122e-07 1.2 6.0140370935e-07 1.44748737342 6.0143546748e-07 1.55 6.0146722561e-07 1.44748737342 6.0149898374e-07 1.2 6.0153074187e-07 0.952512626584 6.015625e-07 0.85 6.0159425813e-07 0.952512626585 6.0162601626e-07 1.2 6.0165777439e-07 1.44748737342 6.0168953252e-07 1.55 6.0172129065e-07 1.44748737342 6.0175304878e-07 1.2 6.01784806911e-07 0.952512626585 6.01816565041e-07 0.85 6.01848323171e-07 0.952512626585 6.01880081301e-07 1.2 6.01911839431e-07 1.44748737342 6.01943597561e-07 1.55 6.01975355691e-07 1.44748737342 6.02007113821e-07 1.2 6.02038871951e-07 0.952512626585 6.02070630081e-07 0.85 6.02102388211e-07 0.952512626584 6.02134146341e-07 1.2 6.02165904472e-07 1.44748737342 6.02197662602e-07 1.55 6.02229420732e-07 1.44748737342 6.02261178862e-07 1.2 6.02292936992e-07 0.952512626585 6.02324695122e-07 0.85 6.02356453252e-07 0.952512626585 6.02388211382e-07 1.2 6.02419969512e-07 1.44748737341 6.02451727642e-07 1.55 6.02483485772e-07 1.44748737341 6.02515243902e-07 1.2 6.02547002033e-07 0.952512626584 6.02578760163e-07 0.85 6.02610518293e-07 0.952512626585 6.02642276423e-07 1.2 6.02674034553e-07 1.44748737342 6.02705792683e-07 1.55 6.02737550813e-07 1.44748737342 6.02769308943e-07 1.2 6.02801067073e-07 0.952512626584 6.02832825203e-07 0.85 6.02864583333e-07 0.952512626585 6.02896341463e-07 1.2 6.02928099593e-07 1.44748737342 6.02959857724e-07 1.55 6.02991615854e-07 1.44748737342 6.03023373984e-07 1.2 6.03055132114e-07 0.952512626585 6.03086890244e-07 0.85 6.03118648374e-07 0.952512626584 6.03150406504e-07 1.2 6.03182164634e-07 1.44748737342 6.03213922764e-07 1.55 6.03245680894e-07 1.44748737342 6.03277439024e-07 1.2 6.03309197154e-07 0.952512626585 6.03340955285e-07 0.85 6.03372713415e-07 0.952512626584 6.03404471545e-07 1.2 6.03436229675e-07 1.44748737341 6.03467987805e-07 1.55 6.03499745935e-07 1.44748737342 6.03531504065e-07 1.2 6.03563262195e-07 0.952512626585 6.03595020325e-07 0.85 6.03626778455e-07 0.952512626585 6.03658536585e-07 1.2 6.03690294715e-07 1.44748737341 6.03722052846e-07 1.55 6.03753810976e-07 1.44748737342 6.03785569106e-07 1.2 6.03817327236e-07 0.952512626585 6.03849085366e-07 0.85 6.03880843496e-07 0.952512626585 6.03912601626e-07 1.2 6.03944359756e-07 1.44748737342 6.03976117886e-07 1.55 6.04007876016e-07 1.44748737342 6.04039634146e-07 1.2 6.04071392276e-07 0.952512626585 6.04103150407e-07 0.85 6.04134908537e-07 0.952512626585 6.04166666667e-07 1.2 6.04198424797e-07 1.44748737342 6.04230182927e-07 1.55 6.04261941057e-07 1.44748737342 6.04293699187e-07 1.2 6.04325457317e-07 0.952512626585 6.04357215447e-07 0.85 6.04388973577e-07 0.952512626585 6.04420731707e-07 1.2 6.04452489837e-07 1.44748737342 6.04484247967e-07 1.55 6.04516006098e-07 1.44748737342 6.04547764228e-07 1.2 6.04579522358e-07 0.952512626585 6.04611280488e-07 0.85 6.04643038618e-07 0.952512626585 6.04674796748e-07 1.2 6.04706554878e-07 1.44748737342 6.04738313008e-07 1.55 6.04770071138e-07 1.44748737342 6.04801829268e-07 1.2 6.04833587398e-07 0.952512626585 6.04865345528e-07 0.85 6.04897103659e-07 0.952512626585 6.04928861789e-07 1.2 6.04960619919e-07 1.44748737342 6.04992378049e-07 1.55 6.05024136179e-07 1.44748737342 6.05055894309e-07 1.2 6.05087652439e-07 0.952512626585 6.05119410569e-07 0.85 6.05151168699e-07 0.952512626585 6.05182926829e-07 1.2 6.05214684959e-07 1.44748737342 6.05246443089e-07 1.55 6.0527820122e-07 1.44748737342 6.0530995935e-07 1.2 6.0534171748e-07 0.952512626585 6.0537347561e-07 0.85 6.0540523374e-07 0.952512626585 6.0543699187e-07 1.2 6.0546875e-07 1.44748737342 6.0550050813e-07 1.55 6.0553226626e-07 1.44748737342 6.0556402439e-07 1.2 6.0559578252e-07 0.952512626585 6.0562754065e-07 0.85 6.0565929878e-07 0.952512626584 6.05691056911e-07 1.2 6.05722815041e-07 1.44748737342 6.05754573171e-07 1.55 6.05786331301e-07 1.44748737342 6.05818089431e-07 1.2 6.05849847561e-07 0.952512626585 6.05881605691e-07 0.85 6.05913363821e-07 0.952512626585 6.05945121951e-07 1.2 6.05976880081e-07 1.44748737342 6.06008638211e-07 1.55 6.06040396341e-07 1.44748737341 6.06072154472e-07 1.2 6.06103912602e-07 0.952512626584 6.06135670732e-07 0.85 6.06167428862e-07 0.952512626585 6.06199186992e-07 1.2 6.06230945122e-07 1.44748737342 6.06262703252e-07 1.55 6.06294461382e-07 1.44748737342 6.06326219512e-07 1.2 6.06357977642e-07 0.952512626584 6.06389735772e-07 0.85 6.06421493902e-07 0.952512626585 6.06453252033e-07 1.2 6.06485010163e-07 1.44748737342 6.06516768293e-07 1.55 6.06548526423e-07 1.44748737342 6.06580284553e-07 1.2 6.06612042683e-07 0.952512626585 6.06643800813e-07 0.85 6.06675558943e-07 0.952512626585 6.06707317073e-07 1.2 6.06739075203e-07 1.44748737342 6.06770833333e-07 1.55 6.06802591463e-07 1.44748737342 6.06834349593e-07 1.2 6.06866107724e-07 0.952512626585 6.06897865854e-07 0.85 6.06929623984e-07 0.952512626584 6.06961382114e-07 1.2 6.06993140244e-07 1.44748737342 6.07024898374e-07 1.55 6.07056656504e-07 1.44748737342 6.07088414634e-07 1.2 6.07120172764e-07 0.952512626585 6.07151930894e-07 0.85 6.07183689024e-07 0.952512626585 6.07215447154e-07 1.2 6.07247205285e-07 1.44748737341 6.07278963415e-07 1.55 6.07310721545e-07 1.44748737342 6.07342479675e-07 1.2 6.07374237805e-07 0.952512626585 6.07405995935e-07 0.85 6.07437754065e-07 0.952512626585 6.07469512195e-07 1.2 6.07501270325e-07 1.44748737342 6.07533028455e-07 1.55 6.07564786585e-07 1.44748737342 6.07596544715e-07 1.2 6.07628302846e-07 0.952512626585 6.07660060976e-07 0.85 6.07691819106e-07 0.952512626585 6.07723577236e-07 1.2 6.07755335366e-07 1.44748737342 6.07787093496e-07 1.55 6.07818851626e-07 1.44748737342 6.07850609756e-07 1.2 6.07882367886e-07 0.952512626585 6.07914126016e-07 0.85 6.07945884146e-07 0.952512626585 6.07977642276e-07 1.2 6.08009400407e-07 1.44748737342 6.08041158537e-07 1.55 6.08072916667e-07 1.44748737342 6.08104674797e-07 1.2 6.08136432927e-07 0.952512626585 6.08168191057e-07 0.85 6.08199949187e-07 0.952512626585 6.08231707317e-07 1.2 6.08263465447e-07 1.44748737342 6.08295223577e-07 1.55 6.08326981707e-07 1.44748737342 6.08358739837e-07 1.2 6.08390497967e-07 0.952512626585 6.08422256098e-07 0.85 6.08454014228e-07 0.952512626584 6.08485772358e-07 1.2 6.08517530488e-07 1.44748737342 6.08549288618e-07 1.55 6.08581046748e-07 1.44748737342 6.08612804878e-07 1.2 6.08644563008e-07 0.952512626585 6.08676321138e-07 0.85 6.08708079268e-07 0.952512626585 6.08739837398e-07 1.2 6.08771595528e-07 1.44748737342 6.08803353659e-07 1.55 6.08835111789e-07 1.44748737342 6.08866869919e-07 1.2 6.08898628049e-07 0.952512626585 6.08930386179e-07 0.85 6.08962144309e-07 0.952512626585 6.08993902439e-07 1.2 6.09025660569e-07 1.44748737342 6.09057418699e-07 1.55 6.09089176829e-07 1.44748737342 6.09120934959e-07 1.2 6.09152693089e-07 0.952512626585 6.0918445122e-07 0.85 6.0921620935e-07 0.952512626584 6.0924796748e-07 1.2 6.0927972561e-07 1.44748737342 6.0931148374e-07 1.55 6.0934324187e-07 1.44748737341 6.09375e-07 1.2 6.0940675813e-07 0.952512626585 6.0943851626e-07 0.85 6.0947027439e-07 0.952512626585 6.0950203252e-07 1.2 6.0953379065e-07 1.44748737342 6.0956554878e-07 1.55 6.09597306911e-07 1.44748737342 6.09629065041e-07 1.2 6.09660823171e-07 0.952512626584 6.09692581301e-07 0.85 6.09724339431e-07 0.952512626585 6.09756097561e-07 1.2 6.09787855691e-07 1.44748737342 6.09819613821e-07 1.55 6.09851371951e-07 1.44748737342 6.09883130081e-07 1.2 6.09914888211e-07 0.952512626584 6.09946646341e-07 0.85 6.09978404472e-07 0.952512626585 6.10010162602e-07 1.2 6.10041920732e-07 1.44748737342 6.10073678862e-07 1.55 6.10105436992e-07 1.44748737342 6.10137195122e-07 1.2 6.10168953252e-07 0.952512626585 6.10200711382e-07 0.85 6.10232469512e-07 0.952512626585 6.10264227642e-07 1.2 6.10295985772e-07 1.44748737342 6.10327743902e-07 1.55 6.10359502033e-07 1.44748737342 6.10391260163e-07 1.2 6.10423018293e-07 0.952512626585 6.10454776423e-07 0.85 6.10486534553e-07 0.952512626584 6.10518292683e-07 1.2 6.10550050813e-07 1.44748737342 6.10581808943e-07 1.55 6.10613567073e-07 1.44748737342 6.10645325203e-07 1.2 6.10677083333e-07 0.952512626585 6.10708841463e-07 0.85 6.10740599593e-07 0.952512626585 6.10772357724e-07 1.2 6.10804115854e-07 1.44748737341 6.10835873984e-07 1.55 6.10867632114e-07 1.44748737341 6.10899390244e-07 1.2 6.10931148374e-07 0.952512626584 6.10962906504e-07 0.85 6.10994664634e-07 0.952512626585 6.11026422764e-07 1.2 6.11058180894e-07 1.44748737342 6.11089939024e-07 1.55 6.11121697154e-07 1.44748737342 6.11153455285e-07 1.2 6.11185213415e-07 0.952512626585 6.11216971545e-07 0.85 6.11248729675e-07 0.952512626585 6.11280487805e-07 1.2 6.11312245935e-07 1.44748737342 6.11344004065e-07 1.55 6.11375762195e-07 1.44748737342 6.11407520325e-07 1.2 6.11439278455e-07 0.952512626585 6.11471036585e-07 0.85 6.11502794715e-07 0.952512626584 6.11534552846e-07 1.2 6.11566310976e-07 1.44748737342 6.11598069106e-07 1.55 6.11629827236e-07 1.44748737342 6.11661585366e-07 1.2 6.11693343496e-07 0.952512626585 6.11725101626e-07 0.85 6.11756859756e-07 0.952512626584 6.11788617886e-07 1.2 6.11820376016e-07 1.44748737342 6.11852134146e-07 1.55 6.11883892276e-07 1.44748737342 6.11915650407e-07 1.2 6.11947408537e-07 0.952512626585 6.11979166667e-07 0.85 6.12010924797e-07 0.952512626584 6.12042682927e-07 1.2 6.12074441057e-07 1.44748737341 6.12106199187e-07 1.55 6.12137957317e-07 1.44748737342 6.12169715447e-07 1.2 6.12201473577e-07 0.952512626585 6.12233231707e-07 0.85 6.12264989837e-07 0.952512626585 6.12296747967e-07 1.2 6.12328506098e-07 1.44748737342 6.12360264228e-07 1.55 6.12392022358e-07 1.44748737342 6.12423780488e-07 1.2 6.12455538618e-07 0.952512626585 6.12487296748e-07 0.85 6.12519054878e-07 0.952512626585 6.12550813008e-07 1.2 6.12582571138e-07 1.44748737342 6.12614329268e-07 1.55 6.12646087398e-07 1.44748737342 6.12677845528e-07 1.2 6.12709603659e-07 0.952512626585 6.12741361789e-07 0.85 6.12773119919e-07 0.952512626585 6.12804878049e-07 1.2 6.12836636179e-07 1.44748737342 6.12868394309e-07 1.55 6.12900152439e-07 1.44748737342 6.12931910569e-07 1.2 6.12963668699e-07 0.952512626585 6.12995426829e-07 0.85 6.13027184959e-07 0.952512626585 6.13058943089e-07 1.2 6.1309070122e-07 1.44748737342 6.1312245935e-07 1.55 6.1315421748e-07 1.44748737342 6.1318597561e-07 1.2 6.1321773374e-07 0.952512626585 6.1324949187e-07 0.85 6.1328125e-07 0.952512626585 6.1331300813e-07 1.2 6.1334476626e-07 1.44748737342 6.1337652439e-07 1.55 6.1340828252e-07 1.44748737342 6.1344004065e-07 1.2 6.1347179878e-07 0.952512626585 6.13503556911e-07 0.85 6.13535315041e-07 0.952512626585 6.13567073171e-07 1.2 6.13598831301e-07 1.44748737342 6.13630589431e-07 1.55 6.13662347561e-07 1.44748737342 6.13694105691e-07 1.2 6.13725863821e-07 0.952512626585 6.13757621951e-07 0.85 6.13789380081e-07 0.952512626585 6.13821138211e-07 1.2 6.13852896341e-07 1.44748737342 6.13884654472e-07 1.55 6.13916412602e-07 1.44748737342 6.13948170732e-07 1.2 6.13979928862e-07 0.952512626585 6.14011686992e-07 0.85 6.14043445122e-07 0.952512626584 6.14075203252e-07 1.2 6.14106961382e-07 1.44748737342 6.14138719512e-07 1.55 6.14170477642e-07 1.44748737342 6.14202235772e-07 1.2 6.14233993902e-07 0.952512626585 6.14265752033e-07 0.85 6.14297510163e-07 0.952512626585 6.14329268293e-07 1.2 6.14361026423e-07 1.44748737342 6.14392784553e-07 1.55 6.14424542683e-07 1.44748737341 6.14456300813e-07 1.2 6.14488058943e-07 0.952512626584 6.14519817073e-07 0.85 6.14551575203e-07 0.952512626585 6.14583333333e-07 1.2 6.14615091463e-07 1.44748737342 6.14646849593e-07 1.55 6.14678607724e-07 1.44748737342 6.14710365854e-07 1.2 6.14742123984e-07 0.952512626584 6.14773882114e-07 0.85 6.14805640244e-07 0.952512626585 6.14837398374e-07 1.2 6.14869156504e-07 1.44748737342 6.14900914634e-07 1.55 6.14932672764e-07 1.44748737342 6.14964430894e-07 1.2 6.14996189024e-07 0.952512626585 6.15027947154e-07 0.85 6.15059705285e-07 0.952512626584 6.15091463415e-07 1.2 6.15123221545e-07 1.44748737342 6.15154979675e-07 1.55 6.15186737805e-07 1.44748737342 6.15218495935e-07 1.2 6.15250254065e-07 0.952512626585 6.15282012195e-07 0.85 6.15313770325e-07 0.952512626584 6.15345528455e-07 1.2 6.15377286585e-07 1.44748737341 6.15409044715e-07 1.55 6.15440802846e-07 1.44748737342 6.15472560976e-07 1.2 6.15504319106e-07 0.952512626585 6.15536077236e-07 0.85 6.15567835366e-07 0.952512626585 6.15599593496e-07 1.2 6.15631351626e-07 1.44748737341 6.15663109756e-07 1.55 6.15694867886e-07 1.44748737342 6.15726626016e-07 1.2 6.15758384146e-07 0.952512626585 6.15790142276e-07 0.85 6.15821900407e-07 0.952512626585 6.15853658537e-07 1.2 6.15885416667e-07 1.44748737342 6.15917174797e-07 1.55 6.15948932927e-07 1.44748737342 6.15980691057e-07 1.2 6.16012449187e-07 0.952512626585 6.16044207317e-07 0.85 6.16075965447e-07 0.952512626585 6.16107723577e-07 1.2 6.16139481707e-07 1.44748737342 6.16171239837e-07 1.55 6.16202997967e-07 1.44748737342 6.16234756098e-07 1.2 6.16266514228e-07 0.952512626585 6.16298272358e-07 0.85 6.16330030488e-07 0.952512626585 6.16361788618e-07 1.2 6.16393546748e-07 1.44748737342 6.16425304878e-07 1.55 6.16457063008e-07 1.44748737342 6.16488821138e-07 1.2 6.16520579268e-07 0.952512626585 6.16552337398e-07 0.85 6.16584095528e-07 0.952512626585 6.16615853659e-07 1.2 6.16647611789e-07 1.44748737342 6.16679369919e-07 1.55 6.16711128049e-07 1.44748737342 6.16742886179e-07 1.2 6.16774644309e-07 0.952512626585 6.16806402439e-07 0.85 6.16838160569e-07 0.952512626585 6.16869918699e-07 1.2 6.16901676829e-07 1.44748737342 6.16933434959e-07 1.55 6.16965193089e-07 1.44748737342 6.1699695122e-07 1.2 6.1702870935e-07 0.952512626585 6.1706046748e-07 0.85 6.1709222561e-07 0.952512626585 6.1712398374e-07 1.2 6.1715574187e-07 1.44748737342 6.171875e-07 1.55 6.1721925813e-07 1.44748737342 6.1725101626e-07 1.2 6.1728277439e-07 0.952512626585 6.1731453252e-07 0.85 6.1734629065e-07 0.952512626585 6.1737804878e-07 1.2 6.17409806911e-07 1.44748737342 6.17441565041e-07 1.55 6.17473323171e-07 1.44748737342 6.17505081301e-07 1.2 6.17536839431e-07 0.952512626585 6.17568597561e-07 0.85 6.17600355691e-07 0.952512626584 6.17632113821e-07 1.2 6.17663871951e-07 1.44748737342 6.17695630081e-07 1.55 6.17727388211e-07 1.44748737341 6.17759146341e-07 1.2 6.17790904472e-07 0.952512626585 6.17822662602e-07 0.85 6.17854420732e-07 0.952512626585 6.17886178862e-07 1.2 6.17917936992e-07 1.44748737342 6.17949695122e-07 1.55 6.17981453252e-07 1.44748737341 6.18013211382e-07 1.2 6.18044969512e-07 0.952512626584 6.18076727642e-07 0.85 6.18108485772e-07 0.952512626585 6.18140243902e-07 1.2 6.18172002033e-07 1.44748737342 6.18203760163e-07 1.55 6.18235518293e-07 1.44748737342 6.18267276423e-07 1.2 6.18299034553e-07 0.952512626584 6.18330792683e-07 0.85 6.18362550813e-07 0.952512626585 6.18394308943e-07 1.2 6.18426067073e-07 1.44748737342 6.18457825203e-07 1.55 6.18489583333e-07 1.44748737342 6.18521341463e-07 1.2 6.18553099593e-07 0.952512626585 6.18584857724e-07 0.85 6.18616615854e-07 0.952512626585 6.18648373984e-07 1.2 6.18680132114e-07 1.44748737342 6.18711890244e-07 1.55 6.18743648374e-07 1.44748737342 6.18775406504e-07 1.2 6.18807164634e-07 0.952512626585 6.18838922764e-07 0.85 6.18870680894e-07 0.952512626584 6.18902439024e-07 1.2 6.18934197154e-07 1.44748737341 6.18965955285e-07 1.55 6.18997713415e-07 1.44748737342 6.19029471545e-07 1.2 6.19061229675e-07 0.952512626585 6.19092987805e-07 0.85 6.19124745935e-07 0.952512626585 6.19156504065e-07 1.2 6.19188262195e-07 1.44748737341 6.19220020325e-07 1.55 6.19251778455e-07 1.44748737342 6.19283536585e-07 1.2 6.19315294715e-07 0.952512626584 6.19347052846e-07 0.85 6.19378810976e-07 0.952512626585 6.19410569106e-07 1.2 6.19442327236e-07 1.44748737342 6.19474085366e-07 1.55 6.19505843496e-07 1.44748737342 6.19537601626e-07 1.2 6.19569359756e-07 0.952512626585 6.19601117886e-07 0.85 6.19632876016e-07 0.952512626585 6.19664634146e-07 1.2 6.19696392276e-07 1.44748737342 6.19728150407e-07 1.55 6.19759908537e-07 1.44748737342 6.19791666667e-07 1.2 6.19823424797e-07 0.952512626585 6.19855182927e-07 0.85 6.19886941057e-07 0.952512626585 6.19918699187e-07 1.2 6.19950457317e-07 1.44748737342 6.19982215447e-07 1.55 6.20013973577e-07 1.44748737342 6.20045731707e-07 1.2 6.20077489837e-07 0.952512626585 6.20109247967e-07 0.85 6.20141006098e-07 0.952512626584 6.20172764228e-07 1.2 6.20204522358e-07 1.44748737342 6.20236280488e-07 1.55 6.20268038618e-07 1.44748737342 6.20299796748e-07 1.2 6.20331554878e-07 0.952512626585 6.20363313008e-07 0.85 6.20395071138e-07 0.952512626584 6.20426829268e-07 1.2 6.20458587398e-07 1.44748737342 6.20490345528e-07 1.55 6.20522103659e-07 1.44748737342 6.20553861789e-07 1.2 6.20585619919e-07 0.952512626585 6.20617378049e-07 0.85 6.20649136179e-07 0.952512626585 6.20680894309e-07 1.2 6.20712652439e-07 1.44748737342 6.20744410569e-07 1.55 6.20776168699e-07 1.44748737342 6.20807926829e-07 1.2 6.20839684959e-07 0.952512626585 6.20871443089e-07 0.85 6.2090320122e-07 0.952512626585 6.2093495935e-07 1.2 6.2096671748e-07 1.44748737342 6.2099847561e-07 1.55 6.2103023374e-07 1.44748737342 6.2106199187e-07 1.2 6.2109375e-07 0.952512626585 6.2112550813e-07 0.85 6.2115726626e-07 0.952512626585 6.2118902439e-07 1.2 6.2122078252e-07 1.44748737342 6.2125254065e-07 1.55 6.2128429878e-07 1.44748737342 6.21316056911e-07 1.2 6.21347815041e-07 0.952512626585 6.21379573171e-07 0.85 6.21411331301e-07 0.952512626585 6.21443089431e-07 1.2 6.21474847561e-07 1.44748737342 6.21506605691e-07 1.55 6.21538363821e-07 1.44748737342 6.21570121951e-07 1.2 6.21601880081e-07 0.952512626584 6.21633638211e-07 0.85 6.21665396341e-07 0.952512626585 6.21697154472e-07 1.2 6.21728912602e-07 1.44748737342 6.21760670732e-07 1.55 6.21792428862e-07 1.44748737342 6.21824186992e-07 1.2 6.21855945122e-07 0.952512626585 6.21887703252e-07 0.85 6.21919461382e-07 0.952512626585 6.21951219512e-07 1.2 6.21982977642e-07 1.44748737342 6.22014735772e-07 1.55 6.22046493902e-07 1.44748737342 6.22078252033e-07 1.2 6.22110010163e-07 0.952512626585 6.22141768293e-07 0.85 6.22173526423e-07 0.952512626585 6.22205284553e-07 1.2 6.22237042683e-07 1.44748737342 6.22268800813e-07 1.55 6.22300558943e-07 1.44748737342 6.22332317073e-07 1.2 6.22364075203e-07 0.952512626585 6.22395833333e-07 0.85 6.22427591463e-07 0.952512626584 6.22459349593e-07 1.2 6.22491107724e-07 1.44748737342 6.22522865854e-07 1.55 6.22554623984e-07 1.44748737342 6.22586382114e-07 1.2 6.22618140244e-07 0.952512626585 6.22649898374e-07 0.85 6.22681656504e-07 0.952512626585 6.22713414634e-07 1.2 6.22745172764e-07 1.44748737342 6.22776930894e-07 1.55 6.22808689024e-07 1.44748737341 6.22840447154e-07 1.2 6.22872205285e-07 0.952512626584 6.22903963415e-07 0.85 6.22935721545e-07 0.952512626585 6.22967479675e-07 1.2 6.22999237805e-07 1.44748737342 6.23030995935e-07 1.55 6.23062754065e-07 1.44748737342 6.23094512195e-07 1.2 6.23126270325e-07 0.952512626585 6.23158028455e-07 0.85 6.23189786585e-07 0.952512626585 6.23221544715e-07 1.2 6.23253302846e-07 1.44748737342 6.23285060976e-07 1.55 6.23316819106e-07 1.44748737342 6.23348577236e-07 1.2 6.23380335366e-07 0.952512626585 6.23412093496e-07 0.85 6.23443851626e-07 0.952512626584 6.23475609756e-07 1.2 6.23507367886e-07 1.44748737342 6.23539126016e-07 1.55 6.23570884146e-07 1.44748737342 6.23602642276e-07 1.2 6.23634400407e-07 0.952512626585 6.23666158537e-07 0.85 6.23697916667e-07 0.952512626584 6.23729674797e-07 1.2 6.23761432927e-07 1.44748737341 6.23793191057e-07 1.55 6.23824949187e-07 1.44748737342 6.23856707317e-07 1.2 6.23888465447e-07 0.952512626585 6.23920223577e-07 0.85 6.23951981707e-07 0.952512626585 6.23983739837e-07 1.2 6.24015497967e-07 1.44748737341 6.24047256098e-07 1.55 6.24079014228e-07 1.44748737342 6.24110772358e-07 1.2 6.24142530488e-07 0.952512626585 6.24174288618e-07 0.85 6.24206046748e-07 0.952512626585 6.24237804878e-07 1.2 6.24269563008e-07 1.44748737342 6.24301321138e-07 1.55 6.24333079268e-07 1.44748737342 6.24364837398e-07 1.2 6.24396595528e-07 0.952512626585 6.24428353659e-07 0.85 6.24460111789e-07 0.952512626585 6.24491869919e-07 1.2 6.24523628049e-07 1.44748737342 6.24555386179e-07 1.55 6.24587144309e-07 1.44748737342 6.24618902439e-07 1.2 6.24650660569e-07 0.952512626585 6.24682418699e-07 0.85 6.24714176829e-07 0.952512626585 6.24745934959e-07 1.2 6.24777693089e-07 1.44748737342 6.2480945122e-07 1.55 6.2484120935e-07 1.44748737342 6.2487296748e-07 1.2 6.2490472561e-07 0.952512626585 6.2493648374e-07 0.85 6.2496824187e-07 0.952512626585 6.25e-07 1.2 6.2503175813e-07 1.44748737342 6.2506351626e-07 1.55 6.2509527439e-07 1.44748737342 6.2512703252e-07 1.2 6.2515879065e-07 0.952512626585 6.2519054878e-07 0.85 6.25222306911e-07 0.952512626585 6.25254065041e-07 1.2 6.25285823171e-07 1.44748737342 6.25317581301e-07 1.55 6.25349339431e-07 1.44748737342 6.25381097561e-07 1.2 6.25412855691e-07 0.952512626585 6.25444613821e-07 0.85 6.25476371951e-07 0.952512626585 6.25508130081e-07 1.2 6.25539888211e-07 1.44748737342 6.25571646341e-07 1.55 6.25603404472e-07 1.44748737342 6.25635162602e-07 1.2 6.25666920732e-07 0.952512626585 6.25698678862e-07 0.85 6.25730436992e-07 0.952512626585 6.25762195122e-07 1.2 6.25793953252e-07 1.44748737342 6.25825711382e-07 1.55 6.25857469512e-07 1.44748737342 6.25889227642e-07 1.2 6.25920985772e-07 0.952512626585 6.25952743902e-07 0.85 6.25984502033e-07 0.952512626584 6.26016260163e-07 1.2 6.26048018293e-07 1.44748737342 6.26079776423e-07 1.55 6.26111534553e-07 1.44748737341 6.26143292683e-07 1.2 6.26175050813e-07 0.952512626585 6.26206808943e-07 0.85 6.26238567073e-07 0.952512626585 6.26270325203e-07 1.2 6.26302083333e-07 1.44748737342 6.26333841463e-07 1.55 6.26365599593e-07 1.44748737341 6.26397357724e-07 1.2 6.26429115854e-07 0.952512626584 6.26460873984e-07 0.85 6.26492632114e-07 0.952512626585 6.26524390244e-07 1.2 6.26556148374e-07 1.44748737342 6.26587906504e-07 1.55 6.26619664634e-07 1.44748737342 6.26651422764e-07 1.2 6.26683180894e-07 0.952512626584 6.26714939024e-07 0.85 6.26746697154e-07 0.952512626585 6.26778455285e-07 1.2 6.26810213415e-07 1.44748737342 6.26841971545e-07 1.55 6.26873729675e-07 1.44748737342 6.26905487805e-07 1.2 6.26937245935e-07 0.952512626585 6.26969004065e-07 0.85 6.27000762195e-07 0.952512626584 6.27032520325e-07 1.2 6.27064278455e-07 1.44748737342 6.27096036585e-07 1.55 6.27127794715e-07 1.44748737342 6.27159552846e-07 1.2 6.27191310976e-07 0.952512626585 6.27223069106e-07 0.85 6.27254827236e-07 0.952512626584 6.27286585366e-07 1.2 6.27318343496e-07 1.44748737341 6.27350101626e-07 1.55 6.27381859756e-07 1.44748737342 6.27413617886e-07 1.2 6.27445376016e-07 0.952512626585 6.27477134146e-07 0.85 6.27508892276e-07 0.952512626585 6.27540650407e-07 1.2 6.27572408537e-07 1.44748737341 6.27604166667e-07 1.55 6.27635924797e-07 1.44748737342 6.27667682927e-07 1.2 6.27699441057e-07 0.952512626585 6.27731199187e-07 0.85 6.27762957317e-07 0.952512626585 6.27794715447e-07 1.2 6.27826473577e-07 1.44748737342 6.27858231707e-07 1.55 6.27889989837e-07 1.44748737342 6.27921747967e-07 1.2 6.27953506098e-07 0.952512626585 6.27985264228e-07 0.85 6.28017022358e-07 0.952512626585 6.28048780488e-07 1.2 6.28080538618e-07 1.44748737342 6.28112296748e-07 1.55 6.28144054878e-07 1.44748737342 6.28175813008e-07 1.2 6.28207571138e-07 0.952512626585 6.28239329268e-07 0.85 6.28271087398e-07 0.952512626585 6.28302845528e-07 1.2 6.28334603659e-07 1.44748737342 6.28366361789e-07 1.55 6.28398119919e-07 1.44748737342 6.28429878049e-07 1.2 6.28461636179e-07 0.952512626585 6.28493394309e-07 0.85 6.28525152439e-07 0.952512626585 6.28556910569e-07 1.2 6.28588668699e-07 1.44748737342 6.28620426829e-07 1.55 6.28652184959e-07 1.44748737342 6.28683943089e-07 1.2 6.2871570122e-07 0.952512626585 6.2874745935e-07 0.85 6.2877921748e-07 0.952512626584 6.2881097561e-07 1.2 6.2884273374e-07 1.44748737342 6.2887449187e-07 1.55 6.2890625e-07 1.44748737342 6.2893800813e-07 1.2 6.2896976626e-07 0.952512626585 6.2900152439e-07 0.85 6.2903328252e-07 0.952512626585 6.2906504065e-07 1.2 6.2909679878e-07 1.44748737342 6.29128556911e-07 1.55 6.29160315041e-07 1.44748737342 6.29192073171e-07 1.2 6.29223831301e-07 0.952512626585 6.29255589431e-07 0.85 6.29287347561e-07 0.952512626585 6.29319105691e-07 1.2 6.29350863821e-07 1.44748737342 6.29382621951e-07 1.55 6.29414380081e-07 1.44748737342 6.29446138211e-07 1.2 6.29477896341e-07 0.952512626585 6.29509654472e-07 0.85 6.29541412602e-07 0.952512626585 6.29573170732e-07 1.2 6.29604928862e-07 1.44748737342 6.29636686992e-07 1.55 6.29668445122e-07 1.44748737341 6.29700203252e-07 1.2 6.29731961382e-07 0.952512626585 6.29763719512e-07 0.85 6.29795477642e-07 0.952512626585 6.29827235772e-07 1.2 6.29858993902e-07 1.44748737342 6.29890752033e-07 1.55 6.29922510163e-07 1.44748737342 6.29954268293e-07 1.2 6.29986026423e-07 0.952512626584 6.30017784553e-07 0.85 6.30049542683e-07 0.952512626585 6.30081300813e-07 1.2 6.30113058943e-07 1.44748737342 6.30144817073e-07 1.55 6.30176575203e-07 1.44748737342 6.30208333333e-07 1.2 6.30240091463e-07 0.952512626584 6.30271849593e-07 0.85 6.30303607724e-07 0.952512626585 6.30335365854e-07 1.2 6.30367123984e-07 1.44748737342 6.30398882114e-07 1.55 6.30430640244e-07 1.44748737342 6.30462398374e-07 1.2 6.30494156504e-07 0.952512626585 6.30525914634e-07 0.85 6.30557672764e-07 0.952512626585 6.30589430894e-07 1.2 6.30621189024e-07 1.44748737342 6.30652947154e-07 1.55 6.30684705285e-07 1.44748737342 6.30716463415e-07 1.2 6.30748221545e-07 0.952512626585 6.30779979675e-07 0.85 6.30811737805e-07 0.952512626584 6.30843495935e-07 1.2 6.30875254065e-07 1.44748737341 6.30907012195e-07 1.55 6.30938770325e-07 1.44748737342 6.30970528455e-07 1.2 6.31002286585e-07 0.952512626585 6.31034044715e-07 0.85 6.31065802846e-07 0.952512626585 6.31097560976e-07 1.2 6.31129319106e-07 1.44748737341 6.31161077236e-07 1.55 6.31192835366e-07 1.44748737342 6.31224593496e-07 1.2 6.31256351626e-07 0.952512626584 6.31288109756e-07 0.85 6.31319867886e-07 0.952512626585 6.31351626016e-07 1.2 6.31383384146e-07 1.44748737342 6.31415142276e-07 1.55 6.31446900407e-07 1.44748737342 6.31478658537e-07 1.2 6.31510416667e-07 0.952512626585 6.31542174797e-07 0.85 6.31573932927e-07 0.952512626585 6.31605691057e-07 1.2 6.31637449187e-07 1.44748737342 6.31669207317e-07 1.55 6.31700965447e-07 1.44748737342 6.31732723577e-07 1.2 6.31764481707e-07 0.952512626585 6.31796239837e-07 0.85 6.31827997967e-07 0.952512626584 6.31859756098e-07 1.2 6.31891514228e-07 1.44748737342 6.31923272358e-07 1.55 6.31955030488e-07 1.44748737342 6.31986788618e-07 1.2 6.32018546748e-07 0.952512626585 6.32050304878e-07 0.85 6.32082063008e-07 0.952512626584 6.32113821138e-07 1.2 6.32145579268e-07 1.44748737342 6.32177337398e-07 1.55 6.32209095528e-07 1.44748737342 6.32240853659e-07 1.2 6.32272611789e-07 0.952512626585 6.32304369919e-07 0.85 6.32336128049e-07 0.952512626585 6.32367886179e-07 1.2 6.32399644309e-07 1.44748737341 6.32431402439e-07 1.55 6.32463160569e-07 1.44748737342 6.32494918699e-07 1.2 6.32526676829e-07 0.952512626585 6.32558434959e-07 0.85 6.32590193089e-07 0.952512626585 6.3262195122e-07 1.2 6.3265370935e-07 1.44748737342 6.3268546748e-07 1.55 6.3271722561e-07 1.44748737342 6.3274898374e-07 1.2 6.3278074187e-07 0.952512626585 6.328125e-07 0.85 6.3284425813e-07 0.952512626585 6.3287601626e-07 1.2 6.3290777439e-07 1.44748737342 6.3293953252e-07 1.55 6.3297129065e-07 1.44748737342 6.3300304878e-07 1.2 6.33034806911e-07 0.952512626585 6.33066565041e-07 0.85 6.33098323171e-07 0.952512626585 6.33130081301e-07 1.2 6.33161839431e-07 1.44748737342 6.33193597561e-07 1.55 6.33225355691e-07 1.44748737342 6.33257113821e-07 1.2 6.33288871951e-07 0.952512626585 6.33320630081e-07 0.85 6.33352388211e-07 0.952512626585 6.33384146341e-07 1.2 6.33415904472e-07 1.44748737342 6.33447662602e-07 1.55 6.33479420732e-07 1.44748737342 6.33511178862e-07 1.2 6.33542936992e-07 0.952512626585 6.33574695122e-07 0.85 6.33606453252e-07 0.952512626585 6.33638211382e-07 1.2 6.33669969512e-07 1.44748737342 6.33701727642e-07 1.55 6.33733485772e-07 1.44748737342 6.33765243902e-07 1.2 6.33797002033e-07 0.952512626585 6.33828760163e-07 0.85 6.33860518293e-07 0.952512626585 6.33892276423e-07 1.2 6.33924034553e-07 1.44748737342 6.33955792683e-07 1.55 6.33987550813e-07 1.44748737342 6.34019308943e-07 1.2 6.34051067073e-07 0.952512626585 6.34082825203e-07 0.85 6.34114583333e-07 0.952512626585 6.34146341463e-07 1.2 6.34178099593e-07 1.44748737342 6.34209857724e-07 1.55 6.34241615854e-07 1.44748737342 6.34273373984e-07 1.2 6.34305132114e-07 0.952512626585 6.34336890244e-07 0.85 6.34368648374e-07 0.952512626584 6.34400406504e-07 1.2 6.34432164634e-07 1.44748737342 6.34463922764e-07 1.55 6.34495680894e-07 1.44748737341 6.34527439024e-07 1.2 6.34559197154e-07 0.952512626585 6.34590955285e-07 0.85 6.34622713415e-07 0.952512626585 6.34654471545e-07 1.2 6.34686229675e-07 1.44748737342 6.34717987805e-07 1.55 6.34749745935e-07 1.44748737342 6.34781504065e-07 1.2 6.34813262195e-07 0.952512626584 6.34845020325e-07 0.85 6.34876778455e-07 0.952512626585 6.34908536585e-07 1.2 6.34940294715e-07 1.44748737342 6.34972052846e-07 1.55 6.35003810976e-07 1.44748737342 6.35035569106e-07 1.2 6.35067327236e-07 0.952512626585 6.35099085366e-07 0.85 6.35130843496e-07 0.952512626585 6.35162601626e-07 1.2 6.35194359756e-07 1.44748737342 6.35226117886e-07 1.55 6.35257876016e-07 1.44748737342 6.35289634146e-07 1.2 6.35321392276e-07 0.952512626585 6.35353150407e-07 0.85 6.35384908537e-07 0.952512626584 6.35416666667e-07 1.2 6.35448424797e-07 1.44748737342 6.35480182927e-07 1.55 6.35511941057e-07 1.44748737342 6.35543699187e-07 1.2 6.35575457317e-07 0.952512626585 6.35607215447e-07 0.85 6.35638973577e-07 0.952512626584 6.35670731707e-07 1.2 6.35702489837e-07 1.44748737341 6.35734247967e-07 1.55 6.35766006098e-07 1.44748737342 6.35797764228e-07 1.2 6.35829522358e-07 0.952512626585 6.35861280488e-07 0.85 6.35893038618e-07 0.952512626585 6.35924796748e-07 1.2 6.35956554878e-07 1.44748737341 6.35988313008e-07 1.55 6.36020071138e-07 1.44748737342 6.36051829268e-07 1.2 6.36083587398e-07 0.952512626585 6.36115345528e-07 0.85 6.36147103659e-07 0.952512626585 6.36178861789e-07 1.2 6.36210619919e-07 1.44748737342 6.36242378049e-07 1.55 6.36274136179e-07 1.44748737342 6.36305894309e-07 1.2 6.36337652439e-07 0.952512626585 6.36369410569e-07 0.85 6.36401168699e-07 0.952512626585 6.36432926829e-07 1.2 6.36464684959e-07 1.44748737342 6.36496443089e-07 1.55 6.3652820122e-07 1.44748737342 6.3655995935e-07 1.2 6.3659171748e-07 0.952512626585 6.3662347561e-07 0.85 6.3665523374e-07 0.952512626585 6.3668699187e-07 1.2 6.3671875e-07 1.44748737342 6.3675050813e-07 1.55 6.3678226626e-07 1.44748737342 6.3681402439e-07 1.2 6.3684578252e-07 0.952512626585 6.3687754065e-07 0.85 6.3690929878e-07 0.952512626585 6.36941056911e-07 1.2 6.36972815041e-07 1.44748737342 6.37004573171e-07 1.55 6.37036331301e-07 1.44748737342 6.37068089431e-07 1.2 6.37099847561e-07 0.952512626585 6.37131605691e-07 0.85 6.37163363821e-07 0.952512626585 6.37195121951e-07 1.2 6.37226880081e-07 1.44748737342 6.37258638211e-07 1.55 6.37290396341e-07 1.44748737342 6.37322154472e-07 1.2 6.37353912602e-07 0.952512626585 6.37385670732e-07 0.85 6.37417428862e-07 0.952512626585 6.37449186992e-07 1.2 6.37480945122e-07 1.44748737342 6.37512703252e-07 1.55 6.37544461382e-07 1.44748737342 6.37576219512e-07 1.2 6.37607977642e-07 0.952512626585 6.37639735772e-07 0.85 6.37671493902e-07 0.952512626585 6.37703252033e-07 1.2 6.37735010163e-07 1.44748737342 6.37766768293e-07 1.55 6.37798526423e-07 1.44748737342 6.37830284553e-07 1.2 6.37862042683e-07 0.952512626585 6.37893800813e-07 0.85 6.37925558943e-07 0.952512626585 6.37957317073e-07 1.2 6.37989075203e-07 1.44748737342 6.38020833333e-07 1.55 6.38052591463e-07 1.44748737341 6.38084349593e-07 1.2 6.38116107724e-07 0.952512626585 6.38147865854e-07 0.85 6.38179623984e-07 0.952512626585 6.38211382114e-07 1.2 6.38243140244e-07 1.44748737342 6.38274898374e-07 1.55 6.38306656504e-07 1.44748737341 6.38338414634e-07 1.2 6.38370172764e-07 0.952512626584 6.38401930894e-07 0.85 6.38433689024e-07 0.952512626585 6.38465447154e-07 1.2 6.38497205285e-07 1.44748737342 6.38528963415e-07 1.55 6.38560721545e-07 1.44748737342 6.38592479675e-07 1.2 6.38624237805e-07 0.952512626585 6.38655995935e-07 0.85 6.38687754065e-07 0.952512626585 6.38719512195e-07 1.2 6.38751270325e-07 1.44748737342 6.38783028455e-07 1.55 6.38814786585e-07 1.44748737342 6.38846544715e-07 1.2 6.38878302846e-07 0.952512626585 6.38910060976e-07 0.85 6.38941819106e-07 0.952512626584 6.38973577236e-07 1.2 6.39005335366e-07 1.44748737342 6.39037093496e-07 1.55 6.39068851626e-07 1.44748737342 6.39100609756e-07 1.2 6.39132367886e-07 0.952512626585 6.39164126016e-07 0.85 6.39195884146e-07 0.952512626584 6.39227642276e-07 1.2 6.39259400407e-07 1.44748737341 6.39291158537e-07 1.55 6.39322916667e-07 1.44748737342 6.39354674797e-07 1.2 6.39386432927e-07 0.952512626585 6.39418191057e-07 0.85 6.39449949187e-07 0.952512626585 6.39481707317e-07 1.2 6.39513465447e-07 1.44748737341 6.39545223577e-07 1.55 6.39576981707e-07 1.44748737342 6.39608739837e-07 1.2 6.39640497967e-07 0.952512626584 6.39672256098e-07 0.85 6.39704014228e-07 0.952512626585 6.39735772358e-07 1.2 6.39767530488e-07 1.44748737342 6.39799288618e-07 1.55 6.39831046748e-07 1.44748737342 6.39862804878e-07 1.2 6.39894563008e-07 0.952512626585 6.39926321138e-07 0.85 6.39958079268e-07 0.952512626585 6.39989837398e-07 1.2 6.40021595528e-07 1.44748737342 6.40053353659e-07 1.55 6.40085111789e-07 1.44748737342 6.40116869919e-07 1.2 6.40148628049e-07 0.952512626585 6.40180386179e-07 0.85 6.40212144309e-07 0.952512626585 6.40243902439e-07 1.2 6.40275660569e-07 1.44748737342 6.40307418699e-07 1.55 6.40339176829e-07 1.44748737342 6.40370934959e-07 1.2 6.40402693089e-07 0.952512626585 6.4043445122e-07 0.85 6.4046620935e-07 0.952512626584 6.4049796748e-07 1.2 6.4052972561e-07 1.44748737342 6.4056148374e-07 1.55 6.4059324187e-07 1.44748737342 6.40625e-07 1.2 6.4065675813e-07 0.952512626585 6.4068851626e-07 0.85 6.4072027439e-07 0.952512626585 6.4075203252e-07 1.2 6.4078379065e-07 1.44748737342 6.4081554878e-07 1.55 6.40847306911e-07 1.44748737342 6.40879065041e-07 1.2 6.40910823171e-07 0.952512626585 6.40942581301e-07 0.85 6.40974339431e-07 0.952512626585 6.41006097561e-07 1.2 6.41037855691e-07 1.44748737342 6.41069613821e-07 1.55 6.41101371951e-07 1.44748737342 6.41133130081e-07 1.2 6.41164888211e-07 0.952512626585 6.41196646341e-07 0.85 6.41228404472e-07 0.952512626585 6.41260162602e-07 1.2 6.41291920732e-07 1.44748737342 6.41323678862e-07 1.55 6.41355436992e-07 1.44748737342 6.41387195122e-07 1.2 6.41418953252e-07 0.952512626585 6.41450711382e-07 0.85 6.41482469512e-07 0.952512626585 6.41514227642e-07 1.2 6.41545985772e-07 1.44748737342 6.41577743902e-07 1.55 6.41609502033e-07 1.44748737342 6.41641260163e-07 1.2 6.41673018293e-07 0.952512626585 6.41704776423e-07 0.85 6.41736534553e-07 0.952512626585 6.41768292683e-07 1.2 6.41800050813e-07 1.44748737342 6.41831808943e-07 1.55 6.41863567073e-07 1.44748737342 6.41895325203e-07 1.2 6.41927083333e-07 0.952512626584 6.41958841463e-07 0.85 6.41990599593e-07 0.952512626585 6.42022357724e-07 1.2 6.42054115854e-07 1.44748737342 6.42085873984e-07 1.55 6.42117632114e-07 1.44748737342 6.42149390244e-07 1.2 6.42181148374e-07 0.952512626585 6.42212906504e-07 0.85 6.42244664634e-07 0.952512626585 6.42276422764e-07 1.2 6.42308180894e-07 1.44748737342 6.42339939024e-07 1.55 6.42371697154e-07 1.44748737342 6.42403455285e-07 1.2 6.42435213415e-07 0.952512626585 6.42466971545e-07 0.85 6.42498729675e-07 0.952512626585 6.42530487805e-07 1.2 6.42562245935e-07 1.44748737342 6.42594004065e-07 1.55 6.42625762195e-07 1.44748737342 6.42657520325e-07 1.2 6.42689278455e-07 0.952512626585 6.42721036585e-07 0.85 6.42752794715e-07 0.952512626584 6.42784552846e-07 1.2 6.42816310976e-07 1.44748737341 6.42848069106e-07 1.55 6.42879827236e-07 1.44748737342 6.42911585366e-07 1.2 6.42943343496e-07 0.952512626585 6.42975101626e-07 0.85 6.43006859756e-07 0.952512626585 6.43038617886e-07 1.2 6.43070376016e-07 1.44748737342 6.43102134146e-07 1.55 6.43133892276e-07 1.44748737342 6.43165650407e-07 1.2 6.43197408537e-07 0.952512626584 6.43229166667e-07 0.85 6.43260924797e-07 0.952512626585 6.43292682927e-07 1.2 6.43324441057e-07 1.44748737342 6.43356199187e-07 1.55 6.43387957317e-07 1.44748737342 6.43419715447e-07 1.2 6.43451473577e-07 0.952512626585 6.43483231707e-07 0.85 6.43514989837e-07 0.952512626585 6.43546747967e-07 1.2 6.43578506098e-07 1.44748737342 6.43610264228e-07 1.55 6.43642022358e-07 1.44748737342 6.43673780488e-07 1.2 6.43705538618e-07 0.952512626585 6.43737296748e-07 0.85 6.43769054878e-07 0.952512626584 6.43800813008e-07 1.2 6.43832571138e-07 1.44748737342 6.43864329268e-07 1.55 6.43896087398e-07 1.44748737342 6.43927845528e-07 1.2 6.43959603659e-07 0.952512626585 6.43991361789e-07 0.85 6.44023119919e-07 0.952512626584 6.44054878049e-07 1.2 6.44086636179e-07 1.44748737341 6.44118394309e-07 1.55 6.44150152439e-07 1.44748737342 6.44181910569e-07 1.2 6.44213668699e-07 0.952512626585 6.44245426829e-07 0.85 6.44277184959e-07 0.952512626585 6.44308943089e-07 1.2 6.4434070122e-07 1.44748737341 6.4437245935e-07 1.55 6.4440421748e-07 1.44748737342 6.4443597561e-07 1.2 6.4446773374e-07 0.952512626585 6.4449949187e-07 0.85 6.4453125e-07 0.952512626585 6.4456300813e-07 1.2 6.4459476626e-07 1.44748737342 6.4462652439e-07 1.55 6.4465828252e-07 1.44748737342 6.4469004065e-07 1.2 6.4472179878e-07 0.952512626585 6.44753556911e-07 0.85 6.44785315041e-07 0.952512626585 6.44817073171e-07 1.2 6.44848831301e-07 1.44748737342 6.44880589431e-07 1.55 6.44912347561e-07 1.44748737342 6.44944105691e-07 1.2 6.44975863821e-07 0.952512626585 6.45007621951e-07 0.85 6.45039380081e-07 0.952512626585 6.45071138211e-07 1.2 6.45102896341e-07 1.44748737342 6.45134654472e-07 1.55 6.45166412602e-07 1.44748737342 6.45198170732e-07 1.2 6.45229928862e-07 0.952512626585 6.45261686992e-07 0.85 6.45293445122e-07 0.952512626585 6.45325203252e-07 1.2 6.45356961382e-07 1.44748737342 6.45388719512e-07 1.55 6.45420477642e-07 1.44748737342 6.45452235772e-07 1.2 6.45483993902e-07 0.952512626585 6.45515752033e-07 0.85 6.45547510163e-07 0.952512626585 6.45579268293e-07 1.2 6.45611026423e-07 1.44748737342 6.45642784553e-07 1.55 6.45674542683e-07 1.44748737342 6.45706300813e-07 1.2 6.45738058943e-07 0.952512626585 6.45769817073e-07 0.85 6.45801575203e-07 0.952512626585 6.45833333333e-07 1.2 6.45865091463e-07 1.44748737342 6.45896849593e-07 1.55 6.45928607724e-07 1.44748737342 6.45960365854e-07 1.2 6.45992123984e-07 0.952512626585 6.46023882114e-07 0.85 6.46055640244e-07 0.952512626585 6.46087398374e-07 1.2 6.46119156504e-07 1.44748737342 6.46150914634e-07 1.55 6.46182672764e-07 1.44748737342 6.46214430894e-07 1.2 6.46246189024e-07 0.952512626585 6.46277947154e-07 0.85 6.46309705285e-07 0.952512626585 6.46341463415e-07 1.2 6.46373221545e-07 1.44748737342 6.46404979675e-07 1.55 6.46436737805e-07 1.44748737341 6.46468495935e-07 1.2 6.46500254065e-07 0.952512626585 6.46532012195e-07 0.85 6.46563770325e-07 0.952512626585 6.46595528455e-07 1.2 6.46627286585e-07 1.44748737342 6.46659044715e-07 1.55 6.46690802846e-07 1.44748737342 6.46722560976e-07 1.2 6.46754319106e-07 0.952512626584 6.46786077236e-07 0.85 6.46817835366e-07 0.952512626585 6.46849593496e-07 1.2 6.46881351626e-07 1.44748737342 6.46913109756e-07 1.55 6.46944867886e-07 1.44748737342 6.46976626016e-07 1.2 6.47008384146e-07 0.952512626585 6.47040142276e-07 0.85 6.47071900407e-07 0.952512626585 6.47103658537e-07 1.2 6.47135416667e-07 1.44748737342 6.47167174797e-07 1.55 6.47198932927e-07 1.44748737342 6.47230691057e-07 1.2 6.47262449187e-07 0.952512626585 6.47294207317e-07 0.85 6.47325965447e-07 0.952512626584 6.47357723577e-07 1.2 6.47389481707e-07 1.44748737342 6.47421239837e-07 1.55 6.47452997967e-07 1.44748737342 6.47484756098e-07 1.2 6.47516514228e-07 0.952512626585 6.47548272358e-07 0.85 6.47580030488e-07 0.952512626584 6.47611788618e-07 1.2 6.47643546748e-07 1.44748737341 6.47675304878e-07 1.55 6.47707063008e-07 1.44748737342 6.47738821138e-07 1.2 6.47770579268e-07 0.952512626585 6.47802337398e-07 0.85 6.47834095528e-07 0.952512626585 6.47865853659e-07 1.2 6.47897611789e-07 1.44748737341 6.47929369919e-07 1.55 6.47961128049e-07 1.44748737342 6.47992886179e-07 1.2 6.48024644309e-07 0.952512626584 6.48056402439e-07 0.85 6.48088160569e-07 0.952512626585 6.48119918699e-07 1.2 6.48151676829e-07 1.44748737342 6.48183434959e-07 1.55 6.48215193089e-07 1.44748737342 6.4824695122e-07 1.2 6.4827870935e-07 0.952512626585 6.4831046748e-07 0.85 6.4834222561e-07 0.952512626585 6.4837398374e-07 1.2 6.4840574187e-07 1.44748737342 6.484375e-07 1.55 6.4846925813e-07 1.44748737342 6.4850101626e-07 1.2 6.4853277439e-07 0.952512626585 6.4856453252e-07 0.85 6.4859629065e-07 0.952512626585 6.4862804878e-07 1.2 6.48659806911e-07 1.44748737342 6.48691565041e-07 1.55 6.48723323171e-07 1.44748737342 6.48755081301e-07 1.2 6.48786839431e-07 0.952512626585 6.48818597561e-07 0.85 6.48850355691e-07 0.952512626584 6.48882113821e-07 1.2 6.48913871951e-07 1.44748737342 6.48945630081e-07 1.55 6.48977388211e-07 1.44748737342 6.49009146341e-07 1.2 6.49040904472e-07 0.952512626585 6.49072662602e-07 0.85 6.49104420732e-07 0.952512626585 6.49136178862e-07 1.2 6.49167936992e-07 1.44748737342 6.49199695122e-07 1.55 6.49231453252e-07 1.44748737342 6.49263211382e-07 1.2 6.49294969512e-07 0.952512626585 6.49326727642e-07 0.85 6.49358485772e-07 0.952512626585 6.49390243902e-07 1.2 6.49422002033e-07 1.44748737342 6.49453760163e-07 1.55 6.49485518293e-07 1.44748737342 6.49517276423e-07 1.2 6.49549034553e-07 0.952512626585 6.49580792683e-07 0.85 6.49612550813e-07 0.952512626585 6.49644308943e-07 1.2 6.49676067073e-07 1.44748737342 6.49707825203e-07 1.55 6.49739583333e-07 1.44748737342 6.49771341463e-07 1.2 6.49803099593e-07 0.952512626585 6.49834857724e-07 0.85 6.49866615854e-07 0.952512626585 6.49898373984e-07 1.2 6.49930132114e-07 1.44748737342 6.49961890244e-07 1.55 6.49993648374e-07 1.44748737341 6.50025406504e-07 1.2 6.50057164634e-07 0.952512626585 6.50088922764e-07 0.85 6.50120680894e-07 0.952512626585 6.50152439024e-07 1.2 6.50184197154e-07 1.44748737342 6.50215955285e-07 1.55 6.50247713415e-07 1.44748737342 6.50279471545e-07 1.2 6.50311229675e-07 0.952512626584 6.50342987805e-07 0.85 6.50374745935e-07 0.952512626585 6.50406504065e-07 1.2 6.50438262195e-07 1.44748737342 6.50470020325e-07 1.55 6.50501778455e-07 1.44748737342 6.50533536585e-07 1.2 6.50565294715e-07 0.952512626585 6.50597052846e-07 0.85 6.50628810976e-07 0.952512626585 6.50660569106e-07 1.2 6.50692327236e-07 1.44748737342 6.50724085366e-07 1.55 6.50755843496e-07 1.44748737342 6.50787601626e-07 1.2 6.50819359756e-07 0.952512626585 6.50851117886e-07 0.85 6.50882876016e-07 0.952512626584 6.50914634146e-07 1.2 6.50946392276e-07 1.44748737342 6.50978150407e-07 1.55 6.51009908537e-07 1.44748737342 6.51041666667e-07 1.2 6.51073424797e-07 0.952512626585 6.51105182927e-07 0.85 6.51136941057e-07 0.952512626584 6.51168699187e-07 1.2 6.51200457317e-07 1.44748737341 6.51232215447e-07 1.55 6.51263973577e-07 1.44748737342 6.51295731707e-07 1.2 6.51327489837e-07 0.952512626585 6.51359247967e-07 0.85 6.51391006098e-07 0.952512626585 6.51422764228e-07 1.2 6.51454522358e-07 1.44748737342 6.51486280488e-07 1.55 6.51518038618e-07 1.44748737342 6.51549796748e-07 1.2 6.51581554878e-07 0.952512626584 6.51613313008e-07 0.85 6.51645071138e-07 0.952512626585 6.51676829268e-07 1.2 6.51708587398e-07 1.44748737342 6.51740345528e-07 1.55 6.51772103659e-07 1.44748737342 6.51803861789e-07 1.2 6.51835619919e-07 0.952512626585 6.51867378049e-07 0.85 6.51899136179e-07 0.952512626585 6.51930894309e-07 1.2 6.51962652439e-07 1.44748737342 6.51994410569e-07 1.55 6.52026168699e-07 1.44748737342 6.52057926829e-07 1.2 6.52089684959e-07 0.952512626585 6.52121443089e-07 0.85 6.5215320122e-07 0.952512626584 6.5218495935e-07 1.2 6.5221671748e-07 1.44748737342 6.5224847561e-07 1.55 6.5228023374e-07 1.44748737342 6.5231199187e-07 1.2 6.5234375e-07 0.952512626585 6.5237550813e-07 0.85 6.5240726626e-07 0.952512626584 6.5243902439e-07 1.2 6.5247078252e-07 1.44748737342 6.5250254065e-07 1.55 6.5253429878e-07 1.44748737342 6.52566056911e-07 1.2 6.52597815041e-07 0.952512626585 6.52629573171e-07 0.85 6.52661331301e-07 0.952512626585 6.52693089431e-07 1.2 6.52724847561e-07 1.44748737341 6.52756605691e-07 1.55 6.52788363821e-07 1.44748737342 6.52820121951e-07 1.2 6.52851880081e-07 0.952512626585 6.52883638211e-07 0.85 6.52915396341e-07 0.952512626585 6.52947154472e-07 1.2 6.52978912602e-07 1.44748737342 6.53010670732e-07 1.55 6.53042428862e-07 1.44748737342 6.53074186992e-07 1.2 6.53105945122e-07 0.952512626585 6.53137703252e-07 0.85 6.53169461382e-07 0.952512626585 6.53201219512e-07 1.2 6.53232977642e-07 1.44748737342 6.53264735772e-07 1.55 6.53296493902e-07 1.44748737342 6.53328252033e-07 1.2 6.53360010163e-07 0.952512626585 6.53391768293e-07 0.85 6.53423526423e-07 0.952512626585 6.53455284553e-07 1.2 6.53487042683e-07 1.44748737342 6.53518800813e-07 1.55 6.53550558943e-07 1.44748737342 6.53582317073e-07 1.2 6.53614075203e-07 0.952512626584 6.53645833333e-07 0.85 6.53677591463e-07 0.952512626585 6.53709349593e-07 1.2 6.53741107724e-07 1.44748737342 6.53772865854e-07 1.55 6.53804623984e-07 1.44748737342 6.53836382114e-07 1.2 6.53868140244e-07 0.952512626585 6.53899898374e-07 0.85 6.53931656504e-07 0.952512626585 6.53963414634e-07 1.2 6.53995172764e-07 1.44748737342 6.54026930894e-07 1.55 6.54058689024e-07 1.44748737342 6.54090447154e-07 1.2 6.54122205285e-07 0.952512626585 6.54153963415e-07 0.85 6.54185721545e-07 0.952512626585 6.54217479675e-07 1.2 6.54249237805e-07 1.44748737342 6.54280995935e-07 1.55 6.54312754065e-07 1.44748737342 6.54344512195e-07 1.2 6.54376270325e-07 0.952512626585 6.54408028455e-07 0.85 6.54439786585e-07 0.952512626584 6.54471544715e-07 1.2 6.54503302846e-07 1.44748737342 6.54535060976e-07 1.55 6.54566819106e-07 1.44748737342 6.54598577236e-07 1.2 6.54630335366e-07 0.952512626585 6.54662093496e-07 0.85 6.54693851626e-07 0.952512626584 6.54725609756e-07 1.2 6.54757367886e-07 1.44748737341 6.54789126016e-07 1.55 6.54820884146e-07 1.44748737341 6.54852642276e-07 1.2 6.54884400407e-07 0.952512626585 6.54916158537e-07 0.85 6.54947916667e-07 0.952512626585 6.54979674797e-07 1.2 6.55011432927e-07 1.44748737342 6.55043191057e-07 1.55 6.55074949187e-07 1.44748737342 6.55106707317e-07 1.2 6.55138465447e-07 0.952512626584 6.55170223577e-07 0.85 6.55201981707e-07 0.952512626585 6.55233739837e-07 1.2 6.55265497967e-07 1.44748737342 6.55297256098e-07 1.55 6.55329014228e-07 1.44748737342 6.55360772358e-07 1.2 6.55392530488e-07 0.952512626585 6.55424288618e-07 0.85 6.55456046748e-07 0.952512626585 6.55487804878e-07 1.2 6.55519563008e-07 1.44748737342 6.55551321138e-07 1.55 6.55583079268e-07 1.44748737342 6.55614837398e-07 1.2 6.55646595528e-07 0.952512626585 6.55678353659e-07 0.85 6.55710111789e-07 0.952512626584 6.55741869919e-07 1.2 6.55773628049e-07 1.44748737342 6.55805386179e-07 1.55 6.55837144309e-07 1.44748737342 6.55868902439e-07 1.2 6.55900660569e-07 0.952512626585 6.55932418699e-07 0.85 6.55964176829e-07 0.952512626584 6.55995934959e-07 1.2 6.56027693089e-07 1.44748737341 6.5605945122e-07 1.55 6.5609120935e-07 1.44748737342 6.5612296748e-07 1.2 6.5615472561e-07 0.952512626585 6.5618648374e-07 0.85 6.5621824187e-07 0.952512626585 6.5625e-07 1.2 6.5628175813e-07 1.44748737341 6.5631351626e-07 1.55 6.5634527439e-07 1.44748737342 6.5637703252e-07 1.2 6.5640879065e-07 0.952512626584 6.5644054878e-07 0.85 6.56472306911e-07 0.952512626585 6.56504065041e-07 1.2 6.56535823171e-07 1.44748737342 6.56567581301e-07 1.55 6.56599339431e-07 1.44748737342 6.56631097561e-07 1.2 6.56662855691e-07 0.952512626585 6.56694613821e-07 0.85 6.56726371951e-07 0.952512626585 6.56758130081e-07 1.2 6.56789888211e-07 1.44748737342 6.56821646341e-07 1.55 6.56853404472e-07 1.44748737342 6.56885162602e-07 1.2 6.56916920732e-07 0.952512626585 6.56948678862e-07 0.85 6.56980436992e-07 0.952512626585 6.57012195122e-07 1.2 6.57043953252e-07 1.44748737342 6.57075711382e-07 1.55 6.57107469512e-07 1.44748737342 6.57139227642e-07 1.2 6.57170985772e-07 0.952512626585 6.57202743902e-07 0.85 6.57234502033e-07 0.952512626585 6.57266260163e-07 1.2 6.57298018293e-07 1.44748737342 6.57329776423e-07 1.55 6.57361534553e-07 1.44748737342 6.57393292683e-07 1.2 6.57425050813e-07 0.952512626585 6.57456808943e-07 0.85 6.57488567073e-07 0.952512626584 6.57520325203e-07 1.2 6.57552083333e-07 1.44748737342 6.57583841463e-07 1.55 6.57615599593e-07 1.44748737342 6.57647357724e-07 1.2 6.57679115854e-07 0.952512626585 6.57710873984e-07 0.85 6.57742632114e-07 0.952512626585 6.57774390244e-07 1.2 6.57806148374e-07 1.44748737342 6.57837906504e-07 1.55 6.57869664634e-07 1.44748737342 6.57901422764e-07 1.2 6.57933180894e-07 0.952512626585 6.57964939024e-07 0.85 6.57996697154e-07 0.952512626585 6.58028455285e-07 1.2 6.58060213415e-07 1.44748737342 6.58091971545e-07 1.55 6.58123729675e-07 1.44748737342 6.58155487805e-07 1.2 6.58187245935e-07 0.952512626585 6.58219004065e-07 0.85 6.58250762195e-07 0.952512626585 6.58282520325e-07 1.2 6.58314278455e-07 1.44748737341 6.58346036585e-07 1.55 6.58377794715e-07 1.44748737341 6.58409552846e-07 1.2 6.58441310976e-07 0.952512626585 6.58473069106e-07 0.85 6.58504827236e-07 0.952512626585 6.58536585366e-07 1.2 6.58568343496e-07 1.44748737342 6.58600101626e-07 1.55 6.58631859756e-07 1.44748737342 6.58663617886e-07 1.2 6.58695376016e-07 0.952512626584 6.58727134146e-07 0.85 6.58758892276e-07 0.952512626585 6.58790650407e-07 1.2 6.58822408537e-07 1.44748737342 6.58854166667e-07 1.55 6.58885924797e-07 1.44748737342 6.58917682927e-07 1.2 6.58949441057e-07 0.952512626585 6.58981199187e-07 0.85 6.59012957317e-07 0.952512626585 6.59044715447e-07 1.2 6.59076473577e-07 1.44748737342 6.59108231707e-07 1.55 6.59139989837e-07 1.44748737342 6.59171747967e-07 1.2 6.59203506098e-07 0.952512626585 6.59235264228e-07 0.85 6.59267022358e-07 0.952512626584 6.59298780488e-07 1.2 6.59330538618e-07 1.44748737342 6.59362296748e-07 1.55 6.59394054878e-07 1.44748737342 6.59425813008e-07 1.2 6.59457571138e-07 0.952512626585 6.59489329268e-07 0.85 6.59521087398e-07 0.952512626584 6.59552845528e-07 1.2 6.59584603659e-07 1.44748737341 6.59616361789e-07 1.55 6.59648119919e-07 1.44748737342 6.59679878049e-07 1.2 6.59711636179e-07 0.952512626585 6.59743394309e-07 0.85 6.59775152439e-07 0.952512626585 6.59806910569e-07 1.2 6.59838668699e-07 1.44748737342 6.59870426829e-07 1.55 6.59902184959e-07 1.44748737342 6.59933943089e-07 1.2 6.5996570122e-07 0.952512626584 6.5999745935e-07 0.85 6.6002921748e-07 0.952512626585 6.6006097561e-07 1.2 6.6009273374e-07 1.44748737342 6.6012449187e-07 1.55 6.6015625e-07 1.44748737342 6.6018800813e-07 1.2 6.6021976626e-07 0.952512626585 6.6025152439e-07 0.85 6.6028328252e-07 0.952512626585 6.6031504065e-07 1.2 6.6034679878e-07 1.44748737342 6.60378556911e-07 1.55 6.60410315041e-07 1.44748737342 6.60442073171e-07 1.2 6.60473831301e-07 0.952512626585 6.60505589431e-07 0.85 6.60537347561e-07 0.952512626584 6.60569105691e-07 1.2 6.60600863821e-07 1.44748737342 6.60632621951e-07 1.55 6.60664380081e-07 1.44748737342 6.60696138211e-07 1.2 6.60727896341e-07 0.952512626585 6.60759654472e-07 0.85 6.60791412602e-07 0.952512626584 6.60823170732e-07 1.2 6.60854928862e-07 1.44748737342 6.60886686992e-07 1.55 6.60918445122e-07 1.44748737342 6.60950203252e-07 1.2 6.60981961382e-07 0.952512626585 6.61013719512e-07 0.85 6.61045477642e-07 0.952512626585 6.61077235772e-07 1.2 6.61108993902e-07 1.44748737342 6.61140752033e-07 1.55 6.61172510163e-07 1.44748737342 6.61204268293e-07 1.2 6.61236026423e-07 0.952512626585 6.61267784553e-07 0.85 6.61299542683e-07 0.952512626585 6.61331300813e-07 1.2 6.61363058943e-07 1.44748737342 6.61394817073e-07 1.55 6.61426575203e-07 1.44748737342 6.61458333333e-07 1.2 6.61490091463e-07 0.952512626585 6.61521849593e-07 0.85 6.61553607724e-07 0.952512626585 6.61585365854e-07 1.2 6.61617123984e-07 1.44748737342 6.61648882114e-07 1.55 6.61680640244e-07 1.44748737342 6.61712398374e-07 1.2 6.61744156504e-07 0.952512626585 6.61775914634e-07 0.85 6.61807672764e-07 0.952512626585 6.61839430894e-07 1.2 6.61871189024e-07 1.44748737342 6.61902947154e-07 1.55 6.61934705285e-07 1.44748737342 6.61966463415e-07 1.2 6.61998221545e-07 0.952512626584 6.62029979675e-07 0.85 6.62061737805e-07 0.952512626585 6.62093495935e-07 1.2 6.62125254065e-07 1.44748737342 6.62157012195e-07 1.55 6.62188770325e-07 1.44748737342 6.62220528455e-07 1.2 6.62252286585e-07 0.952512626584 6.62284044715e-07 0.85 6.62315802846e-07 0.952512626585 6.62347560976e-07 1.2 6.62379319106e-07 1.44748737342 6.62411077236e-07 1.55 6.62442835366e-07 1.44748737342 6.62474593496e-07 1.2 6.62506351626e-07 0.952512626585 6.62538109756e-07 0.85 6.62569867886e-07 0.952512626585 6.62601626016e-07 1.2 6.62633384146e-07 1.44748737342 6.62665142276e-07 1.55 6.62696900407e-07 1.44748737342 6.62728658537e-07 1.2 6.62760416667e-07 0.952512626585 6.62792174797e-07 0.85 6.62823932927e-07 0.952512626585 6.62855691057e-07 1.2 6.62887449187e-07 1.44748737342 6.62919207317e-07 1.55 6.62950965447e-07 1.44748737342 6.62982723577e-07 1.2 6.63014481707e-07 0.952512626585 6.63046239837e-07 0.85 6.63077997967e-07 0.952512626585 6.63109756098e-07 1.2 6.63141514228e-07 1.44748737341 6.63173272358e-07 1.55 6.63205030488e-07 1.44748737342 6.63236788618e-07 1.2 6.63268546748e-07 0.952512626585 6.63300304878e-07 0.85 6.63332063008e-07 0.952512626584 6.63363821138e-07 1.2 6.63395579268e-07 1.44748737342 6.63427337398e-07 1.55 6.63459095528e-07 1.44748737342 6.63490853659e-07 1.2 6.63522611789e-07 0.952512626584 6.63554369919e-07 0.85 6.63586128049e-07 0.952512626584 6.63617886179e-07 1.2 6.63649644309e-07 1.44748737342 6.63681402439e-07 1.55 6.63713160569e-07 1.44748737342 6.63744918699e-07 1.2 6.63776676829e-07 0.952512626585 6.63808434959e-07 0.85 6.63840193089e-07 0.952512626585 6.6387195122e-07 1.2 6.6390370935e-07 1.44748737342 6.6393546748e-07 1.55 6.6396722561e-07 1.44748737341 6.6399898374e-07 1.2 6.6403074187e-07 0.952512626585 6.640625e-07 0.85 6.6409425813e-07 0.952512626585 6.6412601626e-07 1.2 6.6415777439e-07 1.44748737342 6.6418953252e-07 1.55 6.6422129065e-07 1.44748737341 6.6425304878e-07 1.2 6.64284806911e-07 0.952512626585 6.64316565041e-07 0.85 6.64348323171e-07 0.952512626585 6.64380081301e-07 1.2 6.64411839431e-07 1.44748737341 6.64443597561e-07 1.55 6.64475355691e-07 1.44748737341 6.64507113821e-07 1.2 6.64538871951e-07 0.952512626585 6.64570630081e-07 0.85 6.64602388211e-07 0.952512626585 6.64634146341e-07 1.2 6.64665904472e-07 1.44748737341 6.64697662602e-07 1.55 6.64729420732e-07 1.44748737342 6.64761178862e-07 1.2 6.64792936992e-07 0.952512626584 6.64824695122e-07 0.85 6.64856453252e-07 0.952512626585 6.64888211382e-07 1.2 6.64919969512e-07 1.44748737342 6.64951727642e-07 1.55 6.64983485772e-07 1.44748737342 6.65015243902e-07 1.2 6.65047002033e-07 0.952512626585 6.65078760163e-07 0.85 6.65110518293e-07 0.952512626585 6.65142276423e-07 1.2 6.65174034553e-07 1.44748737342 6.65205792683e-07 1.55 6.65237550813e-07 1.44748737342 6.65269308943e-07 1.2 6.65301067073e-07 0.952512626585 6.65332825203e-07 0.85 6.65364583333e-07 0.952512626585 6.65396341463e-07 1.2 6.65428099593e-07 1.44748737342 6.65459857724e-07 1.55 6.65491615854e-07 1.44748737341 6.65523373984e-07 1.2 6.65555132114e-07 0.952512626585 6.65586890244e-07 0.85 6.65618648374e-07 0.952512626585 6.65650406504e-07 1.2 6.65682164634e-07 1.44748737341 6.65713922764e-07 1.55 6.65745680894e-07 1.44748737341 6.65777439024e-07 1.2 6.65809197154e-07 0.952512626585 6.65840955285e-07 0.85 6.65872713415e-07 0.952512626585 6.65904471545e-07 1.2 6.65936229675e-07 1.44748737341 6.65967987805e-07 1.55 6.65999745935e-07 1.44748737342 6.66031504065e-07 1.2 6.66063262195e-07 0.952512626585 6.66095020325e-07 0.85 6.66126778455e-07 0.952512626585 6.66158536585e-07 1.2 6.66190294715e-07 1.44748737342 6.66222052846e-07 1.55 6.66253810976e-07 1.44748737342 6.66285569106e-07 1.2 6.66317327236e-07 0.952512626585 6.66349085366e-07 0.85 6.66380843496e-07 0.952512626584 6.66412601626e-07 1.2 6.66444359756e-07 1.44748737342 6.66476117886e-07 1.55 6.66507876016e-07 1.44748737342 6.66539634146e-07 1.2 6.66571392276e-07 0.952512626585 6.66603150407e-07 0.85 6.66634908537e-07 0.952512626585 6.66666666667e-07 1.2 6.66698424797e-07 1.44748737342 6.66730182927e-07 1.55 6.66761941057e-07 1.44748737341 6.66793699187e-07 1.2 6.66825457317e-07 0.952512626585 6.66857215447e-07 0.85 6.66888973577e-07 0.952512626585 6.66920731707e-07 1.2 6.66952489837e-07 1.44748737342 6.66984247967e-07 1.55 6.67016006098e-07 1.44748737342 6.67047764228e-07 1.2 6.67079522358e-07 0.952512626585 6.67111280488e-07 0.85 6.67143038618e-07 0.952512626585 6.67174796748e-07 1.2 6.67206554878e-07 1.44748737341 6.67238313008e-07 1.55 6.67270071138e-07 1.44748737342 6.67301829268e-07 1.2 6.67333587398e-07 0.952512626585 6.67365345528e-07 0.85 6.67397103659e-07 0.952512626585 6.67428861789e-07 1.2 6.67460619919e-07 1.44748737341 6.67492378049e-07 1.55 6.67524136179e-07 1.44748737342 6.67555894309e-07 1.2 6.67587652439e-07 0.952512626584 6.67619410569e-07 0.85 6.67651168699e-07 0.952512626584 6.67682926829e-07 1.2 6.67714684959e-07 1.44748737342 6.67746443089e-07 1.55 6.6777820122e-07 1.44748737342 6.6780995935e-07 1.2 6.6784171748e-07 0.952512626584 6.6787347561e-07 0.85 6.6790523374e-07 0.952512626584 6.6793699187e-07 1.2 6.6796875e-07 1.44748737342 6.6800050813e-07 1.55 6.6803226626e-07 1.44748737342 6.6806402439e-07 1.2 6.6809578252e-07 0.952512626584 6.6812754065e-07 0.85 6.6815929878e-07 0.952512626585 6.68191056911e-07 1.2 6.68222815041e-07 1.44748737342 6.68254573171e-07 1.55 6.68286331301e-07 1.44748737342 6.68318089431e-07 1.2 6.68349847561e-07 0.952512626585 6.68381605691e-07 0.85 6.68413363821e-07 0.952512626585 6.68445121951e-07 1.2 6.68476880081e-07 1.44748737342 6.68508638211e-07 1.55 6.68540396341e-07 1.44748737342 6.68572154472e-07 1.2 6.68603912602e-07 0.952512626585 6.68635670732e-07 0.85 6.68667428862e-07 0.952512626585 6.68699186992e-07 1.2 6.68730945122e-07 1.44748737342 6.68762703252e-07 1.55 6.68794461382e-07 1.44748737342 6.68826219512e-07 1.2 6.68857977642e-07 0.952512626585 6.68889735772e-07 0.85 6.68921493902e-07 0.952512626584 6.68953252033e-07 1.2 6.68985010163e-07 1.44748737342 6.69016768293e-07 1.55 6.69048526423e-07 1.44748737342 6.69080284553e-07 1.2 6.69112042683e-07 0.952512626584 6.69143800813e-07 0.85 6.69175558943e-07 0.952512626584 6.69207317073e-07 1.2 6.69239075203e-07 1.44748737342 6.69270833333e-07 1.55 6.69302591463e-07 1.44748737342 6.69334349593e-07 1.2 6.69366107724e-07 0.952512626584 6.69397865854e-07 0.85 6.69429623984e-07 0.952512626585 6.69461382114e-07 1.2 6.69493140244e-07 1.44748737342 6.69524898374e-07 1.55 6.69556656504e-07 1.44748737342 6.69588414634e-07 1.2 6.69620172764e-07 0.952512626584 6.69651930894e-07 0.85 6.69683689024e-07 0.952512626585 6.69715447154e-07 1.2 6.69747205285e-07 1.44748737342 6.69778963415e-07 1.55 6.69810721545e-07 1.44748737342 6.69842479675e-07 1.2 6.69874237805e-07 0.952512626585 6.69905995935e-07 0.85 6.69937754065e-07 0.952512626585 6.69969512195e-07 1.2 6.70001270325e-07 1.44748737342 6.70033028455e-07 1.55 6.70064786585e-07 1.44748737342 6.70096544715e-07 1.2 6.70128302846e-07 0.952512626585 6.70160060976e-07 0.85 6.70191819106e-07 0.952512626584 6.70223577236e-07 1.2 6.70255335366e-07 1.44748737341 6.70287093496e-07 1.55 6.70318851626e-07 1.44748737342 6.70350609756e-07 1.2 6.70382367886e-07 0.952512626585 6.70414126016e-07 0.85 6.70445884146e-07 0.952512626584 6.70477642276e-07 1.2 6.70509400407e-07 1.44748737342 6.70541158537e-07 1.55 6.70572916667e-07 1.44748737342 6.70604674797e-07 1.2 6.70636432927e-07 0.952512626584 6.70668191057e-07 0.85 6.70699949187e-07 0.952512626584 6.70731707317e-07 1.2 6.70763465447e-07 1.44748737342 6.70795223577e-07 1.55 6.70826981707e-07 1.44748737342 6.70858739837e-07 1.2 6.70890497967e-07 0.952512626585 6.70922256098e-07 0.85 6.70954014228e-07 0.952512626585 6.70985772358e-07 1.2 6.71017530488e-07 1.44748737342 6.71049288618e-07 1.55 6.71081046748e-07 1.44748737342 6.71112804878e-07 1.2 6.71144563008e-07 0.952512626585 6.71176321138e-07 0.85 6.71208079268e-07 0.952512626585 6.71239837398e-07 1.2 6.71271595528e-07 1.44748737342 6.71303353659e-07 1.55 6.71335111789e-07 1.44748737342 6.71366869919e-07 1.2 6.71398628049e-07 0.952512626585 6.71430386179e-07 0.85 6.71462144309e-07 0.952512626585 6.71493902439e-07 1.2 6.71525660569e-07 1.44748737341 6.71557418699e-07 1.55 6.71589176829e-07 1.44748737342 6.71620934959e-07 1.2 6.71652693089e-07 0.952512626585 6.7168445122e-07 0.85 6.7171620935e-07 0.952512626585 6.7174796748e-07 1.2 6.7177972561e-07 1.44748737342 6.7181148374e-07 1.55 6.7184324187e-07 1.44748737342 6.71875e-07 1.2 6.7190675813e-07 0.952512626584 6.7193851626e-07 0.85 6.7197027439e-07 0.952512626584 6.7200203252e-07 1.2 6.7203379065e-07 1.44748737342 6.7206554878e-07 1.55 6.72097306911e-07 1.44748737342 6.72129065041e-07 1.2 6.72160823171e-07 0.952512626585 6.72192581301e-07 0.85 6.72224339431e-07 0.952512626585 6.72256097561e-07 1.2 6.72287855691e-07 1.44748737342 6.72319613821e-07 1.55 6.72351371951e-07 1.44748737341 6.72383130081e-07 1.2 6.72414888211e-07 0.952512626585 6.72446646341e-07 0.85 6.72478404472e-07 0.952512626585 6.72510162602e-07 1.2 6.72541920732e-07 1.44748737342 6.72573678862e-07 1.55 6.72605436992e-07 1.44748737341 6.72637195122e-07 1.2 6.72668953252e-07 0.952512626585 6.72700711382e-07 0.85 6.72732469512e-07 0.952512626585 6.72764227642e-07 1.2 6.72795985772e-07 1.44748737341 6.72827743902e-07 1.55 6.72859502033e-07 1.44748737341 6.72891260163e-07 1.2 6.72923018293e-07 0.952512626585 6.72954776423e-07 0.85 6.72986534553e-07 0.952512626585 6.73018292683e-07 1.2 6.73050050813e-07 1.44748737341 6.73081808943e-07 1.55 6.73113567073e-07 1.44748737342 6.73145325203e-07 1.2 6.73177083333e-07 0.952512626585 6.73208841463e-07 0.85 6.73240599593e-07 0.952512626585 6.73272357724e-07 1.2 6.73304115854e-07 1.44748737342 6.73335873984e-07 1.55 6.73367632114e-07 1.44748737342 6.73399390244e-07 1.2 6.73431148374e-07 0.952512626585 6.73462906504e-07 0.85 6.73494664634e-07 0.952512626585 6.73526422764e-07 1.2 6.73558180894e-07 1.44748737342 6.73589939024e-07 1.55 6.73621697154e-07 1.44748737342 6.73653455285e-07 1.2 6.73685213415e-07 0.952512626585 6.73716971545e-07 0.85 6.73748729675e-07 0.952512626585 6.73780487805e-07 1.2 6.73812245935e-07 1.44748737342 6.73844004065e-07 1.55 6.73875762195e-07 1.44748737341 6.73907520325e-07 1.2 6.73939278455e-07 0.952512626585 6.73971036585e-07 0.85 6.74002794715e-07 0.952512626585 6.74034552846e-07 1.2 6.74066310976e-07 1.44748737341 6.74098069106e-07 1.55 6.74129827236e-07 1.44748737342 6.74161585366e-07 1.2 6.74193343496e-07 0.952512626585 6.74225101626e-07 0.85 6.74256859756e-07 0.952512626585 6.74288617886e-07 1.2 6.74320376016e-07 1.44748737341 6.74352134146e-07 1.55 6.74383892276e-07 1.44748737342 6.74415650407e-07 1.2 6.74447408537e-07 0.952512626585 6.74479166667e-07 0.85 6.74510924797e-07 0.952512626585 6.74542682927e-07 1.2 6.74574441057e-07 1.44748737342 6.74606199187e-07 1.55 6.74637957317e-07 1.44748737342 6.74669715447e-07 1.2 6.74701473577e-07 0.952512626585 6.74733231707e-07 0.85 6.74764989837e-07 0.952512626584 6.74796747967e-07 1.2 6.74828506098e-07 1.44748737342 6.74860264228e-07 1.55 6.74892022358e-07 1.44748737342 6.74923780488e-07 1.2 6.74955538618e-07 0.952512626585 6.74987296748e-07 0.85 6.75019054878e-07 0.952512626585 6.75050813008e-07 1.2 6.75082571138e-07 1.44748737342 6.75114329268e-07 1.55 6.75146087398e-07 1.44748737341 6.75177845528e-07 1.2 6.75209603659e-07 0.952512626585 6.75241361789e-07 0.85 6.75273119919e-07 0.952512626585 6.75304878049e-07 1.2 6.75336636179e-07 1.44748737342 6.75368394309e-07 1.55 6.75400152439e-07 1.44748737342 6.75431910569e-07 1.2 6.75463668699e-07 0.952512626585 6.75495426829e-07 0.85 6.75527184959e-07 0.952512626585 6.75558943089e-07 1.2 6.7559070122e-07 1.44748737341 6.7562245935e-07 1.55 6.7565421748e-07 1.44748737342 6.7568597561e-07 1.2 6.7571773374e-07 0.952512626585 6.7574949187e-07 0.85 6.7578125e-07 0.952512626585 6.7581300813e-07 1.2 6.7584476626e-07 1.44748737341 6.7587652439e-07 1.55 6.7590828252e-07 1.44748737342 6.7594004065e-07 1.2 6.7597179878e-07 0.952512626585 6.76003556911e-07 0.85 6.76035315041e-07 0.952512626584 6.76067073171e-07 1.2 6.76098831301e-07 1.44748737342 6.76130589431e-07 1.55 6.76162347561e-07 1.44748737342 6.76194105691e-07 1.2 6.76225863821e-07 0.952512626584 6.76257621951e-07 0.85 6.76289380081e-07 0.952512626584 6.76321138211e-07 1.2 6.76352896341e-07 1.44748737342 6.76384654472e-07 1.55 6.76416412602e-07 1.44748737342 6.76448170732e-07 1.2 6.76479928862e-07 0.952512626584 6.76511686992e-07 0.85 6.76543445122e-07 0.952512626585 6.76575203252e-07 1.2 6.76606961382e-07 1.44748737342 6.76638719512e-07 1.55 6.76670477642e-07 1.44748737342 6.76702235772e-07 1.2 6.76733993902e-07 0.952512626584 6.76765752033e-07 0.85 6.76797510163e-07 0.952512626585 6.76829268293e-07 1.2 6.76861026423e-07 1.44748737342 6.76892784553e-07 1.55 6.76924542683e-07 1.44748737342 6.76956300813e-07 1.2 6.76988058943e-07 0.952512626585 6.77019817073e-07 0.85 6.77051575203e-07 0.952512626585 6.77083333333e-07 1.2 6.77115091463e-07 1.44748737342 6.77146849593e-07 1.55 6.77178607724e-07 1.44748737342 6.77210365854e-07 1.2 6.77242123984e-07 0.952512626585 6.77273882114e-07 0.85 6.77305640244e-07 0.952512626584 6.77337398374e-07 1.2 6.77369156504e-07 1.44748737342 6.77400914634e-07 1.55 6.77432672764e-07 1.44748737342 6.77464430894e-07 1.2 6.77496189024e-07 0.952512626584 6.77527947154e-07 0.85 6.77559705285e-07 0.952512626584 6.77591463415e-07 1.2 6.77623221545e-07 1.44748737342 6.77654979675e-07 1.55 6.77686737805e-07 1.44748737342 6.77718495935e-07 1.2 6.77750254065e-07 0.952512626584 6.77782012195e-07 0.85 6.77813770325e-07 0.952512626585 6.77845528455e-07 1.2 6.77877286585e-07 1.44748737342 6.77909044715e-07 1.55 6.77940802846e-07 1.44748737342 6.77972560976e-07 1.2 6.78004319106e-07 0.952512626585 6.78036077236e-07 0.85 6.78067835366e-07 0.952512626585 6.78099593496e-07 1.2 6.78131351626e-07 1.44748737342 6.78163109756e-07 1.55 6.78194867886e-07 1.44748737342 6.78226626016e-07 1.2 6.78258384146e-07 0.952512626585 6.78290142276e-07 0.85 6.78321900407e-07 0.952512626584 6.78353658537e-07 1.2 6.78385416667e-07 1.44748737342 6.78417174797e-07 1.55 6.78448932927e-07 1.44748737342 6.78480691057e-07 1.2 6.78512449187e-07 0.952512626585 6.78544207317e-07 0.85 6.78575965447e-07 0.952512626584 6.78607723577e-07 1.2 6.78639481707e-07 1.44748737341 6.78671239837e-07 1.55 6.78702997967e-07 1.44748737342 6.78734756098e-07 1.2 6.78766514228e-07 0.952512626585 6.78798272358e-07 0.85 6.78830030488e-07 0.952512626584 6.78861788618e-07 1.2 6.78893546748e-07 1.44748737342 6.78925304878e-07 1.55 6.78957063008e-07 1.44748737342 6.78988821138e-07 1.2 6.79020579268e-07 0.952512626584 6.79052337398e-07 0.85 6.79084095528e-07 0.952512626584 6.79115853659e-07 1.2 6.79147611789e-07 1.44748737342 6.79179369919e-07 1.55 6.79211128049e-07 1.44748737342 6.79242886179e-07 1.2 6.79274644309e-07 0.952512626585 6.79306402439e-07 0.85 6.79338160569e-07 0.952512626585 6.79369918699e-07 1.2 6.79401676829e-07 1.44748737342 6.79433434959e-07 1.55 6.79465193089e-07 1.44748737342 6.7949695122e-07 1.2 6.7952870935e-07 0.952512626585 6.7956046748e-07 0.85 6.7959222561e-07 0.952512626585 6.7962398374e-07 1.2 6.7965574187e-07 1.44748737342 6.796875e-07 1.55 6.7971925813e-07 1.44748737342 6.7975101626e-07 1.2 6.7978277439e-07 0.952512626585 6.7981453252e-07 0.85 6.7984629065e-07 0.952512626585 6.7987804878e-07 1.2 6.79909806911e-07 1.44748737341 6.79941565041e-07 1.55 6.79973323171e-07 1.44748737342 6.80005081301e-07 1.2 6.80036839431e-07 0.952512626585 6.80068597561e-07 0.85 6.80100355691e-07 0.952512626585 6.80132113821e-07 1.2 6.80163871951e-07 1.44748737342 6.80195630081e-07 1.55 6.80227388211e-07 1.44748737342 6.80259146341e-07 1.2 6.80290904472e-07 0.952512626584 6.80322662602e-07 0.85 6.80354420732e-07 0.952512626585 6.80386178862e-07 1.2 6.80417936992e-07 1.44748737342 6.80449695122e-07 1.55 6.80481453252e-07 1.44748737342 6.80513211382e-07 1.2 6.80544969512e-07 0.952512626585 6.80576727642e-07 0.85 6.80608485772e-07 0.952512626585 6.80640243902e-07 1.2 6.80672002033e-07 1.44748737342 6.80703760163e-07 1.55 6.80735518293e-07 1.44748737341 6.80767276423e-07 1.2 6.80799034553e-07 0.952512626585 6.80830792683e-07 0.85 6.80862550813e-07 0.952512626585 6.80894308943e-07 1.2 6.80926067073e-07 1.44748737342 6.80957825203e-07 1.55 6.80989583333e-07 1.44748737341 6.81021341463e-07 1.2 6.81053099593e-07 0.952512626585 6.81084857724e-07 0.85 6.81116615854e-07 0.952512626585 6.81148373984e-07 1.2 6.81180132114e-07 1.44748737341 6.81211890244e-07 1.55 6.81243648374e-07 1.44748737341 6.81275406504e-07 1.2 6.81307164634e-07 0.952512626585 6.81338922764e-07 0.85 6.81370680894e-07 0.952512626585 6.81402439024e-07 1.2 6.81434197154e-07 1.44748737341 6.81465955285e-07 1.55 6.81497713415e-07 1.44748737342 6.81529471545e-07 1.2 6.81561229675e-07 0.952512626585 6.81592987805e-07 0.85 6.81624745935e-07 0.952512626585 6.81656504065e-07 1.2 6.81688262195e-07 1.44748737342 6.81720020325e-07 1.55 6.81751778455e-07 1.44748737342 6.81783536585e-07 1.2 6.81815294715e-07 0.952512626585 6.81847052846e-07 0.85 6.81878810976e-07 0.952512626585 6.81910569106e-07 1.2 6.81942327236e-07 1.44748737342 6.81974085366e-07 1.55 6.82005843496e-07 1.44748737342 6.82037601626e-07 1.2 6.82069359756e-07 0.952512626585 6.82101117886e-07 0.85 6.82132876016e-07 0.952512626585 6.82164634146e-07 1.2 6.82196392276e-07 1.44748737341 6.82228150407e-07 1.55 6.82259908537e-07 1.44748737341 6.82291666667e-07 1.2 6.82323424797e-07 0.952512626585 6.82355182927e-07 0.85 6.82386941057e-07 0.952512626585 6.82418699187e-07 1.2 6.82450457317e-07 1.44748737341 6.82482215447e-07 1.55 6.82513973577e-07 1.44748737342 6.82545731707e-07 1.2 6.82577489837e-07 0.952512626585 6.82609247967e-07 0.85 6.82641006098e-07 0.952512626585 6.82672764228e-07 1.2 6.82704522358e-07 1.44748737341 6.82736280488e-07 1.55 6.82768038618e-07 1.44748737342 6.82799796748e-07 1.2 6.82831554878e-07 0.952512626585 6.82863313008e-07 0.85 6.82895071138e-07 0.952512626585 6.82926829268e-07 1.2 6.82958587398e-07 1.44748737342 6.82990345528e-07 1.55 6.83022103659e-07 1.44748737342 6.83053861789e-07 1.2 6.83085619919e-07 0.952512626585 6.83117378049e-07 0.85 6.83149136179e-07 0.952512626584 6.83180894309e-07 1.2 6.83212652439e-07 1.44748737342 6.83244410569e-07 1.55 6.83276168699e-07 1.44748737342 6.83307926829e-07 1.2 6.83339684959e-07 0.952512626585 6.83371443089e-07 0.85 6.8340320122e-07 0.952512626585 6.8343495935e-07 1.2 6.8346671748e-07 1.44748737342 6.8349847561e-07 1.55 6.8353023374e-07 1.44748737341 6.8356199187e-07 1.2 6.8359375e-07 0.952512626585 6.8362550813e-07 0.85 6.8365726626e-07 0.952512626585 6.8368902439e-07 1.2 6.8372078252e-07 1.44748737342 6.8375254065e-07 1.55 6.8378429878e-07 1.44748737342 6.83816056911e-07 1.2 6.83847815041e-07 0.952512626585 6.83879573171e-07 0.85 6.83911331301e-07 0.952512626585 6.83943089431e-07 1.2 6.83974847561e-07 1.44748737342 6.84006605691e-07 1.55 6.84038363821e-07 1.44748737342 6.84070121951e-07 1.2 6.84101880081e-07 0.952512626585 6.84133638211e-07 0.85 6.84165396341e-07 0.952512626585 6.84197154472e-07 1.2 6.84228912602e-07 1.44748737341 6.84260670732e-07 1.55 6.84292428862e-07 1.44748737342 6.84324186992e-07 1.2 6.84355945122e-07 0.952512626585 6.84387703252e-07 0.85 6.84419461382e-07 0.952512626584 6.84451219512e-07 1.2 6.84482977642e-07 1.44748737342 6.84514735772e-07 1.55 6.84546493902e-07 1.44748737342 6.84578252033e-07 1.2 6.84610010163e-07 0.952512626584 6.84641768293e-07 0.85 6.84673526423e-07 0.952512626584 6.84705284553e-07 1.2 6.84737042683e-07 1.44748737342 6.84768800813e-07 1.55 6.84800558943e-07 1.44748737342 6.84832317073e-07 1.2 6.84864075203e-07 0.952512626584 6.84895833333e-07 0.85 6.84927591463e-07 0.952512626585 6.84959349593e-07 1.2 6.84991107724e-07 1.44748737342 6.85022865854e-07 1.55 6.85054623984e-07 1.44748737342 6.85086382114e-07 1.2 6.85118140244e-07 0.952512626584 6.85149898374e-07 0.85 6.85181656504e-07 0.952512626585 6.85213414634e-07 1.2 6.85245172764e-07 1.44748737342 6.85276930894e-07 1.55 6.85308689024e-07 1.44748737342 6.85340447154e-07 1.2 6.85372205285e-07 0.952512626585 6.85403963415e-07 0.85 6.85435721545e-07 0.952512626585 6.85467479675e-07 1.2 6.85499237805e-07 1.44748737342 6.85530995935e-07 1.55 6.85562754065e-07 1.44748737342 6.85594512195e-07 1.2 6.85626270325e-07 0.952512626585 6.85658028455e-07 0.85 6.85689786585e-07 0.952512626584 6.85721544715e-07 1.2 6.85753302846e-07 1.44748737342 6.85785060976e-07 1.55 6.85816819106e-07 1.44748737342 6.85848577236e-07 1.2 6.85880335366e-07 0.952512626584 6.85912093496e-07 0.85 6.85943851626e-07 0.952512626584 6.85975609756e-07 1.2 6.86007367886e-07 1.44748737342 6.86039126016e-07 1.55 6.86070884146e-07 1.44748737342 6.86102642276e-07 1.2 6.86134400407e-07 0.952512626584 6.86166158537e-07 0.85 6.86197916667e-07 0.952512626585 6.86229674797e-07 1.2 6.86261432927e-07 1.44748737342 6.86293191057e-07 1.55 6.86324949187e-07 1.44748737342 6.86356707317e-07 1.2 6.86388465447e-07 0.952512626585 6.86420223577e-07 0.85 6.86451981707e-07 0.952512626585 6.86483739837e-07 1.2 6.86515497967e-07 1.44748737342 6.86547256098e-07 1.55 6.86579014228e-07 1.44748737342 6.86610772358e-07 1.2 6.86642530488e-07 0.952512626585 6.86674288618e-07 0.85 6.86706046748e-07 0.952512626584 6.86737804878e-07 1.2 6.86769563008e-07 1.44748737342 6.86801321138e-07 1.55 6.86833079268e-07 1.44748737342 6.86864837398e-07 1.2 6.86896595528e-07 0.952512626585 6.86928353659e-07 0.85 6.86960111789e-07 0.952512626584 6.86991869919e-07 1.2 6.87023628049e-07 1.44748737341 6.87055386179e-07 1.55 6.87087144309e-07 1.44748737342 6.87118902439e-07 1.2 6.87150660569e-07 0.952512626585 6.87182418699e-07 0.85 6.87214176829e-07 0.952512626584 6.87245934959e-07 1.2 6.87277693089e-07 1.44748737342 6.8730945122e-07 1.55 6.8734120935e-07 1.44748737342 6.8737296748e-07 1.2 6.8740472561e-07 0.952512626584 6.8743648374e-07 0.85 6.8746824187e-07 0.952512626584 6.875e-07 1.2 6.8753175813e-07 1.44748737342 6.8756351626e-07 1.55 6.8759527439e-07 1.44748737342 6.8762703252e-07 1.2 6.8765879065e-07 0.952512626585 6.8769054878e-07 0.85 6.87722306911e-07 0.952512626585 6.87754065041e-07 1.2 6.87785823171e-07 1.44748737342 6.87817581301e-07 1.55 6.87849339431e-07 1.44748737341 6.87881097561e-07 1.2 6.87912855691e-07 0.952512626585 6.87944613821e-07 0.85 6.87976371951e-07 0.952512626585 6.88008130081e-07 1.2 6.88039888211e-07 1.44748737342 6.88071646341e-07 1.55 6.88103404472e-07 1.44748737342 6.88135162602e-07 1.2 6.88166920732e-07 0.952512626585 6.88198678862e-07 0.85 6.88230436992e-07 0.952512626585 6.88262195122e-07 1.2 6.88293953252e-07 1.44748737341 6.88325711382e-07 1.55 6.88357469512e-07 1.44748737342 6.88389227642e-07 1.2 6.88420985772e-07 0.952512626585 6.88452743902e-07 0.85 6.88484502033e-07 0.952512626585 6.88516260163e-07 1.2 6.88548018293e-07 1.44748737342 6.88579776423e-07 1.55 6.88611534553e-07 1.44748737342 6.88643292683e-07 1.2 6.88675050813e-07 0.952512626584 6.88706808943e-07 0.85 6.88738567073e-07 0.952512626585 6.88770325203e-07 1.2 6.88802083333e-07 1.44748737342 6.88833841463e-07 1.55 6.88865599593e-07 1.44748737342 6.88897357724e-07 1.2 6.88929115854e-07 0.952512626585 6.88960873984e-07 0.85 6.88992632114e-07 0.952512626585 6.89024390244e-07 1.2 6.89056148374e-07 1.44748737342 6.89087906504e-07 1.55 6.89119664634e-07 1.44748737341 6.89151422764e-07 1.2 6.89183180894e-07 0.952512626585 6.89214939024e-07 0.85 6.89246697154e-07 0.952512626585 6.89278455285e-07 1.2 6.89310213415e-07 1.44748737342 6.89341971545e-07 1.55 6.89373729675e-07 1.44748737341 6.89405487805e-07 1.2 6.89437245935e-07 0.952512626585 6.89469004065e-07 0.85 6.89500762195e-07 0.952512626585 6.89532520325e-07 1.2 6.89564278455e-07 1.44748737341 6.89596036585e-07 1.55 6.89627794715e-07 1.44748737341 6.89659552846e-07 1.2 6.89691310976e-07 0.952512626585 6.89723069106e-07 0.85 6.89754827236e-07 0.952512626585 6.89786585366e-07 1.2 6.89818343496e-07 1.44748737341 6.89850101626e-07 1.55 6.89881859756e-07 1.44748737342 6.89913617886e-07 1.2 6.89945376016e-07 0.952512626585 6.89977134146e-07 0.85 6.90008892276e-07 0.952512626585 6.90040650407e-07 1.2 6.90072408537e-07 1.44748737342 6.90104166667e-07 1.55 6.90135924797e-07 1.44748737342 6.90167682927e-07 1.2 6.90199441057e-07 0.952512626585 6.90231199187e-07 0.85 6.90262957317e-07 0.952512626584 6.90294715447e-07 1.2 6.90326473577e-07 1.44748737342 6.90358231707e-07 1.55 6.90389989837e-07 1.44748737342 6.90421747967e-07 1.2 6.90453506098e-07 0.952512626585 6.90485264228e-07 0.85 6.90517022358e-07 0.952512626585 6.90548780488e-07 1.2 6.90580538618e-07 1.44748737341 6.90612296748e-07 1.55 6.90644054878e-07 1.44748737341 6.90675813008e-07 1.2 6.90707571138e-07 0.952512626585 6.90739329268e-07 0.85 6.90771087398e-07 0.952512626585 6.90802845528e-07 1.2 6.90834603659e-07 1.44748737341 6.90866361789e-07 1.55 6.90898119919e-07 1.44748737342 6.90929878049e-07 1.2 6.90961636179e-07 0.952512626585 6.90993394309e-07 0.85 6.91025152439e-07 0.952512626585 6.91056910569e-07 1.2 6.91088668699e-07 1.44748737341 6.91120426829e-07 1.55 6.91152184959e-07 1.44748737342 6.91183943089e-07 1.2 6.9121570122e-07 0.952512626585 6.9124745935e-07 0.85 6.9127921748e-07 0.952512626585 6.9131097561e-07 1.2 6.9134273374e-07 1.44748737342 6.9137449187e-07 1.55 6.9140625e-07 1.44748737342 6.9143800813e-07 1.2 6.9146976626e-07 0.952512626584 6.9150152439e-07 0.85 6.9153328252e-07 0.952512626584 6.9156504065e-07 1.2 6.9159679878e-07 1.44748737342 6.91628556911e-07 1.55 6.91660315041e-07 1.44748737342 6.91692073171e-07 1.2 6.91723831301e-07 0.952512626585 6.91755589431e-07 0.85 6.91787347561e-07 0.952512626585 6.91819105691e-07 1.2 6.91850863821e-07 1.44748737342 6.91882621951e-07 1.55 6.91914380081e-07 1.44748737341 6.91946138211e-07 1.2 6.91977896341e-07 0.952512626585 6.92009654472e-07 0.85 6.92041412602e-07 0.952512626585 6.92073170732e-07 1.2 6.92104928862e-07 1.44748737342 6.92136686992e-07 1.55 6.92168445122e-07 1.44748737342 6.92200203252e-07 1.2 6.92231961382e-07 0.952512626585 6.92263719512e-07 0.85 6.92295477642e-07 0.952512626585 6.92327235772e-07 1.2 6.92358993902e-07 1.44748737342 6.92390752033e-07 1.55 6.92422510163e-07 1.44748737342 6.92454268293e-07 1.2 6.92486026423e-07 0.952512626585 6.92517784553e-07 0.85 6.92549542683e-07 0.952512626585 6.92581300813e-07 1.2 6.92613058943e-07 1.44748737342 6.92644817073e-07 1.55 6.92676575203e-07 1.44748737342 6.92708333333e-07 1.2 6.92740091463e-07 0.952512626585 6.92771849593e-07 0.85 6.92803607724e-07 0.952512626584 6.92835365854e-07 1.2 6.92867123984e-07 1.44748737342 6.92898882114e-07 1.55 6.92930640244e-07 1.44748737342 6.92962398374e-07 1.2 6.92994156504e-07 0.952512626584 6.93025914634e-07 0.85 6.93057672764e-07 0.952512626584 6.93089430894e-07 1.2 6.93121189024e-07 1.44748737342 6.93152947154e-07 1.55 6.93184705285e-07 1.44748737342 6.93216463415e-07 1.2 6.93248221545e-07 0.952512626584 6.93279979675e-07 0.85 6.93311737805e-07 0.952512626585 6.93343495935e-07 1.2 6.93375254065e-07 1.44748737342 6.93407012195e-07 1.55 6.93438770325e-07 1.44748737342 6.93470528455e-07 1.2 6.93502286585e-07 0.952512626584 6.93534044715e-07 0.85 6.93565802846e-07 0.952512626585 6.93597560976e-07 1.2 6.93629319106e-07 1.44748737342 6.93661077236e-07 1.55 6.93692835366e-07 1.44748737342 6.93724593496e-07 1.2 6.93756351626e-07 0.952512626585 6.93788109756e-07 0.85 6.93819867886e-07 0.952512626584 6.93851626016e-07 1.2 6.93883384146e-07 1.44748737342 6.93915142276e-07 1.55 6.93946900407e-07 1.44748737342 6.93978658537e-07 1.2 6.94010416667e-07 0.952512626585 6.94042174797e-07 0.85 6.94073932927e-07 0.952512626584 6.94105691057e-07 1.2 6.94137449187e-07 1.44748737342 6.94169207317e-07 1.55 6.94200965447e-07 1.44748737342 6.94232723577e-07 1.2 6.94264481707e-07 0.952512626584 6.94296239837e-07 0.85 6.94327997967e-07 0.952512626584 6.94359756098e-07 1.2 6.94391514228e-07 1.44748737342 6.94423272358e-07 1.55 6.94455030488e-07 1.44748737342 6.94486788618e-07 1.2 6.94518546748e-07 0.952512626584 6.94550304878e-07 0.85 6.94582063008e-07 0.952512626585 6.94613821138e-07 1.2 6.94645579268e-07 1.44748737342 6.94677337398e-07 1.55 6.94709095528e-07 1.44748737342 6.94740853659e-07 1.2 6.94772611789e-07 0.952512626585 6.94804369919e-07 0.85 6.94836128049e-07 0.952512626585 6.94867886179e-07 1.2 6.94899644309e-07 1.44748737342 6.94931402439e-07 1.55 6.94963160569e-07 1.44748737342 6.94994918699e-07 1.2 6.95026676829e-07 0.952512626585 6.95058434959e-07 0.85 6.95090193089e-07 0.952512626585 6.9512195122e-07 1.2 6.9515370935e-07 1.44748737342 6.9518546748e-07 1.55 6.9521722561e-07 1.44748737342 6.9524898374e-07 1.2 6.9528074187e-07 0.952512626585 6.953125e-07 0.85 6.9534425813e-07 0.952512626584 6.9537601626e-07 1.2 6.9540777439e-07 1.44748737341 6.9543953252e-07 1.55 6.9547129065e-07 1.44748737342 6.9550304878e-07 1.2 6.95534806911e-07 0.952512626585 6.95566565041e-07 0.85 6.95598323171e-07 0.952512626584 6.95630081301e-07 1.2 6.95661839431e-07 1.44748737342 6.95693597561e-07 1.55 6.95725355691e-07 1.44748737342 6.95757113821e-07 1.2 6.95788871951e-07 0.952512626584 6.95820630081e-07 0.85 6.95852388211e-07 0.952512626584 6.95884146341e-07 1.2 6.95915904472e-07 1.44748737342 6.95947662602e-07 1.55 6.95979420732e-07 1.44748737342 6.96011178862e-07 1.2 6.96042936992e-07 0.952512626585 6.96074695122e-07 0.85 6.96106453252e-07 0.952512626585 6.96138211382e-07 1.2 6.96169969512e-07 1.44748737342 6.96201727642e-07 1.55 6.96233485772e-07 1.44748737341 6.96265243902e-07 1.2 6.96297002033e-07 0.952512626585 6.96328760163e-07 0.85 6.96360518293e-07 0.952512626585 6.96392276423e-07 1.2 6.96424034553e-07 1.44748737342 6.96455792683e-07 1.55 6.96487550813e-07 1.44748737341 6.96519308943e-07 1.2 6.96551067073e-07 0.952512626585 6.96582825203e-07 0.85 6.96614583333e-07 0.952512626585 6.96646341463e-07 1.2 6.96678099593e-07 1.44748737341 6.96709857724e-07 1.55 6.96741615854e-07 1.44748737342 6.96773373984e-07 1.2 6.96805132114e-07 0.952512626585 6.96836890244e-07 0.85 6.96868648374e-07 0.952512626585 6.96900406504e-07 1.2 6.96932164634e-07 1.44748737342 6.96963922764e-07 1.55 6.96995680894e-07 1.44748737342 6.97027439024e-07 1.2 6.97059197154e-07 0.952512626584 6.97090955285e-07 0.85 6.97122713415e-07 0.952512626585 6.97154471545e-07 1.2 6.97186229675e-07 1.44748737342 6.97217987805e-07 1.55 6.97249745935e-07 1.44748737342 6.97281504065e-07 1.2 6.97313262195e-07 0.952512626585 6.97345020325e-07 0.85 6.97376778455e-07 0.952512626585 6.97408536585e-07 1.2 6.97440294715e-07 1.44748737342 6.97472052846e-07 1.55 6.97503810976e-07 1.44748737341 6.97535569106e-07 1.2 6.97567327236e-07 0.952512626585 6.97599085366e-07 0.85 6.97630843496e-07 0.952512626585 6.97662601626e-07 1.2 6.97694359756e-07 1.44748737342 6.97726117886e-07 1.55 6.97757876016e-07 1.44748737341 6.97789634146e-07 1.2 6.97821392276e-07 0.952512626585 6.97853150407e-07 0.85 6.97884908537e-07 0.952512626585 6.97916666667e-07 1.2 6.97948424797e-07 1.44748737341 6.97980182927e-07 1.55 6.98011941057e-07 1.44748737342 6.98043699187e-07 1.2 6.98075457317e-07 0.952512626585 6.98107215447e-07 0.85 6.98138973577e-07 0.952512626585 6.98170731707e-07 1.2 6.98202489837e-07 1.44748737341 6.98234247967e-07 1.55 6.98266006098e-07 1.44748737342 6.98297764228e-07 1.2 6.98329522358e-07 0.952512626585 6.98361280488e-07 0.85 6.98393038618e-07 0.952512626585 6.98424796748e-07 1.2 6.98456554878e-07 1.44748737342 6.98488313008e-07 1.55 6.98520071138e-07 1.44748737342 6.98551829268e-07 1.2 6.98583587398e-07 0.952512626585 6.98615345528e-07 0.85 6.98647103659e-07 0.952512626584 6.98678861789e-07 1.2 6.98710619919e-07 1.44748737342 6.98742378049e-07 1.55 6.98774136179e-07 1.44748737342 6.98805894309e-07 1.2 6.98837652439e-07 0.952512626585 6.98869410569e-07 0.85 6.98901168699e-07 0.952512626585 6.98932926829e-07 1.2 6.98964684959e-07 1.44748737341 6.98996443089e-07 1.55 6.9902820122e-07 1.44748737341 6.9905995935e-07 1.2 6.9909171748e-07 0.952512626585 6.9912347561e-07 0.85 6.9915523374e-07 0.952512626585 6.9918699187e-07 1.2 6.9921875e-07 1.44748737341 6.9925050813e-07 1.55 6.9928226626e-07 1.44748737342 6.9931402439e-07 1.2 6.9934578252e-07 0.952512626585 6.9937754065e-07 0.85 6.9940929878e-07 0.952512626585 6.99441056911e-07 1.2 6.99472815041e-07 1.44748737341 6.99504573171e-07 1.55 6.99536331301e-07 1.44748737342 6.99568089431e-07 1.2 6.99599847561e-07 0.952512626585 6.99631605691e-07 0.85 6.99663363821e-07 0.952512626585 6.99695121951e-07 1.2 6.99726880081e-07 1.44748737342 6.99758638211e-07 1.55 6.99790396341e-07 1.44748737342 6.99822154472e-07 1.2 6.99853912602e-07 0.952512626584 6.99885670732e-07 0.85 6.99917428862e-07 0.952512626584 6.99949186992e-07 1.2 6.99980945122e-07 1.44748737342 7.00012703252e-07 1.55 7.00044461382e-07 1.44748737342 7.00076219512e-07 1.2 7.00107977642e-07 0.952512626584 7.00139735772e-07 0.85 7.00171493902e-07 0.952512626584 7.00203252033e-07 1.2 7.00235010163e-07 1.44748737342 7.00266768293e-07 1.55 7.00298526423e-07 1.44748737341 7.00330284553e-07 1.2 7.00362042683e-07 0.952512626585 7.00393800813e-07 0.85 7.00425558943e-07 0.952512626585 7.00457317073e-07 1.2 7.00489075203e-07 1.44748737342 7.00520833333e-07 1.55 7.00552591463e-07 1.44748737342 7.00584349593e-07 1.2 7.00616107724e-07 0.952512626585 7.00647865854e-07 0.85 7.00679623984e-07 0.952512626585 7.00711382114e-07 1.2 7.00743140244e-07 1.44748737342 7.00774898374e-07 1.55 7.00806656504e-07 1.44748737342 7.00838414634e-07 1.2 7.00870172764e-07 0.952512626585 7.00901930894e-07 0.85 7.00933689024e-07 0.952512626585 7.00965447154e-07 1.2 7.00997205285e-07 1.44748737342 7.01028963415e-07 1.55 7.01060721545e-07 1.44748737342 7.01092479675e-07 1.2 7.01124237805e-07 0.952512626585 7.01155995935e-07 0.85 7.01187754065e-07 0.952512626584 7.01219512195e-07 1.2 7.01251270325e-07 1.44748737342 7.01283028455e-07 1.55 7.01314786585e-07 1.44748737342 7.01346544715e-07 1.2 7.01378302846e-07 0.952512626584 7.01410060976e-07 0.85 7.01441819106e-07 0.952512626584 7.01473577236e-07 1.2 7.01505335366e-07 1.44748737342 7.01537093496e-07 1.55 7.01568851626e-07 1.44748737342 7.01600609756e-07 1.2 7.01632367886e-07 0.952512626584 7.01664126016e-07 0.85 7.01695884146e-07 0.952512626585 7.01727642276e-07 1.2 7.01759400407e-07 1.44748737342 7.01791158537e-07 1.55 7.01822916667e-07 1.44748737342 7.01854674797e-07 1.2 7.01886432927e-07 0.952512626585 7.01918191057e-07 0.85 7.01949949187e-07 0.952512626585 7.01981707317e-07 1.2 7.02013465447e-07 1.44748737342 7.02045223577e-07 1.55 7.02076981707e-07 1.44748737342 7.02108739837e-07 1.2 7.02140497967e-07 0.952512626585 7.02172256098e-07 0.85 7.02204014228e-07 0.952512626584 7.02235772358e-07 1.2 7.02267530488e-07 1.44748737342 7.02299288618e-07 1.55 7.02331046748e-07 1.44748737342 7.02362804878e-07 1.2 7.02394563008e-07 0.952512626585 7.02426321138e-07 0.85 7.02458079268e-07 0.952512626584 7.02489837398e-07 1.2 7.02521595528e-07 1.44748737342 7.02553353659e-07 1.55 7.02585111789e-07 1.44748737342 7.02616869919e-07 1.2 7.02648628049e-07 0.952512626584 7.02680386179e-07 0.85 7.02712144309e-07 0.952512626584 7.02743902439e-07 1.2 7.02775660569e-07 1.44748737342 7.02807418699e-07 1.55 7.02839176829e-07 1.44748737342 7.02870934959e-07 1.2 7.02902693089e-07 0.952512626584 7.0293445122e-07 0.85 7.0296620935e-07 0.952512626584 7.0299796748e-07 1.2 7.0302972561e-07 1.44748737342 7.0306148374e-07 1.55 7.0309324187e-07 1.44748737342 7.03125e-07 1.2 7.0315675813e-07 0.952512626585 7.0318851626e-07 0.85 7.0322027439e-07 0.952512626585 7.0325203252e-07 1.2 7.0328379065e-07 1.44748737342 7.0331554878e-07 1.55 7.03347306911e-07 1.44748737342 7.03379065041e-07 1.2 7.03410823171e-07 0.952512626585 7.03442581301e-07 0.85 7.03474339431e-07 0.952512626585 7.03506097561e-07 1.2 7.03537855691e-07 1.44748737342 7.03569613821e-07 1.55 7.03601371951e-07 1.44748737342 7.03633130081e-07 1.2 7.03664888211e-07 0.952512626585 7.03696646341e-07 0.85 7.03728404472e-07 0.952512626585 7.03760162602e-07 1.2 7.03791920732e-07 1.44748737341 7.03823678862e-07 1.55 7.03855436992e-07 1.44748737342 7.03887195122e-07 1.2 7.03918953252e-07 0.952512626585 7.03950711382e-07 0.85 7.03982469512e-07 0.952512626584 7.04014227642e-07 1.2 7.04045985772e-07 1.44748737342 7.04077743902e-07 1.55 7.04109502033e-07 1.44748737342 7.04141260163e-07 1.2 7.04173018293e-07 0.952512626584 7.04204776423e-07 0.85 7.04236534553e-07 0.952512626584 7.04268292683e-07 1.2 7.04300050813e-07 1.44748737342 7.04331808943e-07 1.55 7.04363567073e-07 1.44748737342 7.04395325203e-07 1.2 7.04427083333e-07 0.952512626585 7.04458841463e-07 0.85 7.04490599593e-07 0.952512626585 7.04522357724e-07 1.2 7.04554115854e-07 1.44748737342 7.04585873984e-07 1.55 7.04617632114e-07 1.44748737341 7.04649390244e-07 1.2 7.04681148374e-07 0.952512626585 7.04712906504e-07 0.85 7.04744664634e-07 0.952512626585 7.04776422764e-07 1.2 7.04808180894e-07 1.44748737342 7.04839939024e-07 1.55 7.04871697154e-07 1.44748737341 7.04903455285e-07 1.2 7.04935213415e-07 0.952512626585 7.04966971545e-07 0.85 7.04998729675e-07 0.952512626585 7.05030487805e-07 1.2 7.05062245935e-07 1.44748737341 7.05094004065e-07 1.55 7.05125762195e-07 1.44748737342 7.05157520325e-07 1.2 7.05189278455e-07 0.952512626585 7.05221036585e-07 0.85 7.05252794715e-07 0.952512626585 7.05284552846e-07 1.2 7.05316310976e-07 1.44748737342 7.05348069106e-07 1.55 7.05379827236e-07 1.44748737342 7.05411585366e-07 1.2 7.05443343496e-07 0.952512626584 7.05475101626e-07 0.85 7.05506859756e-07 0.952512626585 7.05538617886e-07 1.2 7.05570376016e-07 1.44748737342 7.05602134146e-07 1.55 7.05633892276e-07 1.44748737342 7.05665650407e-07 1.2 7.05697408537e-07 0.952512626585 7.05729166667e-07 0.85 7.05760924797e-07 0.952512626584 7.05792682927e-07 1.2 7.05824441057e-07 1.44748737342 7.05856199187e-07 1.55 7.05887957317e-07 1.44748737341 7.05919715447e-07 1.2 7.05951473577e-07 0.952512626585 7.05983231707e-07 0.85 7.06014989837e-07 0.952512626585 7.06046747967e-07 1.2 7.06078506098e-07 1.44748737341 7.06110264228e-07 1.55 7.06142022358e-07 1.44748737341 7.06173780488e-07 1.2 7.06205538618e-07 0.952512626585 7.06237296748e-07 0.85 7.06269054878e-07 0.952512626585 7.06300813008e-07 1.2 7.06332571138e-07 1.44748737341 7.06364329268e-07 1.55 7.06396087398e-07 1.44748737342 7.06427845528e-07 1.2 7.06459603659e-07 0.952512626585 7.06491361789e-07 0.85 7.06523119919e-07 0.952512626585 7.06554878049e-07 1.2 7.06586636179e-07 1.44748737341 7.06618394309e-07 1.55 7.06650152439e-07 1.44748737342 7.06681910569e-07 1.2 7.06713668699e-07 0.952512626585 7.06745426829e-07 0.85 7.06777184959e-07 0.952512626585 7.06808943089e-07 1.2 7.0684070122e-07 1.44748737342 7.0687245935e-07 1.55 7.0690421748e-07 1.44748737342 7.0693597561e-07 1.2 7.0696773374e-07 0.952512626585 7.0699949187e-07 0.85 7.0703125e-07 0.952512626584 7.0706300813e-07 1.2 7.0709476626e-07 1.44748737342 7.0712652439e-07 1.55 7.0715828252e-07 1.44748737342 7.0719004065e-07 1.2 7.0722179878e-07 0.952512626585 7.07253556911e-07 0.85 7.07285315041e-07 0.952512626585 7.07317073171e-07 1.2 7.07348831301e-07 1.44748737342 7.07380589431e-07 1.55 7.07412347561e-07 1.44748737341 7.07444105691e-07 1.2 7.07475863821e-07 0.952512626585 7.07507621951e-07 0.85 7.07539380081e-07 0.952512626585 7.07571138211e-07 1.2 7.07602896341e-07 1.44748737341 7.07634654472e-07 1.55 7.07666412602e-07 1.44748737342 7.07698170732e-07 1.2 7.07729928862e-07 0.952512626585 7.07761686992e-07 0.85 7.07793445122e-07 0.952512626585 7.07825203252e-07 1.2 7.07856961382e-07 1.44748737341 7.07888719512e-07 1.55 7.07920477642e-07 1.44748737342 7.07952235772e-07 1.2 7.07983993902e-07 0.952512626585 7.08015752033e-07 0.85 7.08047510163e-07 0.952512626585 7.08079268293e-07 1.2 7.08111026423e-07 1.44748737342 7.08142784553e-07 1.55 7.08174542683e-07 1.44748737342 7.08206300813e-07 1.2 7.08238058943e-07 0.952512626584 7.08269817073e-07 0.85 7.08301575203e-07 0.952512626584 7.08333333333e-07 1.2 7.08365091463e-07 1.44748737342 7.08396849593e-07 1.55 7.08428607724e-07 1.44748737342 7.08460365854e-07 1.2 7.08492123984e-07 0.952512626584 7.08523882114e-07 0.85 7.08555640244e-07 0.952512626584 7.08587398374e-07 1.2 7.08619156504e-07 1.44748737342 7.08650914634e-07 1.55 7.08682672764e-07 1.44748737341 7.08714430894e-07 1.2 7.08746189024e-07 0.952512626584 7.08777947154e-07 0.85 7.08809705285e-07 0.952512626585 7.08841463415e-07 1.2 7.08873221545e-07 1.44748737342 7.08904979675e-07 1.55 7.08936737805e-07 1.44748737342 7.08968495935e-07 1.2 7.09000254065e-07 0.952512626585 7.09032012195e-07 0.85 7.09063770325e-07 0.952512626585 7.09095528455e-07 1.2 7.09127286585e-07 1.44748737342 7.09159044715e-07 1.55 7.09190802846e-07 1.44748737342 7.09222560976e-07 1.2 7.09254319106e-07 0.952512626585 7.09286077236e-07 0.85 7.09317835366e-07 0.952512626585 7.09349593496e-07 1.2 7.09381351626e-07 1.44748737342 7.09413109756e-07 1.55 7.09444867886e-07 1.44748737342 7.09476626016e-07 1.2 7.09508384146e-07 0.952512626585 7.09540142276e-07 0.85 7.09571900407e-07 0.952512626584 7.09603658537e-07 1.2 7.09635416667e-07 1.44748737342 7.09667174797e-07 1.55 7.09698932927e-07 1.44748737342 7.09730691057e-07 1.2 7.09762449187e-07 0.952512626584 7.09794207317e-07 0.85 7.09825965447e-07 0.952512626584 7.09857723577e-07 1.2 7.09889481707e-07 1.44748737342 7.09921239837e-07 1.55 7.09952997967e-07 1.44748737342 7.09984756098e-07 1.2 7.10016514228e-07 0.952512626584 7.10048272358e-07 0.85 7.10080030488e-07 0.952512626585 7.10111788618e-07 1.2 7.10143546748e-07 1.44748737342 7.10175304878e-07 1.55 7.10207063008e-07 1.44748737342 7.10238821138e-07 1.2 7.10270579268e-07 0.952512626585 7.10302337398e-07 0.85 7.10334095528e-07 0.952512626585 7.10365853659e-07 1.2 7.10397611789e-07 1.44748737342 7.10429369919e-07 1.55 7.10461128049e-07 1.44748737342 7.10492886179e-07 1.2 7.10524644309e-07 0.952512626585 7.10556402439e-07 0.85 7.10588160569e-07 0.952512626584 7.10619918699e-07 1.2 7.10651676829e-07 1.44748737342 7.10683434959e-07 1.55 7.10715193089e-07 1.44748737342 7.1074695122e-07 1.2 7.1077870935e-07 0.952512626585 7.1081046748e-07 0.85 7.1084222561e-07 0.952512626584 7.1087398374e-07 1.2 7.1090574187e-07 1.44748737342 7.109375e-07 1.55 7.1096925813e-07 1.44748737342 7.1100101626e-07 1.2 7.1103277439e-07 0.952512626584 7.1106453252e-07 0.85 7.1109629065e-07 0.952512626584 7.1112804878e-07 1.2 7.11159806911e-07 1.44748737342 7.11191565041e-07 1.55 7.11223323171e-07 1.44748737342 7.11255081301e-07 1.2 7.11286839431e-07 0.952512626584 7.11318597561e-07 0.85 7.11350355691e-07 0.952512626584 7.11382113821e-07 1.2 7.11413871951e-07 1.44748737342 7.11445630081e-07 1.55 7.11477388211e-07 1.44748737342 7.11509146341e-07 1.2 7.11540904472e-07 0.952512626585 7.11572662602e-07 0.85 7.11604420732e-07 0.952512626585 7.11636178862e-07 1.2 7.11667936992e-07 1.44748737342 7.11699695122e-07 1.55 7.11731453252e-07 1.44748737342 7.11763211382e-07 1.2 7.11794969512e-07 0.952512626585 7.11826727642e-07 0.85 7.11858485772e-07 0.952512626585 7.11890243902e-07 1.2 7.11922002033e-07 1.44748737342 7.11953760163e-07 1.55 7.11985518293e-07 1.44748737342 7.12017276423e-07 1.2 7.12049034553e-07 0.952512626585 7.12080792683e-07 0.85 7.12112550813e-07 0.952512626585 7.12144308943e-07 1.2 7.12176067073e-07 1.44748737341 7.12207825203e-07 1.55 7.12239583333e-07 1.44748737342 7.12271341463e-07 1.2 7.12303099593e-07 0.952512626585 7.12334857724e-07 0.85 7.12366615854e-07 0.952512626585 7.12398373984e-07 1.2 7.12430132114e-07 1.44748737342 7.12461890244e-07 1.55 7.12493648374e-07 1.44748737342 7.12525406504e-07 1.2 7.12557164634e-07 0.952512626584 7.12588922764e-07 0.85 7.12620680894e-07 0.952512626584 7.12652439024e-07 1.2 7.12684197154e-07 1.44748737342 7.12715955285e-07 1.55 7.12747713415e-07 1.44748737342 7.12779471545e-07 1.2 7.12811229675e-07 0.952512626585 7.12842987805e-07 0.85 7.12874745935e-07 0.952512626585 7.12906504065e-07 1.2 7.12938262195e-07 1.44748737342 7.12970020325e-07 1.55 7.13001778455e-07 1.44748737341 7.13033536585e-07 1.2 7.13065294715e-07 0.952512626585 7.13097052846e-07 0.85 7.13128810976e-07 0.952512626585 7.13160569106e-07 1.2 7.13192327236e-07 1.44748737342 7.13224085366e-07 1.55 7.13255843496e-07 1.44748737341 7.13287601626e-07 1.2 7.13319359756e-07 0.952512626585 7.13351117886e-07 0.85 7.13382876016e-07 0.952512626585 7.13414634146e-07 1.2 7.13446392276e-07 1.44748737341 7.13478150407e-07 1.55 7.13509908537e-07 1.44748737342 7.13541666667e-07 1.2 7.13573424797e-07 0.952512626585 7.13605182927e-07 0.85 7.13636941057e-07 0.952512626585 7.13668699187e-07 1.2 7.13700457317e-07 1.44748737342 7.13732215447e-07 1.55 7.13763973577e-07 1.44748737342 7.13795731707e-07 1.2 7.13827489837e-07 0.952512626585 7.13859247967e-07 0.85 7.13891006098e-07 0.952512626585 7.13922764228e-07 1.2 7.13954522358e-07 1.44748737342 7.13986280488e-07 1.55 7.14018038618e-07 1.44748737342 7.14049796748e-07 1.2 7.14081554878e-07 0.952512626585 7.14113313008e-07 0.85 7.14145071138e-07 0.952512626584 7.14176829268e-07 1.2 7.14208587398e-07 1.44748737342 7.14240345528e-07 1.55 7.14272103659e-07 1.44748737341 7.14303861789e-07 1.2 7.14335619919e-07 0.952512626585 7.14367378049e-07 0.85 7.14399136179e-07 0.952512626585 7.14430894309e-07 1.2 7.14462652439e-07 1.44748737341 7.14494410569e-07 1.55 7.14526168699e-07 1.44748737341 7.14557926829e-07 1.2 7.14589684959e-07 0.952512626585 7.14621443089e-07 0.85 7.1465320122e-07 0.952512626585 7.1468495935e-07 1.2 7.1471671748e-07 1.44748737341 7.1474847561e-07 1.55 7.1478023374e-07 1.44748737342 7.1481199187e-07 1.2 7.1484375e-07 0.952512626585 7.1487550813e-07 0.85 7.1490726626e-07 0.952512626585 7.1493902439e-07 1.2 7.1497078252e-07 1.44748737341 7.1500254065e-07 1.55 7.1503429878e-07 1.44748737342 7.15066056911e-07 1.2 7.15097815041e-07 0.952512626585 7.15129573171e-07 0.85 7.15161331301e-07 0.952512626585 7.15193089431e-07 1.2 7.15224847561e-07 1.44748737342 7.15256605691e-07 1.55 7.15288363821e-07 1.44748737342 7.15320121951e-07 1.2 7.15351880081e-07 0.952512626585 7.15383638211e-07 0.85 7.15415396341e-07 0.952512626584 7.15447154472e-07 1.2 7.15478912602e-07 1.44748737342 7.15510670732e-07 1.55 7.15542428862e-07 1.44748737342 7.15574186992e-07 1.2 7.15605945122e-07 0.952512626585 7.15637703252e-07 0.85 7.15669461382e-07 0.952512626585 7.15701219512e-07 1.2 7.15732977642e-07 1.44748737342 7.15764735772e-07 1.55 7.15796493902e-07 1.44748737341 7.15828252033e-07 1.2 7.15860010163e-07 0.952512626585 7.15891768293e-07 0.85 7.15923526423e-07 0.952512626585 7.15955284553e-07 1.2 7.15987042683e-07 1.44748737342 7.16018800813e-07 1.55 7.16050558943e-07 1.44748737342 7.16082317073e-07 1.2 7.16114075203e-07 0.952512626585 7.16145833333e-07 0.85 7.16177591463e-07 0.952512626585 7.16209349593e-07 1.2 7.16241107724e-07 1.44748737341 7.16272865854e-07 1.55 7.16304623984e-07 1.44748737342 7.16336382114e-07 1.2 7.16368140244e-07 0.952512626585 7.16399898374e-07 0.85 7.16431656504e-07 0.952512626585 7.16463414634e-07 1.2 7.16495172764e-07 1.44748737342 7.16526930894e-07 1.55 7.16558689024e-07 1.44748737342 7.16590447154e-07 1.2 7.16622205285e-07 0.952512626584 7.16653963415e-07 0.85 7.16685721545e-07 0.952512626584 7.16717479675e-07 1.2 7.16749237805e-07 1.44748737342 7.16780995935e-07 1.55 7.16812754065e-07 1.44748737342 7.16844512195e-07 1.2 7.16876270325e-07 0.952512626584 7.16908028455e-07 0.85 7.16939786585e-07 0.952512626584 7.16971544715e-07 1.2 7.17003302846e-07 1.44748737342 7.17035060976e-07 1.55 7.17066819106e-07 1.44748737341 7.17098577236e-07 1.2 7.17130335366e-07 0.952512626584 7.17162093496e-07 0.85 7.17193851626e-07 0.952512626585 7.17225609756e-07 1.2 7.17257367886e-07 1.44748737342 7.17289126016e-07 1.55 7.17320884146e-07 1.44748737342 7.17352642276e-07 1.2 7.17384400407e-07 0.952512626584 7.17416158537e-07 0.85 7.17447916667e-07 0.952512626585 7.17479674797e-07 1.2 7.17511432927e-07 1.44748737342 7.17543191057e-07 1.55 7.17574949187e-07 1.44748737342 7.17606707317e-07 1.2 7.17638465447e-07 0.952512626585 7.17670223577e-07 0.85 7.17701981707e-07 0.952512626584 7.17733739837e-07 1.2 7.17765497967e-07 1.44748737342 7.17797256098e-07 1.55 7.17829014228e-07 1.44748737342 7.17860772358e-07 1.2 7.17892530488e-07 0.952512626585 7.17924288618e-07 0.85 7.17956046748e-07 0.952512626584 7.17987804878e-07 1.2 7.18019563008e-07 1.44748737342 7.18051321138e-07 1.55 7.18083079268e-07 1.44748737342 7.18114837398e-07 1.2 7.18146595528e-07 0.952512626584 7.18178353659e-07 0.85 7.18210111789e-07 0.952512626584 7.18241869919e-07 1.2 7.18273628049e-07 1.44748737342 7.18305386179e-07 1.55 7.18337144309e-07 1.44748737342 7.18368902439e-07 1.2 7.18400660569e-07 0.952512626584 7.18432418699e-07 0.85 7.18464176829e-07 0.952512626585 7.18495934959e-07 1.2 7.18527693089e-07 1.44748737342 7.1855945122e-07 1.55 7.1859120935e-07 1.44748737342 7.1862296748e-07 1.2 7.1865472561e-07 0.952512626585 7.1868648374e-07 0.85 7.1871824187e-07 0.952512626585 7.1875e-07 1.2 7.1878175813e-07 1.44748737342 7.1881351626e-07 1.55 7.1884527439e-07 1.44748737342 7.1887703252e-07 1.2 7.1890879065e-07 0.952512626585 7.1894054878e-07 0.85 7.18972306911e-07 0.952512626584 7.19004065041e-07 1.2 7.19035823171e-07 1.44748737342 7.19067581301e-07 1.55 7.19099339431e-07 1.44748737342 7.19131097561e-07 1.2 7.19162855691e-07 0.952512626585 7.19194613821e-07 0.85 7.19226371951e-07 0.952512626584 7.19258130081e-07 1.2 7.19289888211e-07 1.44748737342 7.19321646341e-07 1.55 7.19353404472e-07 1.44748737342 7.19385162602e-07 1.2 7.19416920732e-07 0.952512626584 7.19448678862e-07 0.85 7.19480436992e-07 0.952512626584 7.19512195122e-07 1.2 7.19543953252e-07 1.44748737342 7.19575711382e-07 1.55 7.19607469512e-07 1.44748737342 7.19639227642e-07 1.2 7.19670985772e-07 0.952512626584 7.19702743902e-07 0.85 7.19734502033e-07 0.952512626584 7.19766260163e-07 1.2 7.19798018293e-07 1.44748737342 7.19829776423e-07 1.55 7.19861534553e-07 1.44748737342 7.19893292683e-07 1.2 7.19925050813e-07 0.952512626585 7.19956808943e-07 0.85 7.19988567073e-07 0.952512626585 7.20020325203e-07 1.2 7.20052083333e-07 1.44748737342 7.20083841463e-07 1.55 7.20115599593e-07 1.44748737342 7.20147357724e-07 1.2 7.20179115854e-07 0.952512626585 7.20210873984e-07 0.85 7.20242632114e-07 0.952512626585 7.20274390244e-07 1.2 7.20306148374e-07 1.44748737342 7.20337906504e-07 1.55 7.20369664634e-07 1.44748737342 7.20401422764e-07 1.2 7.20433180894e-07 0.952512626585 7.20464939024e-07 0.85 7.20496697154e-07 0.952512626585 7.20528455285e-07 1.2 7.20560213415e-07 1.44748737341 7.20591971545e-07 1.55 7.20623729675e-07 1.44748737342 7.20655487805e-07 1.2 7.20687245935e-07 0.952512626585 7.20719004065e-07 0.85 7.20750762195e-07 0.952512626585 7.20782520325e-07 1.2 7.20814278455e-07 1.44748737342 7.20846036585e-07 1.55 7.20877794715e-07 1.44748737342 7.20909552846e-07 1.2 7.20941310976e-07 0.952512626584 7.20973069106e-07 0.85 7.21004827236e-07 0.952512626585 7.21036585366e-07 1.2 7.21068343496e-07 1.44748737342 7.21100101626e-07 1.55 7.21131859756e-07 1.44748737342 7.21163617886e-07 1.2 7.21195376016e-07 0.952512626585 7.21227134146e-07 0.85 7.21258892276e-07 0.952512626585 7.21290650407e-07 1.2 7.21322408537e-07 1.44748737342 7.21354166667e-07 1.55 7.21385924797e-07 1.44748737341 7.21417682927e-07 1.2 7.21449441057e-07 0.952512626585 7.21481199187e-07 0.85 7.21512957317e-07 0.952512626585 7.21544715447e-07 1.2 7.21576473577e-07 1.44748737341 7.21608231707e-07 1.55 7.21639989837e-07 1.44748737341 7.21671747967e-07 1.2 7.21703506098e-07 0.952512626585 7.21735264228e-07 0.85 7.21767022358e-07 0.952512626585 7.21798780488e-07 1.2 7.21830538618e-07 1.44748737341 7.21862296748e-07 1.55 7.21894054878e-07 1.44748737342 7.21925813008e-07 1.2 7.21957571138e-07 0.952512626585 7.21989329268e-07 0.85 7.22021087398e-07 0.952512626585 7.22052845528e-07 1.2 7.22084603659e-07 1.44748737342 7.22116361789e-07 1.55 7.22148119919e-07 1.44748737342 7.22179878049e-07 1.2 7.22211636179e-07 0.952512626585 7.22243394309e-07 0.85 7.22275152439e-07 0.952512626585 7.22306910569e-07 1.2 7.22338668699e-07 1.44748737342 7.22370426829e-07 1.55 7.22402184959e-07 1.44748737342 7.22433943089e-07 1.2 7.2246570122e-07 0.952512626585 7.2249745935e-07 0.85 7.2252921748e-07 0.952512626584 7.2256097561e-07 1.2 7.2259273374e-07 1.44748737342 7.2262449187e-07 1.55 7.2265625e-07 1.44748737341 7.2268800813e-07 1.2 7.2271976626e-07 0.952512626585 7.2275152439e-07 0.85 7.2278328252e-07 0.952512626585 7.2281504065e-07 1.2 7.2284679878e-07 1.44748737341 7.22878556911e-07 1.55 7.22910315041e-07 1.44748737341 7.22942073171e-07 1.2 7.22973831301e-07 0.952512626585 7.23005589431e-07 0.85 7.23037347561e-07 0.952512626585 7.23069105691e-07 1.2 7.23100863821e-07 1.44748737341 7.23132621951e-07 1.55 7.23164380081e-07 1.44748737342 7.23196138211e-07 1.2 7.23227896341e-07 0.952512626585 7.23259654472e-07 0.85 7.23291412602e-07 0.952512626585 7.23323170732e-07 1.2 7.23354928862e-07 1.44748737341 7.23386686992e-07 1.55 7.23418445122e-07 1.44748737342 7.23450203252e-07 1.2 7.23481961382e-07 0.952512626585 7.23513719512e-07 0.85 7.23545477642e-07 0.952512626585 7.23577235772e-07 1.2 7.23608993902e-07 1.44748737342 7.23640752033e-07 1.55 7.23672510163e-07 1.44748737342 7.23704268293e-07 1.2 7.23736026423e-07 0.952512626585 7.23767784553e-07 0.85 7.23799542683e-07 0.952512626584 7.23831300813e-07 1.2 7.23863058943e-07 1.44748737342 7.23894817073e-07 1.55 7.23926575203e-07 1.44748737342 7.23958333333e-07 1.2 7.23990091463e-07 0.952512626585 7.24021849593e-07 0.85 7.24053607724e-07 0.952512626585 7.24085365854e-07 1.2 7.24117123984e-07 1.44748737342 7.24148882114e-07 1.55 7.24180640244e-07 1.44748737341 7.24212398374e-07 1.2 7.24244156504e-07 0.952512626585 7.24275914634e-07 0.85 7.24307672764e-07 0.952512626585 7.24339430894e-07 1.2 7.24371189024e-07 1.44748737342 7.24402947154e-07 1.55 7.24434705285e-07 1.44748737342 7.24466463415e-07 1.2 7.24498221545e-07 0.952512626585 7.24529979675e-07 0.85 7.24561737805e-07 0.952512626585 7.24593495935e-07 1.2 7.24625254065e-07 1.44748737342 7.24657012195e-07 1.55 7.24688770325e-07 1.44748737342 7.24720528455e-07 1.2 7.24752286585e-07 0.952512626585 7.24784044715e-07 0.85 7.24815802846e-07 0.952512626585 7.24847560976e-07 1.2 7.24879319106e-07 1.44748737342 7.24911077236e-07 1.55 7.24942835366e-07 1.44748737342 7.24974593496e-07 1.2 7.25006351626e-07 0.952512626584 7.25038109756e-07 0.85 7.25069867886e-07 0.952512626584 7.25101626016e-07 1.2 7.25133384146e-07 1.44748737342 7.25165142276e-07 1.55 7.25196900407e-07 1.44748737342 7.25228658537e-07 1.2 7.25260416667e-07 0.952512626584 7.25292174797e-07 0.85 7.25323932927e-07 0.952512626584 7.25355691057e-07 1.2 7.25387449187e-07 1.44748737342 7.25419207317e-07 1.55 7.25450965447e-07 1.44748737342 7.25482723577e-07 1.2 7.25514481707e-07 0.952512626584 7.25546239837e-07 0.85 7.25577997967e-07 0.952512626585 7.25609756098e-07 1.2 7.25641514228e-07 1.44748737342 7.25673272358e-07 1.55 7.25705030488e-07 1.44748737342 7.25736788618e-07 1.2 7.25768546748e-07 0.952512626585 7.25800304878e-07 0.85 7.25832063008e-07 0.952512626585 7.25863821138e-07 1.2 7.25895579268e-07 1.44748737342 7.25927337398e-07 1.55 7.25959095528e-07 1.44748737342 7.25990853659e-07 1.2 7.26022611789e-07 0.952512626585 7.26054369919e-07 0.85 7.26086128049e-07 0.952512626584 7.26117886179e-07 1.2 7.26149644309e-07 1.44748737342 7.26181402439e-07 1.55 7.26213160569e-07 1.44748737342 7.26244918699e-07 1.2 7.26276676829e-07 0.952512626585 7.26308434959e-07 0.85 7.26340193089e-07 0.952512626584 7.2637195122e-07 1.2 7.2640370935e-07 1.44748737342 7.2643546748e-07 1.55 7.2646722561e-07 1.44748737342 7.2649898374e-07 1.2 7.2653074187e-07 0.952512626584 7.265625e-07 0.85 7.2659425813e-07 0.952512626584 7.2662601626e-07 1.2 7.2665777439e-07 1.44748737342 7.2668953252e-07 1.55 7.2672129065e-07 1.44748737342 7.2675304878e-07 1.2 7.26784806911e-07 0.952512626584 7.26816565041e-07 0.85 7.26848323171e-07 0.952512626585 7.26880081301e-07 1.2 7.26911839431e-07 1.44748737342 7.26943597561e-07 1.55 7.26975355691e-07 1.44748737342 7.27007113821e-07 1.2 7.27038871951e-07 0.952512626585 7.27070630081e-07 0.85 7.27102388211e-07 0.952512626585 7.27134146341e-07 1.2 7.27165904472e-07 1.44748737342 7.27197662602e-07 1.55 7.27229420732e-07 1.44748737342 7.27261178862e-07 1.2 7.27292936992e-07 0.952512626585 7.27324695122e-07 0.85 7.27356453252e-07 0.952512626584 7.27388211382e-07 1.2 7.27419969512e-07 1.44748737342 7.27451727642e-07 1.55 7.27483485772e-07 1.44748737342 7.27515243902e-07 1.2 7.27547002033e-07 0.952512626585 7.27578760163e-07 0.85 7.27610518293e-07 0.952512626584 7.27642276423e-07 1.2 7.27674034553e-07 1.44748737341 7.27705792683e-07 1.55 7.27737550813e-07 1.44748737342 7.27769308943e-07 1.2 7.27801067073e-07 0.952512626584 7.27832825203e-07 0.85 7.27864583333e-07 0.952512626584 7.27896341463e-07 1.2 7.27928099593e-07 1.44748737342 7.27959857724e-07 1.55 7.27991615854e-07 1.44748737342 7.28023373984e-07 1.2 7.28055132114e-07 0.952512626584 7.28086890244e-07 0.85 7.28118648374e-07 0.952512626584 7.28150406504e-07 1.2 7.28182164634e-07 1.44748737342 7.28213922764e-07 1.55 7.28245680894e-07 1.44748737341 7.28277439024e-07 1.2 7.28309197154e-07 0.952512626585 7.28340955285e-07 0.85 7.28372713415e-07 0.952512626585 7.28404471545e-07 1.2 7.28436229675e-07 1.44748737342 7.28467987805e-07 1.55 7.28499745935e-07 1.44748737342 7.28531504065e-07 1.2 7.28563262195e-07 0.952512626585 7.28595020325e-07 0.85 7.28626778455e-07 0.952512626585 7.28658536585e-07 1.2 7.28690294715e-07 1.44748737342 7.28722052846e-07 1.55 7.28753810976e-07 1.44748737342 7.28785569106e-07 1.2 7.28817327236e-07 0.952512626585 7.28849085366e-07 0.85 7.28880843496e-07 0.952512626585 7.28912601626e-07 1.2 7.28944359756e-07 1.44748737341 7.28976117886e-07 1.55 7.29007876016e-07 1.44748737342 7.29039634146e-07 1.2 7.29071392276e-07 0.952512626585 7.29103150407e-07 0.85 7.29134908537e-07 0.952512626585 7.29166666667e-07 1.2 7.29198424797e-07 1.44748737342 7.29230182927e-07 1.55 7.29261941057e-07 1.44748737342 7.29293699187e-07 1.2 7.29325457317e-07 0.952512626585 7.29357215447e-07 0.85 7.29388973577e-07 0.952512626585 7.29420731707e-07 1.2 7.29452489837e-07 1.44748737342 7.29484247967e-07 1.55 7.29516006098e-07 1.44748737342 7.29547764228e-07 1.2 7.29579522358e-07 0.952512626585 7.29611280488e-07 0.85 7.29643038618e-07 0.952512626585 7.29674796748e-07 1.2 7.29706554878e-07 1.44748737342 7.29738313008e-07 1.55 7.29770071138e-07 1.44748737341 7.29801829268e-07 1.2 7.29833587398e-07 0.952512626585 7.29865345528e-07 0.85 7.29897103659e-07 0.952512626585 7.29928861789e-07 1.2 7.29960619919e-07 1.44748737341 7.29992378049e-07 1.55 7.30024136179e-07 1.44748737341 7.30055894309e-07 1.2 7.30087652439e-07 0.952512626585 7.30119410569e-07 0.85 7.30151168699e-07 0.952512626585 7.30182926829e-07 1.2 7.30214684959e-07 1.44748737341 7.30246443089e-07 1.55 7.3027820122e-07 1.44748737342 7.3030995935e-07 1.2 7.3034171748e-07 0.952512626585 7.3037347561e-07 0.85 7.3040523374e-07 0.952512626585 7.3043699187e-07 1.2 7.3046875e-07 1.44748737341 7.3050050813e-07 1.55 7.3053226626e-07 1.44748737342 7.3056402439e-07 1.2 7.3059578252e-07 0.952512626585 7.3062754065e-07 0.85 7.3065929878e-07 0.952512626585 7.30691056911e-07 1.2 7.30722815041e-07 1.44748737342 7.30754573171e-07 1.55 7.30786331301e-07 1.44748737342 7.30818089431e-07 1.2 7.30849847561e-07 0.952512626585 7.30881605691e-07 0.85 7.30913363821e-07 0.952512626584 7.30945121951e-07 1.2 7.30976880081e-07 1.44748737342 7.31008638211e-07 1.55 7.31040396341e-07 1.44748737341 7.31072154472e-07 1.2 7.31103912602e-07 0.952512626585 7.31135670732e-07 0.85 7.31167428862e-07 0.952512626585 7.31199186992e-07 1.2 7.31230945122e-07 1.44748737341 7.31262703252e-07 1.55 7.31294461382e-07 1.44748737341 7.31326219512e-07 1.2 7.31357977642e-07 0.952512626585 7.31389735772e-07 0.85 7.31421493902e-07 0.952512626585 7.31453252033e-07 1.2 7.31485010163e-07 1.44748737341 7.31516768293e-07 1.55 7.31548526423e-07 1.44748737342 7.31580284553e-07 1.2 7.31612042683e-07 0.952512626585 7.31643800813e-07 0.85 7.31675558943e-07 0.952512626585 7.31707317073e-07 1.2 7.31739075203e-07 1.44748737341 7.31770833333e-07 1.55 7.31802591463e-07 1.44748737342 7.31834349593e-07 1.2 7.31866107724e-07 0.952512626585 7.31897865854e-07 0.85 7.31929623984e-07 0.952512626585 7.31961382114e-07 1.2 7.31993140244e-07 1.44748737342 7.32024898374e-07 1.55 7.32056656504e-07 1.44748737342 7.32088414634e-07 1.2 7.32120172764e-07 0.952512626584 7.32151930894e-07 0.85 7.32183689024e-07 0.952512626584 7.32215447154e-07 1.2 7.32247205285e-07 1.44748737342 7.32278963415e-07 1.55 7.32310721545e-07 1.44748737342 7.32342479675e-07 1.2 7.32374237805e-07 0.952512626585 7.32405995935e-07 0.85 7.32437754065e-07 0.952512626585 7.32469512195e-07 1.2 7.32501270325e-07 1.44748737342 7.32533028455e-07 1.55 7.32564786585e-07 1.44748737341 7.32596544715e-07 1.2 7.32628302846e-07 0.952512626585 7.32660060976e-07 0.85 7.32691819106e-07 0.952512626585 7.32723577236e-07 1.2 7.32755335366e-07 1.44748737342 7.32787093496e-07 1.55 7.32818851626e-07 1.44748737342 7.32850609756e-07 1.2 7.32882367886e-07 0.952512626585 7.32914126016e-07 0.85 7.32945884146e-07 0.952512626585 7.32977642276e-07 1.2 7.33009400407e-07 1.44748737342 7.33041158537e-07 1.55 7.33072916667e-07 1.44748737342 7.33104674797e-07 1.2 7.33136432927e-07 0.952512626585 7.33168191057e-07 0.85 7.33199949187e-07 0.952512626584 7.33231707317e-07 1.2 7.33263465447e-07 1.44748737342 7.33295223577e-07 1.55 7.33326981707e-07 1.44748737342 7.33358739837e-07 1.2 7.33390497967e-07 0.952512626584 7.33422256098e-07 0.85 7.33454014228e-07 0.952512626584 7.33485772358e-07 1.2 7.33517530488e-07 1.44748737342 7.33549288618e-07 1.55 7.33581046748e-07 1.44748737342 7.33612804878e-07 1.2 7.33644563008e-07 0.952512626584 7.33676321138e-07 0.85 7.33708079268e-07 0.952512626584 7.33739837398e-07 1.2 7.33771595528e-07 1.44748737342 7.33803353659e-07 1.55 7.33835111789e-07 1.44748737342 7.33866869919e-07 1.2 7.33898628049e-07 0.952512626584 7.33930386179e-07 0.85 7.33962144309e-07 0.952512626585 7.33993902439e-07 1.2 7.34025660569e-07 1.44748737342 7.34057418699e-07 1.55 7.34089176829e-07 1.44748737342 7.34120934959e-07 1.2 7.34152693089e-07 0.952512626585 7.3418445122e-07 0.85 7.3421620935e-07 0.952512626585 7.3424796748e-07 1.2 7.3427972561e-07 1.44748737342 7.3431148374e-07 1.55 7.3434324187e-07 1.44748737342 7.34375e-07 1.2 7.3440675813e-07 0.952512626585 7.3443851626e-07 0.85 7.3447027439e-07 0.952512626584 7.3450203252e-07 1.2 7.3453379065e-07 1.44748737342 7.3456554878e-07 1.55 7.34597306911e-07 1.44748737342 7.34629065041e-07 1.2 7.34660823171e-07 0.952512626585 7.34692581301e-07 0.85 7.34724339431e-07 0.952512626584 7.34756097561e-07 1.2 7.34787855691e-07 1.44748737342 7.34819613821e-07 1.55 7.34851371951e-07 1.44748737342 7.34883130081e-07 1.2 7.34914888211e-07 0.952512626584 7.34946646341e-07 0.85 7.34978404472e-07 0.952512626584 7.35010162602e-07 1.2 7.35041920732e-07 1.44748737342 7.35073678862e-07 1.55 7.35105436992e-07 1.44748737342 7.35137195122e-07 1.2 7.35168953252e-07 0.952512626584 7.35200711382e-07 0.85 7.35232469512e-07 0.952512626585 7.35264227642e-07 1.2 7.35295985772e-07 1.44748737342 7.35327743902e-07 1.55 7.35359502033e-07 1.44748737342 7.35391260163e-07 1.2 7.35423018293e-07 0.952512626585 7.35454776423e-07 0.85 7.35486534553e-07 0.952512626585 7.35518292683e-07 1.2 7.35550050813e-07 1.44748737342 7.35581808943e-07 1.55 7.35613567073e-07 1.44748737342 7.35645325203e-07 1.2 7.35677083333e-07 0.952512626585 7.35708841463e-07 0.85 7.35740599593e-07 0.952512626585 7.35772357724e-07 1.2 7.35804115854e-07 1.44748737342 7.35835873984e-07 1.55 7.35867632114e-07 1.44748737342 7.35899390244e-07 1.2 7.35931148374e-07 0.952512626585 7.35962906504e-07 0.85 7.35994664634e-07 0.952512626584 7.36026422764e-07 1.2 7.36058180894e-07 1.44748737341 7.36089939024e-07 1.55 7.36121697154e-07 1.44748737342 7.36153455285e-07 1.2 7.36185213415e-07 0.952512626584 7.36216971545e-07 0.85 7.36248729675e-07 0.952512626584 7.36280487805e-07 1.2 7.36312245935e-07 1.44748737342 7.36344004065e-07 1.55 7.36375762195e-07 1.44748737342 7.36407520325e-07 1.2 7.36439278455e-07 0.952512626584 7.36471036585e-07 0.85 7.36502794715e-07 0.952512626584 7.36534552846e-07 1.2 7.36566310976e-07 1.44748737342 7.36598069106e-07 1.55 7.36629827236e-07 1.44748737341 7.36661585366e-07 1.2 7.36693343496e-07 0.952512626585 7.36725101626e-07 0.85 7.36756859756e-07 0.952512626585 7.36788617886e-07 1.2 7.36820376016e-07 1.44748737342 7.36852134146e-07 1.55 7.36883892276e-07 1.44748737341 7.36915650407e-07 1.2 7.36947408537e-07 0.952512626585 7.36979166667e-07 0.85 7.37010924797e-07 0.952512626585 7.37042682927e-07 1.2 7.37074441057e-07 1.44748737342 7.37106199187e-07 1.55 7.37137957317e-07 1.44748737342 7.37169715447e-07 1.2 7.37201473577e-07 0.952512626585 7.37233231707e-07 0.85 7.37264989837e-07 0.952512626585 7.37296747967e-07 1.2 7.37328506098e-07 1.44748737341 7.37360264228e-07 1.55 7.37392022358e-07 1.44748737342 7.37423780488e-07 1.2 7.37455538618e-07 0.952512626585 7.37487296748e-07 0.85 7.37519054878e-07 0.952512626585 7.37550813008e-07 1.2 7.37582571138e-07 1.44748737342 7.37614329268e-07 1.55 7.37646087398e-07 1.44748737342 7.37677845528e-07 1.2 7.37709603659e-07 0.952512626585 7.37741361789e-07 0.85 7.37773119919e-07 0.952512626585 7.37804878049e-07 1.2 7.37836636179e-07 1.44748737342 7.37868394309e-07 1.55 7.37900152439e-07 1.44748737342 7.37931910569e-07 1.2 7.37963668699e-07 0.952512626585 7.37995426829e-07 0.85 7.38027184959e-07 0.952512626585 7.38058943089e-07 1.2 7.3809070122e-07 1.44748737342 7.3812245935e-07 1.55 7.3815421748e-07 1.44748737341 7.3818597561e-07 1.2 7.3821773374e-07 0.952512626585 7.3824949187e-07 0.85 7.3828125e-07 0.952512626585 7.3831300813e-07 1.2 7.3834476626e-07 1.44748737341 7.3837652439e-07 1.55 7.3840828252e-07 1.44748737341 7.3844004065e-07 1.2 7.3847179878e-07 0.952512626585 7.38503556911e-07 0.85 7.38535315041e-07 0.952512626585 7.38567073171e-07 1.2 7.38598831301e-07 1.44748737341 7.38630589431e-07 1.55 7.38662347561e-07 1.44748737342 7.38694105691e-07 1.2 7.38725863821e-07 0.952512626585 7.38757621951e-07 0.85 7.38789380081e-07 0.952512626585 7.38821138211e-07 1.2 7.38852896341e-07 1.44748737341 7.38884654472e-07 1.55 7.38916412602e-07 1.44748737342 7.38948170732e-07 1.2 7.38979928862e-07 0.952512626585 7.39011686992e-07 0.85 7.39043445122e-07 0.952512626585 7.39075203252e-07 1.2 7.39106961382e-07 1.44748737342 7.39138719512e-07 1.55 7.39170477642e-07 1.44748737342 7.39202235772e-07 1.2 7.39233993902e-07 0.952512626585 7.39265752033e-07 0.85 7.39297510163e-07 0.952512626584 7.39329268293e-07 1.2 7.39361026423e-07 1.44748737342 7.39392784553e-07 1.55 7.39424542683e-07 1.44748737342 7.39456300813e-07 1.2 7.39488058943e-07 0.952512626585 7.39519817073e-07 0.85 7.39551575203e-07 0.952512626585 7.39583333333e-07 1.2 7.39615091463e-07 1.44748737341 7.39646849593e-07 1.55 7.39678607724e-07 1.44748737341 7.39710365854e-07 1.2 7.39742123984e-07 0.952512626585 7.39773882114e-07 0.85 7.39805640244e-07 0.952512626585 7.39837398374e-07 1.2 7.39869156504e-07 1.44748737341 7.39900914634e-07 1.55 7.39932672764e-07 1.44748737342 7.39964430894e-07 1.2 7.39996189024e-07 0.952512626585 7.40027947154e-07 0.85 7.40059705285e-07 0.952512626585 7.40091463415e-07 1.2 7.40123221545e-07 1.44748737341 7.40154979675e-07 1.55 7.40186737805e-07 1.44748737342 7.40218495935e-07 1.2 7.40250254065e-07 0.952512626585 7.40282012195e-07 0.85 7.40313770325e-07 0.952512626585 7.40345528455e-07 1.2 7.40377286585e-07 1.44748737342 7.40409044715e-07 1.55 7.40440802846e-07 1.44748737342 7.40472560976e-07 1.2 7.40504319106e-07 0.952512626584 7.40536077236e-07 0.85 7.40567835366e-07 0.952512626584 7.40599593496e-07 1.2 7.40631351626e-07 1.44748737342 7.40663109756e-07 1.55 7.40694867886e-07 1.44748737342 7.40726626016e-07 1.2 7.40758384146e-07 0.952512626585 7.40790142276e-07 0.85 7.40821900407e-07 0.952512626585 7.40853658537e-07 1.2 7.40885416667e-07 1.44748737342 7.40917174797e-07 1.55 7.40948932927e-07 1.44748737341 7.40980691057e-07 1.2 7.41012449187e-07 0.952512626585 7.41044207317e-07 0.85 7.41075965447e-07 0.952512626585 7.41107723577e-07 1.2 7.41139481707e-07 1.44748737342 7.41171239837e-07 1.55 7.41202997967e-07 1.44748737342 7.41234756098e-07 1.2 7.41266514228e-07 0.952512626585 7.41298272358e-07 0.85 7.41330030488e-07 0.952512626585 7.41361788618e-07 1.2 7.41393546748e-07 1.44748737342 7.41425304878e-07 1.55 7.41457063008e-07 1.44748737342 7.41488821138e-07 1.2 7.41520579268e-07 0.952512626585 7.41552337398e-07 0.85 7.41584095528e-07 0.952512626584 7.41615853659e-07 1.2 7.41647611789e-07 1.44748737342 7.41679369919e-07 1.55 7.41711128049e-07 1.44748737342 7.41742886179e-07 1.2 7.41774644309e-07 0.952512626584 7.41806402439e-07 0.85 7.41838160569e-07 0.952512626584 7.41869918699e-07 1.2 7.41901676829e-07 1.44748737342 7.41933434959e-07 1.55 7.41965193089e-07 1.44748737342 7.4199695122e-07 1.2 7.4202870935e-07 0.952512626584 7.4206046748e-07 0.85 7.4209222561e-07 0.952512626584 7.4212398374e-07 1.2 7.4215574187e-07 1.44748737342 7.421875e-07 1.55 7.4221925813e-07 1.44748737342 7.4225101626e-07 1.2 7.4228277439e-07 0.952512626584 7.4231453252e-07 0.85 7.4234629065e-07 0.952512626585 7.4237804878e-07 1.2 7.42409806911e-07 1.44748737342 7.42441565041e-07 1.55 7.42473323171e-07 1.44748737342 7.42505081301e-07 1.2 7.42536839431e-07 0.952512626585 7.42568597561e-07 0.85 7.42600355691e-07 0.952512626585 7.42632113821e-07 1.2 7.42663871951e-07 1.44748737342 7.42695630081e-07 1.55 7.42727388211e-07 1.44748737342 7.42759146341e-07 1.2 7.42790904472e-07 0.952512626585 7.42822662602e-07 0.85 7.42854420732e-07 0.952512626584 7.42886178862e-07 1.2 7.42917936992e-07 1.44748737342 7.42949695122e-07 1.55 7.42981453252e-07 1.44748737342 7.43013211382e-07 1.2 7.43044969512e-07 0.952512626585 7.43076727642e-07 0.85 7.43108485772e-07 0.952512626584 7.43140243902e-07 1.2 7.43172002033e-07 1.44748737342 7.43203760163e-07 1.55 7.43235518293e-07 1.44748737342 7.43267276423e-07 1.2 7.43299034553e-07 0.952512626584 7.43330792683e-07 0.85 7.43362550813e-07 0.952512626584 7.43394308943e-07 1.2 7.43426067073e-07 1.44748737342 7.43457825203e-07 1.55 7.43489583333e-07 1.44748737342 7.43521341463e-07 1.2 7.43553099593e-07 0.952512626584 7.43584857724e-07 0.85 7.43616615854e-07 0.952512626585 7.43648373984e-07 1.2 7.43680132114e-07 1.44748737342 7.43711890244e-07 1.55 7.43743648374e-07 1.44748737342 7.43775406504e-07 1.2 7.43807164634e-07 0.952512626585 7.43838922764e-07 0.85 7.43870680894e-07 0.952512626585 7.43902439024e-07 1.2 7.43934197154e-07 1.44748737342 7.43965955285e-07 1.55 7.43997713415e-07 1.44748737342 7.44029471545e-07 1.2 7.44061229675e-07 0.952512626585 7.44092987805e-07 0.85 7.44124745935e-07 0.952512626585 7.44156504065e-07 1.2 7.44188262195e-07 1.44748737342 7.44220020325e-07 1.55 7.44251778455e-07 1.44748737342 7.44283536585e-07 1.2 7.44315294715e-07 0.952512626585 7.44347052846e-07 0.85 7.44378810976e-07 0.952512626585 7.44410569106e-07 1.2 7.44442327236e-07 1.44748737341 7.44474085366e-07 1.55 7.44505843496e-07 1.44748737342 7.44537601626e-07 1.2 7.44569359756e-07 0.952512626584 7.44601117886e-07 0.85 7.44632876016e-07 0.952512626584 7.44664634146e-07 1.2 7.44696392276e-07 1.44748737342 7.44728150407e-07 1.55 7.44759908537e-07 1.44748737342 7.44791666667e-07 1.2 7.44823424797e-07 0.952512626584 7.44855182927e-07 0.85 7.44886941057e-07 0.952512626584 7.44918699187e-07 1.2 7.44950457317e-07 1.44748737342 7.44982215447e-07 1.55 7.45013973577e-07 1.44748737342 7.45045731707e-07 1.2 7.45077489837e-07 0.952512626585 7.45109247967e-07 0.85 7.45141006098e-07 0.952512626585 7.45172764228e-07 1.2 7.45204522358e-07 1.44748737342 7.45236280488e-07 1.55 7.45268038618e-07 1.44748737341 7.45299796748e-07 1.2 7.45331554878e-07 0.952512626585 7.45363313008e-07 0.85 7.45395071138e-07 0.952512626585 7.45426829268e-07 1.2 7.45458587398e-07 1.44748737341 7.45490345528e-07 1.55 7.45522103659e-07 1.44748737341 7.45553861789e-07 1.2 7.45585619919e-07 0.952512626585 7.45617378049e-07 0.85 7.45649136179e-07 0.952512626585 7.45680894309e-07 1.2 7.45712652439e-07 1.44748737341 7.45744410569e-07 1.55 7.45776168699e-07 1.44748737342 7.45807926829e-07 1.2 7.45839684959e-07 0.952512626585 7.45871443089e-07 0.85 7.4590320122e-07 0.952512626585 7.4593495935e-07 1.2 7.4596671748e-07 1.44748737342 7.4599847561e-07 1.55 7.4603023374e-07 1.44748737342 7.4606199187e-07 1.2 7.4609375e-07 0.952512626585 7.4612550813e-07 0.85 7.4615726626e-07 0.952512626585 7.4618902439e-07 1.2 7.4622078252e-07 1.44748737342 7.4625254065e-07 1.55 7.4628429878e-07 1.44748737342 7.46316056911e-07 1.2 7.46347815041e-07 0.952512626585 7.46379573171e-07 0.85 7.46411331301e-07 0.952512626585 7.46443089431e-07 1.2 7.46474847561e-07 1.44748737342 7.46506605691e-07 1.55 7.46538363821e-07 1.44748737341 7.46570121951e-07 1.2 7.46601880081e-07 0.952512626585 7.46633638211e-07 0.85 7.46665396341e-07 0.952512626585 7.46697154472e-07 1.2 7.46728912602e-07 1.44748737341 7.46760670732e-07 1.55 7.46792428862e-07 1.44748737341 7.46824186992e-07 1.2 7.46855945122e-07 0.952512626585 7.46887703252e-07 0.85 7.46919461382e-07 0.952512626585 7.46951219512e-07 1.2 7.46982977642e-07 1.44748737341 7.47014735772e-07 1.55 7.47046493902e-07 1.44748737342 7.47078252033e-07 1.2 7.47110010163e-07 0.952512626585 7.47141768293e-07 0.85 7.47173526423e-07 0.952512626585 7.47205284553e-07 1.2 7.47237042683e-07 1.44748737341 7.47268800813e-07 1.55 7.47300558943e-07 1.44748737342 7.47332317073e-07 1.2 7.47364075203e-07 0.952512626585 7.47395833333e-07 0.85 7.47427591463e-07 0.952512626585 7.47459349593e-07 1.2 7.47491107724e-07 1.44748737342 7.47522865854e-07 1.55 7.47554623984e-07 1.44748737342 7.47586382114e-07 1.2 7.47618140244e-07 0.952512626585 7.47649898374e-07 0.85 7.47681656504e-07 0.952512626584 7.47713414634e-07 1.2 7.47745172764e-07 1.44748737342 7.47776930894e-07 1.55 7.47808689024e-07 1.44748737342 7.47840447154e-07 1.2 7.47872205285e-07 0.952512626585 7.47903963415e-07 0.85 7.47935721545e-07 0.952512626585 7.47967479675e-07 1.2 7.47999237805e-07 1.44748737342 7.48030995935e-07 1.55 7.48062754065e-07 1.44748737341 7.48094512195e-07 1.2 7.48126270325e-07 0.952512626585 7.48158028455e-07 0.85 7.48189786585e-07 0.952512626585 7.48221544715e-07 1.2 7.48253302846e-07 1.44748737341 7.48285060976e-07 1.55 7.48316819106e-07 1.44748737342 7.48348577236e-07 1.2 7.48380335366e-07 0.952512626585 7.48412093496e-07 0.85 7.48443851626e-07 0.952512626585 7.48475609756e-07 1.2 7.48507367886e-07 1.44748737341 7.48539126016e-07 1.55 7.48570884146e-07 1.44748737342 7.48602642276e-07 1.2 7.48634400407e-07 0.952512626585 7.48666158537e-07 0.85 7.48697916667e-07 0.952512626585 7.48729674797e-07 1.2 7.48761432927e-07 1.44748737342 7.48793191057e-07 1.55 7.48824949187e-07 1.44748737342 7.48856707317e-07 1.2 7.48888465447e-07 0.952512626584 7.48920223577e-07 0.85 7.48951981707e-07 0.952512626584 7.48983739837e-07 1.2 7.49015497967e-07 1.44748737342 7.49047256098e-07 1.55 7.49079014228e-07 1.44748737342 7.49110772358e-07 1.2 7.49142530488e-07 0.952512626584 7.49174288618e-07 0.85 7.49206046748e-07 0.952512626585 7.49237804878e-07 1.2 7.49269563008e-07 1.44748737342 7.49301321138e-07 1.55 7.49333079268e-07 1.44748737342 7.49364837398e-07 1.2 7.49396595528e-07 0.952512626585 7.49428353659e-07 0.85 7.49460111789e-07 0.952512626585 7.49491869919e-07 1.2 7.49523628049e-07 1.44748737342 7.49555386179e-07 1.55 7.49587144309e-07 1.44748737342 7.49618902439e-07 1.2 7.49650660569e-07 0.952512626585 7.49682418699e-07 0.85 7.49714176829e-07 0.952512626585 7.49745934959e-07 1.2 7.49777693089e-07 1.44748737342 7.4980945122e-07 1.55 7.4984120935e-07 1.44748737342 7.4987296748e-07 1.2 7.4990472561e-07 0.952512626585 7.4993648374e-07 0.85 7.4996824187e-07 0.952512626584 7.5e-07 1.2 7.5003175813e-07 1.44748737342 7.5006351626e-07 1.55 7.5009527439e-07 1.44748737342 7.5012703252e-07 1.2 7.5015879065e-07 0.952512626584 7.5019054878e-07 0.85 7.50222306911e-07 0.952512626584 7.50254065041e-07 1.2 7.50285823171e-07 1.44748737342 7.50317581301e-07 1.55 7.50349339431e-07 1.44748737342 7.50381097561e-07 1.2 7.50412855691e-07 0.952512626584 7.50444613821e-07 0.85 7.50476371951e-07 0.952512626584 7.50508130081e-07 1.2 7.50539888211e-07 1.44748737342 7.50571646341e-07 1.55 7.50603404472e-07 1.44748737342 7.50635162602e-07 1.2 7.50666920732e-07 0.952512626584 7.50698678862e-07 0.85 7.50730436992e-07 0.952512626585 7.50762195122e-07 1.2 7.50793953252e-07 1.44748737342 7.50825711382e-07 1.55 7.50857469512e-07 1.44748737342 7.50889227642e-07 1.2 7.50920985772e-07 0.952512626585 7.50952743902e-07 0.85 7.50984502033e-07 0.952512626585 7.51016260163e-07 1.2 7.51048018293e-07 1.44748737342 7.51079776423e-07 1.55 7.51111534553e-07 1.44748737342 7.51143292683e-07 1.2 7.51175050813e-07 0.952512626585 7.51206808943e-07 0.85 7.51238567073e-07 0.952512626584 7.51270325203e-07 1.2 7.51302083333e-07 1.44748737342 7.51333841463e-07 1.55 7.51365599593e-07 1.44748737342 7.51397357724e-07 1.2 7.51429115854e-07 0.952512626585 7.51460873984e-07 0.85 7.51492632114e-07 0.952512626584 7.51524390244e-07 1.2 7.51556148374e-07 1.44748737342 7.51587906504e-07 1.55 7.51619664634e-07 1.44748737342 7.51651422764e-07 1.2 7.51683180894e-07 0.952512626584 7.51714939024e-07 0.85 7.51746697154e-07 0.952512626584 7.51778455285e-07 1.2 7.51810213415e-07 1.44748737342 7.51841971545e-07 1.55 7.51873729675e-07 1.44748737342 7.51905487805e-07 1.2 7.51937245935e-07 0.952512626584 7.51969004065e-07 0.85 7.52000762195e-07 0.952512626585 7.52032520325e-07 1.2 7.52064278455e-07 1.44748737342 7.52096036585e-07 1.55 7.52127794715e-07 1.44748737342 7.52159552846e-07 1.2 7.52191310976e-07 0.952512626585 7.52223069106e-07 0.85 7.52254827236e-07 0.952512626585 7.52286585366e-07 1.2 7.52318343496e-07 1.44748737342 7.52350101626e-07 1.55 7.52381859756e-07 1.44748737342 7.52413617886e-07 1.2 7.52445376016e-07 0.952512626585 7.52477134146e-07 0.85 7.52508892276e-07 0.952512626585 7.52540650407e-07 1.2 7.52572408537e-07 1.44748737342 7.52604166667e-07 1.55 7.52635924797e-07 1.44748737342 7.52667682927e-07 1.2 7.52699441057e-07 0.952512626585 7.52731199187e-07 0.85 7.52762957317e-07 0.952512626585 7.52794715447e-07 1.2 7.52826473577e-07 1.44748737341 7.52858231707e-07 1.55 7.52889989837e-07 1.44748737342 7.52921747967e-07 1.2 7.52953506098e-07 0.952512626584 7.52985264228e-07 0.85 7.53017022358e-07 0.952512626585 7.53048780488e-07 1.2 7.53080538618e-07 1.44748737342 7.53112296748e-07 1.55 7.53144054878e-07 1.44748737342 7.53175813008e-07 1.2 7.53207571138e-07 0.952512626585 7.53239329268e-07 0.85 7.53271087398e-07 0.952512626584 7.53302845528e-07 1.2 7.53334603659e-07 1.44748737342 7.53366361789e-07 1.55 7.53398119919e-07 1.44748737342 7.53429878049e-07 1.2 7.53461636179e-07 0.952512626585 7.53493394309e-07 0.85 7.53525152439e-07 0.952512626585 7.53556910569e-07 1.2 7.53588668699e-07 1.44748737342 7.53620426829e-07 1.55 7.53652184959e-07 1.44748737341 7.53683943089e-07 1.2 7.5371570122e-07 0.952512626585 7.5374745935e-07 0.85 7.5377921748e-07 0.952512626585 7.5381097561e-07 1.2 7.5384273374e-07 1.44748737341 7.5387449187e-07 1.55 7.5390625e-07 1.44748737341 7.5393800813e-07 1.2 7.5396976626e-07 0.952512626585 7.5400152439e-07 0.85 7.5403328252e-07 0.952512626585 7.5406504065e-07 1.2 7.5409679878e-07 1.44748737341 7.54128556911e-07 1.55 7.54160315041e-07 1.44748737342 7.54192073171e-07 1.2 7.54223831301e-07 0.952512626585 7.54255589431e-07 0.85 7.54287347561e-07 0.952512626585 7.54319105691e-07 1.2 7.54350863821e-07 1.44748737342 7.54382621951e-07 1.55 7.54414380081e-07 1.44748737342 7.54446138211e-07 1.2 7.54477896341e-07 0.952512626585 7.54509654472e-07 0.85 7.54541412602e-07 0.952512626585 7.54573170732e-07 1.2 7.54604928862e-07 1.44748737342 7.54636686992e-07 1.55 7.54668445122e-07 1.44748737342 7.54700203252e-07 1.2 7.54731961382e-07 0.952512626585 7.54763719512e-07 0.85 7.54795477642e-07 0.952512626585 7.54827235772e-07 1.2 7.54858993902e-07 1.44748737342 7.54890752033e-07 1.55 7.54922510163e-07 1.44748737341 7.54954268293e-07 1.2 7.54986026423e-07 0.952512626585 7.55017784553e-07 0.85 7.55049542683e-07 0.952512626585 7.55081300813e-07 1.2 7.55113058943e-07 1.44748737341 7.55144817073e-07 1.55 7.55176575203e-07 1.44748737341 7.55208333333e-07 1.2 7.55240091463e-07 0.952512626585 7.55271849593e-07 0.85 7.55303607724e-07 0.952512626585 7.55335365854e-07 1.2 7.55367123984e-07 1.44748737341 7.55398882114e-07 1.55 7.55430640244e-07 1.44748737342 7.55462398374e-07 1.2 7.55494156504e-07 0.952512626585 7.55525914634e-07 0.85 7.55557672764e-07 0.952512626585 7.55589430894e-07 1.2 7.55621189024e-07 1.44748737341 7.55652947154e-07 1.55 7.55684705285e-07 1.44748737342 7.55716463415e-07 1.2 7.55748221545e-07 0.952512626585 7.55779979675e-07 0.85 7.55811737805e-07 0.952512626585 7.55843495935e-07 1.2 7.55875254065e-07 1.44748737342 7.55907012195e-07 1.55 7.55938770325e-07 1.44748737342 7.55970528455e-07 1.2 7.56002286585e-07 0.952512626585 7.56034044715e-07 0.85 7.56065802846e-07 0.952512626584 7.56097560976e-07 1.2 7.56129319106e-07 1.44748737342 7.56161077236e-07 1.55 7.56192835366e-07 1.44748737342 7.56224593496e-07 1.2 7.56256351626e-07 0.952512626585 7.56288109756e-07 0.85 7.56319867886e-07 0.952512626585 7.56351626016e-07 1.2 7.56383384146e-07 1.44748737342 7.56415142276e-07 1.55 7.56446900407e-07 1.44748737341 7.56478658537e-07 1.2 7.56510416667e-07 0.952512626585 7.56542174797e-07 0.85 7.56573932927e-07 0.952512626585 7.56605691057e-07 1.2 7.56637449187e-07 1.44748737342 7.56669207317e-07 1.55 7.56700965447e-07 1.44748737342 7.56732723577e-07 1.2 7.56764481707e-07 0.952512626585 7.56796239837e-07 0.85 7.56827997967e-07 0.952512626585 7.56859756098e-07 1.2 7.56891514228e-07 1.44748737341 7.56923272358e-07 1.55 7.56955030488e-07 1.44748737342 7.56986788618e-07 1.2 7.57018546748e-07 0.952512626585 7.57050304878e-07 0.85 7.57082063008e-07 0.952512626584 7.57113821138e-07 1.2 7.57145579268e-07 1.44748737342 7.57177337398e-07 1.55 7.57209095528e-07 1.44748737342 7.57240853659e-07 1.2 7.57272611789e-07 0.952512626584 7.57304369919e-07 0.85 7.57336128049e-07 0.952512626584 7.57367886179e-07 1.2 7.57399644309e-07 1.44748737342 7.57431402439e-07 1.55 7.57463160569e-07 1.44748737342 7.57494918699e-07 1.2 7.57526676829e-07 0.952512626584 7.57558434959e-07 0.85 7.57590193089e-07 0.952512626585 7.5762195122e-07 1.2 7.5765370935e-07 1.44748737342 7.5768546748e-07 1.55 7.5771722561e-07 1.44748737342 7.5774898374e-07 1.2 7.5778074187e-07 0.952512626584 7.578125e-07 0.85 7.5784425813e-07 0.952512626585 7.5787601626e-07 1.2 7.5790777439e-07 1.44748737342 7.5793953252e-07 1.55 7.5797129065e-07 1.44748737342 7.5800304878e-07 1.2 7.58034806911e-07 0.952512626585 7.58066565041e-07 0.85 7.58098323171e-07 0.952512626585 7.58130081301e-07 1.2 7.58161839431e-07 1.44748737342 7.58193597561e-07 1.55 7.58225355691e-07 1.44748737342 7.58257113821e-07 1.2 7.58288871951e-07 0.952512626585 7.58320630081e-07 0.85 7.58352388211e-07 0.952512626584 7.58384146341e-07 1.2 7.58415904472e-07 1.44748737342 7.58447662602e-07 1.55 7.58479420732e-07 1.44748737342 7.58511178862e-07 1.2 7.58542936992e-07 0.952512626584 7.58574695122e-07 0.85 7.58606453252e-07 0.952512626584 7.58638211382e-07 1.2 7.58669969512e-07 1.44748737342 7.58701727642e-07 1.55 7.58733485772e-07 1.44748737342 7.58765243902e-07 1.2 7.58797002033e-07 0.952512626584 7.58828760163e-07 0.85 7.58860518293e-07 0.952512626584 7.58892276423e-07 1.2 7.58924034553e-07 1.44748737342 7.58955792683e-07 1.55 7.58987550813e-07 1.44748737342 7.59019308943e-07 1.2 7.59051067073e-07 0.952512626584 7.59082825203e-07 0.85 7.59114583333e-07 0.952512626585 7.59146341463e-07 1.2 7.59178099593e-07 1.44748737342 7.59209857724e-07 1.55 7.59241615854e-07 1.44748737342 7.59273373984e-07 1.2 7.59305132114e-07 0.952512626585 7.59336890244e-07 0.85 7.59368648374e-07 0.952512626585 7.59400406504e-07 1.2 7.59432164634e-07 1.44748737342 7.59463922764e-07 1.55 7.59495680894e-07 1.44748737342 7.59527439024e-07 1.2 7.59559197154e-07 0.952512626585 7.59590955285e-07 0.85 7.59622713415e-07 0.952512626584 7.59654471545e-07 1.2 7.59686229675e-07 1.44748737342 7.59717987805e-07 1.55 7.59749745935e-07 1.44748737342 7.59781504065e-07 1.2 7.59813262195e-07 0.952512626585 7.59845020325e-07 0.85 7.59876778455e-07 0.952512626584 7.59908536585e-07 1.2 7.59940294715e-07 1.44748737342 7.59972052846e-07 1.55 7.60003810976e-07 1.44748737342 7.60035569106e-07 1.2 7.60067327236e-07 0.952512626584 7.60099085366e-07 0.85 7.60130843496e-07 0.952512626584 7.60162601626e-07 1.2 7.60194359756e-07 1.44748737342 7.60226117886e-07 1.55 7.60257876016e-07 1.44748737342 7.60289634146e-07 1.2 7.60321392276e-07 0.952512626584 7.60353150407e-07 0.85 7.60384908537e-07 0.952512626585 7.60416666667e-07 1.2 7.60448424797e-07 1.44748737342 7.60480182927e-07 1.55 7.60511941057e-07 1.44748737342 7.60543699187e-07 1.2 7.60575457317e-07 0.952512626585 7.60607215447e-07 0.85 7.60638973577e-07 0.952512626585 7.60670731707e-07 1.2 7.60702489837e-07 1.44748737342 7.60734247967e-07 1.55 7.60766006098e-07 1.44748737342 7.60797764228e-07 1.2 7.60829522358e-07 0.952512626585 7.60861280488e-07 0.85 7.60893038618e-07 0.952512626585 7.60924796748e-07 1.2 7.60956554878e-07 1.44748737341 7.60988313008e-07 1.55 7.61020071138e-07 1.44748737342 7.61051829268e-07 1.2 7.61083587398e-07 0.952512626585 7.61115345528e-07 0.85 7.61147103659e-07 0.952512626585 7.61178861789e-07 1.2 7.61210619919e-07 1.44748737341 7.61242378049e-07 1.55 7.61274136179e-07 1.44748737342 7.61305894309e-07 1.2 7.61337652439e-07 0.952512626584 7.61369410569e-07 0.85 7.61401168699e-07 0.952512626585 7.61432926829e-07 1.2 7.61464684959e-07 1.44748737342 7.61496443089e-07 1.55 7.6152820122e-07 1.44748737342 7.6155995935e-07 1.2 7.6159171748e-07 0.952512626585 7.6162347561e-07 0.85 7.6165523374e-07 0.952512626585 7.6168699187e-07 1.2 7.6171875e-07 1.44748737342 7.6175050813e-07 1.55 7.6178226626e-07 1.44748737342 7.6181402439e-07 1.2 7.6184578252e-07 0.952512626585 7.6187754065e-07 0.85 7.6190929878e-07 0.952512626585 7.61941056911e-07 1.2 7.61972815041e-07 1.44748737342 7.62004573171e-07 1.55 7.62036331301e-07 1.44748737341 7.62068089431e-07 1.2 7.62099847561e-07 0.952512626585 7.62131605691e-07 0.85 7.62163363821e-07 0.952512626585 7.62195121951e-07 1.2 7.62226880081e-07 1.44748737341 7.62258638211e-07 1.55 7.62290396341e-07 1.44748737341 7.62322154472e-07 1.2 7.62353912602e-07 0.952512626585 7.62385670732e-07 0.85 7.62417428862e-07 0.952512626585 7.62449186992e-07 1.2 7.62480945122e-07 1.44748737341 7.62512703252e-07 1.55 7.62544461382e-07 1.44748737342 7.62576219512e-07 1.2 7.62607977642e-07 0.952512626585 7.62639735772e-07 0.85 7.62671493902e-07 0.952512626585 7.62703252033e-07 1.2 7.62735010163e-07 1.44748737342 7.62766768293e-07 1.55 7.62798526423e-07 1.44748737342 7.62830284553e-07 1.2 7.62862042683e-07 0.952512626585 7.62893800813e-07 0.85 7.62925558943e-07 0.952512626585 7.62957317073e-07 1.2 7.62989075203e-07 1.44748737342 7.63020833333e-07 1.55 7.63052591463e-07 1.44748737342 7.63084349593e-07 1.2 7.63116107724e-07 0.952512626585 7.63147865854e-07 0.85 7.63179623984e-07 0.952512626585 7.63211382114e-07 1.2 7.63243140244e-07 1.44748737342 7.63274898374e-07 1.55 7.63306656504e-07 1.44748737341 7.63338414634e-07 1.2 7.63370172764e-07 0.952512626585 7.63401930894e-07 0.85 7.63433689024e-07 0.952512626585 7.63465447154e-07 1.2 7.63497205285e-07 1.44748737341 7.63528963415e-07 1.55 7.63560721545e-07 1.44748737341 7.63592479675e-07 1.2 7.63624237805e-07 0.952512626585 7.63655995935e-07 0.85 7.63687754065e-07 0.952512626585 7.63719512195e-07 1.2 7.63751270325e-07 1.44748737341 7.63783028455e-07 1.55 7.63814786585e-07 1.44748737342 7.63846544715e-07 1.2 7.63878302846e-07 0.952512626585 7.63910060976e-07 0.85 7.63941819106e-07 0.952512626585 7.63973577236e-07 1.2 7.64005335366e-07 1.44748737341 7.64037093496e-07 1.55 7.64068851626e-07 1.44748737342 7.64100609756e-07 1.2 7.64132367886e-07 0.952512626585 7.64164126016e-07 0.85 7.64195884146e-07 0.952512626585 7.64227642276e-07 1.2 7.64259400407e-07 1.44748737342 7.64291158537e-07 1.55 7.64322916667e-07 1.44748737342 7.64354674797e-07 1.2 7.64386432927e-07 0.952512626585 7.64418191057e-07 0.85 7.64449949187e-07 0.952512626584 7.64481707317e-07 1.2 7.64513465447e-07 1.44748737342 7.64545223577e-07 1.55 7.64576981707e-07 1.44748737342 7.64608739837e-07 1.2 7.64640497967e-07 0.952512626585 7.64672256098e-07 0.85 7.64704014228e-07 0.952512626585 7.64735772358e-07 1.2 7.64767530488e-07 1.44748737342 7.64799288618e-07 1.55 7.64831046748e-07 1.44748737342 7.64862804878e-07 1.2 7.64894563008e-07 0.952512626585 7.64926321138e-07 0.85 7.64958079268e-07 0.952512626585 7.64989837398e-07 1.2 7.65021595528e-07 1.44748737342 7.65053353659e-07 1.55 7.65085111789e-07 1.44748737342 7.65116869919e-07 1.2 7.65148628049e-07 0.952512626585 7.65180386179e-07 0.85 7.65212144309e-07 0.952512626585 7.65243902439e-07 1.2 7.65275660569e-07 1.44748737342 7.65307418699e-07 1.55 7.65339176829e-07 1.44748737342 7.65370934959e-07 1.2 7.65402693089e-07 0.952512626585 7.6543445122e-07 0.85 7.6546620935e-07 0.952512626584 7.6549796748e-07 1.2 7.6552972561e-07 1.44748737342 7.6556148374e-07 1.55 7.6559324187e-07 1.44748737342 7.65625e-07 1.2 7.6565675813e-07 0.952512626584 7.6568851626e-07 0.85 7.6572027439e-07 0.952512626584 7.6575203252e-07 1.2 7.6578379065e-07 1.44748737342 7.6581554878e-07 1.55 7.65847306911e-07 1.44748737342 7.65879065041e-07 1.2 7.65910823171e-07 0.952512626584 7.65942581301e-07 0.85 7.65974339431e-07 0.952512626585 7.66006097561e-07 1.2 7.66037855691e-07 1.44748737342 7.66069613821e-07 1.55 7.66101371951e-07 1.44748737342 7.66133130081e-07 1.2 7.66164888211e-07 0.952512626584 7.66196646341e-07 0.85 7.66228404472e-07 0.952512626585 7.66260162602e-07 1.2 7.66291920732e-07 1.44748737342 7.66323678862e-07 1.55 7.66355436992e-07 1.44748737342 7.66387195122e-07 1.2 7.66418953252e-07 0.952512626585 7.66450711382e-07 0.85 7.66482469512e-07 0.952512626585 7.66514227642e-07 1.2 7.66545985772e-07 1.44748737342 7.66577743902e-07 1.55 7.66609502033e-07 1.44748737342 7.66641260163e-07 1.2 7.66673018293e-07 0.952512626585 7.66704776423e-07 0.85 7.66736534553e-07 0.952512626584 7.66768292683e-07 1.2 7.66800050813e-07 1.44748737342 7.66831808943e-07 1.55 7.66863567073e-07 1.44748737342 7.66895325203e-07 1.2 7.66927083333e-07 0.952512626585 7.66958841463e-07 0.85 7.66990599593e-07 0.952512626584 7.67022357724e-07 1.2 7.67054115854e-07 1.44748737342 7.67085873984e-07 1.55 7.67117632114e-07 1.44748737342 7.67149390244e-07 1.2 7.67181148374e-07 0.952512626584 7.67212906504e-07 0.85 7.67244664634e-07 0.952512626584 7.67276422764e-07 1.2 7.67308180894e-07 1.44748737342 7.67339939024e-07 1.55 7.67371697154e-07 1.44748737342 7.67403455285e-07 1.2 7.67435213415e-07 0.952512626584 7.67466971545e-07 0.85 7.67498729675e-07 0.952512626585 7.67530487805e-07 1.2 7.67562245935e-07 1.44748737342 7.67594004065e-07 1.55 7.67625762195e-07 1.44748737342 7.67657520325e-07 1.2 7.67689278455e-07 0.952512626585 7.67721036585e-07 0.85 7.67752794715e-07 0.952512626585 7.67784552846e-07 1.2 7.67816310976e-07 1.44748737342 7.67848069106e-07 1.55 7.67879827236e-07 1.44748737342 7.67911585366e-07 1.2 7.67943343496e-07 0.952512626585 7.67975101626e-07 0.85 7.68006859756e-07 0.952512626584 7.68038617886e-07 1.2 7.68070376016e-07 1.44748737342 7.68102134146e-07 1.55 7.68133892276e-07 1.44748737342 7.68165650407e-07 1.2 7.68197408537e-07 0.952512626585 7.68229166667e-07 0.85 7.68260924797e-07 0.952512626584 7.68292682927e-07 1.2 7.68324441057e-07 1.44748737342 7.68356199187e-07 1.55 7.68387957317e-07 1.44748737342 7.68419715447e-07 1.2 7.68451473577e-07 0.952512626584 7.68483231707e-07 0.85 7.68514989837e-07 0.952512626584 7.68546747967e-07 1.2 7.68578506098e-07 1.44748737342 7.68610264228e-07 1.55 7.68642022358e-07 1.44748737342 7.68673780488e-07 1.2 7.68705538618e-07 0.952512626585 7.68737296748e-07 0.85 7.68769054878e-07 0.952512626585 7.68800813008e-07 1.2 7.68832571138e-07 1.44748737342 7.68864329268e-07 1.55 7.68896087398e-07 1.44748737341 7.68927845528e-07 1.2 7.68959603659e-07 0.952512626585 7.68991361789e-07 0.85 7.69023119919e-07 0.952512626585 7.69054878049e-07 1.2 7.69086636179e-07 1.44748737342 7.69118394309e-07 1.55 7.69150152439e-07 1.44748737342 7.69181910569e-07 1.2 7.69213668699e-07 0.952512626585 7.69245426829e-07 0.85 7.69277184959e-07 0.952512626585 7.69308943089e-07 1.2 7.6934070122e-07 1.44748737341 7.6937245935e-07 1.55 7.6940421748e-07 1.44748737342 7.6943597561e-07 1.2 7.6946773374e-07 0.952512626585 7.6949949187e-07 0.85 7.6953125e-07 0.952512626585 7.6956300813e-07 1.2 7.6959476626e-07 1.44748737341 7.6962652439e-07 1.55 7.6965828252e-07 1.44748737342 7.6969004065e-07 1.2 7.6972179878e-07 0.952512626585 7.69753556911e-07 0.85 7.69785315041e-07 0.952512626585 7.69817073171e-07 1.2 7.69848831301e-07 1.44748737342 7.69880589431e-07 1.55 7.69912347561e-07 1.44748737342 7.69944105691e-07 1.2 7.69975863821e-07 0.952512626585 7.70007621951e-07 0.85 7.70039380081e-07 0.952512626585 7.70071138211e-07 1.2 7.70102896341e-07 1.44748737342 7.70134654472e-07 1.55 7.70166412602e-07 1.44748737342 7.70198170732e-07 1.2 7.70229928862e-07 0.952512626585 7.70261686992e-07 0.85 7.70293445122e-07 0.952512626585 7.70325203252e-07 1.2 7.70356961382e-07 1.44748737342 7.70388719512e-07 1.55 7.70420477642e-07 1.44748737341 7.70452235772e-07 1.2 7.70483993902e-07 0.952512626585 7.70515752033e-07 0.85 7.70547510163e-07 0.952512626585 7.70579268293e-07 1.2 7.70611026423e-07 1.44748737341 7.70642784553e-07 1.55 7.70674542683e-07 1.44748737341 7.70706300813e-07 1.2 7.70738058943e-07 0.952512626585 7.70769817073e-07 0.85 7.70801575203e-07 0.952512626585 7.70833333333e-07 1.2 7.70865091463e-07 1.44748737341 7.70896849593e-07 1.55 7.70928607724e-07 1.44748737342 7.70960365854e-07 1.2 7.70992123984e-07 0.952512626585 7.71023882114e-07 0.85 7.71055640244e-07 0.952512626585 7.71087398374e-07 1.2 7.71119156504e-07 1.44748737342 7.71150914634e-07 1.55 7.71182672764e-07 1.44748737342 7.71214430894e-07 1.2 7.71246189024e-07 0.952512626585 7.71277947154e-07 0.85 7.71309705285e-07 0.952512626585 7.71341463415e-07 1.2 7.71373221545e-07 1.44748737342 7.71404979675e-07 1.55 7.71436737805e-07 1.44748737342 7.71468495935e-07 1.2 7.71500254065e-07 0.952512626585 7.71532012195e-07 0.85 7.71563770325e-07 0.952512626585 7.71595528455e-07 1.2 7.71627286585e-07 1.44748737342 7.71659044715e-07 1.55 7.71690802846e-07 1.44748737341 7.71722560976e-07 1.2 7.71754319106e-07 0.952512626585 7.71786077236e-07 0.85 7.71817835366e-07 0.952512626585 7.71849593496e-07 1.2 7.71881351626e-07 1.44748737341 7.71913109756e-07 1.55 7.71944867886e-07 1.44748737341 7.71976626016e-07 1.2 7.72008384146e-07 0.952512626585 7.72040142276e-07 0.85 7.72071900407e-07 0.952512626585 7.72103658537e-07 1.2 7.72135416667e-07 1.44748737341 7.72167174797e-07 1.55 7.72198932927e-07 1.44748737342 7.72230691057e-07 1.2 7.72262449187e-07 0.952512626585 7.72294207317e-07 0.85 7.72325965447e-07 0.952512626585 7.72357723577e-07 1.2 7.72389481707e-07 1.44748737341 7.72421239837e-07 1.55 7.72452997967e-07 1.44748737342 7.72484756098e-07 1.2 7.72516514228e-07 0.952512626585 7.72548272358e-07 0.85 7.72580030488e-07 0.952512626585 7.72611788618e-07 1.2 7.72643546748e-07 1.44748737342 7.72675304878e-07 1.55 7.72707063008e-07 1.44748737342 7.72738821138e-07 1.2 7.72770579268e-07 0.952512626585 7.72802337398e-07 0.85 7.72834095528e-07 0.952512626584 7.72865853659e-07 1.2 7.72897611789e-07 1.44748737342 7.72929369919e-07 1.55 7.72961128049e-07 1.44748737342 7.72992886179e-07 1.2 7.73024644309e-07 0.952512626585 7.73056402439e-07 0.85 7.73088160569e-07 0.952512626585 7.73119918699e-07 1.2 7.73151676829e-07 1.44748737342 7.73183434959e-07 1.55 7.73215193089e-07 1.44748737342 7.7324695122e-07 1.2 7.7327870935e-07 0.952512626585 7.7331046748e-07 0.85 7.7334222561e-07 0.952512626585 7.7337398374e-07 1.2 7.7340574187e-07 1.44748737342 7.734375e-07 1.55 7.7346925813e-07 1.44748737342 7.7350101626e-07 1.2 7.7353277439e-07 0.952512626585 7.7356453252e-07 0.85 7.7359629065e-07 0.952512626585 7.7362804878e-07 1.2 7.73659806911e-07 1.44748737342 7.73691565041e-07 1.55 7.73723323171e-07 1.44748737342 7.73755081301e-07 1.2 7.73786839431e-07 0.952512626585 7.73818597561e-07 0.85 7.73850355691e-07 0.952512626584 7.73882113821e-07 1.2 7.73913871951e-07 1.44748737342 7.73945630081e-07 1.55 7.73977388211e-07 1.44748737342 7.74009146341e-07 1.2 7.74040904472e-07 0.952512626584 7.74072662602e-07 0.85 7.74104420732e-07 0.952512626584 7.74136178862e-07 1.2 7.74167936992e-07 1.44748737342 7.74199695122e-07 1.55 7.74231453252e-07 1.44748737342 7.74263211382e-07 1.2 7.74294969512e-07 0.952512626584 7.74326727642e-07 0.85 7.74358485772e-07 0.952512626585 7.74390243902e-07 1.2 7.74422002033e-07 1.44748737342 7.74453760163e-07 1.55 7.74485518293e-07 1.44748737342 7.74517276423e-07 1.2 7.74549034553e-07 0.952512626584 7.74580792683e-07 0.85 7.74612550813e-07 0.952512626585 7.74644308943e-07 1.2 7.74676067073e-07 1.44748737342 7.74707825203e-07 1.55 7.74739583333e-07 1.44748737342 7.74771341463e-07 1.2 7.74803099593e-07 0.952512626585 7.74834857724e-07 0.85 7.74866615854e-07 0.952512626585 7.74898373984e-07 1.2 7.74930132114e-07 1.44748737342 7.74961890244e-07 1.55 7.74993648374e-07 1.44748737342 7.75025406504e-07 1.2 7.75057164634e-07 0.952512626585 7.75088922764e-07 0.85 7.75120680894e-07 0.952512626584 7.75152439024e-07 1.2 7.75184197154e-07 1.44748737342 7.75215955285e-07 1.55 7.75247713415e-07 1.44748737342 7.75279471545e-07 1.2 7.75311229675e-07 0.952512626585 7.75342987805e-07 0.85 7.75374745935e-07 0.952512626584 7.75406504065e-07 1.2 7.75438262195e-07 1.44748737342 7.75470020325e-07 1.55 7.75501778455e-07 1.44748737342 7.75533536585e-07 1.2 7.75565294715e-07 0.952512626584 7.75597052846e-07 0.85 7.75628810976e-07 0.952512626584 7.75660569106e-07 1.2 7.75692327236e-07 1.44748737342 7.75724085366e-07 1.55 7.75755843496e-07 1.44748737342 7.75787601626e-07 1.2 7.75819359756e-07 0.952512626584 7.75851117886e-07 0.85 7.75882876016e-07 0.952512626585 7.75914634146e-07 1.2 7.75946392276e-07 1.44748737342 7.75978150407e-07 1.55 7.76009908537e-07 1.44748737342 7.76041666667e-07 1.2 7.76073424797e-07 0.952512626585 7.76105182927e-07 0.85 7.76136941057e-07 0.952512626585 7.76168699187e-07 1.2 7.76200457317e-07 1.44748737342 7.76232215447e-07 1.55 7.76263973577e-07 1.44748737342 7.76295731707e-07 1.2 7.76327489837e-07 0.952512626585 7.76359247967e-07 0.85 7.76391006098e-07 0.952512626584 7.76422764228e-07 1.2 7.76454522358e-07 1.44748737342 7.76486280488e-07 1.55 7.76518038618e-07 1.44748737342 7.76549796748e-07 1.2 7.76581554878e-07 0.952512626585 7.76613313008e-07 0.85 7.76645071138e-07 0.952512626584 7.76676829268e-07 1.2 7.76708587398e-07 1.44748737342 7.76740345528e-07 1.55 7.76772103659e-07 1.44748737342 7.76803861789e-07 1.2 7.76835619919e-07 0.952512626584 7.76867378049e-07 0.85 7.76899136179e-07 0.952512626584 7.76930894309e-07 1.2 7.76962652439e-07 1.44748737342 7.76994410569e-07 1.55 7.77026168699e-07 1.44748737342 7.77057926829e-07 1.2 7.77089684959e-07 0.952512626585 7.77121443089e-07 0.85 7.7715320122e-07 0.952512626585 7.7718495935e-07 1.2 7.7721671748e-07 1.44748737342 7.7724847561e-07 1.55 7.7728023374e-07 1.44748737341 7.7731199187e-07 1.2 7.7734375e-07 0.952512626585 7.7737550813e-07 0.85 7.7740726626e-07 0.952512626585 7.7743902439e-07 1.2 7.7747078252e-07 1.44748737342 7.7750254065e-07 1.55 7.7753429878e-07 1.44748737341 7.77566056911e-07 1.2 7.77597815041e-07 0.952512626585 7.77629573171e-07 0.85 7.77661331301e-07 0.952512626585 7.77693089431e-07 1.2 7.77724847561e-07 1.44748737341 7.77756605691e-07 1.55 7.77788363821e-07 1.44748737342 7.77820121951e-07 1.2 7.77851880081e-07 0.952512626585 7.77883638211e-07 0.85 7.77915396341e-07 0.952512626585 7.77947154472e-07 1.2 7.77978912602e-07 1.44748737341 7.78010670732e-07 1.55 7.78042428862e-07 1.44748737342 7.78074186992e-07 1.2 7.78105945122e-07 0.952512626585 7.78137703252e-07 0.85 7.78169461382e-07 0.952512626585 7.78201219512e-07 1.2 7.78232977642e-07 1.44748737342 7.78264735772e-07 1.55 7.78296493902e-07 1.44748737342 7.78328252033e-07 1.2 7.78360010163e-07 0.952512626585 7.78391768293e-07 0.85 7.78423526423e-07 0.952512626585 7.78455284553e-07 1.2 7.78487042683e-07 1.44748737342 7.78518800813e-07 1.55 7.78550558943e-07 1.44748737342 7.78582317073e-07 1.2 7.78614075203e-07 0.952512626585 7.78645833333e-07 0.85 7.78677591463e-07 0.952512626585 7.78709349593e-07 1.2 7.78741107724e-07 1.44748737342 7.78772865854e-07 1.55 7.78804623984e-07 1.44748737341 7.78836382114e-07 1.2 7.78868140244e-07 0.952512626585 7.78899898374e-07 0.85 7.78931656504e-07 0.952512626585 7.78963414634e-07 1.2 7.78995172764e-07 1.44748737341 7.79026930894e-07 1.55 7.79058689024e-07 1.44748737341 7.79090447154e-07 1.2 7.79122205285e-07 0.952512626585 7.79153963415e-07 0.85 7.79185721545e-07 0.952512626585 7.79217479675e-07 1.2 7.79249237805e-07 1.44748737341 7.79280995935e-07 1.55 7.79312754065e-07 1.44748737342 7.79344512195e-07 1.2 7.79376270325e-07 0.952512626585 7.79408028455e-07 0.85 7.79439786585e-07 0.952512626585 7.79471544715e-07 1.2 7.79503302846e-07 1.44748737342 7.79535060976e-07 1.55 7.79566819106e-07 1.44748737342 7.79598577236e-07 1.2 7.79630335366e-07 0.952512626585 7.79662093496e-07 0.85 7.79693851626e-07 0.952512626585 7.79725609756e-07 1.2 7.79757367886e-07 1.44748737342 7.79789126016e-07 1.55 7.79820884146e-07 1.44748737342 7.79852642276e-07 1.2 7.79884400407e-07 0.952512626585 7.79916158537e-07 0.85 7.79947916667e-07 0.952512626585 7.79979674797e-07 1.2 7.80011432927e-07 1.44748737342 7.80043191057e-07 1.55 7.80074949187e-07 1.44748737341 7.80106707317e-07 1.2 7.80138465447e-07 0.952512626585 7.80170223577e-07 0.85 7.80201981707e-07 0.952512626585 7.80233739837e-07 1.2 7.80265497967e-07 1.44748737341 7.80297256098e-07 1.55 7.80329014228e-07 1.44748737341 7.80360772358e-07 1.2 7.80392530488e-07 0.952512626585 7.80424288618e-07 0.85 7.80456046748e-07 0.952512626585 7.80487804878e-07 1.2 7.80519563008e-07 1.44748737341 7.80551321138e-07 1.55 7.80583079268e-07 1.44748737342 7.80614837398e-07 1.2 7.80646595528e-07 0.952512626585 7.80678353659e-07 0.85 7.80710111789e-07 0.952512626585 7.80741869919e-07 1.2 7.80773628049e-07 1.44748737341 7.80805386179e-07 1.55 7.80837144309e-07 1.44748737342 7.80868902439e-07 1.2 7.80900660569e-07 0.952512626585 7.80932418699e-07 0.85 7.80964176829e-07 0.952512626584 7.80995934959e-07 1.2 7.81027693089e-07 1.44748737342 7.8105945122e-07 1.55 7.8109120935e-07 1.44748737342 7.8112296748e-07 1.2 7.8115472561e-07 0.952512626584 7.8118648374e-07 0.85 7.8121824187e-07 0.952512626584 7.8125e-07 1.2 7.8128175813e-07 1.44748737342 7.8131351626e-07 1.55 7.8134527439e-07 1.44748737342 7.8137703252e-07 1.2 7.8140879065e-07 0.952512626585 7.8144054878e-07 0.85 7.81472306911e-07 0.952512626585 7.81504065041e-07 1.2 7.81535823171e-07 1.44748737342 7.81567581301e-07 1.55 7.81599339431e-07 1.44748737342 7.81631097561e-07 1.2 7.81662855691e-07 0.952512626585 7.81694613821e-07 0.85 7.81726371951e-07 0.952512626585 7.81758130081e-07 1.2 7.81789888211e-07 1.44748737342 7.81821646341e-07 1.55 7.81853404472e-07 1.44748737342 7.81885162602e-07 1.2 7.81916920732e-07 0.952512626585 7.81948678862e-07 0.85 7.81980436992e-07 0.952512626585 7.82012195122e-07 1.2 7.82043953252e-07 1.44748737342 7.82075711382e-07 1.55 7.82107469512e-07 1.44748737342 7.82139227642e-07 1.2 7.82170985772e-07 0.952512626585 7.82202743902e-07 0.85 7.82234502033e-07 0.952512626584 7.82266260163e-07 1.2 7.82298018293e-07 1.44748737342 7.82329776423e-07 1.55 7.82361534553e-07 1.44748737342 7.82393292683e-07 1.2 7.82425050813e-07 0.952512626584 7.82456808943e-07 0.85 7.82488567073e-07 0.952512626584 7.82520325203e-07 1.2 7.82552083333e-07 1.44748737342 7.82583841463e-07 1.55 7.82615599593e-07 1.44748737342 7.82647357724e-07 1.2 7.82679115854e-07 0.952512626584 7.82710873984e-07 0.85 7.82742632114e-07 0.952512626585 7.82774390244e-07 1.2 7.82806148374e-07 1.44748737342 7.82837906504e-07 1.55 7.82869664634e-07 1.44748737342 7.82901422764e-07 1.2 7.82933180894e-07 0.952512626584 7.82964939024e-07 0.85 7.82996697154e-07 0.952512626585 7.83028455285e-07 1.2 7.83060213415e-07 1.44748737342 7.83091971545e-07 1.55 7.83123729675e-07 1.44748737342 7.83155487805e-07 1.2 7.83187245935e-07 0.952512626585 7.83219004065e-07 0.85 7.83250762195e-07 0.952512626585 7.83282520325e-07 1.2 7.83314278455e-07 1.44748737342 7.83346036585e-07 1.55 7.83377794715e-07 1.44748737342 7.83409552846e-07 1.2 7.83441310976e-07 0.952512626585 7.83473069106e-07 0.85 7.83504827236e-07 0.952512626584 7.83536585366e-07 1.2 7.83568343496e-07 1.44748737342 7.83600101626e-07 1.55 7.83631859756e-07 1.44748737342 7.83663617886e-07 1.2 7.83695376016e-07 0.952512626585 7.83727134146e-07 0.85 7.83758892276e-07 0.952512626584 7.83790650407e-07 1.2 7.83822408537e-07 1.44748737342 7.83854166667e-07 1.55 7.83885924797e-07 1.44748737342 7.83917682927e-07 1.2 7.83949441057e-07 0.952512626584 7.83981199187e-07 0.85 7.84012957317e-07 0.952512626584 7.84044715447e-07 1.2 7.84076473577e-07 1.44748737342 7.84108231707e-07 1.55 7.84139989837e-07 1.44748737342 7.84171747967e-07 1.2 7.84203506098e-07 0.952512626584 7.84235264228e-07 0.85 7.84267022358e-07 0.952512626585 7.84298780488e-07 1.2 7.84330538618e-07 1.44748737342 7.84362296748e-07 1.55 7.84394054878e-07 1.44748737342 7.84425813008e-07 1.2 7.84457571138e-07 0.952512626585 7.84489329268e-07 0.85 7.84521087398e-07 0.952512626585 7.84552845528e-07 1.2 7.84584603659e-07 1.44748737342 7.84616361789e-07 1.55 7.84648119919e-07 1.44748737342 7.84679878049e-07 1.2 7.84711636179e-07 0.952512626585 7.84743394309e-07 0.85 7.84775152439e-07 0.952512626585 7.84806910569e-07 1.2 7.84838668699e-07 1.44748737341 7.84870426829e-07 1.55 7.84902184959e-07 1.44748737342 7.84933943089e-07 1.2 7.8496570122e-07 0.952512626585 7.8499745935e-07 0.85 7.8502921748e-07 0.952512626584 7.8506097561e-07 1.2 7.8509273374e-07 1.44748737342 7.8512449187e-07 1.55 7.8515625e-07 1.44748737342 7.8518800813e-07 1.2 7.8521976626e-07 0.952512626584 7.8525152439e-07 0.85 7.8528328252e-07 0.952512626584 7.8531504065e-07 1.2 7.8534679878e-07 1.44748737342 7.85378556911e-07 1.55 7.85410315041e-07 1.44748737342 7.85442073171e-07 1.2 7.85473831301e-07 0.952512626585 7.85505589431e-07 0.85 7.85537347561e-07 0.952512626585 7.85569105691e-07 1.2 7.85600863821e-07 1.44748737342 7.85632621951e-07 1.55 7.85664380081e-07 1.44748737341 7.85696138211e-07 1.2 7.85727896341e-07 0.952512626585 7.85759654472e-07 0.85 7.85791412602e-07 0.952512626585 7.85823170732e-07 1.2 7.85854928862e-07 1.44748737342 7.85886686992e-07 1.55 7.85918445122e-07 1.44748737341 7.85950203252e-07 1.2 7.85981961382e-07 0.952512626585 7.86013719512e-07 0.85 7.86045477642e-07 0.952512626585 7.86077235772e-07 1.2 7.86108993902e-07 1.44748737341 7.86140752033e-07 1.55 7.86172510163e-07 1.44748737341 7.86204268293e-07 1.2 7.86236026423e-07 0.952512626585 7.86267784553e-07 0.85 7.86299542683e-07 0.952512626585 7.86331300813e-07 1.2 7.86363058943e-07 1.44748737341 7.86394817073e-07 1.55 7.86426575203e-07 1.44748737342 7.86458333333e-07 1.2 7.86490091463e-07 0.952512626585 7.86521849593e-07 0.85 7.86553607724e-07 0.952512626585 7.86585365854e-07 1.2 7.86617123984e-07 1.44748737342 7.86648882114e-07 1.55 7.86680640244e-07 1.44748737342 7.86712398374e-07 1.2 7.86744156504e-07 0.952512626585 7.86775914634e-07 0.85 7.86807672764e-07 0.952512626585 7.86839430894e-07 1.2 7.86871189024e-07 1.44748737342 7.86902947154e-07 1.55 7.86934705285e-07 1.44748737342 7.86966463415e-07 1.2 7.86998221545e-07 0.952512626585 7.87029979675e-07 0.85 7.87061737805e-07 0.952512626585 7.87093495935e-07 1.2 7.87125254065e-07 1.44748737342 7.87157012195e-07 1.55 7.87188770325e-07 1.44748737341 7.87220528455e-07 1.2 7.87252286585e-07 0.952512626585 7.87284044715e-07 0.85 7.87315802846e-07 0.952512626585 7.87347560976e-07 1.2 7.87379319106e-07 1.44748737341 7.87411077236e-07 1.55 7.87442835366e-07 1.44748737341 7.87474593496e-07 1.2 7.87506351626e-07 0.952512626585 7.87538109756e-07 0.85 7.87569867886e-07 0.952512626585 7.87601626016e-07 1.2 7.87633384146e-07 1.44748737341 7.87665142276e-07 1.55 7.87696900407e-07 1.44748737342 7.87728658537e-07 1.2 7.87760416667e-07 0.952512626585 7.87792174797e-07 0.85 7.87823932927e-07 0.952512626585 7.87855691057e-07 1.2 7.87887449187e-07 1.44748737342 7.87919207317e-07 1.55 7.87950965447e-07 1.44748737342 7.87982723577e-07 1.2 7.88014481707e-07 0.952512626585 7.88046239837e-07 0.85 7.88077997967e-07 0.952512626585 7.88109756098e-07 1.2 7.88141514228e-07 1.44748737342 7.88173272358e-07 1.55 7.88205030488e-07 1.44748737342 7.88236788618e-07 1.2 7.88268546748e-07 0.952512626585 7.88300304878e-07 0.85 7.88332063008e-07 0.952512626585 7.88363821138e-07 1.2 7.88395579268e-07 1.44748737342 7.88427337398e-07 1.55 7.88459095528e-07 1.44748737341 7.88490853659e-07 1.2 7.88522611789e-07 0.952512626585 7.88554369919e-07 0.85 7.88586128049e-07 0.952512626585 7.88617886179e-07 1.2 7.88649644309e-07 1.44748737342 7.88681402439e-07 1.55 7.88713160569e-07 1.44748737342 7.88744918699e-07 1.2 7.88776676829e-07 0.952512626585 7.88808434959e-07 0.85 7.88840193089e-07 0.952512626585 7.8887195122e-07 1.2 7.8890370935e-07 1.44748737341 7.8893546748e-07 1.55 7.8896722561e-07 1.44748737342 7.8899898374e-07 1.2 7.8903074187e-07 0.952512626585 7.890625e-07 0.85 7.8909425813e-07 0.952512626585 7.8912601626e-07 1.2 7.8915777439e-07 1.44748737341 7.8918953252e-07 1.55 7.8922129065e-07 1.44748737342 7.8925304878e-07 1.2 7.89284806911e-07 0.952512626585 7.89316565041e-07 0.85 7.89348323171e-07 0.952512626584 7.89380081301e-07 1.2 7.89411839431e-07 1.44748737342 7.89443597561e-07 1.55 7.89475355691e-07 1.44748737342 7.89507113821e-07 1.2 7.89538871951e-07 0.952512626584 7.89570630081e-07 0.85 7.89602388211e-07 0.952512626584 7.89634146341e-07 1.2 7.89665904472e-07 1.44748737342 7.89697662602e-07 1.55 7.89729420732e-07 1.44748737342 7.89761178862e-07 1.2 7.89792936992e-07 0.952512626584 7.89824695122e-07 0.85 7.89856453252e-07 0.952512626585 7.89888211382e-07 1.2 7.89919969512e-07 1.44748737342 7.89951727642e-07 1.55 7.89983485772e-07 1.44748737342 7.90015243902e-07 1.2 7.90047002033e-07 0.952512626585 7.90078760163e-07 0.85 7.90110518293e-07 0.952512626585 7.90142276423e-07 1.2 7.90174034553e-07 1.44748737342 7.90205792683e-07 1.55 7.90237550813e-07 1.44748737342 7.90269308943e-07 1.2 7.90301067073e-07 0.952512626585 7.90332825203e-07 0.85 7.90364583333e-07 0.952512626585 7.90396341463e-07 1.2 7.90428099593e-07 1.44748737342 7.90459857724e-07 1.55 7.90491615854e-07 1.44748737342 7.90523373984e-07 1.2 7.90555132114e-07 0.952512626585 7.90586890244e-07 0.85 7.90618648374e-07 0.952512626584 7.90650406504e-07 1.2 7.90682164634e-07 1.44748737342 7.90713922764e-07 1.55 7.90745680894e-07 1.44748737342 7.90777439024e-07 1.2 7.90809197154e-07 0.952512626584 7.90840955285e-07 0.85 7.90872713415e-07 0.952512626584 7.90904471545e-07 1.2 7.90936229675e-07 1.44748737342 7.90967987805e-07 1.55 7.90999745935e-07 1.44748737342 7.91031504065e-07 1.2 7.91063262195e-07 0.952512626584 7.91095020325e-07 0.85 7.91126778455e-07 0.952512626585 7.91158536585e-07 1.2 7.91190294715e-07 1.44748737342 7.91222052846e-07 1.55 7.91253810976e-07 1.44748737342 7.91285569106e-07 1.2 7.91317327236e-07 0.952512626584 7.91349085366e-07 0.85 7.91380843496e-07 0.952512626585 7.91412601626e-07 1.2 7.91444359756e-07 1.44748737342 7.91476117886e-07 1.55 7.91507876016e-07 1.44748737342 7.91539634146e-07 1.2 7.91571392276e-07 0.952512626585 7.91603150407e-07 0.85 7.91634908537e-07 0.952512626585 7.91666666667e-07 1.2 7.91698424797e-07 1.44748737342 7.91730182927e-07 1.55 7.91761941057e-07 1.44748737342 7.91793699187e-07 1.2 7.91825457317e-07 0.952512626585 7.91857215447e-07 0.85 7.91888973577e-07 0.952512626584 7.91920731707e-07 1.2 7.91952489837e-07 1.44748737342 7.91984247967e-07 1.55 7.92016006098e-07 1.44748737342 7.92047764228e-07 1.2 7.92079522358e-07 0.952512626585 7.92111280488e-07 0.85 7.92143038618e-07 0.952512626584 7.92174796748e-07 1.2 7.92206554878e-07 1.44748737342 7.92238313008e-07 1.55 7.92270071138e-07 1.44748737342 7.92301829268e-07 1.2 7.92333587398e-07 0.952512626584 7.92365345528e-07 0.85 7.92397103659e-07 0.952512626584 7.92428861789e-07 1.2 7.92460619919e-07 1.44748737342 7.92492378049e-07 1.55 7.92524136179e-07 1.44748737342 7.92555894309e-07 1.2 7.92587652439e-07 0.952512626585 7.92619410569e-07 0.85 7.92651168699e-07 0.952512626585 7.92682926829e-07 1.2 7.92714684959e-07 1.44748737342 7.92746443089e-07 1.55 7.9277820122e-07 1.44748737342 7.9280995935e-07 1.2 7.9284171748e-07 0.952512626585 7.9287347561e-07 0.85 7.9290523374e-07 0.952512626585 7.9293699187e-07 1.2 7.9296875e-07 1.44748737342 7.9300050813e-07 1.55 7.9303226626e-07 1.44748737342 7.9306402439e-07 1.2 7.9309578252e-07 0.952512626585 7.9312754065e-07 0.85 7.9315929878e-07 0.952512626585 7.93191056911e-07 1.2 7.93222815041e-07 1.44748737341 7.93254573171e-07 1.55 7.93286331301e-07 1.44748737342 7.93318089431e-07 1.2 7.93349847561e-07 0.952512626585 7.93381605691e-07 0.85 7.93413363821e-07 0.952512626585 7.93445121951e-07 1.2 7.93476880081e-07 1.44748737342 7.93508638211e-07 1.55 7.93540396341e-07 1.44748737342 7.93572154472e-07 1.2 7.93603912602e-07 0.952512626584 7.93635670732e-07 0.85 7.93667428862e-07 0.952512626584 7.93699186992e-07 1.2 7.93730945122e-07 1.44748737342 7.93762703252e-07 1.55 7.93794461382e-07 1.44748737342 7.93826219512e-07 1.2 7.93857977642e-07 0.952512626585 7.93889735772e-07 0.85 7.93921493902e-07 0.952512626585 7.93953252033e-07 1.2 7.93985010163e-07 1.44748737342 7.94016768293e-07 1.55 7.94048526423e-07 1.44748737341 7.94080284553e-07 1.2 7.94112042683e-07 0.952512626585 7.94143800813e-07 0.85 7.94175558943e-07 0.952512626585 7.94207317073e-07 1.2 7.94239075203e-07 1.44748737342 7.94270833333e-07 1.55 7.94302591463e-07 1.44748737341 7.94334349593e-07 1.2 7.94366107724e-07 0.952512626585 7.94397865854e-07 0.85 7.94429623984e-07 0.952512626585 7.94461382114e-07 1.2 7.94493140244e-07 1.44748737341 7.94524898374e-07 1.55 7.94556656504e-07 1.44748737341 7.94588414634e-07 1.2 7.94620172764e-07 0.952512626585 7.94651930894e-07 0.85 7.94683689024e-07 0.952512626585 7.94715447154e-07 1.2 7.94747205285e-07 1.44748737341 7.94778963415e-07 1.55 7.94810721545e-07 1.44748737342 7.94842479675e-07 1.2 7.94874237805e-07 0.952512626585 7.94905995935e-07 0.85 7.94937754065e-07 0.952512626585 7.94969512195e-07 1.2 7.95001270325e-07 1.44748737342 7.95033028455e-07 1.55 7.95064786585e-07 1.44748737342 7.95096544715e-07 1.2 7.95128302846e-07 0.952512626585 7.95160060976e-07 0.85 7.95191819106e-07 0.952512626585 7.95223577236e-07 1.2 7.95255335366e-07 1.44748737342 7.95287093496e-07 1.55 7.95318851626e-07 1.44748737342 7.95350609756e-07 1.2 7.95382367886e-07 0.952512626585 7.95414126016e-07 0.85 7.95445884146e-07 0.952512626585 7.95477642276e-07 1.2 7.95509400407e-07 1.44748737342 7.95541158537e-07 1.55 7.95572916667e-07 1.44748737341 7.95604674797e-07 1.2 7.95636432927e-07 0.952512626585 7.95668191057e-07 0.85 7.95699949187e-07 0.952512626585 7.95731707317e-07 1.2 7.95763465447e-07 1.44748737341 7.95795223577e-07 1.55 7.95826981707e-07 1.44748737341 7.95858739837e-07 1.2 7.95890497967e-07 0.952512626585 7.95922256098e-07 0.85 7.95954014228e-07 0.952512626585 7.95985772358e-07 1.2 7.96017530488e-07 1.44748737341 7.96049288618e-07 1.55 7.96081046748e-07 1.44748737342 7.96112804878e-07 1.2 7.96144563008e-07 0.952512626585 7.96176321138e-07 0.85 7.96208079268e-07 0.952512626585 7.96239837398e-07 1.2 7.96271595528e-07 1.44748737342 7.96303353659e-07 1.55 7.96335111789e-07 1.44748737342 7.96366869919e-07 1.2 7.96398628049e-07 0.952512626585 7.96430386179e-07 0.85 7.96462144309e-07 0.952512626584 7.96493902439e-07 1.2 7.96525660569e-07 1.44748737342 7.96557418699e-07 1.55 7.96589176829e-07 1.44748737342 7.96620934959e-07 1.2 7.96652693089e-07 0.952512626585 7.9668445122e-07 0.85 7.9671620935e-07 0.952512626584 7.9674796748e-07 1.2 7.9677972561e-07 1.44748737342 7.9681148374e-07 1.55 7.9684324187e-07 1.44748737341 7.96875e-07 1.2 7.9690675813e-07 0.952512626585 7.9693851626e-07 0.85 7.9697027439e-07 0.952512626585 7.9700203252e-07 1.2 7.9703379065e-07 1.44748737342 7.9706554878e-07 1.55 7.97097306911e-07 1.44748737342 7.97129065041e-07 1.2 7.97160823171e-07 0.952512626585 7.97192581301e-07 0.85 7.97224339431e-07 0.952512626585 7.97256097561e-07 1.2 7.97287855691e-07 1.44748737342 7.97319613821e-07 1.55 7.97351371951e-07 1.44748737342 7.97383130081e-07 1.2 7.97414888211e-07 0.952512626585 7.97446646341e-07 0.85 7.97478404472e-07 0.952512626585 7.97510162602e-07 1.2 7.97541920732e-07 1.44748737341 7.97573678862e-07 1.55 7.97605436992e-07 1.44748737342 7.97637195122e-07 1.2 7.97668953252e-07 0.952512626585 7.97700711382e-07 0.85 7.97732469512e-07 0.952512626584 7.97764227642e-07 1.2 7.97795985772e-07 1.44748737342 7.97827743902e-07 1.55 7.97859502033e-07 1.44748737342 7.97891260163e-07 1.2 7.97923018293e-07 0.952512626584 7.97954776423e-07 0.85 7.97986534553e-07 0.952512626584 7.98018292683e-07 1.2 7.98050050813e-07 1.44748737342 7.98081808943e-07 1.55 7.98113567073e-07 1.44748737342 7.98145325203e-07 1.2 7.98177083333e-07 0.952512626584 7.98208841463e-07 0.85 7.98240599593e-07 0.952512626585 7.98272357724e-07 1.2 7.98304115854e-07 1.44748737342 7.98335873984e-07 1.55 7.98367632114e-07 1.44748737342 7.98399390244e-07 1.2 7.98431148374e-07 0.952512626584 7.98462906504e-07 0.85 7.98494664634e-07 0.952512626585 7.98526422764e-07 1.2 7.98558180894e-07 1.44748737342 7.98589939024e-07 1.55 7.98621697154e-07 1.44748737342 7.98653455285e-07 1.2 7.98685213415e-07 0.952512626585 7.98716971545e-07 0.85 7.98748729675e-07 0.952512626585 7.98780487805e-07 1.2 7.98812245935e-07 1.44748737342 7.98844004065e-07 1.55 7.98875762195e-07 1.44748737342 7.98907520325e-07 1.2 7.98939278455e-07 0.952512626585 7.98971036585e-07 0.85 7.99002794715e-07 0.952512626584 7.99034552846e-07 1.2 7.99066310976e-07 1.44748737342 7.99098069106e-07 1.55 7.99129827236e-07 1.44748737342 7.99161585366e-07 1.2 7.99193343496e-07 0.952512626584 7.99225101626e-07 0.85 7.99256859756e-07 0.952512626584 7.99288617886e-07 1.2 7.99320376016e-07 1.44748737342 7.99352134146e-07 1.55 7.99383892276e-07 1.44748737342 7.99415650407e-07 1.2 7.99447408537e-07 0.952512626584 7.99479166667e-07 0.85 7.99510924797e-07 0.952512626584 7.99542682927e-07 1.2 7.99574441057e-07 1.44748737342 7.99606199187e-07 1.55 7.99637957317e-07 1.44748737342 7.99669715447e-07 1.2 7.99701473577e-07 0.952512626584 7.99733231707e-07 0.85 7.99764989837e-07 0.952512626585 7.99796747967e-07 1.2 7.99828506098e-07 1.44748737342 7.99860264228e-07 1.55 7.99892022358e-07 1.44748737342 7.99923780488e-07 1.2 7.99955538618e-07 0.952512626585 7.99987296748e-07 0.85 8.00019054878e-07 0.952512626585 8.00050813008e-07 1.2 8.00082571138e-07 1.44748737342 8.00114329268e-07 1.55 8.00146087398e-07 1.44748737342 8.00177845528e-07 1.2 8.00209603659e-07 0.952512626585 8.00241361789e-07 0.85 8.00273119919e-07 0.952512626584 8.00304878049e-07 1.2 8.00336636179e-07 1.44748737341 8.00368394309e-07 1.55 8.00400152439e-07 1.44748737342 8.00431910569e-07 1.2 8.00463668699e-07 0.952512626585 8.00495426829e-07 0.85 8.00527184959e-07 0.952512626584 8.00558943089e-07 1.2 8.0059070122e-07 1.44748737342 8.0062245935e-07 1.55 8.0065421748e-07 1.44748737342 8.0068597561e-07 1.2 8.0071773374e-07 0.952512626584 8.0074949187e-07 0.85 8.0078125e-07 0.952512626584 8.0081300813e-07 1.2 8.0084476626e-07 1.44748737342 8.0087652439e-07 1.55 8.0090828252e-07 1.44748737342 8.0094004065e-07 1.2 8.0097179878e-07 0.952512626585 8.01003556911e-07 0.85 8.01035315041e-07 0.952512626585 8.01067073171e-07 1.2 8.01098831301e-07 1.44748737342 8.01130589431e-07 1.55 8.01162347561e-07 1.44748737342 8.01194105691e-07 1.2 8.01225863821e-07 0.952512626585 8.01257621951e-07 0.85 8.01289380081e-07 0.952512626585 8.01321138211e-07 1.2 8.01352896341e-07 1.44748737342 8.01384654472e-07 1.55 8.01416412602e-07 1.44748737342 8.01448170732e-07 1.2 8.01479928862e-07 0.952512626585 8.01511686992e-07 0.85 8.01543445122e-07 0.952512626585 8.01575203252e-07 1.2 8.01606961382e-07 1.44748737341 8.01638719512e-07 1.55 8.01670477642e-07 1.44748737342 8.01702235772e-07 1.2 8.01733993902e-07 0.952512626585 8.01765752033e-07 0.85 8.01797510163e-07 0.952512626585 8.01829268293e-07 1.2 8.01861026423e-07 1.44748737342 8.01892784553e-07 1.55 8.01924542683e-07 1.44748737342 8.01956300813e-07 1.2 8.01988058943e-07 0.952512626584 8.02019817073e-07 0.85 8.02051575203e-07 0.952512626585 8.02083333333e-07 1.2 8.02115091463e-07 1.44748737342 8.02146849593e-07 1.55 8.02178607724e-07 1.44748737342 8.02210365854e-07 1.2 8.02242123984e-07 0.952512626585 8.02273882114e-07 0.85 8.02305640244e-07 0.952512626584 8.02337398374e-07 1.2 8.02369156504e-07 1.44748737342 8.02400914634e-07 1.55 8.02432672764e-07 1.44748737341 8.02464430894e-07 1.2 8.02496189024e-07 0.952512626585 8.02527947154e-07 0.85 8.02559705285e-07 0.952512626585 8.02591463415e-07 1.2 8.02623221545e-07 1.44748737342 8.02654979675e-07 1.55 8.02686737805e-07 1.44748737341 8.02718495935e-07 1.2 8.02750254065e-07 0.952512626585 8.02782012195e-07 0.85 8.02813770325e-07 0.952512626585 8.02845528455e-07 1.2 8.02877286585e-07 1.44748737341 8.02909044715e-07 1.55 8.02940802846e-07 1.44748737341 8.02972560976e-07 1.2 8.03004319106e-07 0.952512626585 8.03036077236e-07 0.85 8.03067835366e-07 0.952512626585 8.03099593496e-07 1.2 8.03131351626e-07 1.44748737341 8.03163109756e-07 1.55 8.03194867886e-07 1.44748737342 8.03226626016e-07 1.2 8.03258384146e-07 0.952512626585 8.03290142276e-07 0.85 8.03321900407e-07 0.952512626585 8.03353658537e-07 1.2 8.03385416667e-07 1.44748737342 8.03417174797e-07 1.55 8.03448932927e-07 1.44748737342 8.03480691057e-07 1.2 8.03512449187e-07 0.952512626585 8.03544207317e-07 0.85 8.03575965447e-07 0.952512626585 8.03607723577e-07 1.2 8.03639481707e-07 1.44748737342 8.03671239837e-07 1.55 8.03702997967e-07 1.44748737342 8.03734756098e-07 1.2 8.03766514228e-07 0.952512626585 8.03798272358e-07 0.85 8.03830030488e-07 0.952512626585 8.03861788618e-07 1.2 8.03893546748e-07 1.44748737342 8.03925304878e-07 1.55 8.03957063008e-07 1.44748737341 8.03988821138e-07 1.2 8.04020579268e-07 0.952512626585 8.04052337398e-07 0.85 8.04084095528e-07 0.952512626585 8.04115853659e-07 1.2 8.04147611789e-07 1.44748737341 8.04179369919e-07 1.55 8.04211128049e-07 1.44748737342 8.04242886179e-07 1.2 8.04274644309e-07 0.952512626585 8.04306402439e-07 0.85 8.04338160569e-07 0.952512626585 8.04369918699e-07 1.2 8.04401676829e-07 1.44748737341 8.04433434959e-07 1.55 8.04465193089e-07 1.44748737342 8.0449695122e-07 1.2 8.0452870935e-07 0.952512626585 8.0456046748e-07 0.85 8.0459222561e-07 0.952512626585 8.0462398374e-07 1.2 8.0465574187e-07 1.44748737342 8.046875e-07 1.55 8.0471925813e-07 1.44748737342 8.0475101626e-07 1.2 8.0478277439e-07 0.952512626585 8.0481453252e-07 0.85 8.0484629065e-07 0.952512626584 8.0487804878e-07 1.2 8.04909806911e-07 1.44748737342 8.04941565041e-07 1.55 8.04973323171e-07 1.44748737342 8.05005081301e-07 1.2 8.05036839431e-07 0.952512626585 8.05068597561e-07 0.85 8.05100355691e-07 0.952512626584 8.05132113821e-07 1.2 8.05163871951e-07 1.44748737342 8.05195630081e-07 1.55 8.05227388211e-07 1.44748737341 8.05259146341e-07 1.2 8.05290904472e-07 0.952512626585 8.05322662602e-07 0.85 8.05354420732e-07 0.952512626585 8.05386178862e-07 1.2 8.05417936992e-07 1.44748737342 8.05449695122e-07 1.55 8.05481453252e-07 1.44748737342 8.05513211382e-07 1.2 8.05544969512e-07 0.952512626585 8.05576727642e-07 0.85 8.05608485772e-07 0.952512626585 8.05640243902e-07 1.2 8.05672002033e-07 1.44748737342 8.05703760163e-07 1.55 8.05735518293e-07 1.44748737342 8.05767276423e-07 1.2 8.05799034553e-07 0.952512626585 8.05830792683e-07 0.85 8.05862550813e-07 0.952512626585 8.05894308943e-07 1.2 8.05926067073e-07 1.44748737341 8.05957825203e-07 1.55 8.05989583333e-07 1.44748737342 8.06021341463e-07 1.2 8.06053099593e-07 0.952512626585 8.06084857724e-07 0.85 8.06116615854e-07 0.952512626584 8.06148373984e-07 1.2 8.06180132114e-07 1.44748737342 8.06211890244e-07 1.55 8.06243648374e-07 1.44748737342 8.06275406504e-07 1.2 8.06307164634e-07 0.952512626584 8.06338922764e-07 0.85 8.06370680894e-07 0.952512626584 8.06402439024e-07 1.2 8.06434197154e-07 1.44748737342 8.06465955285e-07 1.55 8.06497713415e-07 1.44748737342 8.06529471545e-07 1.2 8.06561229675e-07 0.952512626584 8.06592987805e-07 0.85 8.06624745935e-07 0.952512626585 8.06656504065e-07 1.2 8.06688262195e-07 1.44748737342 8.06720020325e-07 1.55 8.06751778455e-07 1.44748737342 8.06783536585e-07 1.2 8.06815294715e-07 0.952512626584 8.06847052846e-07 0.85 8.06878810976e-07 0.952512626585 8.06910569106e-07 1.2 8.06942327236e-07 1.44748737342 8.06974085366e-07 1.55 8.07005843496e-07 1.44748737342 8.07037601626e-07 1.2 8.07069359756e-07 0.952512626585 8.07101117886e-07 0.85 8.07132876016e-07 0.952512626585 8.07164634146e-07 1.2 8.07196392276e-07 1.44748737342 8.07228150407e-07 1.55 8.07259908537e-07 1.44748737342 8.07291666667e-07 1.2 8.07323424797e-07 0.952512626585 8.07355182927e-07 0.85 8.07386941057e-07 0.952512626584 8.07418699187e-07 1.2 8.07450457317e-07 1.44748737342 8.07482215447e-07 1.55 8.07513973577e-07 1.44748737342 8.07545731707e-07 1.2 8.07577489837e-07 0.952512626584 8.07609247967e-07 0.85 8.07641006098e-07 0.952512626584 8.07672764228e-07 1.2 8.07704522358e-07 1.44748737342 8.07736280488e-07 1.55 8.07768038618e-07 1.44748737342 8.07799796748e-07 1.2 8.07831554878e-07 0.952512626584 8.07863313008e-07 0.85 8.07895071138e-07 0.952512626584 8.07926829268e-07 1.2 8.07958587398e-07 1.44748737342 8.07990345528e-07 1.55 8.08022103659e-07 1.44748737342 8.08053861789e-07 1.2 8.08085619919e-07 0.952512626585 8.08117378049e-07 0.85 8.08149136179e-07 0.952512626585 8.08180894309e-07 1.2 8.08212652439e-07 1.44748737342 8.08244410569e-07 1.55 8.08276168699e-07 1.44748737342 8.08307926829e-07 1.2 8.08339684959e-07 0.952512626585 8.08371443089e-07 0.85 8.0840320122e-07 0.952512626584 8.0843495935e-07 1.2 8.0846671748e-07 1.44748737342 8.0849847561e-07 1.55 8.0853023374e-07 1.44748737342 8.0856199187e-07 1.2 8.0859375e-07 0.952512626585 8.0862550813e-07 0.85 8.0865726626e-07 0.952512626584 8.0868902439e-07 1.2 8.0872078252e-07 1.44748737341 8.0875254065e-07 1.55 8.0878429878e-07 1.44748737342 8.08816056911e-07 1.2 8.08847815041e-07 0.952512626585 8.08879573171e-07 0.85 8.08911331301e-07 0.952512626584 8.08943089431e-07 1.2 8.08974847561e-07 1.44748737342 8.09006605691e-07 1.55 8.09038363821e-07 1.44748737342 8.09070121951e-07 1.2 8.09101880081e-07 0.952512626584 8.09133638211e-07 0.85 8.09165396341e-07 0.952512626584 8.09197154472e-07 1.2 8.09228912602e-07 1.44748737342 8.09260670732e-07 1.55 8.09292428862e-07 1.44748737342 8.09324186992e-07 1.2 8.09355945122e-07 0.952512626585 8.09387703252e-07 0.85 8.09419461382e-07 0.952512626585 8.09451219512e-07 1.2 8.09482977642e-07 1.44748737342 8.09514735772e-07 1.55 8.09546493902e-07 1.44748737341 8.09578252033e-07 1.2 8.09610010163e-07 0.952512626585 8.09641768293e-07 0.85 8.09673526423e-07 0.952512626585 8.09705284553e-07 1.2 8.09737042683e-07 1.44748737342 8.09768800813e-07 1.55 8.09800558943e-07 1.44748737342 8.09832317073e-07 1.2 8.09864075203e-07 0.952512626585 8.09895833333e-07 0.85 8.09927591463e-07 0.952512626585 8.09959349593e-07 1.2 8.09991107724e-07 1.44748737341 8.10022865854e-07 1.55 8.10054623984e-07 1.44748737342 8.10086382114e-07 1.2 8.10118140244e-07 0.952512626585 8.10149898374e-07 0.85 8.10181656504e-07 0.952512626585 8.10213414634e-07 1.2 8.10245172764e-07 1.44748737342 8.10276930894e-07 1.55 8.10308689024e-07 1.44748737342 8.10340447154e-07 1.2 8.10372205285e-07 0.952512626584 8.10403963415e-07 0.85 8.10435721545e-07 0.952512626585 8.10467479675e-07 1.2 8.10499237805e-07 1.44748737342 8.10530995935e-07 1.55 8.10562754065e-07 1.44748737342 8.10594512195e-07 1.2 8.10626270325e-07 0.952512626585 8.10658028455e-07 0.85 8.10689786585e-07 0.952512626585 8.10721544715e-07 1.2 8.10753302846e-07 1.44748737342 8.10785060976e-07 1.55 8.10816819106e-07 1.44748737341 8.10848577236e-07 1.2 8.10880335366e-07 0.952512626585 8.10912093496e-07 0.85 8.10943851626e-07 0.952512626585 8.10975609756e-07 1.2 8.11007367886e-07 1.44748737342 8.11039126016e-07 1.55 8.11070884146e-07 1.44748737341 8.11102642276e-07 1.2 8.11134400407e-07 0.952512626585 8.11166158537e-07 0.85 8.11197916667e-07 0.952512626585 8.11229674797e-07 1.2 8.11261432927e-07 1.44748737341 8.11293191057e-07 1.55 8.11324949187e-07 1.44748737341 8.11356707317e-07 1.2 8.11388465447e-07 0.952512626585 8.11420223577e-07 0.85 8.11451981707e-07 0.952512626585 8.11483739837e-07 1.2 8.11515497967e-07 1.44748737341 8.11547256098e-07 1.55 8.11579014228e-07 1.44748737342 8.11610772358e-07 1.2 8.11642530488e-07 0.952512626585 8.11674288618e-07 0.85 8.11706046748e-07 0.952512626585 8.11737804878e-07 1.2 8.11769563008e-07 1.44748737342 8.11801321138e-07 1.55 8.11833079268e-07 1.44748737342 8.11864837398e-07 1.2 8.11896595528e-07 0.952512626585 8.11928353659e-07 0.85 8.11960111789e-07 0.952512626585 8.11991869919e-07 1.2 8.12023628049e-07 1.44748737342 8.12055386179e-07 1.55 8.12087144309e-07 1.44748737342 8.12118902439e-07 1.2 8.12150660569e-07 0.952512626585 8.12182418699e-07 0.85 8.12214176829e-07 0.952512626585 8.12245934959e-07 1.2 8.12277693089e-07 1.44748737341 8.1230945122e-07 1.55 8.1234120935e-07 1.44748737341 8.1237296748e-07 1.2 8.1240472561e-07 0.952512626585 8.1243648374e-07 0.85 8.1246824187e-07 0.952512626585 8.125e-07 1.2 8.1253175813e-07 1.44748737341 8.1256351626e-07 1.55 8.1259527439e-07 1.44748737342 8.1262703252e-07 1.2 8.1265879065e-07 0.952512626585 8.1269054878e-07 0.85 8.12722306911e-07 0.952512626585 8.12754065041e-07 1.2 8.12785823171e-07 1.44748737341 8.12817581301e-07 1.55 8.12849339431e-07 1.44748737342 8.12881097561e-07 1.2 8.12912855691e-07 0.952512626585 8.12944613821e-07 0.85 8.12976371951e-07 0.952512626585 8.13008130081e-07 1.2 8.13039888211e-07 1.44748737342 8.13071646341e-07 1.55 8.13103404472e-07 1.44748737342 8.13135162602e-07 1.2 8.13166920732e-07 0.952512626584 8.13198678862e-07 0.85 8.13230436992e-07 0.952512626584 8.13262195122e-07 1.2 8.13293953252e-07 1.44748737342 8.13325711382e-07 1.55 8.13357469512e-07 1.44748737342 8.13389227642e-07 1.2 8.13420985772e-07 0.952512626585 8.13452743902e-07 0.85 8.13484502033e-07 0.952512626584 8.13516260163e-07 1.2 8.13548018293e-07 1.44748737342 8.13579776423e-07 1.55 8.13611534553e-07 1.44748737341 8.13643292683e-07 1.2 8.13675050813e-07 0.952512626585 8.13706808943e-07 0.85 8.13738567073e-07 0.952512626585 8.13770325203e-07 1.2 8.13802083333e-07 1.44748737342 8.13833841463e-07 1.55 8.13865599593e-07 1.44748737342 8.13897357724e-07 1.2 8.13929115854e-07 0.952512626585 8.13960873984e-07 0.85 8.13992632114e-07 0.952512626585 8.14024390244e-07 1.2 8.14056148374e-07 1.44748737342 8.14087906504e-07 1.55 8.14119664634e-07 1.44748737342 8.14151422764e-07 1.2 8.14183180894e-07 0.952512626585 8.14214939024e-07 0.85 8.14246697154e-07 0.952512626585 8.14278455285e-07 1.2 8.14310213415e-07 1.44748737342 8.14341971545e-07 1.55 8.14373729675e-07 1.44748737342 8.14405487805e-07 1.2 8.14437245935e-07 0.952512626585 8.14469004065e-07 0.85 8.14500762195e-07 0.952512626584 8.14532520325e-07 1.2 8.14564278455e-07 1.44748737342 8.14596036585e-07 1.55 8.14627794715e-07 1.44748737342 8.14659552846e-07 1.2 8.14691310976e-07 0.952512626584 8.14723069106e-07 0.85 8.14754827236e-07 0.952512626584 8.14786585366e-07 1.2 8.14818343496e-07 1.44748737342 8.14850101626e-07 1.55 8.14881859756e-07 1.44748737342 8.14913617886e-07 1.2 8.14945376016e-07 0.952512626584 8.14977134146e-07 0.85 8.15008892276e-07 0.952512626585 8.15040650407e-07 1.2 8.15072408537e-07 1.44748737342 8.15104166667e-07 1.55 8.15135924797e-07 1.44748737342 8.15167682927e-07 1.2 8.15199441057e-07 0.952512626584 8.15231199187e-07 0.85 8.15262957317e-07 0.952512626585 8.15294715447e-07 1.2 8.15326473577e-07 1.44748737342 8.15358231707e-07 1.55 8.15389989837e-07 1.44748737342 8.15421747967e-07 1.2 8.15453506098e-07 0.952512626585 8.15485264228e-07 0.85 8.15517022358e-07 0.952512626585 8.15548780488e-07 1.2 8.15580538618e-07 1.44748737342 8.15612296748e-07 1.55 8.15644054878e-07 1.44748737342 8.15675813008e-07 1.2 8.15707571138e-07 0.952512626585 8.15739329268e-07 0.85 8.15771087398e-07 0.952512626584 8.15802845528e-07 1.2 8.15834603659e-07 1.44748737342 8.15866361789e-07 1.55 8.15898119919e-07 1.44748737342 8.15929878049e-07 1.2 8.15961636179e-07 0.952512626584 8.15993394309e-07 0.85 8.16025152439e-07 0.952512626584 8.16056910569e-07 1.2 8.16088668699e-07 1.44748737342 8.16120426829e-07 1.55 8.16152184959e-07 1.44748737342 8.16183943089e-07 1.2 8.1621570122e-07 0.952512626584 8.1624745935e-07 0.85 8.1627921748e-07 0.952512626584 8.1631097561e-07 1.2 8.1634273374e-07 1.44748737342 8.1637449187e-07 1.55 8.1640625e-07 1.44748737342 8.1643800813e-07 1.2 8.1646976626e-07 0.952512626585 8.1650152439e-07 0.85 8.1653328252e-07 0.952512626585 8.1656504065e-07 1.2 8.1659679878e-07 1.44748737342 8.16628556911e-07 1.55 8.16660315041e-07 1.44748737342 8.16692073171e-07 1.2 8.16723831301e-07 0.952512626585 8.16755589431e-07 0.85 8.16787347561e-07 0.952512626585 8.16819105691e-07 1.2 8.16850863821e-07 1.44748737342 8.16882621951e-07 1.55 8.16914380081e-07 1.44748737342 8.16946138211e-07 1.2 8.16977896341e-07 0.952512626585 8.17009654472e-07 0.85 8.17041412602e-07 0.952512626584 8.17073170732e-07 1.2 8.17104928862e-07 1.44748737341 8.17136686992e-07 1.55 8.17168445122e-07 1.44748737342 8.17200203252e-07 1.2 8.17231961382e-07 0.952512626585 8.17263719512e-07 0.85 8.17295477642e-07 0.952512626584 8.17327235772e-07 1.2 8.17358993902e-07 1.44748737342 8.17390752033e-07 1.55 8.17422510163e-07 1.44748737342 8.17454268293e-07 1.2 8.17486026423e-07 0.952512626584 8.17517784553e-07 0.85 8.17549542683e-07 0.952512626584 8.17581300813e-07 1.2 8.17613058943e-07 1.44748737342 8.17644817073e-07 1.55 8.17676575203e-07 1.44748737342 8.17708333333e-07 1.2 8.17740091463e-07 0.952512626585 8.17771849593e-07 0.85 8.17803607724e-07 0.952512626585 8.17835365854e-07 1.2 8.17867123984e-07 1.44748737342 8.17898882114e-07 1.55 8.17930640244e-07 1.44748737341 8.17962398374e-07 1.2 8.17994156504e-07 0.952512626585 8.18025914634e-07 0.85 8.18057672764e-07 0.952512626585 8.18089430894e-07 1.2 8.18121189024e-07 1.44748737342 8.18152947154e-07 1.55 8.18184705285e-07 1.44748737341 8.18216463415e-07 1.2 8.18248221545e-07 0.952512626585 8.18279979675e-07 0.85 8.18311737805e-07 0.952512626585 8.18343495935e-07 1.2 8.18375254065e-07 1.44748737341 8.18407012195e-07 1.55 8.18438770325e-07 1.44748737342 8.18470528455e-07 1.2 8.18502286585e-07 0.952512626585 8.18534044715e-07 0.85 8.18565802846e-07 0.952512626585 8.18597560976e-07 1.2 8.18629319106e-07 1.44748737342 8.18661077236e-07 1.55 8.18692835366e-07 1.44748737342 8.18724593496e-07 1.2 8.18756351626e-07 0.952512626584 8.18788109756e-07 0.85 8.18819867886e-07 0.952512626585 8.18851626016e-07 1.2 8.18883384146e-07 1.44748737342 8.18915142276e-07 1.55 8.18946900407e-07 1.44748737342 8.18978658537e-07 1.2 8.19010416667e-07 0.952512626585 8.19042174797e-07 0.85 8.19073932927e-07 0.952512626585 8.19105691057e-07 1.2 8.19137449187e-07 1.44748737342 8.19169207317e-07 1.55 8.19200965447e-07 1.44748737341 8.19232723577e-07 1.2 8.19264481707e-07 0.952512626585 8.19296239837e-07 0.85 8.19327997967e-07 0.952512626585 8.19359756098e-07 1.2 8.19391514228e-07 1.44748737342 8.19423272358e-07 1.55 8.19455030488e-07 1.44748737341 8.19486788618e-07 1.2 8.19518546748e-07 0.952512626585 8.19550304878e-07 0.85 8.19582063008e-07 0.952512626585 8.19613821138e-07 1.2 8.19645579268e-07 1.44748737341 8.19677337398e-07 1.55 8.19709095528e-07 1.44748737341 8.19740853659e-07 1.2 8.19772611789e-07 0.952512626585 8.19804369919e-07 0.85 8.19836128049e-07 0.952512626585 8.19867886179e-07 1.2 8.19899644309e-07 1.44748737341 8.19931402439e-07 1.55 8.19963160569e-07 1.44748737342 8.19994918699e-07 1.2 8.20026676829e-07 0.952512626585 8.20058434959e-07 0.85 8.20090193089e-07 0.952512626585 8.2012195122e-07 1.2 8.2015370935e-07 1.44748737342 8.2018546748e-07 1.55 8.2021722561e-07 1.44748737342 8.2024898374e-07 1.2 8.2028074187e-07 0.952512626585 8.203125e-07 0.85 8.2034425813e-07 0.952512626584 8.2037601626e-07 1.2 8.2040777439e-07 1.44748737342 8.2043953252e-07 1.55 8.2047129065e-07 1.44748737342 8.2050304878e-07 1.2 8.20534806911e-07 0.952512626585 8.20566565041e-07 0.85 8.20598323171e-07 0.952512626585 8.20630081301e-07 1.2 8.20661839431e-07 1.44748737341 8.20693597561e-07 1.55 8.20725355691e-07 1.44748737341 8.20757113821e-07 1.2 8.20788871951e-07 0.952512626585 8.20820630081e-07 0.85 8.20852388211e-07 0.952512626585 8.20884146341e-07 1.2 8.20915904472e-07 1.44748737341 8.20947662602e-07 1.55 8.20979420732e-07 1.44748737342 8.21011178862e-07 1.2 8.21042936992e-07 0.952512626585 8.21074695122e-07 0.85 8.21106453252e-07 0.952512626585 8.21138211382e-07 1.2 8.21169969512e-07 1.44748737341 8.21201727642e-07 1.55 8.21233485772e-07 1.44748737342 8.21265243902e-07 1.2 8.21297002033e-07 0.952512626585 8.21328760163e-07 0.85 8.21360518293e-07 0.952512626585 8.21392276423e-07 1.2 8.21424034553e-07 1.44748737341 8.21455792683e-07 1.55 8.21487550813e-07 1.44748737342 8.21519308943e-07 1.2 8.21551067073e-07 0.952512626584 8.21582825203e-07 0.85 8.21614583333e-07 0.952512626584 8.21646341463e-07 1.2 8.21678099593e-07 1.44748737342 8.21709857724e-07 1.55 8.21741615854e-07 1.44748737342 8.21773373984e-07 1.2 8.21805132114e-07 0.952512626584 8.21836890244e-07 0.85 8.21868648374e-07 0.952512626584 8.21900406504e-07 1.2 8.21932164634e-07 1.44748737342 8.21963922764e-07 1.55 8.21995680894e-07 1.44748737341 8.22027439024e-07 1.2 8.22059197154e-07 0.952512626585 8.22090955285e-07 0.85 8.22122713415e-07 0.952512626585 8.22154471545e-07 1.2 8.22186229675e-07 1.44748737342 8.22217987805e-07 1.55 8.22249745935e-07 1.44748737342 8.22281504065e-07 1.2 8.22313262195e-07 0.952512626585 8.22345020325e-07 0.85 8.22376778455e-07 0.952512626585 8.22408536585e-07 1.2 8.22440294715e-07 1.44748737342 8.22472052846e-07 1.55 8.22503810976e-07 1.44748737342 8.22535569106e-07 1.2 8.22567327236e-07 0.952512626585 8.22599085366e-07 0.85 8.22630843496e-07 0.952512626585 8.22662601626e-07 1.2 8.22694359756e-07 1.44748737342 8.22726117886e-07 1.55 8.22757876016e-07 1.44748737342 8.22789634146e-07 1.2 8.22821392276e-07 0.952512626585 8.22853150407e-07 0.85 8.22884908537e-07 0.952512626584 8.22916666667e-07 1.2 8.22948424797e-07 1.44748737342 8.22980182927e-07 1.55 8.23011941057e-07 1.44748737342 8.23043699187e-07 1.2 8.23075457317e-07 0.952512626584 8.23107215447e-07 0.85 8.23138973577e-07 0.952512626584 8.23170731707e-07 1.2 8.23202489837e-07 1.44748737342 8.23234247967e-07 1.55 8.23266006098e-07 1.44748737342 8.23297764228e-07 1.2 8.23329522358e-07 0.952512626584 8.23361280488e-07 0.85 8.23393038618e-07 0.952512626585 8.23424796748e-07 1.2 8.23456554878e-07 1.44748737342 8.23488313008e-07 1.55 8.23520071138e-07 1.44748737342 8.23551829268e-07 1.2 8.23583587398e-07 0.952512626584 8.23615345528e-07 0.85 8.23647103659e-07 0.952512626585 8.23678861789e-07 1.2 8.23710619919e-07 1.44748737342 8.23742378049e-07 1.55 8.23774136179e-07 1.44748737342 8.23805894309e-07 1.2 8.23837652439e-07 0.952512626585 8.23869410569e-07 0.85 8.23901168699e-07 0.952512626584 8.23932926829e-07 1.2 8.23964684959e-07 1.44748737342 8.23996443089e-07 1.55 8.2402820122e-07 1.44748737342 8.2405995935e-07 1.2 8.2409171748e-07 0.952512626585 8.2412347561e-07 0.85 8.2415523374e-07 0.952512626584 8.2418699187e-07 1.2 8.2421875e-07 1.44748737341 8.2425050813e-07 1.55 8.2428226626e-07 1.44748737342 8.2431402439e-07 1.2 8.2434578252e-07 0.952512626584 8.2437754065e-07 0.85 8.2440929878e-07 0.952512626584 8.24441056911e-07 1.2 8.24472815041e-07 1.44748737342 8.24504573171e-07 1.55 8.24536331301e-07 1.44748737342 8.24568089431e-07 1.2 8.24599847561e-07 0.952512626584 8.24631605691e-07 0.85 8.24663363821e-07 0.952512626584 8.24695121951e-07 1.2 8.24726880081e-07 1.44748737342 8.24758638211e-07 1.55 8.24790396341e-07 1.44748737342 8.24822154472e-07 1.2 8.24853912602e-07 0.952512626585 8.24885670732e-07 0.85 8.24917428862e-07 0.952512626585 8.24949186992e-07 1.2 8.24980945122e-07 1.44748737342 8.25012703252e-07 1.55 8.25044461382e-07 1.44748737342 8.25076219512e-07 1.2 8.25107977642e-07 0.952512626585 8.25139735772e-07 0.85 8.25171493902e-07 0.952512626585 8.25203252033e-07 1.2 8.25235010163e-07 1.44748737342 8.25266768293e-07 1.55 8.25298526423e-07 1.44748737342 8.25330284553e-07 1.2 8.25362042683e-07 0.952512626585 8.25393800813e-07 0.85 8.25425558943e-07 0.952512626585 8.25457317073e-07 1.2 8.25489075203e-07 1.44748737341 8.25520833333e-07 1.55 8.25552591463e-07 1.44748737342 8.25584349593e-07 1.2 8.25616107724e-07 0.952512626585 8.25647865854e-07 0.85 8.25679623984e-07 0.952512626584 8.25711382114e-07 1.2 8.25743140244e-07 1.44748737342 8.25774898374e-07 1.55 8.25806656504e-07 1.44748737342 8.25838414634e-07 1.2 8.25870172764e-07 0.952512626584 8.25901930894e-07 0.85 8.25933689024e-07 0.952512626584 8.25965447154e-07 1.2 8.25997205285e-07 1.44748737342 8.26028963415e-07 1.55 8.26060721545e-07 1.44748737342 8.26092479675e-07 1.2 8.26124237805e-07 0.952512626585 8.26155995935e-07 0.85 8.26187754065e-07 0.952512626585 8.26219512195e-07 1.2 8.26251270325e-07 1.44748737342 8.26283028455e-07 1.55 8.26314786585e-07 1.44748737341 8.26346544715e-07 1.2 8.26378302846e-07 0.952512626585 8.26410060976e-07 0.85 8.26441819106e-07 0.952512626585 8.26473577236e-07 1.2 8.26505335366e-07 1.44748737342 8.26537093496e-07 1.55 8.26568851626e-07 1.44748737341 8.26600609756e-07 1.2 8.26632367886e-07 0.952512626585 8.26664126016e-07 0.85 8.26695884146e-07 0.952512626585 8.26727642276e-07 1.2 8.26759400407e-07 1.44748737341 8.26791158537e-07 1.55 8.26822916667e-07 1.44748737341 8.26854674797e-07 1.2 8.26886432927e-07 0.952512626585 8.26918191057e-07 0.85 8.26949949187e-07 0.952512626585 8.26981707317e-07 1.2 8.27013465447e-07 1.44748737341 8.27045223577e-07 1.55 8.27076981707e-07 1.44748737342 8.27108739837e-07 1.2 8.27140497967e-07 0.952512626584 8.27172256098e-07 0.85 8.27204014228e-07 0.952512626585 8.27235772358e-07 1.2 8.27267530488e-07 1.44748737342 8.27299288618e-07 1.55 8.27331046748e-07 1.44748737342 8.27362804878e-07 1.2 8.27394563008e-07 0.952512626585 8.27426321138e-07 0.85 8.27458079268e-07 0.952512626585 8.27489837398e-07 1.2 8.27521595528e-07 1.44748737342 8.27553353659e-07 1.55 8.27585111789e-07 1.44748737341 8.27616869919e-07 1.2 8.27648628049e-07 0.952512626585 8.27680386179e-07 0.85 8.27712144309e-07 0.952512626585 8.27743902439e-07 1.2 8.27775660569e-07 1.44748737342 8.27807418699e-07 1.55 8.27839176829e-07 1.44748737341 8.27870934959e-07 1.2 8.27902693089e-07 0.952512626585 8.2793445122e-07 0.85 8.2796620935e-07 0.952512626585 8.2799796748e-07 1.2 8.2802972561e-07 1.44748737341 8.2806148374e-07 1.55 8.2809324187e-07 1.44748737342 8.28125e-07 1.2 8.2815675813e-07 0.952512626585 8.2818851626e-07 0.85 8.2822027439e-07 0.952512626585 8.2825203252e-07 1.2 8.2828379065e-07 1.44748737341 8.2831554878e-07 1.55 8.28347306911e-07 1.44748737342 8.28379065041e-07 1.2 8.28410823171e-07 0.952512626585 8.28442581301e-07 0.85 8.28474339431e-07 0.952512626585 8.28506097561e-07 1.2 8.28537855691e-07 1.44748737342 8.28569613821e-07 1.55 8.28601371951e-07 1.44748737342 8.28633130081e-07 1.2 8.28664888211e-07 0.952512626585 8.28696646341e-07 0.85 8.28728404472e-07 0.952512626584 8.28760162602e-07 1.2 8.28791920732e-07 1.44748737342 8.28823678862e-07 1.55 8.28855436992e-07 1.44748737342 8.28887195122e-07 1.2 8.28918953252e-07 0.952512626585 8.28950711382e-07 0.85 8.28982469512e-07 0.952512626585 8.29014227642e-07 1.2 8.29045985772e-07 1.44748737342 8.29077743902e-07 1.55 8.29109502033e-07 1.44748737341 8.29141260163e-07 1.2 8.29173018293e-07 0.952512626585 8.29204776423e-07 0.85 8.29236534553e-07 0.952512626585 8.29268292683e-07 1.2 8.29300050813e-07 1.44748737341 8.29331808943e-07 1.55 8.29363567073e-07 1.44748737342 8.29395325203e-07 1.2 8.29427083333e-07 0.952512626585 8.29458841463e-07 0.85 8.29490599593e-07 0.952512626585 8.29522357724e-07 1.2 8.29554115854e-07 1.44748737341 8.29585873984e-07 1.55 8.29617632114e-07 1.44748737342 8.29649390244e-07 1.2 8.29681148374e-07 0.952512626585 8.29712906504e-07 0.85 8.29744664634e-07 0.952512626585 8.29776422764e-07 1.2 8.29808180894e-07 1.44748737341 8.29839939024e-07 1.55 8.29871697154e-07 1.44748737342 8.29903455285e-07 1.2 8.29935213415e-07 0.952512626584 8.29966971545e-07 0.85 8.29998729675e-07 0.952512626584 8.30030487805e-07 1.2 8.30062245935e-07 1.44748737342 8.30094004065e-07 1.55 8.30125762195e-07 1.44748737342 8.30157520325e-07 1.2 8.30189278455e-07 0.952512626584 8.30221036585e-07 0.85 8.30252794715e-07 0.952512626584 8.30284552846e-07 1.2 8.30316310976e-07 1.44748737342 8.30348069106e-07 1.55 8.30379827236e-07 1.44748737341 8.30411585366e-07 1.2 8.30443343496e-07 0.952512626584 8.30475101626e-07 0.85 8.30506859756e-07 0.952512626585 8.30538617886e-07 1.2 8.30570376016e-07 1.44748737342 8.30602134146e-07 1.55 8.30633892276e-07 1.44748737342 8.30665650407e-07 1.2 8.30697408537e-07 0.952512626585 8.30729166667e-07 0.85 8.30760924797e-07 0.952512626585 8.30792682927e-07 1.2 8.30824441057e-07 1.44748737342 8.30856199187e-07 1.55 8.30887957317e-07 1.44748737342 8.30919715447e-07 1.2 8.30951473577e-07 0.952512626585 8.30983231707e-07 0.85 8.31014989837e-07 0.952512626585 8.31046747967e-07 1.2 8.31078506098e-07 1.44748737342 8.31110264228e-07 1.55 8.31142022358e-07 1.44748737342 8.31173780488e-07 1.2 8.31205538618e-07 0.952512626585 8.31237296748e-07 0.85 8.31269054878e-07 0.952512626584 8.31300813008e-07 1.2 8.31332571138e-07 1.44748737342 8.31364329268e-07 1.55 8.31396087398e-07 1.44748737342 8.31427845528e-07 1.2 8.31459603659e-07 0.952512626584 8.31491361789e-07 0.85 8.31523119919e-07 0.952512626584 8.31554878049e-07 1.2 8.31586636179e-07 1.44748737342 8.31618394309e-07 1.55 8.31650152439e-07 1.44748737342 8.31681910569e-07 1.2 8.31713668699e-07 0.952512626584 8.31745426829e-07 0.85 8.31777184959e-07 0.952512626585 8.31808943089e-07 1.2 8.3184070122e-07 1.44748737342 8.3187245935e-07 1.55 8.3190421748e-07 1.44748737342 8.3193597561e-07 1.2 8.3196773374e-07 0.952512626585 8.3199949187e-07 0.85 8.3203125e-07 0.952512626585 8.3206300813e-07 1.2 8.3209476626e-07 1.44748737342 8.3212652439e-07 1.55 8.3215828252e-07 1.44748737342 8.3219004065e-07 1.2 8.3222179878e-07 0.952512626585 8.32253556911e-07 0.85 8.32285315041e-07 0.952512626584 8.32317073171e-07 1.2 8.32348831301e-07 1.44748737342 8.32380589431e-07 1.55 8.32412347561e-07 1.44748737342 8.32444105691e-07 1.2 8.32475863821e-07 0.952512626585 8.32507621951e-07 0.85 8.32539380081e-07 0.952512626584 8.32571138211e-07 1.2 8.32602896341e-07 1.44748737341 8.32634654472e-07 1.55 8.32666412602e-07 1.44748737342 8.32698170732e-07 1.2 8.32729928862e-07 0.952512626584 8.32761686992e-07 0.85 8.32793445122e-07 0.952512626584 8.32825203252e-07 1.2 8.32856961382e-07 1.44748737342 8.32888719512e-07 1.55 8.32920477642e-07 1.44748737342 8.32952235772e-07 1.2 8.32983993902e-07 0.952512626584 8.33015752033e-07 0.85 8.33047510163e-07 0.952512626584 8.33079268293e-07 1.2 8.33111026423e-07 1.44748737342 8.33142784553e-07 1.55 8.33174542683e-07 1.44748737342 8.33206300813e-07 1.2 8.33238058943e-07 0.952512626585 8.33269817073e-07 0.85 8.33301575203e-07 0.952512626585 8.33333333333e-07 1.2 8.33365091463e-07 1.44748737342 8.33396849593e-07 1.55 8.33428607724e-07 1.44748737342 8.33460365854e-07 1.2 8.33492123984e-07 0.952512626585 8.33523882114e-07 0.85 8.33555640244e-07 0.952512626585 8.33587398374e-07 1.2 8.33619156504e-07 1.44748737342 8.33650914634e-07 1.55 8.33682672764e-07 1.44748737342 8.33714430894e-07 1.2 8.33746189024e-07 0.952512626585 8.33777947154e-07 0.85 8.33809705285e-07 0.952512626585 8.33841463415e-07 1.2 8.33873221545e-07 1.44748737341 8.33904979675e-07 1.55 8.33936737805e-07 1.44748737342 8.33968495935e-07 1.2 8.34000254065e-07 0.952512626585 8.34032012195e-07 0.85 8.34063770325e-07 0.952512626585 8.34095528455e-07 1.2 8.34127286585e-07 1.44748737342 8.34159044715e-07 1.55 8.34190802846e-07 1.44748737342 8.34222560976e-07 1.2 8.34254319106e-07 0.952512626584 8.34286077236e-07 0.85 8.34317835366e-07 0.952512626584 8.34349593496e-07 1.2 8.34381351626e-07 1.44748737342 8.34413109756e-07 1.55 8.34444867886e-07 1.44748737342 8.34476626016e-07 1.2 8.34508384146e-07 0.952512626585 8.34540142276e-07 0.85 8.34571900407e-07 0.952512626585 8.34603658537e-07 1.2 8.34635416667e-07 1.44748737342 8.34667174797e-07 1.55 8.34698932927e-07 1.44748737341 8.34730691057e-07 1.2 8.34762449187e-07 0.952512626585 8.34794207317e-07 0.85 8.34825965447e-07 0.952512626585 8.34857723577e-07 1.2 8.34889481707e-07 1.44748737342 8.34921239837e-07 1.55 8.34952997967e-07 1.44748737341 8.34984756098e-07 1.2 8.35016514228e-07 0.952512626585 8.35048272358e-07 0.85 8.35080030488e-07 0.952512626585 8.35111788618e-07 1.2 8.35143546748e-07 1.44748737341 8.35175304878e-07 1.55 8.35207063008e-07 1.44748737341 8.35238821138e-07 1.2 8.35270579268e-07 0.952512626585 8.35302337398e-07 0.85 8.35334095528e-07 0.952512626585 8.35365853659e-07 1.2 8.35397611789e-07 1.44748737341 8.35429369919e-07 1.55 8.35461128049e-07 1.44748737342 8.35492886179e-07 1.2 8.35524644309e-07 0.952512626584 8.35556402439e-07 0.85 8.35588160569e-07 0.952512626585 8.35619918699e-07 1.2 8.35651676829e-07 1.44748737342 8.35683434959e-07 1.55 8.35715193089e-07 1.44748737342 8.3574695122e-07 1.2 8.3577870935e-07 0.952512626585 8.3581046748e-07 0.85 8.3584222561e-07 0.952512626584 8.3587398374e-07 1.2 8.3590574187e-07 1.44748737342 8.359375e-07 1.55 8.3596925813e-07 1.44748737342 8.3600101626e-07 1.2 8.3603277439e-07 0.952512626585 8.3606453252e-07 0.85 8.3609629065e-07 0.952512626585 8.3612804878e-07 1.2 8.36159806911e-07 1.44748737341 8.36191565041e-07 1.55 8.36223323171e-07 1.44748737341 8.36255081301e-07 1.2 8.36286839431e-07 0.952512626585 8.36318597561e-07 0.85 8.36350355691e-07 0.952512626585 8.36382113821e-07 1.2 8.36413871951e-07 1.44748737341 8.36445630081e-07 1.55 8.36477388211e-07 1.44748737342 8.36509146341e-07 1.2 8.36540904472e-07 0.952512626585 8.36572662602e-07 0.85 8.36604420732e-07 0.952512626585 8.36636178862e-07 1.2 8.36667936992e-07 1.44748737341 8.36699695122e-07 1.55 8.36731453252e-07 1.44748737342 8.36763211382e-07 1.2 8.36794969512e-07 0.952512626585 8.36826727642e-07 0.85 8.36858485772e-07 0.952512626585 8.36890243902e-07 1.2 8.36922002033e-07 1.44748737342 8.36953760163e-07 1.55 8.36985518293e-07 1.44748737342 8.37017276423e-07 1.2 8.37049034553e-07 0.952512626585 8.37080792683e-07 0.85 8.37112550813e-07 0.952512626584 8.37144308943e-07 1.2 8.37176067073e-07 1.44748737342 8.37207825203e-07 1.55 8.37239583333e-07 1.44748737342 8.37271341463e-07 1.2 8.37303099593e-07 0.952512626585 8.37334857724e-07 0.85 8.37366615854e-07 0.952512626585 8.37398373984e-07 1.2 8.37430132114e-07 1.44748737342 8.37461890244e-07 1.55 8.37493648374e-07 1.44748737341 8.37525406504e-07 1.2 8.37557164634e-07 0.952512626585 8.37588922764e-07 0.85 8.37620680894e-07 0.952512626585 8.37652439024e-07 1.2 8.37684197154e-07 1.44748737342 8.37715955285e-07 1.55 8.37747713415e-07 1.44748737342 8.37779471545e-07 1.2 8.37811229675e-07 0.952512626585 8.37842987805e-07 0.85 8.37874745935e-07 0.952512626585 8.37906504065e-07 1.2 8.37938262195e-07 1.44748737341 8.37970020325e-07 1.55 8.38001778455e-07 1.44748737342 8.38033536585e-07 1.2 8.38065294715e-07 0.952512626585 8.38097052846e-07 0.85 8.38128810976e-07 0.952512626585 8.38160569106e-07 1.2 8.38192327236e-07 1.44748737341 8.38224085366e-07 1.55 8.38255843496e-07 1.44748737342 8.38287601626e-07 1.2 8.38319359756e-07 0.952512626584 8.38351117886e-07 0.85 8.38382876016e-07 0.952512626584 8.38414634146e-07 1.2 8.38446392276e-07 1.44748737342 8.38478150407e-07 1.55 8.38509908537e-07 1.44748737342 8.38541666667e-07 1.2 8.38573424797e-07 0.952512626584 8.38605182927e-07 0.85 8.38636941057e-07 0.952512626584 8.38668699187e-07 1.2 8.38700457317e-07 1.44748737342 8.38732215447e-07 1.55 8.38763973577e-07 1.44748737342 8.38795731707e-07 1.2 8.38827489837e-07 0.952512626584 8.38859247967e-07 0.85 8.38891006098e-07 0.952512626585 8.38922764228e-07 1.2 8.38954522358e-07 1.44748737342 8.38986280488e-07 1.55 8.39018038618e-07 1.44748737342 8.39049796748e-07 1.2 8.39081554878e-07 0.952512626584 8.39113313008e-07 0.85 8.39145071138e-07 0.952512626585 8.39176829268e-07 1.2 8.39208587398e-07 1.44748737342 8.39240345528e-07 1.55 8.39272103659e-07 1.44748737342 8.39303861789e-07 1.2 8.39335619919e-07 0.952512626585 8.39367378049e-07 0.85 8.39399136179e-07 0.952512626585 8.39430894309e-07 1.2 8.39462652439e-07 1.44748737342 8.39494410569e-07 1.55 8.39526168699e-07 1.44748737342 8.39557926829e-07 1.2 8.39589684959e-07 0.952512626585 8.39621443089e-07 0.85 8.3965320122e-07 0.952512626584 8.3968495935e-07 1.2 8.3971671748e-07 1.44748737342 8.3974847561e-07 1.55 8.3978023374e-07 1.44748737342 8.3981199187e-07 1.2 8.3984375e-07 0.952512626584 8.3987550813e-07 0.85 8.3990726626e-07 0.952512626584 8.3993902439e-07 1.2 8.3997078252e-07 1.44748737342 8.4000254065e-07 1.55 8.4003429878e-07 1.44748737342 8.40066056911e-07 1.2 8.40097815041e-07 0.952512626584 8.40129573171e-07 0.85 8.40161331301e-07 0.952512626585 8.40193089431e-07 1.2 8.40224847561e-07 1.44748737342 8.40256605691e-07 1.55 8.40288363821e-07 1.44748737342 8.40320121951e-07 1.2 8.40351880081e-07 0.952512626585 8.40383638211e-07 0.85 8.40415396341e-07 0.952512626585 8.40447154472e-07 1.2 8.40478912602e-07 1.44748737342 8.40510670732e-07 1.55 8.40542428862e-07 1.44748737342 8.40574186992e-07 1.2 8.40605945122e-07 0.952512626585 8.40637703252e-07 0.85 8.40669461382e-07 0.952512626584 8.40701219512e-07 1.2 8.40732977642e-07 1.44748737342 8.40764735772e-07 1.55 8.40796493902e-07 1.44748737342 8.40828252033e-07 1.2 8.40860010163e-07 0.952512626585 8.40891768293e-07 0.85 8.40923526423e-07 0.952512626584 8.40955284553e-07 1.2 8.40987042683e-07 1.44748737341 8.41018800813e-07 1.55 8.41050558943e-07 1.44748737342 8.41082317073e-07 1.2 8.41114075203e-07 0.952512626584 8.41145833333e-07 0.85 8.41177591463e-07 0.952512626584 8.41209349593e-07 1.2 8.41241107724e-07 1.44748737342 8.41272865854e-07 1.55 8.41304623984e-07 1.44748737342 8.41336382114e-07 1.2 8.41368140244e-07 0.952512626584 8.41399898374e-07 0.85 8.41431656504e-07 0.952512626584 8.41463414634e-07 1.2 8.41495172764e-07 1.44748737342 8.41526930894e-07 1.55 8.41558689024e-07 1.44748737342 8.41590447154e-07 1.2 8.41622205285e-07 0.952512626585 8.41653963415e-07 0.85 8.41685721545e-07 0.952512626585 8.41717479675e-07 1.2 8.41749237805e-07 1.44748737342 8.41780995935e-07 1.55 8.41812754065e-07 1.44748737342 8.41844512195e-07 1.2 8.41876270325e-07 0.952512626585 8.41908028455e-07 0.85 8.41939786585e-07 0.952512626585 8.41971544715e-07 1.2 8.42003302846e-07 1.44748737342 8.42035060976e-07 1.55 8.42066819106e-07 1.44748737342 8.42098577236e-07 1.2 8.42130335366e-07 0.952512626585 8.42162093496e-07 0.85 8.42193851626e-07 0.952512626585 8.42225609756e-07 1.2 8.42257367886e-07 1.44748737341 8.42289126016e-07 1.55 8.42320884146e-07 1.44748737342 8.42352642276e-07 1.2 8.42384400407e-07 0.952512626585 8.42416158537e-07 0.85 8.42447916667e-07 0.952512626585 8.42479674797e-07 1.2 8.42511432927e-07 1.44748737342 8.42543191057e-07 1.55 8.42574949187e-07 1.44748737342 8.42606707317e-07 1.2 8.42638465447e-07 0.952512626584 8.42670223577e-07 0.85 8.42701981707e-07 0.952512626585 8.42733739837e-07 1.2 8.42765497967e-07 1.44748737342 8.42797256098e-07 1.55 8.42829014228e-07 1.44748737342 8.42860772358e-07 1.2 8.42892530488e-07 0.952512626585 8.42924288618e-07 0.85 8.42956046748e-07 0.952512626585 8.42987804878e-07 1.2 8.43019563008e-07 1.44748737342 8.43051321138e-07 1.55 8.43083079268e-07 1.44748737341 8.43114837398e-07 1.2 8.43146595528e-07 0.952512626585 8.43178353659e-07 0.85 8.43210111789e-07 0.952512626585 8.43241869919e-07 1.2 8.43273628049e-07 1.44748737342 8.43305386179e-07 1.55 8.43337144309e-07 1.44748737341 8.43368902439e-07 1.2 8.43400660569e-07 0.952512626585 8.43432418699e-07 0.85 8.43464176829e-07 0.952512626585 8.43495934959e-07 1.2 8.43527693089e-07 1.44748737341 8.4355945122e-07 1.55 8.4359120935e-07 1.44748737342 8.4362296748e-07 1.2 8.4365472561e-07 0.952512626585 8.4368648374e-07 0.85 8.4371824187e-07 0.952512626585 8.4375e-07 1.2 8.4378175813e-07 1.44748737341 8.4381351626e-07 1.55 8.4384527439e-07 1.44748737342 8.4387703252e-07 1.2 8.4390879065e-07 0.952512626585 8.4394054878e-07 0.85 8.43972306911e-07 0.952512626585 8.44004065041e-07 1.2 8.44035823171e-07 1.44748737342 8.44067581301e-07 1.55 8.44099339431e-07 1.44748737342 8.44131097561e-07 1.2 8.44162855691e-07 0.952512626585 8.44194613821e-07 0.85 8.44226371951e-07 0.952512626584 8.44258130081e-07 1.2 8.44289888211e-07 1.44748737342 8.44321646341e-07 1.55 8.44353404472e-07 1.44748737342 8.44385162602e-07 1.2 8.44416920732e-07 0.952512626585 8.44448678862e-07 0.85 8.44480436992e-07 0.952512626585 8.44512195122e-07 1.2 8.44543953252e-07 1.44748737341 8.44575711382e-07 1.55 8.44607469512e-07 1.44748737341 8.44639227642e-07 1.2 8.44670985772e-07 0.952512626585 8.44702743902e-07 0.85 8.44734502033e-07 0.952512626585 8.44766260163e-07 1.2 8.44798018293e-07 1.44748737341 8.44829776423e-07 1.55 8.44861534553e-07 1.44748737342 8.44893292683e-07 1.2 8.44925050813e-07 0.952512626585 8.44956808943e-07 0.85 8.44988567073e-07 0.952512626585 8.45020325203e-07 1.2 8.45052083333e-07 1.44748737341 8.45083841463e-07 1.55 8.45115599593e-07 1.44748737342 8.45147357724e-07 1.2 8.45179115854e-07 0.952512626585 8.45210873984e-07 0.85 8.45242632114e-07 0.952512626585 8.45274390244e-07 1.2 8.45306148374e-07 1.44748737342 8.45337906504e-07 1.55 8.45369664634e-07 1.44748737342 8.45401422764e-07 1.2 8.45433180894e-07 0.952512626585 8.45464939024e-07 0.85 8.45496697154e-07 0.952512626584 8.45528455285e-07 1.2 8.45560213415e-07 1.44748737342 8.45591971545e-07 1.55 8.45623729675e-07 1.44748737342 8.45655487805e-07 1.2 8.45687245935e-07 0.952512626585 8.45719004065e-07 0.85 8.45750762195e-07 0.952512626585 8.45782520325e-07 1.2 8.45814278455e-07 1.44748737342 8.45846036585e-07 1.55 8.45877794715e-07 1.44748737341 8.45909552846e-07 1.2 8.45941310976e-07 0.952512626585 8.45973069106e-07 0.85 8.46004827236e-07 0.952512626585 8.46036585366e-07 1.2 8.46068343496e-07 1.44748737342 8.46100101626e-07 1.55 8.46131859756e-07 1.44748737342 8.46163617886e-07 1.2 8.46195376016e-07 0.952512626585 8.46227134146e-07 0.85 8.46258892276e-07 0.952512626585 8.46290650407e-07 1.2 8.46322408537e-07 1.44748737342 8.46354166667e-07 1.55 8.46385924797e-07 1.44748737342 8.46417682927e-07 1.2 8.46449441057e-07 0.952512626585 8.46481199187e-07 0.85 8.46512957317e-07 0.952512626585 8.46544715447e-07 1.2 8.46576473577e-07 1.44748737341 8.46608231707e-07 1.55 8.46639989837e-07 1.44748737342 8.46671747967e-07 1.2 8.46703506098e-07 0.952512626584 8.46735264228e-07 0.85 8.46767022358e-07 0.952512626584 8.46798780488e-07 1.2 8.46830538618e-07 1.44748737342 8.46862296748e-07 1.55 8.46894054878e-07 1.44748737342 8.46925813008e-07 1.2 8.46957571138e-07 0.952512626584 8.46989329268e-07 0.85 8.47021087398e-07 0.952512626584 8.47052845528e-07 1.2 8.47084603659e-07 1.44748737342 8.47116361789e-07 1.55 8.47148119919e-07 1.44748737342 8.47179878049e-07 1.2 8.47211636179e-07 0.952512626584 8.47243394309e-07 0.85 8.47275152439e-07 0.952512626585 8.47306910569e-07 1.2 8.47338668699e-07 1.44748737342 8.47370426829e-07 1.55 8.47402184959e-07 1.44748737342 8.47433943089e-07 1.2 8.4746570122e-07 0.952512626584 8.4749745935e-07 0.85 8.4752921748e-07 0.952512626585 8.4756097561e-07 1.2 8.4759273374e-07 1.44748737342 8.4762449187e-07 1.55 8.4765625e-07 1.44748737342 8.4768800813e-07 1.2 8.4771976626e-07 0.952512626585 8.4775152439e-07 0.85 8.4778328252e-07 0.952512626584 8.4781504065e-07 1.2 8.4784679878e-07 1.44748737342 8.47878556911e-07 1.55 8.47910315041e-07 1.44748737342 8.47942073171e-07 1.2 8.47973831301e-07 0.952512626585 8.48005589431e-07 0.85 8.48037347561e-07 0.952512626584 8.48069105691e-07 1.2 8.48100863821e-07 1.44748737342 8.48132621951e-07 1.55 8.48164380081e-07 1.44748737342 8.48196138211e-07 1.2 8.48227896341e-07 0.952512626584 8.48259654472e-07 0.85 8.48291412602e-07 0.952512626584 8.48323170732e-07 1.2 8.48354928862e-07 1.44748737342 8.48386686992e-07 1.55 8.48418445122e-07 1.44748737342 8.48450203252e-07 1.2 8.48481961382e-07 0.952512626584 8.48513719512e-07 0.85 8.48545477642e-07 0.952512626585 8.48577235772e-07 1.2 8.48608993902e-07 1.44748737342 8.48640752033e-07 1.55 8.48672510163e-07 1.44748737342 8.48704268293e-07 1.2 8.48736026423e-07 0.952512626585 8.48767784553e-07 0.85 8.48799542683e-07 0.952512626585 8.48831300813e-07 1.2 8.48863058943e-07 1.44748737342 8.48894817073e-07 1.55 8.48926575203e-07 1.44748737342 8.48958333333e-07 1.2 8.48990091463e-07 0.952512626585 8.49021849593e-07 0.85 8.49053607724e-07 0.952512626584 8.49085365854e-07 1.2 8.49117123984e-07 1.44748737342 8.49148882114e-07 1.55 8.49180640244e-07 1.44748737342 8.49212398374e-07 1.2 8.49244156504e-07 0.952512626585 8.49275914634e-07 0.85 8.49307672764e-07 0.952512626584 8.49339430894e-07 1.2 8.49371189024e-07 1.44748737341 8.49402947154e-07 1.55 8.49434705285e-07 1.44748737342 8.49466463415e-07 1.2 8.49498221545e-07 0.952512626584 8.49529979675e-07 0.85 8.49561737805e-07 0.952512626584 8.49593495935e-07 1.2 8.49625254065e-07 1.44748737342 8.49657012195e-07 1.55 8.49688770325e-07 1.44748737342 8.49720528455e-07 1.2 8.49752286585e-07 0.952512626584 8.49784044715e-07 0.85 8.49815802846e-07 0.952512626584 8.49847560976e-07 1.2 8.49879319106e-07 1.44748737342 8.49911077236e-07 1.55 8.49942835366e-07 1.44748737342 8.49974593496e-07 1.2 8.50006351626e-07 0.952512626585 8.50038109756e-07 0.85 8.50069867886e-07 0.952512626585 8.50101626016e-07 1.2 8.50133384146e-07 1.44748737342 8.50165142276e-07 1.55 8.50196900407e-07 1.44748737342 8.50228658537e-07 1.2 8.50260416667e-07 0.952512626585 8.50292174797e-07 0.85 8.50323932927e-07 0.952512626585 8.50355691057e-07 1.2 8.50387449187e-07 1.44748737342 8.50419207317e-07 1.55 8.50450965447e-07 1.44748737342 8.50482723577e-07 1.2 8.50514481707e-07 0.952512626585 8.50546239837e-07 0.85 8.50577997967e-07 0.952512626585 8.50609756098e-07 1.2 8.50641514228e-07 1.44748737341 8.50673272358e-07 1.55 8.50705030488e-07 1.44748737342 8.50736788618e-07 1.2 8.50768546748e-07 0.952512626585 8.50800304878e-07 0.85 8.50832063008e-07 0.952512626585 8.50863821138e-07 1.2 8.50895579268e-07 1.44748737342 8.50927337398e-07 1.55 8.50959095528e-07 1.44748737342 8.50990853659e-07 1.2 8.51022611789e-07 0.952512626584 8.51054369919e-07 0.85 8.51086128049e-07 0.952512626585 8.51117886179e-07 1.2 8.51149644309e-07 1.44748737342 8.51181402439e-07 1.55 8.51213160569e-07 1.44748737342 8.51244918699e-07 1.2 8.51276676829e-07 0.952512626585 8.51308434959e-07 0.85 8.51340193089e-07 0.952512626585 8.5137195122e-07 1.2 8.5140370935e-07 1.44748737342 8.5143546748e-07 1.55 8.5146722561e-07 1.44748737341 8.5149898374e-07 1.2 8.5153074187e-07 0.952512626585 8.515625e-07 0.85 8.5159425813e-07 0.952512626585 8.5162601626e-07 1.2 8.5165777439e-07 1.44748737341 8.5168953252e-07 1.55 8.5172129065e-07 1.44748737341 8.5175304878e-07 1.2 8.51784806911e-07 0.952512626585 8.51816565041e-07 0.85 8.51848323171e-07 0.952512626585 8.51880081301e-07 1.2 8.51911839431e-07 1.44748737341 8.51943597561e-07 1.55 8.51975355691e-07 1.44748737342 8.52007113821e-07 1.2 8.52038871951e-07 0.952512626585 8.52070630081e-07 0.85 8.52102388211e-07 0.952512626585 8.52134146341e-07 1.2 8.52165904472e-07 1.44748737341 8.52197662602e-07 1.55 8.52229420732e-07 1.44748737342 8.52261178862e-07 1.2 8.52292936992e-07 0.952512626585 8.52324695122e-07 0.85 8.52356453252e-07 0.952512626585 8.52388211382e-07 1.2 8.52419969512e-07 1.44748737342 8.52451727642e-07 1.55 8.52483485772e-07 1.44748737342 8.52515243902e-07 1.2 8.52547002033e-07 0.952512626585 8.52578760163e-07 0.85 8.52610518293e-07 0.952512626584 8.52642276423e-07 1.2 8.52674034553e-07 1.44748737342 8.52705792683e-07 1.55 8.52737550813e-07 1.44748737342 8.52769308943e-07 1.2 8.52801067073e-07 0.952512626585 8.52832825203e-07 0.85 8.52864583333e-07 0.952512626585 8.52896341463e-07 1.2 8.52928099593e-07 1.44748737341 8.52959857724e-07 1.55 8.52991615854e-07 1.44748737341 8.53023373984e-07 1.2 8.53055132114e-07 0.952512626585 8.53086890244e-07 0.85 8.53118648374e-07 0.952512626585 8.53150406504e-07 1.2 8.53182164634e-07 1.44748737341 8.53213922764e-07 1.55 8.53245680894e-07 1.44748737342 8.53277439024e-07 1.2 8.53309197154e-07 0.952512626585 8.53340955285e-07 0.85 8.53372713415e-07 0.952512626585 8.53404471545e-07 1.2 8.53436229675e-07 1.44748737341 8.53467987805e-07 1.55 8.53499745935e-07 1.44748737342 8.53531504065e-07 1.2 8.53563262195e-07 0.952512626585 8.53595020325e-07 0.85 8.53626778455e-07 0.952512626585 8.53658536585e-07 1.2 8.53690294715e-07 1.44748737342 8.53722052846e-07 1.55 8.53753810976e-07 1.44748737342 8.53785569106e-07 1.2 8.53817327236e-07 0.952512626584 8.53849085366e-07 0.85 8.53880843496e-07 0.952512626584 8.53912601626e-07 1.2 8.53944359756e-07 1.44748737342 8.53976117886e-07 1.55 8.54007876016e-07 1.44748737342 8.54039634146e-07 1.2 8.54071392276e-07 0.952512626585 8.54103150407e-07 0.85 8.54134908537e-07 0.952512626585 8.54166666667e-07 1.2 8.54198424797e-07 1.44748737342 8.54230182927e-07 1.55 8.54261941057e-07 1.44748737341 8.54293699187e-07 1.2 8.54325457317e-07 0.952512626585 8.54357215447e-07 0.85 8.54388973577e-07 0.952512626585 8.54420731707e-07 1.2 8.54452489837e-07 1.44748737342 8.54484247967e-07 1.55 8.54516006098e-07 1.44748737342 8.54547764228e-07 1.2 8.54579522358e-07 0.952512626585 8.54611280488e-07 0.85 8.54643038618e-07 0.952512626585 8.54674796748e-07 1.2 8.54706554878e-07 1.44748737342 8.54738313008e-07 1.55 8.54770071138e-07 1.44748737342 8.54801829268e-07 1.2 8.54833587398e-07 0.952512626585 8.54865345528e-07 0.85 8.54897103659e-07 0.952512626585 8.54928861789e-07 1.2 8.54960619919e-07 1.44748737342 8.54992378049e-07 1.55 8.55024136179e-07 1.44748737342 8.55055894309e-07 1.2 8.55087652439e-07 0.952512626584 8.55119410569e-07 0.85 8.55151168699e-07 0.952512626584 8.55182926829e-07 1.2 8.55214684959e-07 1.44748737342 8.55246443089e-07 1.55 8.5527820122e-07 1.44748737342 8.5530995935e-07 1.2 8.5534171748e-07 0.952512626584 8.5537347561e-07 0.85 8.5540523374e-07 0.952512626584 8.5543699187e-07 1.2 8.5546875e-07 1.44748737342 8.5550050813e-07 1.55 8.5553226626e-07 1.44748737342 8.5556402439e-07 1.2 8.5559578252e-07 0.952512626584 8.5562754065e-07 0.85 8.5565929878e-07 0.952512626585 8.55691056911e-07 1.2 8.55722815041e-07 1.44748737342 8.55754573171e-07 1.55 8.55786331301e-07 1.44748737342 8.55818089431e-07 1.2 8.55849847561e-07 0.952512626585 8.55881605691e-07 0.85 8.55913363821e-07 0.952512626585 8.55945121951e-07 1.2 8.55976880081e-07 1.44748737342 8.56008638211e-07 1.55 8.56040396341e-07 1.44748737342 8.56072154472e-07 1.2 8.56103912602e-07 0.952512626585 8.56135670732e-07 0.85 8.56167428862e-07 0.952512626584 8.56199186992e-07 1.2 8.56230945122e-07 1.44748737342 8.56262703252e-07 1.55 8.56294461382e-07 1.44748737342 8.56326219512e-07 1.2 8.56357977642e-07 0.952512626585 8.56389735772e-07 0.85 8.56421493902e-07 0.952512626584 8.56453252033e-07 1.2 8.56485010163e-07 1.44748737342 8.56516768293e-07 1.55 8.56548526423e-07 1.44748737342 8.56580284553e-07 1.2 8.56612042683e-07 0.952512626584 8.56643800813e-07 0.85 8.56675558943e-07 0.952512626584 8.56707317073e-07 1.2 8.56739075203e-07 1.44748737342 8.56770833333e-07 1.55 8.56802591463e-07 1.44748737342 8.56834349593e-07 1.2 8.56866107724e-07 0.952512626584 8.56897865854e-07 0.85 8.56929623984e-07 0.952512626585 8.56961382114e-07 1.2 8.56993140244e-07 1.44748737342 8.57024898374e-07 1.55 8.57056656504e-07 1.44748737342 8.57088414634e-07 1.2 8.57120172764e-07 0.952512626585 8.57151930894e-07 0.85 8.57183689024e-07 0.952512626585 8.57215447154e-07 1.2 8.57247205285e-07 1.44748737342 8.57278963415e-07 1.55 8.57310721545e-07 1.44748737342 8.57342479675e-07 1.2 8.57374237805e-07 0.952512626585 8.57405995935e-07 0.85 8.57437754065e-07 0.952512626585 8.57469512195e-07 1.2 8.57501270325e-07 1.44748737342 8.57533028455e-07 1.55 8.57564786585e-07 1.44748737342 8.57596544715e-07 1.2 8.57628302846e-07 0.952512626585 8.57660060976e-07 0.85 8.57691819106e-07 0.952512626584 8.57723577236e-07 1.2 8.57755335366e-07 1.44748737341 8.57787093496e-07 1.55 8.57818851626e-07 1.44748737342 8.57850609756e-07 1.2 8.57882367886e-07 0.952512626585 8.57914126016e-07 0.85 8.57945884146e-07 0.952512626584 8.57977642276e-07 1.2 8.58009400407e-07 1.44748737342 8.58041158537e-07 1.55 8.58072916667e-07 1.44748737342 8.58104674797e-07 1.2 8.58136432927e-07 0.952512626584 8.58168191057e-07 0.85 8.58199949187e-07 0.952512626584 8.58231707317e-07 1.2 8.58263465447e-07 1.44748737342 8.58295223577e-07 1.55 8.58326981707e-07 1.44748737342 8.58358739837e-07 1.2 8.58390497967e-07 0.952512626585 8.58422256098e-07 0.85 8.58454014228e-07 0.952512626585 8.58485772358e-07 1.2 8.58517530488e-07 1.44748737342 8.58549288618e-07 1.55 8.58581046748e-07 1.44748737341 8.58612804878e-07 1.2 8.58644563008e-07 0.952512626585 8.58676321138e-07 0.85 8.58708079268e-07 0.952512626585 8.58739837398e-07 1.2 8.58771595528e-07 1.44748737342 8.58803353659e-07 1.55 8.58835111789e-07 1.44748737342 8.58866869919e-07 1.2 8.58898628049e-07 0.952512626585 8.58930386179e-07 0.85 8.58962144309e-07 0.952512626585 8.58993902439e-07 1.2 8.59025660569e-07 1.44748737341 8.59057418699e-07 1.55 8.59089176829e-07 1.44748737342 8.59120934959e-07 1.2 8.59152693089e-07 0.952512626585 8.5918445122e-07 0.85 8.5921620935e-07 0.952512626585 8.5924796748e-07 1.2 8.5927972561e-07 1.44748737342 8.5931148374e-07 1.55 8.5934324187e-07 1.44748737342 8.59375e-07 1.2 8.5940675813e-07 0.952512626585 8.5943851626e-07 0.85 8.5947027439e-07 0.952512626585 8.5950203252e-07 1.2 8.5953379065e-07 1.44748737342 8.5956554878e-07 1.55 8.59597306911e-07 1.44748737342 8.59629065041e-07 1.2 8.59660823171e-07 0.952512626585 8.59692581301e-07 0.85 8.59724339431e-07 0.952512626585 8.59756097561e-07 1.2 8.59787855691e-07 1.44748737342 8.59819613821e-07 1.55 8.59851371951e-07 1.44748737341 8.59883130081e-07 1.2 8.59914888211e-07 0.952512626585 8.59946646341e-07 0.85 8.59978404472e-07 0.952512626585 8.60010162602e-07 1.2 8.60041920732e-07 1.44748737341 8.60073678862e-07 1.55 8.60105436992e-07 1.44748737341 8.60137195122e-07 1.2 8.60168953252e-07 0.952512626585 8.60200711382e-07 0.85 8.60232469512e-07 0.952512626585 8.60264227642e-07 1.2 8.60295985772e-07 1.44748737341 8.60327743902e-07 1.55 8.60359502033e-07 1.44748737342 8.60391260163e-07 1.2 8.60423018293e-07 0.952512626585 8.60454776423e-07 0.85 8.60486534553e-07 0.952512626585 8.60518292683e-07 1.2 8.60550050813e-07 1.44748737341 8.60581808943e-07 1.55 8.60613567073e-07 1.44748737342 8.60645325203e-07 1.2 8.60677083333e-07 0.952512626585 8.60708841463e-07 0.85 8.60740599593e-07 0.952512626585 8.60772357724e-07 1.2 8.60804115854e-07 1.44748737342 8.60835873984e-07 1.55 8.60867632114e-07 1.44748737342 8.60899390244e-07 1.2 8.60931148374e-07 0.952512626585 8.60962906504e-07 0.85 8.60994664634e-07 0.952512626584 8.61026422764e-07 1.2 8.61058180894e-07 1.44748737342 8.61089939024e-07 1.55 8.61121697154e-07 1.44748737342 8.61153455285e-07 1.2 8.61185213415e-07 0.952512626585 8.61216971545e-07 0.85 8.61248729675e-07 0.952512626585 8.61280487805e-07 1.2 8.61312245935e-07 1.44748737341 8.61344004065e-07 1.55 8.61375762195e-07 1.44748737341 8.61407520325e-07 1.2 8.61439278455e-07 0.952512626585 8.61471036585e-07 0.85 8.61502794715e-07 0.952512626585 8.61534552846e-07 1.2 8.61566310976e-07 1.44748737341 8.61598069106e-07 1.55 8.61629827236e-07 1.44748737342 8.61661585366e-07 1.2 8.61693343496e-07 0.952512626585 8.61725101626e-07 0.85 8.61756859756e-07 0.952512626585 8.61788617886e-07 1.2 8.61820376016e-07 1.44748737341 8.61852134146e-07 1.55 8.61883892276e-07 1.44748737342 8.61915650407e-07 1.2 8.61947408537e-07 0.952512626585 8.61979166667e-07 0.85 8.62010924797e-07 0.952512626585 8.62042682927e-07 1.2 8.62074441057e-07 1.44748737342 8.62106199187e-07 1.55 8.62137957317e-07 1.44748737342 8.62169715447e-07 1.2 8.62201473577e-07 0.952512626584 8.62233231707e-07 0.85 8.62264989837e-07 0.952512626584 8.62296747967e-07 1.2 8.62328506098e-07 1.44748737342 8.62360264228e-07 1.55 8.62392022358e-07 1.44748737342 8.62423780488e-07 1.2 8.62455538618e-07 0.952512626584 8.62487296748e-07 0.85 8.62519054878e-07 0.952512626585 8.62550813008e-07 1.2 8.62582571138e-07 1.44748737342 8.62614329268e-07 1.55 8.62646087398e-07 1.44748737341 8.62677845528e-07 1.2 8.62709603659e-07 0.952512626585 8.62741361789e-07 0.85 8.62773119919e-07 0.952512626585 8.62804878049e-07 1.2 8.62836636179e-07 1.44748737342 8.62868394309e-07 1.55 8.62900152439e-07 1.44748737342 8.62931910569e-07 1.2 8.62963668699e-07 0.952512626585 8.62995426829e-07 0.85 8.63027184959e-07 0.952512626585 8.63058943089e-07 1.2 8.6309070122e-07 1.44748737342 8.6312245935e-07 1.55 8.6315421748e-07 1.44748737342 8.6318597561e-07 1.2 8.6321773374e-07 0.952512626585 8.6324949187e-07 0.85 8.6328125e-07 0.952512626584 8.6331300813e-07 1.2 8.6334476626e-07 1.44748737342 8.6337652439e-07 1.55 8.6340828252e-07 1.44748737342 8.6344004065e-07 1.2 8.6347179878e-07 0.952512626585 8.63503556911e-07 0.85 8.63535315041e-07 0.952512626584 8.63567073171e-07 1.2 8.63598831301e-07 1.44748737342 8.63630589431e-07 1.55 8.63662347561e-07 1.44748737342 8.63694105691e-07 1.2 8.63725863821e-07 0.952512626584 8.63757621951e-07 0.85 8.63789380081e-07 0.952512626584 8.63821138211e-07 1.2 8.63852896341e-07 1.44748737342 8.63884654472e-07 1.55 8.63916412602e-07 1.44748737342 8.63948170732e-07 1.2 8.63979928862e-07 0.952512626584 8.64011686992e-07 0.85 8.64043445122e-07 0.952512626585 8.64075203252e-07 1.2 8.64106961382e-07 1.44748737342 8.64138719512e-07 1.55 8.64170477642e-07 1.44748737342 8.64202235772e-07 1.2 8.64233993902e-07 0.952512626585 8.64265752033e-07 0.85 8.64297510163e-07 0.952512626585 8.64329268293e-07 1.2 8.64361026423e-07 1.44748737342 8.64392784553e-07 1.55 8.64424542683e-07 1.44748737342 8.64456300813e-07 1.2 8.64488058943e-07 0.952512626585 8.64519817073e-07 0.85 8.64551575203e-07 0.952512626584 8.64583333333e-07 1.2 8.64615091463e-07 1.44748737342 8.64646849593e-07 1.55 8.64678607724e-07 1.44748737342 8.64710365854e-07 1.2 8.64742123984e-07 0.952512626585 8.64773882114e-07 0.85 8.64805640244e-07 0.952512626584 8.64837398374e-07 1.2 8.64869156504e-07 1.44748737342 8.64900914634e-07 1.55 8.64932672764e-07 1.44748737342 8.64964430894e-07 1.2 8.64996189024e-07 0.952512626584 8.65027947154e-07 0.85 8.65059705285e-07 0.952512626584 8.65091463415e-07 1.2 8.65123221545e-07 1.44748737342 8.65154979675e-07 1.55 8.65186737805e-07 1.44748737342 8.65218495935e-07 1.2 8.65250254065e-07 0.952512626584 8.65282012195e-07 0.85 8.65313770325e-07 0.952512626585 8.65345528455e-07 1.2 8.65377286585e-07 1.44748737342 8.65409044715e-07 1.55 8.65440802846e-07 1.44748737342 8.65472560976e-07 1.2 8.65504319106e-07 0.952512626585 8.65536077236e-07 0.85 8.65567835366e-07 0.952512626585 8.65599593496e-07 1.2 8.65631351626e-07 1.44748737342 8.65663109756e-07 1.55 8.65694867886e-07 1.44748737342 8.65726626016e-07 1.2 8.65758384146e-07 0.952512626585 8.65790142276e-07 0.85 8.65821900407e-07 0.952512626585 8.65853658537e-07 1.2 8.65885416667e-07 1.44748737342 8.65917174797e-07 1.55 8.65948932927e-07 1.44748737342 8.65980691057e-07 1.2 8.66012449187e-07 0.952512626585 8.66044207317e-07 0.85 8.66075965447e-07 0.952512626585 8.66107723577e-07 1.2 8.66139481707e-07 1.44748737341 8.66171239837e-07 1.55 8.66202997967e-07 1.44748737342 8.66234756098e-07 1.2 8.66266514228e-07 0.952512626585 8.66298272358e-07 0.85 8.66330030488e-07 0.952512626584 8.66361788618e-07 1.2 8.66393546748e-07 1.44748737342 8.66425304878e-07 1.55 8.66457063008e-07 1.44748737342 8.66488821138e-07 1.2 8.66520579268e-07 0.952512626584 8.66552337398e-07 0.85 8.66584095528e-07 0.952512626584 8.66615853659e-07 1.2 8.66647611789e-07 1.44748737342 8.66679369919e-07 1.55 8.66711128049e-07 1.44748737342 8.66742886179e-07 1.2 8.66774644309e-07 0.952512626585 8.66806402439e-07 0.85 8.66838160569e-07 0.952512626585 8.66869918699e-07 1.2 8.66901676829e-07 1.44748737342 8.66933434959e-07 1.55 8.66965193089e-07 1.44748737341 8.6699695122e-07 1.2 8.6702870935e-07 0.952512626585 8.6706046748e-07 0.85 8.6709222561e-07 0.952512626585 8.6712398374e-07 1.2 8.6715574187e-07 1.44748737342 8.671875e-07 1.55 8.6721925813e-07 1.44748737341 8.6725101626e-07 1.2 8.6728277439e-07 0.952512626585 8.6731453252e-07 0.85 8.6734629065e-07 0.952512626585 8.6737804878e-07 1.2 8.67409806911e-07 1.44748737341 8.67441565041e-07 1.55 8.67473323171e-07 1.44748737342 8.67505081301e-07 1.2 8.67536839431e-07 0.952512626585 8.67568597561e-07 0.85 8.67600355691e-07 0.952512626585 8.67632113821e-07 1.2 8.67663871951e-07 1.44748737342 8.67695630081e-07 1.55 8.67727388211e-07 1.44748737342 8.67759146341e-07 1.2 8.67790904472e-07 0.952512626585 8.67822662602e-07 0.85 8.67854420732e-07 0.952512626585 8.67886178862e-07 1.2 8.67917936992e-07 1.44748737342 8.67949695122e-07 1.55 8.67981453252e-07 1.44748737342 8.68013211382e-07 1.2 8.68044969512e-07 0.952512626585 8.68076727642e-07 0.85 8.68108485772e-07 0.952512626585 8.68140243902e-07 1.2 8.68172002033e-07 1.44748737342 8.68203760163e-07 1.55 8.68235518293e-07 1.44748737341 8.68267276423e-07 1.2 8.68299034553e-07 0.952512626585 8.68330792683e-07 0.85 8.68362550813e-07 0.952512626585 8.68394308943e-07 1.2 8.68426067073e-07 1.44748737341 8.68457825203e-07 1.55 8.68489583333e-07 1.44748737341 8.68521341463e-07 1.2 8.68553099593e-07 0.952512626585 8.68584857724e-07 0.85 8.68616615854e-07 0.952512626585 8.68648373984e-07 1.2 8.68680132114e-07 1.44748737341 8.68711890244e-07 1.55 8.68743648374e-07 1.44748737342 8.68775406504e-07 1.2 8.68807164634e-07 0.952512626585 8.68838922764e-07 0.85 8.68870680894e-07 0.952512626585 8.68902439024e-07 1.2 8.68934197154e-07 1.44748737341 8.68965955285e-07 1.55 8.68997713415e-07 1.44748737342 8.69029471545e-07 1.2 8.69061229675e-07 0.952512626585 8.69092987805e-07 0.85 8.69124745935e-07 0.952512626585 8.69156504065e-07 1.2 8.69188262195e-07 1.44748737342 8.69220020325e-07 1.55 8.69251778455e-07 1.44748737342 8.69283536585e-07 1.2 8.69315294715e-07 0.952512626585 8.69347052846e-07 0.85 8.69378810976e-07 0.952512626584 8.69410569106e-07 1.2 8.69442327236e-07 1.44748737342 8.69474085366e-07 1.55 8.69505843496e-07 1.44748737342 8.69537601626e-07 1.2 8.69569359756e-07 0.952512626585 8.69601117886e-07 0.85 8.69632876016e-07 0.952512626585 8.69664634146e-07 1.2 8.69696392276e-07 1.44748737342 8.69728150407e-07 1.55 8.69759908537e-07 1.44748737341 8.69791666667e-07 1.2 8.69823424797e-07 0.952512626585 8.69855182927e-07 0.85 8.69886941057e-07 0.952512626585 8.69918699187e-07 1.2 8.69950457317e-07 1.44748737341 8.69982215447e-07 1.55 8.70013973577e-07 1.44748737342 8.70045731707e-07 1.2 8.70077489837e-07 0.952512626585 8.70109247967e-07 0.85 8.70141006098e-07 0.952512626585 8.70172764228e-07 1.2 8.70204522358e-07 1.44748737341 8.70236280488e-07 1.55 8.70268038618e-07 1.44748737342 8.70299796748e-07 1.2 8.70331554878e-07 0.952512626585 8.70363313008e-07 0.85 8.70395071138e-07 0.952512626585 8.70426829268e-07 1.2 8.70458587398e-07 1.44748737342 8.70490345528e-07 1.55 8.70522103659e-07 1.44748737342 8.70553861789e-07 1.2 8.70585619919e-07 0.952512626584 8.70617378049e-07 0.85 8.70649136179e-07 0.952512626584 8.70680894309e-07 1.2 8.70712652439e-07 1.44748737342 8.70744410569e-07 1.55 8.70776168699e-07 1.44748737342 8.70807926829e-07 1.2 8.70839684959e-07 0.952512626584 8.70871443089e-07 0.85 8.7090320122e-07 0.952512626585 8.7093495935e-07 1.2 8.7096671748e-07 1.44748737342 8.7099847561e-07 1.55 8.7103023374e-07 1.44748737341 8.7106199187e-07 1.2 8.7109375e-07 0.952512626585 8.7112550813e-07 0.85 8.7115726626e-07 0.952512626585 8.7118902439e-07 1.2 8.7122078252e-07 1.44748737342 8.7125254065e-07 1.55 8.7128429878e-07 1.44748737342 8.71316056911e-07 1.2 8.71347815041e-07 0.952512626585 8.71379573171e-07 0.85 8.71411331301e-07 0.952512626585 8.71443089431e-07 1.2 8.71474847561e-07 1.44748737342 8.71506605691e-07 1.55 8.71538363821e-07 1.44748737342 8.71570121951e-07 1.2 8.71601880081e-07 0.952512626585 8.71633638211e-07 0.85 8.71665396341e-07 0.952512626584 8.71697154472e-07 1.2 8.71728912602e-07 1.44748737342 8.71760670732e-07 1.55 8.71792428862e-07 1.44748737342 8.71824186992e-07 1.2 8.71855945122e-07 0.952512626585 8.71887703252e-07 0.85 8.71919461382e-07 0.952512626584 8.71951219512e-07 1.2 8.71982977642e-07 1.44748737342 8.72014735772e-07 1.55 8.72046493902e-07 1.44748737342 8.72078252033e-07 1.2 8.72110010163e-07 0.952512626584 8.72141768293e-07 0.85 8.72173526423e-07 0.952512626584 8.72205284553e-07 1.2 8.72237042683e-07 1.44748737342 8.72268800813e-07 1.55 8.72300558943e-07 1.44748737342 8.72332317073e-07 1.2 8.72364075203e-07 0.952512626584 8.72395833333e-07 0.85 8.72427591463e-07 0.952512626585 8.72459349593e-07 1.2 8.72491107724e-07 1.44748737342 8.72522865854e-07 1.55 8.72554623984e-07 1.44748737342 8.72586382114e-07 1.2 8.72618140244e-07 0.952512626585 8.72649898374e-07 0.85 8.72681656504e-07 0.952512626585 8.72713414634e-07 1.2 8.72745172764e-07 1.44748737342 8.72776930894e-07 1.55 8.72808689024e-07 1.44748737342 8.72840447154e-07 1.2 8.72872205285e-07 0.952512626585 8.72903963415e-07 0.85 8.72935721545e-07 0.952512626584 8.72967479675e-07 1.2 8.72999237805e-07 1.44748737342 8.73030995935e-07 1.55 8.73062754065e-07 1.44748737342 8.73094512195e-07 1.2 8.73126270325e-07 0.952512626585 8.73158028455e-07 0.85 8.73189786585e-07 0.952512626584 8.73221544715e-07 1.2 8.73253302846e-07 1.44748737342 8.73285060976e-07 1.55 8.73316819106e-07 1.44748737342 8.73348577236e-07 1.2 8.73380335366e-07 0.952512626584 8.73412093496e-07 0.85 8.73443851626e-07 0.952512626584 8.73475609756e-07 1.2 8.73507367886e-07 1.44748737342 8.73539126016e-07 1.55 8.73570884146e-07 1.44748737342 8.73602642276e-07 1.2 8.73634400407e-07 0.952512626584 8.73666158537e-07 0.85 8.73697916667e-07 0.952512626585 8.73729674797e-07 1.2 8.73761432927e-07 1.44748737342 8.73793191057e-07 1.55 8.73824949187e-07 1.44748737342 8.73856707317e-07 1.2 8.73888465447e-07 0.952512626585 8.73920223577e-07 0.85 8.73951981707e-07 0.952512626585 8.73983739837e-07 1.2 8.74015497967e-07 1.44748737342 8.74047256098e-07 1.55 8.74079014228e-07 1.44748737342 8.74110772358e-07 1.2 8.74142530488e-07 0.952512626585 8.74174288618e-07 0.85 8.74206046748e-07 0.952512626585 8.74237804878e-07 1.2 8.74269563008e-07 1.44748737342 8.74301321138e-07 1.55 8.74333079268e-07 1.44748737342 8.74364837398e-07 1.2 8.74396595528e-07 0.952512626585 8.74428353659e-07 0.85 8.74460111789e-07 0.952512626585 8.74491869919e-07 1.2 8.74523628049e-07 1.44748737341 8.74555386179e-07 1.55 8.74587144309e-07 1.44748737342 8.74618902439e-07 1.2 8.74650660569e-07 0.952512626585 8.74682418699e-07 0.85 8.74714176829e-07 0.952512626585 8.74745934959e-07 1.2 8.74777693089e-07 1.44748737342 8.7480945122e-07 1.55 8.7484120935e-07 1.44748737342 8.7487296748e-07 1.2 8.7490472561e-07 0.952512626584 8.7493648374e-07 0.85 8.7496824187e-07 0.952512626584 8.75e-07 1.2 8.7503175813e-07 1.44748737342 8.7506351626e-07 1.55 8.7509527439e-07 1.44748737342 8.7512703252e-07 1.2 8.7515879065e-07 0.952512626585 8.7519054878e-07 0.85 8.75222306911e-07 0.952512626585 8.75254065041e-07 1.2 8.75285823171e-07 1.44748737342 8.75317581301e-07 1.55 8.75349339431e-07 1.44748737341 8.75381097561e-07 1.2 8.75412855691e-07 0.952512626585 8.75444613821e-07 0.85 8.75476371951e-07 0.952512626585 8.75508130081e-07 1.2 8.75539888211e-07 1.44748737341 8.75571646341e-07 1.55 8.75603404472e-07 1.44748737341 8.75635162602e-07 1.2 8.75666920732e-07 0.952512626585 8.75698678862e-07 0.85 8.75730436992e-07 0.952512626585 8.75762195122e-07 1.2 8.75793953252e-07 1.44748737341 8.75825711382e-07 1.55 8.75857469512e-07 1.44748737342 8.75889227642e-07 1.2 8.75920985772e-07 0.952512626585 8.75952743902e-07 0.85 8.75984502033e-07 0.952512626585 8.76016260163e-07 1.2 8.76048018293e-07 1.44748737342 8.76079776423e-07 1.55 8.76111534553e-07 1.44748737342 8.76143292683e-07 1.2 8.76175050813e-07 0.952512626585 8.76206808943e-07 0.85 8.76238567073e-07 0.952512626585 8.76270325203e-07 1.2 8.76302083333e-07 1.44748737342 8.76333841463e-07 1.55 8.76365599593e-07 1.44748737342 8.76397357724e-07 1.2 8.76429115854e-07 0.952512626585 8.76460873984e-07 0.85 8.76492632114e-07 0.952512626585 8.76524390244e-07 1.2 8.76556148374e-07 1.44748737342 8.76587906504e-07 1.55 8.76619664634e-07 1.44748737341 8.76651422764e-07 1.2 8.76683180894e-07 0.952512626585 8.76714939024e-07 0.85 8.76746697154e-07 0.952512626585 8.76778455285e-07 1.2 8.76810213415e-07 1.44748737341 8.76841971545e-07 1.55 8.76873729675e-07 1.44748737341 8.76905487805e-07 1.2 8.76937245935e-07 0.952512626585 8.76969004065e-07 0.85 8.77000762195e-07 0.952512626585 8.77032520325e-07 1.2 8.77064278455e-07 1.44748737341 8.77096036585e-07 1.55 8.77127794715e-07 1.44748737342 8.77159552846e-07 1.2 8.77191310976e-07 0.952512626585 8.77223069106e-07 0.85 8.77254827236e-07 0.952512626585 8.77286585366e-07 1.2 8.77318343496e-07 1.44748737341 8.77350101626e-07 1.55 8.77381859756e-07 1.44748737342 8.77413617886e-07 1.2 8.77445376016e-07 0.952512626585 8.77477134146e-07 0.85 8.77508892276e-07 0.952512626585 8.77540650407e-07 1.2 8.77572408537e-07 1.44748737342 8.77604166667e-07 1.55 8.77635924797e-07 1.44748737342 8.77667682927e-07 1.2 8.77699441057e-07 0.952512626585 8.77731199187e-07 0.85 8.77762957317e-07 0.952512626584 8.77794715447e-07 1.2 8.77826473577e-07 1.44748737342 8.77858231707e-07 1.55 8.77889989837e-07 1.44748737342 8.77921747967e-07 1.2 8.77953506098e-07 0.952512626585 8.77985264228e-07 0.85 8.78017022358e-07 0.952512626585 8.78048780488e-07 1.2 8.78080538618e-07 1.44748737342 8.78112296748e-07 1.55 8.78144054878e-07 1.44748737341 8.78175813008e-07 1.2 8.78207571138e-07 0.952512626585 8.78239329268e-07 0.85 8.78271087398e-07 0.952512626585 8.78302845528e-07 1.2 8.78334603659e-07 1.44748737342 8.78366361789e-07 1.55 8.78398119919e-07 1.44748737342 8.78429878049e-07 1.2 8.78461636179e-07 0.952512626585 8.78493394309e-07 0.85 8.78525152439e-07 0.952512626585 8.78556910569e-07 1.2 8.78588668699e-07 1.44748737341 8.78620426829e-07 1.55 8.78652184959e-07 1.44748737342 8.78683943089e-07 1.2 8.7871570122e-07 0.952512626585 8.7874745935e-07 0.85 8.7877921748e-07 0.952512626585 8.7881097561e-07 1.2 8.7884273374e-07 1.44748737342 8.7887449187e-07 1.55 8.7890625e-07 1.44748737342 8.7893800813e-07 1.2 8.7896976626e-07 0.952512626584 8.7900152439e-07 0.85 8.7903328252e-07 0.952512626584 8.7906504065e-07 1.2 8.7909679878e-07 1.44748737342 8.79128556911e-07 1.55 8.79160315041e-07 1.44748737342 8.79192073171e-07 1.2 8.79223831301e-07 0.952512626584 8.79255589431e-07 0.85 8.79287347561e-07 0.952512626585 8.79319105691e-07 1.2 8.79350863821e-07 1.44748737342 8.79382621951e-07 1.55 8.79414380081e-07 1.44748737342 8.79446138211e-07 1.2 8.79477896341e-07 0.952512626584 8.79509654472e-07 0.85 8.79541412602e-07 0.952512626585 8.79573170732e-07 1.2 8.79604928862e-07 1.44748737342 8.79636686992e-07 1.55 8.79668445122e-07 1.44748737342 8.79700203252e-07 1.2 8.79731961382e-07 0.952512626585 8.79763719512e-07 0.85 8.79795477642e-07 0.952512626585 8.79827235772e-07 1.2 8.79858993902e-07 1.44748737342 8.79890752033e-07 1.55 8.79922510163e-07 1.44748737342 8.79954268293e-07 1.2 8.79986026423e-07 0.952512626585 8.80017784553e-07 0.85 8.80049542683e-07 0.952512626584 8.80081300813e-07 1.2 8.80113058943e-07 1.44748737342 8.80144817073e-07 1.55 8.80176575203e-07 1.44748737342 8.80208333333e-07 1.2 8.80240091463e-07 0.952512626585 8.80271849593e-07 0.85 8.80303607724e-07 0.952512626584 8.80335365854e-07 1.2 8.80367123984e-07 1.44748737342 8.80398882114e-07 1.55 8.80430640244e-07 1.44748737342 8.80462398374e-07 1.2 8.80494156504e-07 0.952512626584 8.80525914634e-07 0.85 8.80557672764e-07 0.952512626584 8.80589430894e-07 1.2 8.80621189024e-07 1.44748737342 8.80652947154e-07 1.55 8.80684705285e-07 1.44748737342 8.80716463415e-07 1.2 8.80748221545e-07 0.952512626584 8.80779979675e-07 0.85 8.80811737805e-07 0.952512626585 8.80843495935e-07 1.2 8.80875254065e-07 1.44748737342 8.80907012195e-07 1.55 8.80938770325e-07 1.44748737342 8.80970528455e-07 1.2 8.81002286585e-07 0.952512626585 8.81034044715e-07 0.85 8.81065802846e-07 0.952512626585 8.81097560976e-07 1.2 8.81129319106e-07 1.44748737342 8.81161077236e-07 1.55 8.81192835366e-07 1.44748737342 8.81224593496e-07 1.2 8.81256351626e-07 0.952512626585 8.81288109756e-07 0.85 8.81319867886e-07 0.952512626584 8.81351626016e-07 1.2 8.81383384146e-07 1.44748737342 8.81415142276e-07 1.55 8.81446900407e-07 1.44748737342 8.81478658537e-07 1.2 8.81510416667e-07 0.952512626585 8.81542174797e-07 0.85 8.81573932927e-07 0.952512626584 8.81605691057e-07 1.2 8.81637449187e-07 1.44748737342 8.81669207317e-07 1.55 8.81700965447e-07 1.44748737342 8.81732723577e-07 1.2 8.81764481707e-07 0.952512626584 8.81796239837e-07 0.85 8.81827997967e-07 0.952512626584 8.81859756098e-07 1.2 8.81891514228e-07 1.44748737342 8.81923272358e-07 1.55 8.81955030488e-07 1.44748737342 8.81986788618e-07 1.2 8.82018546748e-07 0.952512626584 8.82050304878e-07 0.85 8.82082063008e-07 0.952512626585 8.82113821138e-07 1.2 8.82145579268e-07 1.44748737342 8.82177337398e-07 1.55 8.82209095528e-07 1.44748737342 8.82240853659e-07 1.2 8.82272611789e-07 0.952512626585 8.82304369919e-07 0.85 8.82336128049e-07 0.952512626585 8.82367886179e-07 1.2 8.82399644309e-07 1.44748737342 8.82431402439e-07 1.55 8.82463160569e-07 1.44748737342 8.82494918699e-07 1.2 8.82526676829e-07 0.952512626585 8.82558434959e-07 0.85 8.82590193089e-07 0.952512626585 8.8262195122e-07 1.2 8.8265370935e-07 1.44748737342 8.8268546748e-07 1.55 8.8271722561e-07 1.44748737342 8.8274898374e-07 1.2 8.8278074187e-07 0.952512626585 8.828125e-07 0.85 8.8284425813e-07 0.952512626585 8.8287601626e-07 1.2 8.8290777439e-07 1.44748737341 8.8293953252e-07 1.55 8.8297129065e-07 1.44748737342 8.8300304878e-07 1.2 8.83034806911e-07 0.952512626585 8.83066565041e-07 0.85 8.83098323171e-07 0.952512626585 8.83130081301e-07 1.2 8.83161839431e-07 1.44748737342 8.83193597561e-07 1.55 8.83225355691e-07 1.44748737342 8.83257113821e-07 1.2 8.83288871951e-07 0.952512626585 8.83320630081e-07 0.85 8.83352388211e-07 0.952512626585 8.83384146341e-07 1.2 8.83415904472e-07 1.44748737342 8.83447662602e-07 1.55 8.83479420732e-07 1.44748737342 8.83511178862e-07 1.2 8.83542936992e-07 0.952512626585 8.83574695122e-07 0.85 8.83606453252e-07 0.952512626585 8.83638211382e-07 1.2 8.83669969512e-07 1.44748737342 8.83701727642e-07 1.55 8.83733485772e-07 1.44748737341 8.83765243902e-07 1.2 8.83797002033e-07 0.952512626585 8.83828760163e-07 0.85 8.83860518293e-07 0.952512626585 8.83892276423e-07 1.2 8.83924034553e-07 1.44748737341 8.83955792683e-07 1.55 8.83987550813e-07 1.44748737341 8.84019308943e-07 1.2 8.84051067073e-07 0.952512626585 8.84082825203e-07 0.85 8.84114583333e-07 0.952512626585 8.84146341463e-07 1.2 8.84178099593e-07 1.44748737341 8.84209857724e-07 1.55 8.84241615854e-07 1.44748737342 8.84273373984e-07 1.2 8.84305132114e-07 0.952512626585 8.84336890244e-07 0.85 8.84368648374e-07 0.952512626585 8.84400406504e-07 1.2 8.84432164634e-07 1.44748737342 8.84463922764e-07 1.55 8.84495680894e-07 1.44748737342 8.84527439024e-07 1.2 8.84559197154e-07 0.952512626585 8.84590955285e-07 0.85 8.84622713415e-07 0.952512626585 8.84654471545e-07 1.2 8.84686229675e-07 1.44748737342 8.84717987805e-07 1.55 8.84749745935e-07 1.44748737342 8.84781504065e-07 1.2 8.84813262195e-07 0.952512626585 8.84845020325e-07 0.85 8.84876778455e-07 0.952512626585 8.84908536585e-07 1.2 8.84940294715e-07 1.44748737342 8.84972052846e-07 1.55 8.85003810976e-07 1.44748737341 8.85035569106e-07 1.2 8.85067327236e-07 0.952512626585 8.85099085366e-07 0.85 8.85130843496e-07 0.952512626585 8.85162601626e-07 1.2 8.85194359756e-07 1.44748737341 8.85226117886e-07 1.55 8.85257876016e-07 1.44748737341 8.85289634146e-07 1.2 8.85321392276e-07 0.952512626585 8.85353150407e-07 0.85 8.85384908537e-07 0.952512626585 8.85416666667e-07 1.2 8.85448424797e-07 1.44748737341 8.85480182927e-07 1.55 8.85511941057e-07 1.44748737342 8.85543699187e-07 1.2 8.85575457317e-07 0.952512626585 8.85607215447e-07 0.85 8.85638973577e-07 0.952512626585 8.85670731707e-07 1.2 8.85702489837e-07 1.44748737341 8.85734247967e-07 1.55 8.85766006098e-07 1.44748737342 8.85797764228e-07 1.2 8.85829522358e-07 0.952512626585 8.85861280488e-07 0.85 8.85893038618e-07 0.952512626585 8.85924796748e-07 1.2 8.85956554878e-07 1.44748737342 8.85988313008e-07 1.55 8.86020071138e-07 1.44748737342 8.86051829268e-07 1.2 8.86083587398e-07 0.952512626585 8.86115345528e-07 0.85 8.86147103659e-07 0.952512626584 8.86178861789e-07 1.2 8.86210619919e-07 1.44748737342 8.86242378049e-07 1.55 8.86274136179e-07 1.44748737342 8.86305894309e-07 1.2 8.86337652439e-07 0.952512626585 8.86369410569e-07 0.85 8.86401168699e-07 0.952512626585 8.86432926829e-07 1.2 8.86464684959e-07 1.44748737342 8.86496443089e-07 1.55 8.8652820122e-07 1.44748737341 8.8655995935e-07 1.2 8.8659171748e-07 0.952512626585 8.8662347561e-07 0.85 8.8665523374e-07 0.952512626585 8.8668699187e-07 1.2 8.8671875e-07 1.44748737342 8.8675050813e-07 1.55 8.8678226626e-07 1.44748737342 8.8681402439e-07 1.2 8.8684578252e-07 0.952512626585 8.8687754065e-07 0.85 8.8690929878e-07 0.952512626585 8.86941056911e-07 1.2 8.86972815041e-07 1.44748737342 8.87004573171e-07 1.55 8.87036331301e-07 1.44748737342 8.87068089431e-07 1.2 8.87099847561e-07 0.952512626585 8.87131605691e-07 0.85 8.87163363821e-07 0.952512626584 8.87195121951e-07 1.2 8.87226880081e-07 1.44748737342 8.87258638211e-07 1.55 8.87290396341e-07 1.44748737342 8.87322154472e-07 1.2 8.87353912602e-07 0.952512626584 8.87385670732e-07 0.85 8.87417428862e-07 0.952512626584 8.87449186992e-07 1.2 8.87480945122e-07 1.44748737342 8.87512703252e-07 1.55 8.87544461382e-07 1.44748737342 8.87576219512e-07 1.2 8.87607977642e-07 0.952512626584 8.87639735772e-07 0.85 8.87671493902e-07 0.952512626585 8.87703252033e-07 1.2 8.87735010163e-07 1.44748737342 8.87766768293e-07 1.55 8.87798526423e-07 1.44748737342 8.87830284553e-07 1.2 8.87862042683e-07 0.952512626584 8.87893800813e-07 0.85 8.87925558943e-07 0.952512626585 8.87957317073e-07 1.2 8.87989075203e-07 1.44748737342 8.88020833333e-07 1.55 8.88052591463e-07 1.44748737342 8.88084349593e-07 1.2 8.88116107724e-07 0.952512626585 8.88147865854e-07 0.85 8.88179623984e-07 0.952512626585 8.88211382114e-07 1.2 8.88243140244e-07 1.44748737342 8.88274898374e-07 1.55 8.88306656504e-07 1.44748737342 8.88338414634e-07 1.2 8.88370172764e-07 0.952512626585 8.88401930894e-07 0.85 8.88433689024e-07 0.952512626584 8.88465447154e-07 1.2 8.88497205285e-07 1.44748737342 8.88528963415e-07 1.55 8.88560721545e-07 1.44748737342 8.88592479675e-07 1.2 8.88624237805e-07 0.952512626585 8.88655995935e-07 0.85 8.88687754065e-07 0.952512626584 8.88719512195e-07 1.2 8.88751270325e-07 1.44748737342 8.88783028455e-07 1.55 8.88814786585e-07 1.44748737342 8.88846544715e-07 1.2 8.88878302846e-07 0.952512626584 8.88910060976e-07 0.85 8.88941819106e-07 0.952512626584 8.88973577236e-07 1.2 8.89005335366e-07 1.44748737342 8.89037093496e-07 1.55 8.89068851626e-07 1.44748737342 8.89100609756e-07 1.2 8.89132367886e-07 0.952512626584 8.89164126016e-07 0.85 8.89195884146e-07 0.952512626585 8.89227642276e-07 1.2 8.89259400407e-07 1.44748737342 8.89291158537e-07 1.55 8.89322916667e-07 1.44748737342 8.89354674797e-07 1.2 8.89386432927e-07 0.952512626585 8.89418191057e-07 0.85 8.89449949187e-07 0.952512626585 8.89481707317e-07 1.2 8.89513465447e-07 1.44748737342 8.89545223577e-07 1.55 8.89576981707e-07 1.44748737342 8.89608739837e-07 1.2 8.89640497967e-07 0.952512626585 8.89672256098e-07 0.85 8.89704014228e-07 0.952512626584 8.89735772358e-07 1.2 8.89767530488e-07 1.44748737342 8.89799288618e-07 1.55 8.89831046748e-07 1.44748737342 8.89862804878e-07 1.2 8.89894563008e-07 0.952512626585 8.89926321138e-07 0.85 8.89958079268e-07 0.952512626584 8.89989837398e-07 1.2 8.90021595528e-07 1.44748737342 8.90053353659e-07 1.55 8.90085111789e-07 1.44748737342 8.90116869919e-07 1.2 8.90148628049e-07 0.952512626584 8.90180386179e-07 0.85 8.90212144309e-07 0.952512626584 8.90243902439e-07 1.2 8.90275660569e-07 1.44748737342 8.90307418699e-07 1.55 8.90339176829e-07 1.44748737342 8.90370934959e-07 1.2 8.90402693089e-07 0.952512626584 8.9043445122e-07 0.85 8.9046620935e-07 0.952512626584 8.9049796748e-07 1.2 8.9052972561e-07 1.44748737342 8.9056148374e-07 1.55 8.9059324187e-07 1.44748737341 8.90625e-07 1.2 8.9065675813e-07 0.952512626585 8.9068851626e-07 0.85 8.9072027439e-07 0.952512626585 8.9075203252e-07 1.2 8.9078379065e-07 1.44748737342 8.9081554878e-07 1.55 8.90847306911e-07 1.44748737342 8.90879065041e-07 1.2 8.90910823171e-07 0.952512626585 8.90942581301e-07 0.85 8.90974339431e-07 0.952512626585 8.91006097561e-07 1.2 8.91037855691e-07 1.44748737341 8.91069613821e-07 1.55 8.91101371951e-07 1.44748737342 8.91133130081e-07 1.2 8.91164888211e-07 0.952512626585 8.91196646341e-07 0.85 8.91228404472e-07 0.952512626585 8.91260162602e-07 1.2 8.91291920732e-07 1.44748737341 8.91323678862e-07 1.55 8.91355436992e-07 1.44748737342 8.91387195122e-07 1.2 8.91418953252e-07 0.952512626585 8.91450711382e-07 0.85 8.91482469512e-07 0.952512626585 8.91514227642e-07 1.2 8.91545985772e-07 1.44748737342 8.91577743902e-07 1.55 8.91609502033e-07 1.44748737342 8.91641260163e-07 1.2 8.91673018293e-07 0.952512626585 8.91704776423e-07 0.85 8.91736534553e-07 0.952512626585 8.91768292683e-07 1.2 8.91800050813e-07 1.44748737342 8.91831808943e-07 1.55 8.91863567073e-07 1.44748737342 8.91895325203e-07 1.2 8.91927083333e-07 0.952512626585 8.91958841463e-07 0.85 8.91990599593e-07 0.952512626585 8.92022357724e-07 1.2 8.92054115854e-07 1.44748737342 8.92085873984e-07 1.55 8.92117632114e-07 1.44748737341 8.92149390244e-07 1.2 8.92181148374e-07 0.952512626585 8.92212906504e-07 0.85 8.92244664634e-07 0.952512626585 8.92276422764e-07 1.2 8.92308180894e-07 1.44748737341 8.92339939024e-07 1.55 8.92371697154e-07 1.44748737341 8.92403455285e-07 1.2 8.92435213415e-07 0.952512626585 8.92466971545e-07 0.85 8.92498729675e-07 0.952512626585 8.92530487805e-07 1.2 8.92562245935e-07 1.44748737341 8.92594004065e-07 1.55 8.92625762195e-07 1.44748737342 8.92657520325e-07 1.2 8.92689278455e-07 0.952512626585 8.92721036585e-07 0.85 8.92752794715e-07 0.952512626585 8.92784552846e-07 1.2 8.92816310976e-07 1.44748737342 8.92848069106e-07 1.55 8.92879827236e-07 1.44748737342 8.92911585366e-07 1.2 8.92943343496e-07 0.952512626585 8.92975101626e-07 0.85 8.93006859756e-07 0.952512626585 8.93038617886e-07 1.2 8.93070376016e-07 1.44748737342 8.93102134146e-07 1.55 8.93133892276e-07 1.44748737342 8.93165650407e-07 1.2 8.93197408537e-07 0.952512626585 8.93229166667e-07 0.85 8.93260924797e-07 0.952512626584 8.93292682927e-07 1.2 8.93324441057e-07 1.44748737342 8.93356199187e-07 1.55 8.93387957317e-07 1.44748737341 8.93419715447e-07 1.2 8.93451473577e-07 0.952512626585 8.93483231707e-07 0.85 8.93514989837e-07 0.952512626585 8.93546747967e-07 1.2 8.93578506098e-07 1.44748737341 8.93610264228e-07 1.55 8.93642022358e-07 1.44748737341 8.93673780488e-07 1.2 8.93705538618e-07 0.952512626585 8.93737296748e-07 0.85 8.93769054878e-07 0.952512626585 8.93800813008e-07 1.2 8.93832571138e-07 1.44748737341 8.93864329268e-07 1.55 8.93896087398e-07 1.44748737342 8.93927845528e-07 1.2 8.93959603659e-07 0.952512626585 8.93991361789e-07 0.85 8.94023119919e-07 0.952512626585 8.94054878049e-07 1.2 8.94086636179e-07 1.44748737341 8.94118394309e-07 1.55 8.94150152439e-07 1.44748737342 8.94181910569e-07 1.2 8.94213668699e-07 0.952512626585 8.94245426829e-07 0.85 8.94277184959e-07 0.952512626585 8.94308943089e-07 1.2 8.9434070122e-07 1.44748737342 8.9437245935e-07 1.55 8.9440421748e-07 1.44748737342 8.9443597561e-07 1.2 8.9446773374e-07 0.952512626585 8.9449949187e-07 0.85 8.9453125e-07 0.952512626584 8.9456300813e-07 1.2 8.9459476626e-07 1.44748737342 8.9462652439e-07 1.55 8.9465828252e-07 1.44748737342 8.9469004065e-07 1.2 8.9472179878e-07 0.952512626585 8.94753556911e-07 0.85 8.94785315041e-07 0.952512626585 8.94817073171e-07 1.2 8.94848831301e-07 1.44748737342 8.94880589431e-07 1.55 8.94912347561e-07 1.44748737342 8.94944105691e-07 1.2 8.94975863821e-07 0.952512626585 8.95007621951e-07 0.85 8.95039380081e-07 0.952512626585 8.95071138211e-07 1.2 8.95102896341e-07 1.44748737342 8.95134654472e-07 1.55 8.95166412602e-07 1.44748737342 8.95198170732e-07 1.2 8.95229928862e-07 0.952512626585 8.95261686992e-07 0.85 8.95293445122e-07 0.952512626585 8.95325203252e-07 1.2 8.95356961382e-07 1.44748737342 8.95388719512e-07 1.55 8.95420477642e-07 1.44748737342 8.95452235772e-07 1.2 8.95483993902e-07 0.952512626585 8.95515752033e-07 0.85 8.95547510163e-07 0.952512626584 8.95579268293e-07 1.2 8.95611026423e-07 1.44748737342 8.95642784553e-07 1.55 8.95674542683e-07 1.44748737342 8.95706300813e-07 1.2 8.95738058943e-07 0.952512626584 8.95769817073e-07 0.85 8.95801575203e-07 0.952512626584 8.95833333333e-07 1.2 8.95865091463e-07 1.44748737342 8.95896849593e-07 1.55 8.95928607724e-07 1.44748737342 8.95960365854e-07 1.2 8.95992123984e-07 0.952512626584 8.96023882114e-07 0.85 8.96055640244e-07 0.952512626584 8.96087398374e-07 1.2 8.96119156504e-07 1.44748737342 8.96150914634e-07 1.55 8.96182672764e-07 1.44748737342 8.96214430894e-07 1.2 8.96246189024e-07 0.952512626584 8.96277947154e-07 0.85 8.96309705285e-07 0.952512626585 8.96341463415e-07 1.2 8.96373221545e-07 1.44748737342 8.96404979675e-07 1.55 8.96436737805e-07 1.44748737342 8.96468495935e-07 1.2 8.96500254065e-07 0.952512626585 8.96532012195e-07 0.85 8.96563770325e-07 0.952512626585 8.96595528455e-07 1.2 8.96627286585e-07 1.44748737342 8.96659044715e-07 1.55 8.96690802846e-07 1.44748737342 8.96722560976e-07 1.2 8.96754319106e-07 0.952512626585 8.96786077236e-07 0.85 8.96817835366e-07 0.952512626584 8.96849593496e-07 1.2 8.96881351626e-07 1.44748737342 8.96913109756e-07 1.55 8.96944867886e-07 1.44748737342 8.96976626016e-07 1.2 8.97008384146e-07 0.952512626585 8.97040142276e-07 0.85 8.97071900407e-07 0.952512626584 8.97103658537e-07 1.2 8.97135416667e-07 1.44748737342 8.97167174797e-07 1.55 8.97198932927e-07 1.44748737342 8.97230691057e-07 1.2 8.97262449187e-07 0.952512626584 8.97294207317e-07 0.85 8.97325965447e-07 0.952512626584 8.97357723577e-07 1.2 8.97389481707e-07 1.44748737342 8.97421239837e-07 1.55 8.97452997967e-07 1.44748737342 8.97484756098e-07 1.2 8.97516514228e-07 0.952512626584 8.97548272358e-07 0.85 8.97580030488e-07 0.952512626585 8.97611788618e-07 1.2 8.97643546748e-07 1.44748737342 8.97675304878e-07 1.55 8.97707063008e-07 1.44748737342 8.97738821138e-07 1.2 8.97770579268e-07 0.952512626585 8.97802337398e-07 0.85 8.97834095528e-07 0.952512626585 8.97865853659e-07 1.2 8.97897611789e-07 1.44748737342 8.97929369919e-07 1.55 8.97961128049e-07 1.44748737342 8.97992886179e-07 1.2 8.98024644309e-07 0.952512626585 8.98056402439e-07 0.85 8.98088160569e-07 0.952512626585 8.98119918699e-07 1.2 8.98151676829e-07 1.44748737342 8.98183434959e-07 1.55 8.98215193089e-07 1.44748737342 8.9824695122e-07 1.2 8.9827870935e-07 0.952512626585 8.9831046748e-07 0.85 8.9834222561e-07 0.952512626584 8.9837398374e-07 1.2 8.9840574187e-07 1.44748737342 8.984375e-07 1.55 8.9846925813e-07 1.44748737342 8.9850101626e-07 1.2 8.9853277439e-07 0.952512626584 8.9856453252e-07 0.85 8.9859629065e-07 0.952512626584 8.9862804878e-07 1.2 8.98659806911e-07 1.44748737342 8.98691565041e-07 1.55 8.98723323171e-07 1.44748737342 8.98755081301e-07 1.2 8.98786839431e-07 0.952512626585 8.98818597561e-07 0.85 8.98850355691e-07 0.952512626584 8.98882113821e-07 1.2 8.98913871951e-07 1.44748737342 8.98945630081e-07 1.55 8.98977388211e-07 1.44748737341 8.99009146341e-07 1.2 8.99040904472e-07 0.952512626585 8.99072662602e-07 0.85 8.99104420732e-07 0.952512626585 8.99136178862e-07 1.2 8.99167936992e-07 1.44748737342 8.99199695122e-07 1.55 8.99231453252e-07 1.44748737341 8.99263211382e-07 1.2 8.99294969512e-07 0.952512626585 8.99326727642e-07 0.85 8.99358485772e-07 0.952512626585 8.99390243902e-07 1.2 8.99422002033e-07 1.44748737341 8.99453760163e-07 1.55 8.99485518293e-07 1.44748737342 8.99517276423e-07 1.2 8.99549034553e-07 0.952512626585 8.99580792683e-07 0.85 8.99612550813e-07 0.952512626585 8.99644308943e-07 1.2 8.99676067073e-07 1.44748737341 8.99707825203e-07 1.55 8.99739583333e-07 1.44748737342 8.99771341463e-07 1.2 8.99803099593e-07 0.952512626585 8.99834857724e-07 0.85 8.99866615854e-07 0.952512626585 8.99898373984e-07 1.2 8.99930132114e-07 1.44748737342 8.99961890244e-07 1.55 8.99993648374e-07 1.44748737342 9.00025406504e-07 1.2 9.00057164634e-07 0.952512626585 9.00088922764e-07 0.85 9.00120680894e-07 0.952512626585 9.00152439024e-07 1.2 9.00184197154e-07 1.44748737342 9.00215955285e-07 1.55 9.00247713415e-07 1.44748737342 9.00279471545e-07 1.2 9.00311229675e-07 0.952512626585 9.00342987805e-07 0.85 9.00374745935e-07 0.952512626585 9.00406504065e-07 1.2 9.00438262195e-07 1.44748737342 9.00470020325e-07 1.55 9.00501778455e-07 1.44748737341 9.00533536585e-07 1.2 9.00565294715e-07 0.952512626585 9.00597052846e-07 0.85 9.00628810976e-07 0.952512626585 9.00660569106e-07 1.2 9.00692327236e-07 1.44748737341 9.00724085366e-07 1.55 9.00755843496e-07 1.44748737341 9.00787601626e-07 1.2 9.00819359756e-07 0.952512626585 9.00851117886e-07 0.85 9.00882876016e-07 0.952512626585 9.00914634146e-07 1.2 9.00946392276e-07 1.44748737341 9.00978150407e-07 1.55 9.01009908537e-07 1.44748737342 9.01041666667e-07 1.2 9.01073424797e-07 0.952512626585 9.01105182927e-07 0.85 9.01136941057e-07 0.952512626585 9.01168699187e-07 1.2 9.01200457317e-07 1.44748737342 9.01232215447e-07 1.55 9.01263973577e-07 1.44748737342 9.01295731707e-07 1.2 9.01327489837e-07 0.952512626585 9.01359247967e-07 0.85 9.01391006098e-07 0.952512626585 9.01422764228e-07 1.2 9.01454522358e-07 1.44748737342 9.01486280488e-07 1.55 9.01518038618e-07 1.44748737342 9.01549796748e-07 1.2 9.01581554878e-07 0.952512626585 9.01613313008e-07 0.85 9.01645071138e-07 0.952512626584 9.01676829268e-07 1.2 9.01708587398e-07 1.44748737342 9.01740345528e-07 1.55 9.01772103659e-07 1.44748737341 9.01803861789e-07 1.2 9.01835619919e-07 0.952512626585 9.01867378049e-07 0.85 9.01899136179e-07 0.952512626585 9.01930894309e-07 1.2 9.01962652439e-07 1.44748737341 9.01994410569e-07 1.55 9.02026168699e-07 1.44748737341 9.02057926829e-07 1.2 9.02089684959e-07 0.952512626585 9.02121443089e-07 0.85 9.0215320122e-07 0.952512626585 9.0218495935e-07 1.2 9.0221671748e-07 1.44748737341 9.0224847561e-07 1.55 9.0228023374e-07 1.44748737342 9.0231199187e-07 1.2 9.0234375e-07 0.952512626585 9.0237550813e-07 0.85 9.0240726626e-07 0.952512626585 9.0243902439e-07 1.2 9.0247078252e-07 1.44748737341 9.0250254065e-07 1.55 9.0253429878e-07 1.44748737342 9.02566056911e-07 1.2 9.02597815041e-07 0.952512626585 9.02629573171e-07 0.85 9.02661331301e-07 0.952512626585 9.02693089431e-07 1.2 9.02724847561e-07 1.44748737342 9.02756605691e-07 1.55 9.02788363821e-07 1.44748737342 9.02820121951e-07 1.2 9.02851880081e-07 0.952512626584 9.02883638211e-07 0.85 9.02915396341e-07 0.952512626584 9.02947154472e-07 1.2 9.02978912602e-07 1.44748737342 9.03010670732e-07 1.55 9.03042428862e-07 1.44748737342 9.03074186992e-07 1.2 9.03105945122e-07 0.952512626585 9.03137703252e-07 0.85 9.03169461382e-07 0.952512626585 9.03201219512e-07 1.2 9.03232977642e-07 1.44748737342 9.03264735772e-07 1.55 9.03296493902e-07 1.44748737342 9.03328252033e-07 1.2 9.03360010163e-07 0.952512626585 9.03391768293e-07 0.85 9.03423526423e-07 0.952512626585 9.03455284553e-07 1.2 9.03487042683e-07 1.44748737342 9.03518800813e-07 1.55 9.03550558943e-07 1.44748737342 9.03582317073e-07 1.2 9.03614075203e-07 0.952512626585 9.03645833333e-07 0.85 9.03677591463e-07 0.952512626585 9.03709349593e-07 1.2 9.03741107724e-07 1.44748737342 9.03772865854e-07 1.55 9.03804623984e-07 1.44748737342 9.03836382114e-07 1.2 9.03868140244e-07 0.952512626585 9.03899898374e-07 0.85 9.03931656504e-07 0.952512626584 9.03963414634e-07 1.2 9.03995172764e-07 1.44748737342 9.04026930894e-07 1.55 9.04058689024e-07 1.44748737342 9.04090447154e-07 1.2 9.04122205285e-07 0.952512626584 9.04153963415e-07 0.85 9.04185721545e-07 0.952512626584 9.04217479675e-07 1.2 9.04249237805e-07 1.44748737342 9.04280995935e-07 1.55 9.04312754065e-07 1.44748737342 9.04344512195e-07 1.2 9.04376270325e-07 0.952512626584 9.04408028455e-07 0.85 9.04439786585e-07 0.952512626584 9.04471544715e-07 1.2 9.04503302846e-07 1.44748737342 9.04535060976e-07 1.55 9.04566819106e-07 1.44748737342 9.04598577236e-07 1.2 9.04630335366e-07 0.952512626584 9.04662093496e-07 0.85 9.04693851626e-07 0.952512626585 9.04725609756e-07 1.2 9.04757367886e-07 1.44748737342 9.04789126016e-07 1.55 9.04820884146e-07 1.44748737342 9.04852642276e-07 1.2 9.04884400407e-07 0.952512626585 9.04916158537e-07 0.85 9.04947916667e-07 0.952512626585 9.04979674797e-07 1.2 9.05011432927e-07 1.44748737342 9.05043191057e-07 1.55 9.05074949187e-07 1.44748737342 9.05106707317e-07 1.2 9.05138465447e-07 0.952512626585 9.05170223577e-07 0.85 9.05201981707e-07 0.952512626584 9.05233739837e-07 1.2 9.05265497967e-07 1.44748737342 9.05297256098e-07 1.55 9.05329014228e-07 1.44748737342 9.05360772358e-07 1.2 9.05392530488e-07 0.952512626585 9.05424288618e-07 0.85 9.05456046748e-07 0.952512626584 9.05487804878e-07 1.2 9.05519563008e-07 1.44748737342 9.05551321138e-07 1.55 9.05583079268e-07 1.44748737342 9.05614837398e-07 1.2 9.05646595528e-07 0.952512626584 9.05678353659e-07 0.85 9.05710111789e-07 0.952512626584 9.05741869919e-07 1.2 9.05773628049e-07 1.44748737342 9.05805386179e-07 1.55 9.05837144309e-07 1.44748737342 9.05868902439e-07 1.2 9.05900660569e-07 0.952512626584 9.05932418699e-07 0.85 9.05964176829e-07 0.952512626585 9.05995934959e-07 1.2 9.06027693089e-07 1.44748737342 9.0605945122e-07 1.55 9.0609120935e-07 1.44748737342 9.0612296748e-07 1.2 9.0615472561e-07 0.952512626585 9.0618648374e-07 0.85 9.0621824187e-07 0.952512626585 9.0625e-07 1.2 9.0628175813e-07 1.44748737342 9.0631351626e-07 1.55 9.0634527439e-07 1.44748737342 9.0637703252e-07 1.2 9.0640879065e-07 0.952512626585 9.0644054878e-07 0.85 9.06472306911e-07 0.952512626585 9.06504065041e-07 1.2 9.06535823171e-07 1.44748737342 9.06567581301e-07 1.55 9.06599339431e-07 1.44748737342 9.06631097561e-07 1.2 9.06662855691e-07 0.952512626585 9.06694613821e-07 0.85 9.06726371951e-07 0.952512626584 9.06758130081e-07 1.2 9.06789888211e-07 1.44748737342 9.06821646341e-07 1.55 9.06853404472e-07 1.44748737342 9.06885162602e-07 1.2 9.06916920732e-07 0.952512626584 9.06948678862e-07 0.85 9.06980436992e-07 0.952512626584 9.07012195122e-07 1.2 9.07043953252e-07 1.44748737342 9.07075711382e-07 1.55 9.07107469512e-07 1.44748737342 9.07139227642e-07 1.2 9.07170985772e-07 0.952512626585 9.07202743902e-07 0.85 9.07234502033e-07 0.952512626584 9.07266260163e-07 1.2 9.07298018293e-07 1.44748737342 9.07329776423e-07 1.55 9.07361534553e-07 1.44748737341 9.07393292683e-07 1.2 9.07425050813e-07 0.952512626585 9.07456808943e-07 0.85 9.07488567073e-07 0.952512626585 9.07520325203e-07 1.2 9.07552083333e-07 1.44748737342 9.07583841463e-07 1.55 9.07615599593e-07 1.44748737341 9.07647357724e-07 1.2 9.07679115854e-07 0.952512626585 9.07710873984e-07 0.85 9.07742632114e-07 0.952512626585 9.07774390244e-07 1.2 9.07806148374e-07 1.44748737341 9.07837906504e-07 1.55 9.07869664634e-07 1.44748737341 9.07901422764e-07 1.2 9.07933180894e-07 0.952512626585 9.07964939024e-07 0.85 9.07996697154e-07 0.952512626585 9.08028455285e-07 1.2 9.08060213415e-07 1.44748737341 9.08091971545e-07 1.55 9.08123729675e-07 1.44748737342 9.08155487805e-07 1.2 9.08187245935e-07 0.952512626585 9.08219004065e-07 0.85 9.08250762195e-07 0.952512626585 9.08282520325e-07 1.2 9.08314278455e-07 1.44748737342 9.08346036585e-07 1.55 9.08377794715e-07 1.44748737342 9.08409552846e-07 1.2 9.08441310976e-07 0.952512626585 9.08473069106e-07 0.85 9.08504827236e-07 0.952512626585 9.08536585366e-07 1.2 9.08568343496e-07 1.44748737342 9.08600101626e-07 1.55 9.08631859756e-07 1.44748737342 9.08663617886e-07 1.2 9.08695376016e-07 0.952512626585 9.08727134146e-07 0.85 9.08758892276e-07 0.952512626585 9.08790650407e-07 1.2 9.08822408537e-07 1.44748737342 9.08854166667e-07 1.55 9.08885924797e-07 1.44748737341 9.08917682927e-07 1.2 9.08949441057e-07 0.952512626585 9.08981199187e-07 0.85 9.09012957317e-07 0.952512626585 9.09044715447e-07 1.2 9.09076473577e-07 1.44748737341 9.09108231707e-07 1.55 9.09139989837e-07 1.44748737341 9.09171747967e-07 1.2 9.09203506098e-07 0.952512626585 9.09235264228e-07 0.85 9.09267022358e-07 0.952512626585 9.09298780488e-07 1.2 9.09330538618e-07 1.44748737341 9.09362296748e-07 1.55 9.09394054878e-07 1.44748737342 9.09425813008e-07 1.2 9.09457571138e-07 0.952512626585 9.09489329268e-07 0.85 9.09521087398e-07 0.952512626585 9.09552845528e-07 1.2 9.09584603659e-07 1.44748737342 9.09616361789e-07 1.55 9.09648119919e-07 1.44748737342 9.09679878049e-07 1.2 9.09711636179e-07 0.952512626585 9.09743394309e-07 0.85 9.09775152439e-07 0.952512626585 9.09806910569e-07 1.2 9.09838668699e-07 1.44748737342 9.09870426829e-07 1.55 9.09902184959e-07 1.44748737342 9.09933943089e-07 1.2 9.0996570122e-07 0.952512626585 9.0999745935e-07 0.85 9.1002921748e-07 0.952512626584 9.1006097561e-07 1.2 9.1009273374e-07 1.44748737342 9.1012449187e-07 1.55 9.1015625e-07 1.44748737341 9.1018800813e-07 1.2 9.1021976626e-07 0.952512626585 9.1025152439e-07 0.85 9.1028328252e-07 0.952512626585 9.1031504065e-07 1.2 9.1034679878e-07 1.44748737342 9.10378556911e-07 1.55 9.10410315041e-07 1.44748737341 9.10442073171e-07 1.2 9.10473831301e-07 0.952512626585 9.10505589431e-07 0.85 9.10537347561e-07 0.952512626585 9.10569105691e-07 1.2 9.10600863821e-07 1.44748737341 9.10632621951e-07 1.55 9.10664380081e-07 1.44748737342 9.10696138211e-07 1.2 9.10727896341e-07 0.952512626585 9.10759654472e-07 0.85 9.10791412602e-07 0.952512626585 9.10823170732e-07 1.2 9.10854928862e-07 1.44748737341 9.10886686992e-07 1.55 9.10918445122e-07 1.44748737342 9.10950203252e-07 1.2 9.10981961382e-07 0.952512626585 9.11013719512e-07 0.85 9.11045477642e-07 0.952512626584 9.11077235772e-07 1.2 9.11108993902e-07 1.44748737342 9.11140752033e-07 1.55 9.11172510163e-07 1.44748737342 9.11204268293e-07 1.2 9.11236026423e-07 0.952512626584 9.11267784553e-07 0.85 9.11299542683e-07 0.952512626584 9.11331300813e-07 1.2 9.11363058943e-07 1.44748737342 9.11394817073e-07 1.55 9.11426575203e-07 1.44748737342 9.11458333333e-07 1.2 9.11490091463e-07 0.952512626584 9.11521849593e-07 0.85 9.11553607724e-07 0.952512626585 9.11585365854e-07 1.2 9.11617123984e-07 1.44748737342 9.11648882114e-07 1.55 9.11680640244e-07 1.44748737342 9.11712398374e-07 1.2 9.11744156504e-07 0.952512626585 9.11775914634e-07 0.85 9.11807672764e-07 0.952512626585 9.11839430894e-07 1.2 9.11871189024e-07 1.44748737342 9.11902947154e-07 1.55 9.11934705285e-07 1.44748737342 9.11966463415e-07 1.2 9.11998221545e-07 0.952512626585 9.12029979675e-07 0.85 9.12061737805e-07 0.952512626585 9.12093495935e-07 1.2 9.12125254065e-07 1.44748737342 9.12157012195e-07 1.55 9.12188770325e-07 1.44748737342 9.12220528455e-07 1.2 9.12252286585e-07 0.952512626585 9.12284044715e-07 0.85 9.12315802846e-07 0.952512626584 9.12347560976e-07 1.2 9.12379319106e-07 1.44748737342 9.12411077236e-07 1.55 9.12442835366e-07 1.44748737342 9.12474593496e-07 1.2 9.12506351626e-07 0.952512626584 9.12538109756e-07 0.85 9.12569867886e-07 0.952512626584 9.12601626016e-07 1.2 9.12633384146e-07 1.44748737342 9.12665142276e-07 1.55 9.12696900407e-07 1.44748737342 9.12728658537e-07 1.2 9.12760416667e-07 0.952512626584 9.12792174797e-07 0.85 9.12823932927e-07 0.952512626584 9.12855691057e-07 1.2 9.12887449187e-07 1.44748737342 9.12919207317e-07 1.55 9.12950965447e-07 1.44748737342 9.12982723577e-07 1.2 9.13014481707e-07 0.952512626584 9.13046239837e-07 0.85 9.13077997967e-07 0.952512626585 9.13109756098e-07 1.2 9.13141514228e-07 1.44748737342 9.13173272358e-07 1.55 9.13205030488e-07 1.44748737342 9.13236788618e-07 1.2 9.13268546748e-07 0.952512626585 9.13300304878e-07 0.85 9.13332063008e-07 0.952512626585 9.13363821138e-07 1.2 9.13395579268e-07 1.44748737342 9.13427337398e-07 1.55 9.13459095528e-07 1.44748737342 9.13490853659e-07 1.2 9.13522611789e-07 0.952512626585 9.13554369919e-07 0.85 9.13586128049e-07 0.952512626584 9.13617886179e-07 1.2 9.13649644309e-07 1.44748737342 9.13681402439e-07 1.55 9.13713160569e-07 1.44748737342 9.13744918699e-07 1.2 9.13776676829e-07 0.952512626585 9.13808434959e-07 0.85 9.13840193089e-07 0.952512626584 9.1387195122e-07 1.2 9.1390370935e-07 1.44748737342 9.1393546748e-07 1.55 9.1396722561e-07 1.44748737342 9.1399898374e-07 1.2 9.1403074187e-07 0.952512626584 9.140625e-07 0.85 9.1409425813e-07 0.952512626584 9.1412601626e-07 1.2 9.1415777439e-07 1.44748737342 9.1418953252e-07 1.55 9.1422129065e-07 1.44748737342 9.1425304878e-07 1.2 9.14284806911e-07 0.952512626584 9.14316565041e-07 0.85 9.14348323171e-07 0.952512626585 9.14380081301e-07 1.2 9.14411839431e-07 1.44748737342 9.14443597561e-07 1.55 9.14475355691e-07 1.44748737342 9.14507113821e-07 1.2 9.14538871951e-07 0.952512626585 9.14570630081e-07 0.85 9.14602388211e-07 0.952512626585 9.14634146341e-07 1.2 9.14665904472e-07 1.44748737342 9.14697662602e-07 1.55 9.14729420732e-07 1.44748737342 9.14761178862e-07 1.2 9.14792936992e-07 0.952512626585 9.14824695122e-07 0.85 9.14856453252e-07 0.952512626585 9.14888211382e-07 1.2 9.14919969512e-07 1.44748737341 9.14951727642e-07 1.55 9.14983485772e-07 1.44748737342 9.15015243902e-07 1.2 9.15047002033e-07 0.952512626585 9.15078760163e-07 0.85 9.15110518293e-07 0.952512626585 9.15142276423e-07 1.2 9.15174034553e-07 1.44748737341 9.15205792683e-07 1.55 9.15237550813e-07 1.44748737342 9.15269308943e-07 1.2 9.15301067073e-07 0.952512626584 9.15332825203e-07 0.85 9.15364583333e-07 0.952512626584 9.15396341463e-07 1.2 9.15428099593e-07 1.44748737342 9.15459857724e-07 1.55 9.15491615854e-07 1.44748737342 9.15523373984e-07 1.2 9.15555132114e-07 0.952512626585 9.15586890244e-07 0.85 9.15618648374e-07 0.952512626584 9.15650406504e-07 1.2 9.15682164634e-07 1.44748737342 9.15713922764e-07 1.55 9.15745680894e-07 1.44748737341 9.15777439024e-07 1.2 9.15809197154e-07 0.952512626585 9.15840955285e-07 0.85 9.15872713415e-07 0.952512626585 9.15904471545e-07 1.2 9.15936229675e-07 1.44748737342 9.15967987805e-07 1.55 9.15999745935e-07 1.44748737341 9.16031504065e-07 1.2 9.16063262195e-07 0.952512626585 9.16095020325e-07 0.85 9.16126778455e-07 0.952512626585 9.16158536585e-07 1.2 9.16190294715e-07 1.44748737341 9.16222052846e-07 1.55 9.16253810976e-07 1.44748737341 9.16285569106e-07 1.2 9.16317327236e-07 0.952512626585 9.16349085366e-07 0.85 9.16380843496e-07 0.952512626585 9.16412601626e-07 1.2 9.16444359756e-07 1.44748737341 9.16476117886e-07 1.55 9.16507876016e-07 1.44748737342 9.16539634146e-07 1.2 9.16571392276e-07 0.952512626585 9.16603150407e-07 0.85 9.16634908537e-07 0.952512626585 9.16666666667e-07 1.2 9.16698424797e-07 1.44748737342 9.16730182927e-07 1.55 9.16761941057e-07 1.44748737342 9.16793699187e-07 1.2 9.16825457317e-07 0.952512626585 9.16857215447e-07 0.85 9.16888973577e-07 0.952512626585 9.16920731707e-07 1.2 9.16952489837e-07 1.44748737342 9.16984247967e-07 1.55 9.17016006098e-07 1.44748737342 9.17047764228e-07 1.2 9.17079522358e-07 0.952512626585 9.17111280488e-07 0.85 9.17143038618e-07 0.952512626585 9.17174796748e-07 1.2 9.17206554878e-07 1.44748737342 9.17238313008e-07 1.55 9.17270071138e-07 1.44748737341 9.17301829268e-07 1.2 9.17333587398e-07 0.952512626585 9.17365345528e-07 0.85 9.17397103659e-07 0.952512626585 9.17428861789e-07 1.2 9.17460619919e-07 1.44748737341 9.17492378049e-07 1.55 9.17524136179e-07 1.44748737341 9.17555894309e-07 1.2 9.17587652439e-07 0.952512626585 9.17619410569e-07 0.85 9.17651168699e-07 0.952512626585 9.17682926829e-07 1.2 9.17714684959e-07 1.44748737341 9.17746443089e-07 1.55 9.1777820122e-07 1.44748737342 9.1780995935e-07 1.2 9.1784171748e-07 0.952512626585 9.1787347561e-07 0.85 9.1790523374e-07 0.952512626585 9.1793699187e-07 1.2 9.1796875e-07 1.44748737341 9.1800050813e-07 1.55 9.1803226626e-07 1.44748737342 9.1806402439e-07 1.2 9.1809578252e-07 0.952512626585 9.1812754065e-07 0.85 9.1815929878e-07 0.952512626585 9.18191056911e-07 1.2 9.18222815041e-07 1.44748737342 9.18254573171e-07 1.55 9.18286331301e-07 1.44748737342 9.18318089431e-07 1.2 9.18349847561e-07 0.952512626585 9.18381605691e-07 0.85 9.18413363821e-07 0.952512626584 9.18445121951e-07 1.2 9.18476880081e-07 1.44748737342 9.18508638211e-07 1.55 9.18540396341e-07 1.44748737341 9.18572154472e-07 1.2 9.18603912602e-07 0.952512626585 9.18635670732e-07 0.85 9.18667428862e-07 0.952512626585 9.18699186992e-07 1.2 9.18730945122e-07 1.44748737342 9.18762703252e-07 1.55 9.18794461382e-07 1.44748737342 9.18826219512e-07 1.2 9.18857977642e-07 0.952512626585 9.18889735772e-07 0.85 9.18921493902e-07 0.952512626585 9.18953252033e-07 1.2 9.18985010163e-07 1.44748737342 9.19016768293e-07 1.55 9.19048526423e-07 1.44748737342 9.19080284553e-07 1.2 9.19112042683e-07 0.952512626585 9.19143800813e-07 0.85 9.19175558943e-07 0.952512626585 9.19207317073e-07 1.2 9.19239075203e-07 1.44748737341 9.19270833333e-07 1.55 9.19302591463e-07 1.44748737342 9.19334349593e-07 1.2 9.19366107724e-07 0.952512626585 9.19397865854e-07 0.85 9.19429623984e-07 0.952512626584 9.19461382114e-07 1.2 9.19493140244e-07 1.44748737342 9.19524898374e-07 1.55 9.19556656504e-07 1.44748737342 9.19588414634e-07 1.2 9.19620172764e-07 0.952512626584 9.19651930894e-07 0.85 9.19683689024e-07 0.952512626584 9.19715447154e-07 1.2 9.19747205285e-07 1.44748737342 9.19778963415e-07 1.55 9.19810721545e-07 1.44748737342 9.19842479675e-07 1.2 9.19874237805e-07 0.952512626584 9.19905995935e-07 0.85 9.19937754065e-07 0.952512626585 9.19969512195e-07 1.2 9.20001270325e-07 1.44748737342 9.20033028455e-07 1.55 9.20064786585e-07 1.44748737342 9.20096544715e-07 1.2 9.20128302846e-07 0.952512626584 9.20160060976e-07 0.85 9.20191819106e-07 0.952512626585 9.20223577236e-07 1.2 9.20255335366e-07 1.44748737342 9.20287093496e-07 1.55 9.20318851626e-07 1.44748737342 9.20350609756e-07 1.2 9.20382367886e-07 0.952512626585 9.20414126016e-07 0.85 9.20445884146e-07 0.952512626585 9.20477642276e-07 1.2 9.20509400407e-07 1.44748737342 9.20541158537e-07 1.55 9.20572916667e-07 1.44748737342 9.20604674797e-07 1.2 9.20636432927e-07 0.952512626585 9.20668191057e-07 0.85 9.20699949187e-07 0.952512626584 9.20731707317e-07 1.2 9.20763465447e-07 1.44748737342 9.20795223577e-07 1.55 9.20826981707e-07 1.44748737342 9.20858739837e-07 1.2 9.20890497967e-07 0.952512626584 9.20922256098e-07 0.85 9.20954014228e-07 0.952512626584 9.20985772358e-07 1.2 9.21017530488e-07 1.44748737342 9.21049288618e-07 1.55 9.21081046748e-07 1.44748737342 9.21112804878e-07 1.2 9.21144563008e-07 0.952512626584 9.21176321138e-07 0.85 9.21208079268e-07 0.952512626584 9.21239837398e-07 1.2 9.21271595528e-07 1.44748737342 9.21303353659e-07 1.55 9.21335111789e-07 1.44748737342 9.21366869919e-07 1.2 9.21398628049e-07 0.952512626584 9.21430386179e-07 0.85 9.21462144309e-07 0.952512626585 9.21493902439e-07 1.2 9.21525660569e-07 1.44748737342 9.21557418699e-07 1.55 9.21589176829e-07 1.44748737342 9.21620934959e-07 1.2 9.21652693089e-07 0.952512626585 9.2168445122e-07 0.85 9.2171620935e-07 0.952512626585 9.2174796748e-07 1.2 9.2177972561e-07 1.44748737342 9.2181148374e-07 1.55 9.2184324187e-07 1.44748737342 9.21875e-07 1.2 9.2190675813e-07 0.952512626585 9.2193851626e-07 0.85 9.2197027439e-07 0.952512626584 9.2200203252e-07 1.2 9.2203379065e-07 1.44748737342 9.2206554878e-07 1.55 9.22097306911e-07 1.44748737342 9.22129065041e-07 1.2 9.22160823171e-07 0.952512626585 9.22192581301e-07 0.85 9.22224339431e-07 0.952512626584 9.22256097561e-07 1.2 9.22287855691e-07 1.44748737342 9.22319613821e-07 1.55 9.22351371951e-07 1.44748737342 9.22383130081e-07 1.2 9.22414888211e-07 0.952512626584 9.22446646341e-07 0.85 9.22478404472e-07 0.952512626584 9.22510162602e-07 1.2 9.22541920732e-07 1.44748737342 9.22573678862e-07 1.55 9.22605436992e-07 1.44748737342 9.22637195122e-07 1.2 9.22668953252e-07 0.952512626585 9.22700711382e-07 0.85 9.22732469512e-07 0.952512626585 9.22764227642e-07 1.2 9.22795985772e-07 1.44748737342 9.22827743902e-07 1.55 9.22859502033e-07 1.44748737342 9.22891260163e-07 1.2 9.22923018293e-07 0.952512626585 9.22954776423e-07 0.85 9.22986534553e-07 0.952512626585 9.23018292683e-07 1.2 9.23050050813e-07 1.44748737342 9.23081808943e-07 1.55 9.23113567073e-07 1.44748737342 9.23145325203e-07 1.2 9.23177083333e-07 0.952512626585 9.23208841463e-07 0.85 9.23240599593e-07 0.952512626585 9.23272357724e-07 1.2 9.23304115854e-07 1.44748737341 9.23335873984e-07 1.55 9.23367632114e-07 1.44748737342 9.23399390244e-07 1.2 9.23431148374e-07 0.952512626585 9.23462906504e-07 0.85 9.23494664634e-07 0.952512626585 9.23526422764e-07 1.2 9.23558180894e-07 1.44748737341 9.23589939024e-07 1.55 9.23621697154e-07 1.44748737342 9.23653455285e-07 1.2 9.23685213415e-07 0.952512626584 9.23716971545e-07 0.85 9.23748729675e-07 0.952512626585 9.23780487805e-07 1.2 9.23812245935e-07 1.44748737342 9.23844004065e-07 1.55 9.23875762195e-07 1.44748737342 9.23907520325e-07 1.2 9.23939278455e-07 0.952512626585 9.23971036585e-07 0.85 9.24002794715e-07 0.952512626584 9.24034552846e-07 1.2 9.24066310976e-07 1.44748737342 9.24098069106e-07 1.55 9.24129827236e-07 1.44748737341 9.24161585366e-07 1.2 9.24193343496e-07 0.952512626585 9.24225101626e-07 0.85 9.24256859756e-07 0.952512626585 9.24288617886e-07 1.2 9.24320376016e-07 1.44748737342 9.24352134146e-07 1.55 9.24383892276e-07 1.44748737341 9.24415650407e-07 1.2 9.24447408537e-07 0.952512626585 9.24479166667e-07 0.85 9.24510924797e-07 0.952512626585 9.24542682927e-07 1.2 9.24574441057e-07 1.44748737341 9.24606199187e-07 1.55 9.24637957317e-07 1.44748737341 9.24669715447e-07 1.2 9.24701473577e-07 0.952512626585 9.24733231707e-07 0.85 9.24764989837e-07 0.952512626585 9.24796747967e-07 1.2 9.24828506098e-07 1.44748737341 9.24860264228e-07 1.55 9.24892022358e-07 1.44748737342 9.24923780488e-07 1.2 9.24955538618e-07 0.952512626585 9.24987296748e-07 0.85 9.25019054878e-07 0.952512626585 9.25050813008e-07 1.2 9.25082571138e-07 1.44748737342 9.25114329268e-07 1.55 9.25146087398e-07 1.44748737342 9.25177845528e-07 1.2 9.25209603659e-07 0.952512626585 9.25241361789e-07 0.85 9.25273119919e-07 0.952512626585 9.25304878049e-07 1.2 9.25336636179e-07 1.44748737342 9.25368394309e-07 1.55 9.25400152439e-07 1.44748737342 9.25431910569e-07 1.2 9.25463668699e-07 0.952512626585 9.25495426829e-07 0.85 9.25527184959e-07 0.952512626585 9.25558943089e-07 1.2 9.2559070122e-07 1.44748737342 9.2562245935e-07 1.55 9.2565421748e-07 1.44748737341 9.2568597561e-07 1.2 9.2571773374e-07 0.952512626585 9.2574949187e-07 0.85 9.2578125e-07 0.952512626585 9.2581300813e-07 1.2 9.2584476626e-07 1.44748737341 9.2587652439e-07 1.55 9.2590828252e-07 1.44748737341 9.2594004065e-07 1.2 9.2597179878e-07 0.952512626585 9.26003556911e-07 0.85 9.26035315041e-07 0.952512626585 9.26067073171e-07 1.2 9.26098831301e-07 1.44748737341 9.26130589431e-07 1.55 9.26162347561e-07 1.44748737342 9.26194105691e-07 1.2 9.26225863821e-07 0.952512626585 9.26257621951e-07 0.85 9.26289380081e-07 0.952512626585 9.26321138211e-07 1.2 9.26352896341e-07 1.44748737341 9.26384654472e-07 1.55 9.26416412602e-07 1.44748737342 9.26448170732e-07 1.2 9.26479928862e-07 0.952512626585 9.26511686992e-07 0.85 9.26543445122e-07 0.952512626584 9.26575203252e-07 1.2 9.26606961382e-07 1.44748737342 9.26638719512e-07 1.55 9.26670477642e-07 1.44748737342 9.26702235772e-07 1.2 9.26733993902e-07 0.952512626585 9.26765752033e-07 0.85 9.26797510163e-07 0.952512626584 9.26829268293e-07 1.2 9.26861026423e-07 1.44748737342 9.26892784553e-07 1.55 9.26924542683e-07 1.44748737342 9.26956300813e-07 1.2 9.26988058943e-07 0.952512626585 9.27019817073e-07 0.85 9.27051575203e-07 0.952512626585 9.27083333333e-07 1.2 9.27115091463e-07 1.44748737342 9.27146849593e-07 1.55 9.27178607724e-07 1.44748737342 9.27210365854e-07 1.2 9.27242123984e-07 0.952512626585 9.27273882114e-07 0.85 9.27305640244e-07 0.952512626585 9.27337398374e-07 1.2 9.27369156504e-07 1.44748737342 9.27400914634e-07 1.55 9.27432672764e-07 1.44748737342 9.27464430894e-07 1.2 9.27496189024e-07 0.952512626585 9.27527947154e-07 0.85 9.27559705285e-07 0.952512626585 9.27591463415e-07 1.2 9.27623221545e-07 1.44748737342 9.27654979675e-07 1.55 9.27686737805e-07 1.44748737342 9.27718495935e-07 1.2 9.27750254065e-07 0.952512626585 9.27782012195e-07 0.85 9.27813770325e-07 0.952512626584 9.27845528455e-07 1.2 9.27877286585e-07 1.44748737342 9.27909044715e-07 1.55 9.27940802846e-07 1.44748737342 9.27972560976e-07 1.2 9.28004319106e-07 0.952512626584 9.28036077236e-07 0.85 9.28067835366e-07 0.952512626584 9.28099593496e-07 1.2 9.28131351626e-07 1.44748737342 9.28163109756e-07 1.55 9.28194867886e-07 1.44748737342 9.28226626016e-07 1.2 9.28258384146e-07 0.952512626584 9.28290142276e-07 0.85 9.28321900407e-07 0.952512626585 9.28353658537e-07 1.2 9.28385416667e-07 1.44748737342 9.28417174797e-07 1.55 9.28448932927e-07 1.44748737342 9.28480691057e-07 1.2 9.28512449187e-07 0.952512626584 9.28544207317e-07 0.85 9.28575965447e-07 0.952512626585 9.28607723577e-07 1.2 9.28639481707e-07 1.44748737342 9.28671239837e-07 1.55 9.28702997967e-07 1.44748737342 9.28734756098e-07 1.2 9.28766514228e-07 0.952512626585 9.28798272358e-07 0.85 9.28830030488e-07 0.952512626585 9.28861788618e-07 1.2 9.28893546748e-07 1.44748737342 9.28925304878e-07 1.55 9.28957063008e-07 1.44748737342 9.28988821138e-07 1.2 9.29020579268e-07 0.952512626585 9.29052337398e-07 0.85 9.29084095528e-07 0.952512626584 9.29115853659e-07 1.2 9.29147611789e-07 1.44748737342 9.29179369919e-07 1.55 9.29211128049e-07 1.44748737342 9.29242886179e-07 1.2 9.29274644309e-07 0.952512626584 9.29306402439e-07 0.85 9.29338160569e-07 0.952512626584 9.29369918699e-07 1.2 9.29401676829e-07 1.44748737342 9.29433434959e-07 1.55 9.29465193089e-07 1.44748737342 9.2949695122e-07 1.2 9.2952870935e-07 0.952512626584 9.2956046748e-07 0.85 9.2959222561e-07 0.952512626584 9.2962398374e-07 1.2 9.2965574187e-07 1.44748737342 9.296875e-07 1.55 9.2971925813e-07 1.44748737342 9.2975101626e-07 1.2 9.2978277439e-07 0.952512626584 9.2981453252e-07 0.85 9.2984629065e-07 0.952512626585 9.2987804878e-07 1.2 9.29909806911e-07 1.44748737342 9.29941565041e-07 1.55 9.29973323171e-07 1.44748737342 9.30005081301e-07 1.2 9.30036839431e-07 0.952512626585 9.30068597561e-07 0.85 9.30100355691e-07 0.952512626585 9.30132113821e-07 1.2 9.30163871951e-07 1.44748737342 9.30195630081e-07 1.55 9.30227388211e-07 1.44748737342 9.30259146341e-07 1.2 9.30290904472e-07 0.952512626585 9.30322662602e-07 0.85 9.30354420732e-07 0.952512626584 9.30386178862e-07 1.2 9.30417936992e-07 1.44748737341 9.30449695122e-07 1.55 9.30481453252e-07 1.44748737342 9.30513211382e-07 1.2 9.30544969512e-07 0.952512626585 9.30576727642e-07 0.85 9.30608485772e-07 0.952512626584 9.30640243902e-07 1.2 9.30672002033e-07 1.44748737342 9.30703760163e-07 1.55 9.30735518293e-07 1.44748737342 9.30767276423e-07 1.2 9.30799034553e-07 0.952512626584 9.30830792683e-07 0.85 9.30862550813e-07 0.952512626584 9.30894308943e-07 1.2 9.30926067073e-07 1.44748737342 9.30957825203e-07 1.55 9.30989583333e-07 1.44748737342 9.31021341463e-07 1.2 9.31053099593e-07 0.952512626585 9.31084857724e-07 0.85 9.31116615854e-07 0.952512626585 9.31148373984e-07 1.2 9.31180132114e-07 1.44748737342 9.31211890244e-07 1.55 9.31243648374e-07 1.44748737341 9.31275406504e-07 1.2 9.31307164634e-07 0.952512626585 9.31338922764e-07 0.85 9.31370680894e-07 0.952512626585 9.31402439024e-07 1.2 9.31434197154e-07 1.44748737342 9.31465955285e-07 1.55 9.31497713415e-07 1.44748737342 9.31529471545e-07 1.2 9.31561229675e-07 0.952512626585 9.31592987805e-07 0.85 9.31624745935e-07 0.952512626585 9.31656504065e-07 1.2 9.31688262195e-07 1.44748737341 9.31720020325e-07 1.55 9.31751778455e-07 1.44748737342 9.31783536585e-07 1.2 9.31815294715e-07 0.952512626585 9.31847052846e-07 0.85 9.31878810976e-07 0.952512626585 9.31910569106e-07 1.2 9.31942327236e-07 1.44748737341 9.31974085366e-07 1.55 9.32005843496e-07 1.44748737342 9.32037601626e-07 1.2 9.32069359756e-07 0.952512626584 9.32101117886e-07 0.85 9.32132876016e-07 0.952512626585 9.32164634146e-07 1.2 9.32196392276e-07 1.44748737342 9.32228150407e-07 1.55 9.32259908537e-07 1.44748737342 9.32291666667e-07 1.2 9.32323424797e-07 0.952512626585 9.32355182927e-07 0.85 9.32386941057e-07 0.952512626585 9.32418699187e-07 1.2 9.32450457317e-07 1.44748737342 9.32482215447e-07 1.55 9.32513973577e-07 1.44748737342 9.32545731707e-07 1.2 9.32577489837e-07 0.952512626585 9.32609247967e-07 0.85 9.32641006098e-07 0.952512626585 9.32672764228e-07 1.2 9.32704522358e-07 1.44748737342 9.32736280488e-07 1.55 9.32768038618e-07 1.44748737341 9.32799796748e-07 1.2 9.32831554878e-07 0.952512626585 9.32863313008e-07 0.85 9.32895071138e-07 0.952512626585 9.32926829268e-07 1.2 9.32958587398e-07 1.44748737341 9.32990345528e-07 1.55 9.33022103659e-07 1.44748737341 9.33053861789e-07 1.2 9.33085619919e-07 0.952512626585 9.33117378049e-07 0.85 9.33149136179e-07 0.952512626585 9.33180894309e-07 1.2 9.33212652439e-07 1.44748737341 9.33244410569e-07 1.55 9.33276168699e-07 1.44748737342 9.33307926829e-07 1.2 9.33339684959e-07 0.952512626585 9.33371443089e-07 0.85 9.3340320122e-07 0.952512626585 9.3343495935e-07 1.2 9.3346671748e-07 1.44748737342 9.3349847561e-07 1.55 9.3353023374e-07 1.44748737342 9.3356199187e-07 1.2 9.3359375e-07 0.952512626585 9.3362550813e-07 0.85 9.3365726626e-07 0.952512626585 9.3368902439e-07 1.2 9.3372078252e-07 1.44748737342 9.3375254065e-07 1.55 9.3378429878e-07 1.44748737342 9.33816056911e-07 1.2 9.33847815041e-07 0.952512626585 9.33879573171e-07 0.85 9.33911331301e-07 0.952512626585 9.33943089431e-07 1.2 9.33974847561e-07 1.44748737342 9.34006605691e-07 1.55 9.34038363821e-07 1.44748737341 9.34070121951e-07 1.2 9.34101880081e-07 0.952512626585 9.34133638211e-07 0.85 9.34165396341e-07 0.952512626585 9.34197154472e-07 1.2 9.34228912602e-07 1.44748737341 9.34260670732e-07 1.55 9.34292428862e-07 1.44748737342 9.34324186992e-07 1.2 9.34355945122e-07 0.952512626585 9.34387703252e-07 0.85 9.34419461382e-07 0.952512626585 9.34451219512e-07 1.2 9.34482977642e-07 1.44748737341 9.34514735772e-07 1.55 9.34546493902e-07 1.44748737342 9.34578252033e-07 1.2 9.34610010163e-07 0.952512626585 9.34641768293e-07 0.85 9.34673526423e-07 0.952512626585 9.34705284553e-07 1.2 9.34737042683e-07 1.44748737341 9.34768800813e-07 1.55 9.34800558943e-07 1.44748737342 9.34832317073e-07 1.2 9.34864075203e-07 0.952512626584 9.34895833333e-07 0.85 9.34927591463e-07 0.952512626584 9.34959349593e-07 1.2 9.34991107724e-07 1.44748737342 9.35022865854e-07 1.55 9.35054623984e-07 1.44748737342 9.35086382114e-07 1.2 9.35118140244e-07 0.952512626585 9.35149898374e-07 0.85 9.35181656504e-07 0.952512626584 9.35213414634e-07 1.2 9.35245172764e-07 1.44748737342 9.35276930894e-07 1.55 9.35308689024e-07 1.44748737342 9.35340447154e-07 1.2 9.35372205285e-07 0.952512626585 9.35403963415e-07 0.85 9.35435721545e-07 0.952512626585 9.35467479675e-07 1.2 9.35499237805e-07 1.44748737342 9.35530995935e-07 1.55 9.35562754065e-07 1.44748737342 9.35594512195e-07 1.2 9.35626270325e-07 0.952512626585 9.35658028455e-07 0.85 9.35689786585e-07 0.952512626585 9.35721544715e-07 1.2 9.35753302846e-07 1.44748737342 9.35785060976e-07 1.55 9.35816819106e-07 1.44748737342 9.35848577236e-07 1.2 9.35880335366e-07 0.952512626585 9.35912093496e-07 0.85 9.35943851626e-07 0.952512626585 9.35975609756e-07 1.2 9.36007367886e-07 1.44748737342 9.36039126016e-07 1.55 9.36070884146e-07 1.44748737342 9.36102642276e-07 1.2 9.36134400407e-07 0.952512626585 9.36166158537e-07 0.85 9.36197916667e-07 0.952512626584 9.36229674797e-07 1.2 9.36261432927e-07 1.44748737342 9.36293191057e-07 1.55 9.36324949187e-07 1.44748737342 9.36356707317e-07 1.2 9.36388465447e-07 0.952512626584 9.36420223577e-07 0.85 9.36451981707e-07 0.952512626584 9.36483739837e-07 1.2 9.36515497967e-07 1.44748737342 9.36547256098e-07 1.55 9.36579014228e-07 1.44748737342 9.36610772358e-07 1.2 9.36642530488e-07 0.952512626584 9.36674288618e-07 0.85 9.36706046748e-07 0.952512626585 9.36737804878e-07 1.2 9.36769563008e-07 1.44748737342 9.36801321138e-07 1.55 9.36833079268e-07 1.44748737342 9.36864837398e-07 1.2 9.36896595528e-07 0.952512626584 9.36928353659e-07 0.85 9.36960111789e-07 0.952512626585 9.36991869919e-07 1.2 9.37023628049e-07 1.44748737342 9.37055386179e-07 1.55 9.37087144309e-07 1.44748737342 9.37118902439e-07 1.2 9.37150660569e-07 0.952512626585 9.37182418699e-07 0.85 9.37214176829e-07 0.952512626585 9.37245934959e-07 1.2 9.37277693089e-07 1.44748737342 9.3730945122e-07 1.55 9.3734120935e-07 1.44748737342 9.3737296748e-07 1.2 9.3740472561e-07 0.952512626585 9.3743648374e-07 0.85 9.3746824187e-07 0.952512626584 9.375e-07 1.2 9.3753175813e-07 1.44748737342 9.3756351626e-07 1.55 9.3759527439e-07 1.44748737342 9.3762703252e-07 1.2 9.3765879065e-07 0.952512626584 9.3769054878e-07 0.85 9.37722306911e-07 0.952512626584 9.37754065041e-07 1.2 9.37785823171e-07 1.44748737342 9.37817581301e-07 1.55 9.37849339431e-07 1.44748737342 9.37881097561e-07 1.2 9.37912855691e-07 0.952512626584 9.37944613821e-07 0.85 9.37976371951e-07 0.952512626584 9.38008130081e-07 1.2 9.38039888211e-07 1.44748737342 9.38071646341e-07 1.55 9.38103404472e-07 1.44748737342 9.38135162602e-07 1.2 9.38166920732e-07 0.952512626585 9.38198678862e-07 0.85 9.38230436992e-07 0.952512626585 9.38262195122e-07 1.2 9.38293953252e-07 1.44748737342 9.38325711382e-07 1.55 9.38357469512e-07 1.44748737342 9.38389227642e-07 1.2 9.38420985772e-07 0.952512626585 9.38452743902e-07 0.85 9.38484502033e-07 0.952512626585 9.38516260163e-07 1.2 9.38548018293e-07 1.44748737342 9.38579776423e-07 1.55 9.38611534553e-07 1.44748737342 9.38643292683e-07 1.2 9.38675050813e-07 0.952512626585 9.38706808943e-07 0.85 9.38738567073e-07 0.952512626584 9.38770325203e-07 1.2 9.38802083333e-07 1.44748737341 9.38833841463e-07 1.55 9.38865599593e-07 1.44748737342 9.38897357724e-07 1.2 9.38929115854e-07 0.952512626585 9.38960873984e-07 0.85 9.38992632114e-07 0.952512626584 9.39024390244e-07 1.2 9.39056148374e-07 1.44748737342 9.39087906504e-07 1.55 9.39119664634e-07 1.44748737342 9.39151422764e-07 1.2 9.39183180894e-07 0.952512626584 9.39214939024e-07 0.85 9.39246697154e-07 0.952512626584 9.39278455285e-07 1.2 9.39310213415e-07 1.44748737342 9.39341971545e-07 1.55 9.39373729675e-07 1.44748737342 9.39405487805e-07 1.2 9.39437245935e-07 0.952512626585 9.39469004065e-07 0.85 9.39500762195e-07 0.952512626585 9.39532520325e-07 1.2 9.39564278455e-07 1.44748737342 9.39596036585e-07 1.55 9.39627794715e-07 1.44748737341 9.39659552846e-07 1.2 9.39691310976e-07 0.952512626585 9.39723069106e-07 0.85 9.39754827236e-07 0.952512626585 9.39786585366e-07 1.2 9.39818343496e-07 1.44748737342 9.39850101626e-07 1.55 9.39881859756e-07 1.44748737341 9.39913617886e-07 1.2 9.39945376016e-07 0.952512626585 9.39977134146e-07 0.85 9.40008892276e-07 0.952512626585 9.40040650407e-07 1.2 9.40072408537e-07 1.44748737341 9.40104166667e-07 1.55 9.40135924797e-07 1.44748737342 9.40167682927e-07 1.2 9.40199441057e-07 0.952512626585 9.40231199187e-07 0.85 9.40262957317e-07 0.952512626585 9.40294715447e-07 1.2 9.40326473577e-07 1.44748737341 9.40358231707e-07 1.55 9.40389989837e-07 1.44748737342 9.40421747967e-07 1.2 9.40453506098e-07 0.952512626584 9.40485264228e-07 0.85 9.40517022358e-07 0.952512626585 9.40548780488e-07 1.2 9.40580538618e-07 1.44748737342 9.40612296748e-07 1.55 9.40644054878e-07 1.44748737342 9.40675813008e-07 1.2 9.40707571138e-07 0.952512626585 9.40739329268e-07 0.85 9.40771087398e-07 0.952512626585 9.40802845528e-07 1.2 9.40834603659e-07 1.44748737342 9.40866361789e-07 1.55 9.40898119919e-07 1.44748737342 9.40929878049e-07 1.2 9.40961636179e-07 0.952512626585 9.40993394309e-07 0.85 9.41025152439e-07 0.952512626585 9.41056910569e-07 1.2 9.41088668699e-07 1.44748737342 9.41120426829e-07 1.55 9.41152184959e-07 1.44748737341 9.41183943089e-07 1.2 9.4121570122e-07 0.952512626585 9.4124745935e-07 0.85 9.4127921748e-07 0.952512626585 9.4131097561e-07 1.2 9.4134273374e-07 1.44748737341 9.4137449187e-07 1.55 9.4140625e-07 1.44748737341 9.4143800813e-07 1.2 9.4146976626e-07 0.952512626585 9.4150152439e-07 0.85 9.4153328252e-07 0.952512626585 9.4156504065e-07 1.2 9.4159679878e-07 1.44748737341 9.41628556911e-07 1.55 9.41660315041e-07 1.44748737342 9.41692073171e-07 1.2 9.41723831301e-07 0.952512626585 9.41755589431e-07 0.85 9.41787347561e-07 0.952512626585 9.41819105691e-07 1.2 9.41850863821e-07 1.44748737342 9.41882621951e-07 1.55 9.41914380081e-07 1.44748737342 9.41946138211e-07 1.2 9.41977896341e-07 0.952512626585 9.42009654472e-07 0.85 9.42041412602e-07 0.952512626585 9.42073170732e-07 1.2 9.42104928862e-07 1.44748737342 9.42136686992e-07 1.55 9.42168445122e-07 1.44748737342 9.42200203252e-07 1.2 9.42231961382e-07 0.952512626585 9.42263719512e-07 0.85 9.42295477642e-07 0.952512626585 9.42327235772e-07 1.2 9.42358993902e-07 1.44748737341 9.42390752033e-07 1.55 9.42422510163e-07 1.44748737341 9.42454268293e-07 1.2 9.42486026423e-07 0.952512626585 9.42517784553e-07 0.85 9.42549542683e-07 0.952512626585 9.42581300813e-07 1.2 9.42613058943e-07 1.44748737341 9.42644817073e-07 1.55 9.42676575203e-07 1.44748737342 9.42708333333e-07 1.2 9.42740091463e-07 0.952512626585 9.42771849593e-07 0.85 9.42803607724e-07 0.952512626585 9.42835365854e-07 1.2 9.42867123984e-07 1.44748737341 9.42898882114e-07 1.55 9.42930640244e-07 1.44748737342 9.42962398374e-07 1.2 9.42994156504e-07 0.952512626585 9.43025914634e-07 0.85 9.43057672764e-07 0.952512626585 9.43089430894e-07 1.2 9.43121189024e-07 1.44748737341 9.43152947154e-07 1.55 9.43184705285e-07 1.44748737342 9.43216463415e-07 1.2 9.43248221545e-07 0.952512626584 9.43279979675e-07 0.85 9.43311737805e-07 0.952512626584 9.43343495935e-07 1.2 9.43375254065e-07 1.44748737342 9.43407012195e-07 1.55 9.43438770325e-07 1.44748737342 9.43470528455e-07 1.2 9.43502286585e-07 0.952512626584 9.43534044715e-07 0.85 9.43565802846e-07 0.952512626584 9.43597560976e-07 1.2 9.43629319106e-07 1.44748737342 9.43661077236e-07 1.55 9.43692835366e-07 1.44748737342 9.43724593496e-07 1.2 9.43756351626e-07 0.952512626585 9.43788109756e-07 0.85 9.43819867886e-07 0.952512626585 9.43851626016e-07 1.2 9.43883384146e-07 1.44748737342 9.43915142276e-07 1.55 9.43946900407e-07 1.44748737342 9.43978658537e-07 1.2 9.44010416667e-07 0.952512626585 9.44042174797e-07 0.85 9.44073932927e-07 0.952512626585 9.44105691057e-07 1.2 9.44137449187e-07 1.44748737342 9.44169207317e-07 1.55 9.44200965447e-07 1.44748737342 9.44232723577e-07 1.2 9.44264481707e-07 0.952512626585 9.44296239837e-07 0.85 9.44327997967e-07 0.952512626585 9.44359756098e-07 1.2 9.44391514228e-07 1.44748737342 9.44423272358e-07 1.55 9.44455030488e-07 1.44748737342 9.44486788618e-07 1.2 9.44518546748e-07 0.952512626585 9.44550304878e-07 0.85 9.44582063008e-07 0.952512626584 9.44613821138e-07 1.2 9.44645579268e-07 1.44748737342 9.44677337398e-07 1.55 9.44709095528e-07 1.44748737342 9.44740853659e-07 1.2 9.44772611789e-07 0.952512626584 9.44804369919e-07 0.85 9.44836128049e-07 0.952512626584 9.44867886179e-07 1.2 9.44899644309e-07 1.44748737342 9.44931402439e-07 1.55 9.44963160569e-07 1.44748737342 9.44994918699e-07 1.2 9.45026676829e-07 0.952512626584 9.45058434959e-07 0.85 9.45090193089e-07 0.952512626585 9.4512195122e-07 1.2 9.4515370935e-07 1.44748737342 9.4518546748e-07 1.55 9.4521722561e-07 1.44748737342 9.4524898374e-07 1.2 9.4528074187e-07 0.952512626584 9.453125e-07 0.85 9.4534425813e-07 0.952512626585 9.4537601626e-07 1.2 9.4540777439e-07 1.44748737342 9.4543953252e-07 1.55 9.4547129065e-07 1.44748737342 9.4550304878e-07 1.2 9.45534806911e-07 0.952512626585 9.45566565041e-07 0.85 9.45598323171e-07 0.952512626585 9.45630081301e-07 1.2 9.45661839431e-07 1.44748737342 9.45693597561e-07 1.55 9.45725355691e-07 1.44748737342 9.45757113821e-07 1.2 9.45788871951e-07 0.952512626585 9.45820630081e-07 0.85 9.45852388211e-07 0.952512626584 9.45884146341e-07 1.2 9.45915904472e-07 1.44748737342 9.45947662602e-07 1.55 9.45979420732e-07 1.44748737342 9.46011178862e-07 1.2 9.46042936992e-07 0.952512626584 9.46074695122e-07 0.85 9.46106453252e-07 0.952512626584 9.46138211382e-07 1.2 9.46169969512e-07 1.44748737342 9.46201727642e-07 1.55 9.46233485772e-07 1.44748737342 9.46265243902e-07 1.2 9.46297002033e-07 0.952512626584 9.46328760163e-07 0.85 9.46360518293e-07 0.952512626584 9.46392276423e-07 1.2 9.46424034553e-07 1.44748737342 9.46455792683e-07 1.55 9.46487550813e-07 1.44748737342 9.46519308943e-07 1.2 9.46551067073e-07 0.952512626585 9.46582825203e-07 0.85 9.46614583333e-07 0.952512626585 9.46646341463e-07 1.2 9.46678099593e-07 1.44748737342 9.46709857724e-07 1.55 9.46741615854e-07 1.44748737342 9.46773373984e-07 1.2 9.46805132114e-07 0.952512626585 9.46836890244e-07 0.85 9.46868648374e-07 0.952512626585 9.46900406504e-07 1.2 9.46932164634e-07 1.44748737342 9.46963922764e-07 1.55 9.46995680894e-07 1.44748737342 9.47027439024e-07 1.2 9.47059197154e-07 0.952512626585 9.47090955285e-07 0.85 9.47122713415e-07 0.952512626585 9.47154471545e-07 1.2 9.47186229675e-07 1.44748737341 9.47217987805e-07 1.55 9.47249745935e-07 1.44748737342 9.47281504065e-07 1.2 9.47313262195e-07 0.952512626585 9.47345020325e-07 0.85 9.47376778455e-07 0.952512626584 9.47408536585e-07 1.2 9.47440294715e-07 1.44748737342 9.47472052846e-07 1.55 9.47503810976e-07 1.44748737342 9.47535569106e-07 1.2 9.47567327236e-07 0.952512626584 9.47599085366e-07 0.85 9.47630843496e-07 0.952512626584 9.47662601626e-07 1.2 9.47694359756e-07 1.44748737342 9.47726117886e-07 1.55 9.47757876016e-07 1.44748737342 9.47789634146e-07 1.2 9.47821392276e-07 0.952512626585 9.47853150407e-07 0.85 9.47884908537e-07 0.952512626585 9.47916666667e-07 1.2 9.47948424797e-07 1.44748737342 9.47980182927e-07 1.55 9.48011941057e-07 1.44748737341 9.48043699187e-07 1.2 9.48075457317e-07 0.952512626585 9.48107215447e-07 0.85 9.48138973577e-07 0.952512626585 9.48170731707e-07 1.2 9.48202489837e-07 1.44748737342 9.48234247967e-07 1.55 9.48266006098e-07 1.44748737341 9.48297764228e-07 1.2 9.48329522358e-07 0.952512626585 9.48361280488e-07 0.85 9.48393038618e-07 0.952512626585 9.48424796748e-07 1.2 9.48456554878e-07 1.44748737341 9.48488313008e-07 1.55 9.48520071138e-07 1.44748737341 9.48551829268e-07 1.2 9.48583587398e-07 0.952512626585 9.48615345528e-07 0.85 9.48647103659e-07 0.952512626585 9.48678861789e-07 1.2 9.48710619919e-07 1.44748737341 9.48742378049e-07 1.55 9.48774136179e-07 1.44748737342 9.48805894309e-07 1.2 9.48837652439e-07 0.952512626584 9.48869410569e-07 0.85 9.48901168699e-07 0.952512626585 9.48932926829e-07 1.2 9.48964684959e-07 1.44748737342 9.48996443089e-07 1.55 9.4902820122e-07 1.44748737342 9.4905995935e-07 1.2 9.4909171748e-07 0.952512626585 9.4912347561e-07 0.85 9.4915523374e-07 0.952512626585 9.4918699187e-07 1.2 9.4921875e-07 1.44748737342 9.4925050813e-07 1.55 9.4928226626e-07 1.44748737342 9.4931402439e-07 1.2 9.4934578252e-07 0.952512626585 9.4937754065e-07 0.85 9.4940929878e-07 0.952512626585 9.49441056911e-07 1.2 9.49472815041e-07 1.44748737342 9.49504573171e-07 1.55 9.49536331301e-07 1.44748737341 9.49568089431e-07 1.2 9.49599847561e-07 0.952512626585 9.49631605691e-07 0.85 9.49663363821e-07 0.952512626585 9.49695121951e-07 1.2 9.49726880081e-07 1.44748737341 9.49758638211e-07 1.55 9.49790396341e-07 1.44748737341 9.49822154472e-07 1.2 9.49853912602e-07 0.952512626585 9.49885670732e-07 0.85 9.49917428862e-07 0.952512626585 9.49949186992e-07 1.2 9.49980945122e-07 1.44748737341 9.50012703252e-07 1.55 9.50044461382e-07 1.44748737342 9.50076219512e-07 1.2 9.50107977642e-07 0.952512626585 9.50139735772e-07 0.85 9.50171493902e-07 0.952512626585 9.50203252033e-07 1.2 9.50235010163e-07 1.44748737342 9.50266768293e-07 1.55 9.50298526423e-07 1.44748737342 9.50330284553e-07 1.2 9.50362042683e-07 0.952512626585 9.50393800813e-07 0.85 9.50425558943e-07 0.952512626584 9.50457317073e-07 1.2 9.50489075203e-07 1.44748737342 9.50520833333e-07 1.55 9.50552591463e-07 1.44748737342 9.50584349593e-07 1.2 9.50616107724e-07 0.952512626585 9.50647865854e-07 0.85 9.50679623984e-07 0.952512626585 9.50711382114e-07 1.2 9.50743140244e-07 1.44748737342 9.50774898374e-07 1.55 9.50806656504e-07 1.44748737341 9.50838414634e-07 1.2 9.50870172764e-07 0.952512626585 9.50901930894e-07 0.85 9.50933689024e-07 0.952512626585 9.50965447154e-07 1.2 9.50997205285e-07 1.44748737341 9.51028963415e-07 1.55 9.51060721545e-07 1.44748737342 9.51092479675e-07 1.2 9.51124237805e-07 0.952512626585 9.51155995935e-07 0.85 9.51187754065e-07 0.952512626585 9.51219512195e-07 1.2 9.51251270325e-07 1.44748737341 9.51283028455e-07 1.55 9.51314786585e-07 1.44748737342 9.51346544715e-07 1.2 9.51378302846e-07 0.952512626585 9.51410060976e-07 0.85 9.51441819106e-07 0.952512626585 9.51473577236e-07 1.2 9.51505335366e-07 1.44748737341 9.51537093496e-07 1.55 9.51568851626e-07 1.44748737342 9.51600609756e-07 1.2 9.51632367886e-07 0.952512626585 9.51664126016e-07 0.85 9.51695884146e-07 0.952512626584 9.51727642276e-07 1.2 9.51759400407e-07 1.44748737342 9.51791158537e-07 1.55 9.51822916667e-07 1.44748737342 9.51854674797e-07 1.2 9.51886432927e-07 0.952512626584 9.51918191057e-07 0.85 9.51949949187e-07 0.952512626584 9.51981707317e-07 1.2 9.52013465447e-07 1.44748737342 9.52045223577e-07 1.55 9.52076981707e-07 1.44748737342 9.52108739837e-07 1.2 9.52140497967e-07 0.952512626584 9.52172256098e-07 0.85 9.52204014228e-07 0.952512626585 9.52235772358e-07 1.2 9.52267530488e-07 1.44748737342 9.52299288618e-07 1.55 9.52331046748e-07 1.44748737342 9.52362804878e-07 1.2 9.52394563008e-07 0.952512626585 9.52426321138e-07 0.85 9.52458079268e-07 0.952512626585 9.52489837398e-07 1.2 9.52521595528e-07 1.44748737342 9.52553353659e-07 1.55 9.52585111789e-07 1.44748737342 9.52616869919e-07 1.2 9.52648628049e-07 0.952512626585 9.52680386179e-07 0.85 9.52712144309e-07 0.952512626585 9.52743902439e-07 1.2 9.52775660569e-07 1.44748737342 9.52807418699e-07 1.55 9.52839176829e-07 1.44748737342 9.52870934959e-07 1.2 9.52902693089e-07 0.952512626585 9.5293445122e-07 0.85 9.5296620935e-07 0.952512626584 9.5299796748e-07 1.2 9.5302972561e-07 1.44748737342 9.5306148374e-07 1.55 9.5309324187e-07 1.44748737342 9.53125e-07 1.2 9.5315675813e-07 0.952512626584 9.5318851626e-07 0.85 9.5322027439e-07 0.952512626584 9.5325203252e-07 1.2 9.5328379065e-07 1.44748737342 9.5331554878e-07 1.55 9.53347306911e-07 1.44748737342 9.53379065041e-07 1.2 9.53410823171e-07 0.952512626584 9.53442581301e-07 0.85 9.53474339431e-07 0.952512626585 9.53506097561e-07 1.2 9.53537855691e-07 1.44748737342 9.53569613821e-07 1.55 9.53601371951e-07 1.44748737342 9.53633130081e-07 1.2 9.53664888211e-07 0.952512626584 9.53696646341e-07 0.85 9.53728404472e-07 0.952512626585 9.53760162602e-07 1.2 9.53791920732e-07 1.44748737342 9.53823678862e-07 1.55 9.53855436992e-07 1.44748737342 9.53887195122e-07 1.2 9.53918953252e-07 0.952512626585 9.53950711382e-07 0.85 9.53982469512e-07 0.952512626584 9.54014227642e-07 1.2 9.54045985772e-07 1.44748737341 9.54077743902e-07 1.55 9.54109502033e-07 1.44748737342 9.54141260163e-07 1.2 9.54173018293e-07 0.952512626584 9.54204776423e-07 0.85 9.54236534553e-07 0.952512626585 9.54268292683e-07 1.2 9.54300050813e-07 1.44748737342 9.54331808943e-07 1.55 9.54363567073e-07 1.44748737342 9.54395325203e-07 1.2 9.54427083333e-07 0.952512626585 9.54458841463e-07 0.85 9.54490599593e-07 0.952512626584 9.54522357724e-07 1.2 9.54554115854e-07 1.44748737342 9.54585873984e-07 1.55 9.54617632114e-07 1.44748737342 9.54649390244e-07 1.2 9.54681148374e-07 0.952512626585 9.54712906504e-07 0.85 9.54744664634e-07 0.952512626584 9.54776422764e-07 1.2 9.54808180894e-07 1.44748737342 9.54839939024e-07 1.55 9.54871697154e-07 1.44748737342 9.54903455285e-07 1.2 9.54935213415e-07 0.952512626584 9.54966971545e-07 0.85 9.54998729675e-07 0.952512626585 9.55030487805e-07 1.2 9.55062245935e-07 1.44748737342 9.55094004065e-07 1.55 9.55125762195e-07 1.44748737342 9.55157520325e-07 1.2 9.55189278455e-07 0.952512626585 9.55221036585e-07 0.85 9.55252794715e-07 0.952512626585 9.55284552846e-07 1.2 9.55316310976e-07 1.44748737341 9.55348069106e-07 1.55 9.55379827236e-07 1.44748737342 9.55411585366e-07 1.2 9.55443343496e-07 0.952512626584 9.55475101626e-07 0.85 9.55506859756e-07 0.952512626585 9.55538617886e-07 1.2 9.55570376016e-07 1.44748737342 9.55602134146e-07 1.55 9.55633892276e-07 1.44748737342 9.55665650407e-07 1.2 9.55697408537e-07 0.952512626585 9.55729166667e-07 0.85 9.55760924797e-07 0.952512626585 9.55792682927e-07 1.2 9.55824441057e-07 1.44748737342 9.55856199187e-07 1.55 9.55887957317e-07 1.44748737342 9.55919715447e-07 1.2 9.55951473577e-07 0.952512626585 9.55983231707e-07 0.85 9.56014989837e-07 0.952512626584 9.56046747967e-07 1.2 9.56078506098e-07 1.44748737341 9.56110264228e-07 1.55 9.56142022358e-07 1.44748737342 9.56173780488e-07 1.2 9.56205538618e-07 0.952512626584 9.56237296748e-07 0.85 9.56269054878e-07 0.952512626585 9.56300813008e-07 1.2 9.56332571138e-07 1.44748737342 9.56364329268e-07 1.55 9.56396087398e-07 1.44748737341 9.56427845528e-07 1.2 9.56459603659e-07 0.952512626585 9.56491361789e-07 0.85 9.56523119919e-07 0.952512626585 9.56554878049e-07 1.2 9.56586636179e-07 1.44748737341 9.56618394309e-07 1.55 9.56650152439e-07 1.44748737342 9.56681910569e-07 1.2 9.56713668699e-07 0.952512626586 9.56745426829e-07 0.85 9.56777184959e-07 0.952512626585 9.56808943089e-07 1.2 9.5684070122e-07 1.44748737342 9.5687245935e-07 1.55 9.5690421748e-07 1.44748737341 9.5693597561e-07 1.2 9.5696773374e-07 0.952512626585 9.5699949187e-07 0.85 9.5703125e-07 0.952512626585 9.5706300813e-07 1.2 9.5709476626e-07 1.44748737341 9.5712652439e-07 1.55 9.5715828252e-07 1.44748737342 9.5719004065e-07 1.2 9.5722179878e-07 0.952512626585 9.57253556911e-07 0.85 9.57285315041e-07 0.952512626584 9.57317073171e-07 1.2 9.57348831301e-07 1.44748737341 9.57380589431e-07 1.55 9.57412347561e-07 1.44748737342 9.57444105691e-07 1.2 9.57475863821e-07 0.952512626584 9.57507621951e-07 0.85 9.57539380081e-07 0.952512626585 9.57571138211e-07 1.2 9.57602896341e-07 1.44748737342 9.57634654472e-07 1.55 9.57666412602e-07 1.44748737342 9.57698170732e-07 1.2 9.57729928862e-07 0.952512626585 9.57761686992e-07 0.85 9.57793445122e-07 0.952512626585 9.57825203252e-07 1.2 9.57856961382e-07 1.44748737341 9.57888719512e-07 1.55 9.57920477642e-07 1.44748737342 9.57952235772e-07 1.2 9.57983993902e-07 0.952512626585 9.58015752033e-07 0.85 9.58047510163e-07 0.952512626586 9.58079268293e-07 1.2 9.58111026423e-07 1.44748737342 9.58142784553e-07 1.55 9.58174542683e-07 1.44748737341 9.58206300813e-07 1.2 9.58238058943e-07 0.952512626585 9.58269817073e-07 0.85 9.58301575203e-07 0.952512626585 9.58333333333e-07 1.2 9.58365091463e-07 1.44748737341 9.58396849593e-07 1.55 9.58428607724e-07 1.44748737342 9.58460365854e-07 1.2 9.58492123984e-07 0.952512626585 9.58523882114e-07 0.85 9.58555640244e-07 0.952512626584 9.58587398374e-07 1.2 9.58619156504e-07 1.44748737342 9.58650914634e-07 1.55 9.58682672764e-07 1.44748737341 9.58714430894e-07 1.2 9.58746189024e-07 0.952512626584 9.58777947154e-07 0.85 9.58809705285e-07 0.952512626585 9.58841463415e-07 1.2 9.58873221545e-07 1.44748737342 9.58904979675e-07 1.55 9.58936737805e-07 1.44748737342 9.58968495935e-07 1.2 9.59000254065e-07 0.952512626585 9.59032012195e-07 0.85 9.59063770325e-07 0.952512626585 9.59095528455e-07 1.2 9.59127286585e-07 1.44748737342 9.59159044715e-07 1.55 9.59190802846e-07 1.44748737342 9.59222560976e-07 1.2 9.59254319106e-07 0.952512626585 9.59286077236e-07 0.85 9.59317835366e-07 0.952512626586 9.59349593496e-07 1.2 9.59381351626e-07 1.44748737342 9.59413109756e-07 1.55 9.59444867886e-07 1.44748737341 9.59476626016e-07 1.2 9.59508384146e-07 0.952512626585 9.59540142276e-07 0.85 9.59571900407e-07 0.952512626585 9.59603658537e-07 1.2 9.59635416667e-07 1.44748737341 9.59667174797e-07 1.55 9.59698932927e-07 1.44748737342 9.59730691057e-07 1.2 9.59762449187e-07 0.952512626585 9.59794207317e-07 0.85 9.59825965447e-07 0.952512626584 9.59857723577e-07 1.2 9.59889481707e-07 1.44748737341 9.59921239837e-07 1.55 9.59952997967e-07 1.44748737342 9.59984756098e-07 1.2 9.60016514228e-07 0.952512626585 9.60048272358e-07 0.85 9.60080030488e-07 0.952512626585 9.60111788618e-07 1.2 9.60143546748e-07 1.44748737342 9.60175304878e-07 1.55 9.60207063008e-07 1.44748737342 9.60238821138e-07 1.2 9.60270579268e-07 0.952512626584 9.60302337398e-07 0.85 9.60334095528e-07 0.952512626584 9.60365853659e-07 1.2 9.60397611789e-07 1.44748737342 9.60429369919e-07 1.55 9.60461128049e-07 1.44748737342 9.60492886179e-07 1.2 9.60524644309e-07 0.952512626585 9.60556402439e-07 0.85 9.60588160569e-07 0.952512626584 9.60619918699e-07 1.2 9.60651676829e-07 1.44748737342 9.60683434959e-07 1.55 9.60715193089e-07 1.44748737341 9.6074695122e-07 1.2 9.6077870935e-07 0.952512626584 9.6081046748e-07 0.85 9.6084222561e-07 0.952512626585 9.6087398374e-07 1.2 9.6090574187e-07 1.44748737342 9.609375e-07 1.55 9.6096925813e-07 1.44748737342 9.6100101626e-07 1.2 9.6103277439e-07 0.952512626585 9.6106453252e-07 0.85 9.6109629065e-07 0.952512626584 9.6112804878e-07 1.2 9.61159806911e-07 1.44748737341 9.61191565041e-07 1.55 9.61223323171e-07 1.44748737342 9.61255081301e-07 1.2 9.61286839431e-07 0.952512626585 9.61318597561e-07 0.85 9.61350355691e-07 0.952512626585 9.61382113821e-07 1.2 9.61413871951e-07 1.44748737342 9.61445630081e-07 1.55 9.61477388211e-07 1.44748737342 9.61509146341e-07 1.2 9.61540904472e-07 0.952512626584 9.61572662602e-07 0.85 9.61604420732e-07 0.952512626584 9.61636178862e-07 1.2 9.61667936992e-07 1.44748737342 9.61699695122e-07 1.55 9.61731453252e-07 1.44748737342 9.61763211382e-07 1.2 9.61794969512e-07 0.952512626585 9.61826727642e-07 0.85 9.61858485772e-07 0.952512626585 9.61890243902e-07 1.2 9.61922002033e-07 1.44748737342 9.61953760163e-07 1.55 9.61985518293e-07 1.44748737341 9.62017276423e-07 1.2 9.62049034553e-07 0.952512626584 9.62080792683e-07 0.85 9.62112550813e-07 0.952512626585 9.62144308943e-07 1.2 9.62176067073e-07 1.44748737342 9.62207825203e-07 1.55 9.62239583333e-07 1.44748737342 9.62271341463e-07 1.2 9.62303099593e-07 0.952512626585 9.62334857724e-07 0.85 9.62366615854e-07 0.952512626584 9.62398373984e-07 1.2 9.62430132114e-07 1.44748737341 9.62461890244e-07 1.55 9.62493648374e-07 1.44748737342 9.62525406504e-07 1.2 9.62557164634e-07 0.952512626584 9.62588922764e-07 0.85 9.62620680894e-07 0.952512626585 9.62652439024e-07 1.2 9.62684197154e-07 1.44748737342 9.62715955285e-07 1.55 9.62747713415e-07 1.44748737342 9.62779471545e-07 1.2 9.62811229675e-07 0.952512626585 9.62842987805e-07 0.85 9.62874745935e-07 0.952512626584 9.62906504065e-07 1.2 9.62938262195e-07 1.44748737342 9.62970020325e-07 1.55 9.63001778455e-07 1.44748737342 9.63033536585e-07 1.2 9.63065294715e-07 0.952512626585 9.63097052846e-07 0.85 9.63128810976e-07 0.952512626584 9.63160569106e-07 1.2 9.63192327236e-07 1.44748737342 9.63224085366e-07 1.55 9.63255843496e-07 1.44748737342 9.63287601626e-07 1.2 9.63319359756e-07 0.952512626584 9.63351117886e-07 0.85 9.63382876016e-07 0.952512626585 9.63414634146e-07 1.2 9.63446392276e-07 1.44748737342 9.63478150407e-07 1.55 9.63509908537e-07 1.44748737342 9.63541666667e-07 1.2 9.63573424797e-07 0.952512626585 9.63605182927e-07 0.85 9.63636941057e-07 0.952512626585 9.63668699187e-07 1.2 9.63700457317e-07 1.44748737341 9.63732215447e-07 1.55 9.63763973577e-07 1.44748737342 9.63795731707e-07 1.2 9.63827489837e-07 0.952512626586 9.63859247967e-07 0.85 9.63891006098e-07 0.952512626585 9.63922764228e-07 1.2 9.63954522358e-07 1.44748737342 9.63986280488e-07 1.55 9.64018038618e-07 1.44748737342 9.64049796748e-07 1.2 9.64081554878e-07 0.952512626585 9.64113313008e-07 0.85 9.64145071138e-07 0.952512626585 9.64176829268e-07 1.2 9.64208587398e-07 1.44748737342 9.64240345528e-07 1.55 9.64272103659e-07 1.44748737342 9.64303861789e-07 1.2 9.64335619919e-07 0.952512626585 9.64367378049e-07 0.85 9.64399136179e-07 0.952512626584 9.64430894309e-07 1.2 9.64462652439e-07 1.44748737341 9.64494410569e-07 1.55 9.64526168699e-07 1.44748737342 9.64557926829e-07 1.2 9.64589684959e-07 0.952512626584 9.64621443089e-07 0.85 9.6465320122e-07 0.952512626585 9.6468495935e-07 1.2 9.6471671748e-07 1.44748737342 9.6474847561e-07 1.55 9.6478023374e-07 1.44748737341 9.6481199187e-07 1.2 9.6484375e-07 0.952512626585 9.6487550813e-07 0.85 9.6490726626e-07 0.952512626585 9.6493902439e-07 1.2 9.6497078252e-07 1.44748737341 9.6500254065e-07 1.55 9.6503429878e-07 1.44748737342 9.65066056911e-07 1.2 9.65097815041e-07 0.952512626586 9.65129573171e-07 0.85 9.65161331301e-07 0.952512626585 9.65193089431e-07 1.2 9.65224847561e-07 1.44748737342 9.65256605691e-07 1.55 9.65288363821e-07 1.44748737341 9.65320121951e-07 1.2 9.65351880081e-07 0.952512626585 9.65383638211e-07 0.85 9.65415396341e-07 0.952512626585 9.65447154472e-07 1.2 9.65478912602e-07 1.44748737341 9.65510670732e-07 1.55 9.65542428862e-07 1.44748737342 9.65574186992e-07 1.2 9.65605945122e-07 0.952512626585 9.65637703252e-07 0.85 9.65669461382e-07 0.952512626584 9.65701219512e-07 1.2 9.65732977642e-07 1.44748737341 9.65764735772e-07 1.55 9.65796493902e-07 1.44748737342 9.65828252033e-07 1.2 9.65860010163e-07 0.952512626584 9.65891768293e-07 0.85 9.65923526423e-07 0.952512626585 9.65955284553e-07 1.2 9.65987042683e-07 1.44748737342 9.66018800813e-07 1.55 9.66050558943e-07 1.44748737342 9.66082317073e-07 1.2 9.66114075203e-07 0.952512626585 9.66145833333e-07 0.85 9.66177591463e-07 0.952512626585 9.66209349593e-07 1.2 9.66241107724e-07 1.44748737341 9.66272865854e-07 1.55 9.66304623984e-07 1.44748737342 9.66336382114e-07 1.2 9.66368140244e-07 0.952512626585 9.66399898374e-07 0.85 9.66431656504e-07 0.952512626586 9.66463414634e-07 1.2 9.66495172764e-07 1.44748737342 9.66526930894e-07 1.55 9.66558689024e-07 1.44748737341 9.66590447154e-07 1.2 9.66622205285e-07 0.952512626585 9.66653963415e-07 0.85 9.66685721545e-07 0.952512626585 9.66717479675e-07 1.2 9.66749237805e-07 1.44748737341 9.66780995935e-07 1.55 9.66812754065e-07 1.44748737342 9.66844512195e-07 1.2 9.66876270325e-07 0.952512626585 9.66908028455e-07 0.85 9.66939786585e-07 0.952512626584 9.66971544715e-07 1.2 9.67003302846e-07 1.44748737342 9.67035060976e-07 1.55 9.67066819106e-07 1.44748737341 9.67098577236e-07 1.2 9.67130335366e-07 0.952512626584 9.67162093496e-07 0.85 9.67193851626e-07 0.952512626585 9.67225609756e-07 1.2 9.67257367886e-07 1.44748737342 9.67289126016e-07 1.55 9.67320884146e-07 1.44748737342 9.67352642276e-07 1.2 9.67384400407e-07 0.952512626585 9.67416158537e-07 0.85 9.67447916667e-07 0.952512626585 9.67479674797e-07 1.2 9.67511432927e-07 1.44748737342 9.67543191057e-07 1.55 9.67574949187e-07 1.44748737342 9.67606707317e-07 1.2 9.67638465447e-07 0.952512626585 9.67670223577e-07 0.85 9.67701981707e-07 0.952512626586 9.67733739837e-07 1.2 9.67765497967e-07 1.44748737342 9.67797256098e-07 1.55 9.67829014228e-07 1.44748737341 9.67860772358e-07 1.2 9.67892530488e-07 0.952512626585 9.67924288618e-07 0.85 9.67956046748e-07 0.952512626585 9.67987804878e-07 1.2 9.68019563008e-07 1.44748737342 9.68051321138e-07 1.55 9.68083079268e-07 1.44748737342 9.68114837398e-07 1.2 9.68146595528e-07 0.952512626585 9.68178353659e-07 0.85 9.68210111789e-07 0.952512626584 9.68241869919e-07 1.2 9.68273628049e-07 1.44748737341 9.68305386179e-07 1.55 9.68337144309e-07 1.44748737342 9.68368902439e-07 1.2 9.68400660569e-07 0.952512626585 9.68432418699e-07 0.85 9.68464176829e-07 0.952512626585 9.68495934959e-07 1.2 9.68527693089e-07 1.44748737342 9.6855945122e-07 1.55 9.6859120935e-07 1.44748737342 9.6862296748e-07 1.2 9.6865472561e-07 0.952512626584 9.6868648374e-07 0.85 9.6871824187e-07 0.952512626584 9.6875e-07 1.2 9.6878175813e-07 1.44748737342 9.6881351626e-07 1.55 9.6884527439e-07 1.44748737342 9.6887703252e-07 1.2 9.6890879065e-07 0.952512626585 9.6894054878e-07 0.85 9.68972306911e-07 0.952512626584 9.69004065041e-07 1.2 9.69035823171e-07 1.44748737342 9.69067581301e-07 1.55 9.69099339431e-07 1.44748737341 9.69131097561e-07 1.2 9.69162855691e-07 0.952512626584 9.69194613821e-07 0.85 9.69226371951e-07 0.952512626585 9.69258130081e-07 1.2 9.69289888211e-07 1.44748737342 9.69321646341e-07 1.55 9.69353404472e-07 1.44748737342 9.69385162602e-07 1.2 9.69416920732e-07 0.952512626585 9.69448678862e-07 0.85 9.69480436992e-07 0.952512626584 9.69512195122e-07 1.2 9.69543953252e-07 1.44748737341 9.69575711382e-07 1.55 9.69607469512e-07 1.44748737342 9.69639227642e-07 1.2 9.69670985772e-07 0.952512626585 9.69702743902e-07 0.85 9.69734502033e-07 0.952512626585 9.69766260163e-07 1.2 9.69798018293e-07 1.44748737342 9.69829776423e-07 1.55 9.69861534553e-07 1.44748737342 9.69893292683e-07 1.2 9.69925050813e-07 0.952512626584 9.69956808943e-07 0.85 9.69988567073e-07 0.952512626584 9.70020325203e-07 1.2 9.70052083333e-07 1.44748737342 9.70083841463e-07 1.55 9.70115599593e-07 1.44748737342 9.70147357724e-07 1.2 9.70179115854e-07 0.952512626585 9.70210873984e-07 0.85 9.70242632114e-07 0.952512626585 9.70274390244e-07 1.2 9.70306148374e-07 1.44748737342 9.70337906504e-07 1.55 9.70369664634e-07 1.44748737341 9.70401422764e-07 1.2 9.70433180894e-07 0.952512626584 9.70464939024e-07 0.85 9.70496697154e-07 0.952512626585 9.70528455285e-07 1.2 9.70560213415e-07 1.44748737342 9.70591971545e-07 1.55 9.70623729675e-07 1.44748737342 9.70655487805e-07 1.2 9.70687245935e-07 0.952512626585 9.70719004065e-07 0.85 9.70750762195e-07 0.952512626584 9.70782520325e-07 1.2 9.70814278455e-07 1.44748737341 9.70846036585e-07 1.55 9.70877794715e-07 1.44748737342 9.70909552846e-07 1.2 9.70941310976e-07 0.952512626584 9.70973069106e-07 0.85 9.71004827236e-07 0.952512626585 9.71036585366e-07 1.2 9.71068343496e-07 1.44748737342 9.71100101626e-07 1.55 9.71131859756e-07 1.44748737342 9.71163617886e-07 1.2 9.71195376016e-07 0.952512626585 9.71227134146e-07 0.85 9.71258892276e-07 0.952512626584 9.71290650407e-07 1.2 9.71322408537e-07 1.44748737342 9.71354166667e-07 1.55 9.71385924797e-07 1.44748737342 9.71417682927e-07 1.2 9.71449441057e-07 0.952512626585 9.71481199187e-07 0.85 9.71512957317e-07 0.952512626584 9.71544715447e-07 1.2 9.71576473577e-07 1.44748737342 9.71608231707e-07 1.55 9.71639989837e-07 1.44748737342 9.71671747967e-07 1.2 9.71703506098e-07 0.952512626584 9.71735264228e-07 0.85 9.71767022358e-07 0.952512626585 9.71798780488e-07 1.2 9.71830538618e-07 1.44748737342 9.71862296748e-07 1.55 9.71894054878e-07 1.44748737342 9.71925813008e-07 1.2 9.71957571138e-07 0.952512626585 9.71989329268e-07 0.85 9.72021087398e-07 0.952512626585 9.72052845528e-07 1.2 9.72084603659e-07 1.44748737341 9.72116361789e-07 1.55 9.72148119919e-07 1.44748737342 9.72179878049e-07 1.2 9.72211636179e-07 0.952512626586 9.72243394309e-07 0.85 9.72275152439e-07 0.952512626585 9.72306910569e-07 1.2 9.72338668699e-07 1.44748737342 9.72370426829e-07 1.55 9.72402184959e-07 1.44748737342 9.72433943089e-07 1.2 9.7246570122e-07 0.952512626585 9.7249745935e-07 0.85 9.7252921748e-07 0.952512626585 9.7256097561e-07 1.2 9.7259273374e-07 1.44748737342 9.7262449187e-07 1.55 9.7265625e-07 1.44748737342 9.7268800813e-07 1.2 9.7271976626e-07 0.952512626585 9.7275152439e-07 0.85 9.7278328252e-07 0.952512626584 9.7281504065e-07 1.2 9.7284679878e-07 1.44748737341 9.72878556911e-07 1.55 9.72910315041e-07 1.44748737342 9.72942073171e-07 1.2 9.72973831301e-07 0.952512626584 9.73005589431e-07 0.85 9.73037347561e-07 0.952512626585 9.73069105691e-07 1.2 9.73100863821e-07 1.44748737342 9.73132621951e-07 1.55 9.73164380081e-07 1.44748737341 9.73196138211e-07 1.2 9.73227896341e-07 0.952512626585 9.73259654472e-07 0.85 9.73291412602e-07 0.952512626585 9.73323170732e-07 1.2 9.73354928862e-07 1.44748737341 9.73386686992e-07 1.55 9.73418445122e-07 1.44748737342 9.73450203252e-07 1.2 9.73481961382e-07 0.952512626586 9.73513719512e-07 0.85 9.73545477642e-07 0.952512626585 9.73577235772e-07 1.2 9.73608993902e-07 1.44748737342 9.73640752033e-07 1.55 9.73672510163e-07 1.44748737341 9.73704268293e-07 1.2 9.73736026423e-07 0.952512626585 9.73767784553e-07 0.85 9.73799542683e-07 0.952512626585 9.73831300813e-07 1.2 9.73863058943e-07 1.44748737341 9.73894817073e-07 1.55 9.73926575203e-07 1.44748737342 9.73958333333e-07 1.2 9.73990091463e-07 0.952512626585 9.74021849593e-07 0.85 9.74053607724e-07 0.952512626584 9.74085365854e-07 1.2 9.74117123984e-07 1.44748737342 9.74148882114e-07 1.55 9.74180640244e-07 1.44748737341 9.74212398374e-07 1.2 9.74244156504e-07 0.952512626584 9.74275914634e-07 0.85 9.74307672764e-07 0.952512626585 9.74339430894e-07 1.2 9.74371189024e-07 1.44748737342 9.74402947154e-07 1.55 9.74434705285e-07 1.44748737342 9.74466463415e-07 1.2 9.74498221545e-07 0.952512626585 9.74529979675e-07 0.85 9.74561737805e-07 0.952512626585 9.74593495935e-07 1.2 9.74625254065e-07 1.44748737341 9.74657012195e-07 1.55 9.74688770325e-07 1.44748737342 9.74720528455e-07 1.2 9.74752286585e-07 0.952512626585 9.74784044715e-07 0.85 9.74815802846e-07 0.952512626586 9.74847560976e-07 1.2 9.74879319106e-07 1.44748737342 9.74911077236e-07 1.55 9.74942835366e-07 1.44748737341 9.74974593496e-07 1.2 9.75006351626e-07 0.952512626585 9.75038109756e-07 0.85 9.75069867886e-07 0.952512626585 9.75101626016e-07 1.2 9.75133384146e-07 1.44748737341 9.75165142276e-07 1.55 9.75196900407e-07 1.44748737342 9.75228658537e-07 1.2 9.75260416667e-07 0.952512626585 9.75292174797e-07 0.85 9.75323932927e-07 0.952512626584 9.75355691057e-07 1.2 9.75387449187e-07 1.44748737342 9.75419207317e-07 1.55 9.75450965447e-07 1.44748737341 9.75482723577e-07 1.2 9.75514481707e-07 0.952512626584 9.75546239837e-07 0.85 9.75577997967e-07 0.952512626585 9.75609756098e-07 1.2 9.75641514228e-07 1.44748737342 9.75673272358e-07 1.55 9.75705030488e-07 1.44748737342 9.75736788618e-07 1.2 9.75768546748e-07 0.952512626585 9.75800304878e-07 0.85 9.75832063008e-07 0.952512626585 9.75863821138e-07 1.2 9.75895579268e-07 1.44748737342 9.75927337398e-07 1.55 9.75959095528e-07 1.44748737342 9.75990853659e-07 1.2 9.76022611789e-07 0.952512626585 9.76054369919e-07 0.85 9.76086128049e-07 0.952512626584 9.76117886179e-07 1.2 9.76149644309e-07 1.44748737342 9.76181402439e-07 1.55 9.76213160569e-07 1.44748737341 9.76244918699e-07 1.2 9.76276676829e-07 0.952512626585 9.76308434959e-07 0.85 9.76340193089e-07 0.952512626585 9.7637195122e-07 1.2 9.7640370935e-07 1.44748737342 9.7643546748e-07 1.55 9.7646722561e-07 1.44748737342 9.7649898374e-07 1.2 9.7653074187e-07 0.952512626585 9.765625e-07 0.85 9.7659425813e-07 0.952512626584 9.7662601626e-07 1.2 9.7665777439e-07 1.44748737341 9.7668953252e-07 1.55 9.7672129065e-07 1.44748737342 9.7675304878e-07 1.2 9.76784806911e-07 0.952512626585 9.76816565041e-07 0.85 9.76848323171e-07 0.952512626585 9.76880081301e-07 1.2 9.76911839431e-07 1.44748737342 9.76943597561e-07 1.55 9.76975355691e-07 1.44748737342 9.77007113821e-07 1.2 9.77038871951e-07 0.952512626584 9.77070630081e-07 0.85 9.77102388211e-07 0.952512626584 9.77134146341e-07 1.2 9.77165904472e-07 1.44748737342 9.77197662602e-07 1.55 9.77229420732e-07 1.44748737342 9.77261178862e-07 1.2 9.77292936992e-07 0.952512626585 9.77324695122e-07 0.85 9.77356453252e-07 0.952512626584 9.77388211382e-07 1.2 9.77419969512e-07 1.44748737342 9.77451727642e-07 1.55 9.77483485772e-07 1.44748737341 9.77515243902e-07 1.2 9.77547002033e-07 0.952512626584 9.77578760163e-07 0.85 9.77610518293e-07 0.952512626585 9.77642276423e-07 1.2 9.77674034553e-07 1.44748737342 9.77705792683e-07 1.55 9.77737550813e-07 1.44748737342 9.77769308943e-07 1.2 9.77801067073e-07 0.952512626585 9.77832825203e-07 0.85 9.77864583333e-07 0.952512626584 9.77896341463e-07 1.2 9.77928099593e-07 1.44748737341 9.77959857724e-07 1.55 9.77991615854e-07 1.44748737342 9.78023373984e-07 1.2 9.78055132114e-07 0.952512626584 9.78086890244e-07 0.85 9.78118648374e-07 0.952512626585 9.78150406504e-07 1.2 9.78182164634e-07 1.44748737342 9.78213922764e-07 1.55 9.78245680894e-07 1.44748737342 9.78277439024e-07 1.2 9.78309197154e-07 0.952512626584 9.78340955285e-07 0.85 9.78372713415e-07 0.952512626584 9.78404471545e-07 1.2 9.78436229675e-07 1.44748737342 9.78467987805e-07 1.55 9.78499745935e-07 1.44748737342 9.78531504065e-07 1.2 9.78563262195e-07 0.952512626585 9.78595020325e-07 0.85 9.78626778455e-07 0.952512626585 9.78658536585e-07 1.2 9.78690294715e-07 1.44748737342 9.78722052846e-07 1.55 9.78753810976e-07 1.44748737341 9.78785569106e-07 1.2 9.78817327236e-07 0.952512626584 9.78849085366e-07 0.85 9.78880843496e-07 0.952512626585 9.78912601626e-07 1.2 9.78944359756e-07 1.44748737342 9.78976117886e-07 1.55 9.79007876016e-07 1.44748737342 9.79039634146e-07 1.2 9.79071392276e-07 0.952512626585 9.79103150407e-07 0.85 9.79134908537e-07 0.952512626585 9.79166666667e-07 1.2 9.79198424797e-07 1.44748737341 9.79230182927e-07 1.55 9.79261941057e-07 1.44748737342 9.79293699187e-07 1.2 9.79325457317e-07 0.952512626584 9.79357215447e-07 0.85 9.79388973577e-07 0.952512626585 9.79420731707e-07 1.2 9.79452489837e-07 1.44748737342 9.79484247967e-07 1.55 9.79516006098e-07 1.44748737342 9.79547764228e-07 1.2 9.79579522358e-07 0.952512626585 9.79611280488e-07 0.85 9.79643038618e-07 0.952512626584 9.79674796748e-07 1.2 9.79706554878e-07 1.44748737342 9.79738313008e-07 1.55 9.79770071138e-07 1.44748737342 9.79801829268e-07 1.2 9.79833587398e-07 0.952512626585 9.79865345528e-07 0.85 9.79897103659e-07 0.952512626584 9.79928861789e-07 1.2 9.79960619919e-07 1.44748737341 9.79992378049e-07 1.55 9.80024136179e-07 1.44748737342 9.80055894309e-07 1.2 9.80087652439e-07 0.952512626584 9.80119410569e-07 0.85 9.80151168699e-07 0.952512626585 9.80182926829e-07 1.2 9.80214684959e-07 1.44748737342 9.80246443089e-07 1.55 9.8027820122e-07 1.44748737341 9.8030995935e-07 1.2 9.8034171748e-07 0.952512626585 9.8037347561e-07 0.85 9.8040523374e-07 0.952512626585 9.8043699187e-07 1.2 9.8046875e-07 1.44748737341 9.8050050813e-07 1.55 9.8053226626e-07 1.44748737342 9.8056402439e-07 1.2 9.8059578252e-07 0.952512626586 9.8062754065e-07 0.85 9.8065929878e-07 0.952512626585 9.80691056911e-07 1.2 9.80722815041e-07 1.44748737342 9.80754573171e-07 1.55 9.80786331301e-07 1.44748737342 9.80818089431e-07 1.2 9.80849847561e-07 0.952512626585 9.80881605691e-07 0.85 9.80913363821e-07 0.952512626585 9.80945121951e-07 1.2 9.80976880081e-07 1.44748737342 9.81008638211e-07 1.55 9.81040396341e-07 1.44748737342 9.81072154472e-07 1.2 9.81103912602e-07 0.952512626585 9.81135670732e-07 0.85 9.81167428862e-07 0.952512626584 9.81199186992e-07 1.2 9.81230945122e-07 1.44748737341 9.81262703252e-07 1.55 9.81294461382e-07 1.44748737342 9.81326219512e-07 1.2 9.81357977642e-07 0.952512626584 9.81389735772e-07 0.85 9.81421493902e-07 0.952512626585 9.81453252033e-07 1.2 9.81485010163e-07 1.44748737342 9.81516768293e-07 1.55 9.81548526423e-07 1.44748737341 9.81580284553e-07 1.2 9.81612042683e-07 0.952512626585 9.81643800813e-07 0.85 9.81675558943e-07 0.952512626585 9.81707317073e-07 1.2 9.81739075203e-07 1.44748737341 9.81770833333e-07 1.55 9.81802591463e-07 1.44748737342 9.81834349593e-07 1.2 9.81866107724e-07 0.952512626586 9.81897865854e-07 0.85 9.81929623984e-07 0.952512626585 9.81961382114e-07 1.2 9.81993140244e-07 1.44748737342 9.82024898374e-07 1.55 9.82056656504e-07 1.44748737341 9.82088414634e-07 1.2 9.82120172764e-07 0.952512626585 9.82151930894e-07 0.85 9.82183689024e-07 0.952512626585 9.82215447154e-07 1.2 9.82247205285e-07 1.44748737341 9.82278963415e-07 1.55 9.82310721545e-07 1.44748737342 9.82342479675e-07 1.2 9.82374237805e-07 0.952512626585 9.82405995935e-07 0.85 9.82437754065e-07 0.952512626584 9.82469512195e-07 1.2 9.82501270325e-07 1.44748737342 9.82533028455e-07 1.55 9.82564786585e-07 1.44748737341 9.82596544715e-07 1.2 9.82628302846e-07 0.952512626584 9.82660060976e-07 0.85 9.82691819106e-07 0.952512626585 9.82723577236e-07 1.2 9.82755335366e-07 1.44748737342 9.82787093496e-07 1.55 9.82818851626e-07 1.44748737342 9.82850609756e-07 1.2 9.82882367886e-07 0.952512626585 9.82914126016e-07 0.85 9.82945884146e-07 0.952512626585 9.82977642276e-07 1.2 9.83009400407e-07 1.44748737341 9.83041158537e-07 1.55 9.83072916667e-07 1.44748737342 9.83104674797e-07 1.2 9.83136432927e-07 0.952512626585 9.83168191057e-07 0.85 9.83199949187e-07 0.952512626586 9.83231707317e-07 1.2 9.83263465447e-07 1.44748737342 9.83295223577e-07 1.55 9.83326981707e-07 1.44748737341 9.83358739837e-07 1.2 9.83390497967e-07 0.952512626585 9.83422256098e-07 0.85 9.83454014228e-07 0.952512626585 9.83485772358e-07 1.2 9.83517530488e-07 1.44748737341 9.83549288618e-07 1.55 9.83581046748e-07 1.44748737342 9.83612804878e-07 1.2 9.83644563008e-07 0.952512626585 9.83676321138e-07 0.85 9.83708079268e-07 0.952512626584 9.83739837398e-07 1.2 9.83771595528e-07 1.44748737342 9.83803353659e-07 1.55 9.83835111789e-07 1.44748737342 9.83866869919e-07 1.2 9.83898628049e-07 0.952512626584 9.83930386179e-07 0.85 9.83962144309e-07 0.952512626585 9.83993902439e-07 1.2 9.84025660569e-07 1.44748737342 9.84057418699e-07 1.55 9.84089176829e-07 1.44748737342 9.84120934959e-07 1.2 9.84152693089e-07 0.952512626584 9.8418445122e-07 0.85 9.8421620935e-07 0.952512626584 9.8424796748e-07 1.2 9.8427972561e-07 1.44748737342 9.8431148374e-07 1.55 9.8434324187e-07 1.44748737342 9.84375e-07 1.2 9.8440675813e-07 0.952512626585 9.8443851626e-07 0.85 9.8447027439e-07 0.952512626584 9.8450203252e-07 1.2 9.8453379065e-07 1.44748737342 9.8456554878e-07 1.55 9.84597306911e-07 1.44748737341 9.84629065041e-07 1.2 9.84660823171e-07 0.952512626585 9.84692581301e-07 0.85 9.84724339431e-07 0.952512626585 9.84756097561e-07 1.2 9.84787855691e-07 1.44748737342 9.84819613821e-07 1.55 9.84851371951e-07 1.44748737342 9.84883130081e-07 1.2 9.84914888211e-07 0.952512626585 9.84946646341e-07 0.85 9.84978404472e-07 0.952512626584 9.85010162602e-07 1.2 9.85041920732e-07 1.44748737341 9.85073678862e-07 1.55 9.85105436992e-07 1.44748737342 9.85137195122e-07 1.2 9.85168953252e-07 0.952512626585 9.85200711382e-07 0.85 9.85232469512e-07 0.952512626585 9.85264227642e-07 1.2 9.85295985772e-07 1.44748737342 9.85327743902e-07 1.55 9.85359502033e-07 1.44748737342 9.85391260163e-07 1.2 9.85423018293e-07 0.952512626584 9.85454776423e-07 0.85 9.85486534553e-07 0.952512626584 9.85518292683e-07 1.2 9.85550050813e-07 1.44748737342 9.85581808943e-07 1.55 9.85613567073e-07 1.44748737342 9.85645325203e-07 1.2 9.85677083333e-07 0.952512626585 9.85708841463e-07 0.85 9.85740599593e-07 0.952512626584 9.85772357724e-07 1.2 9.85804115854e-07 1.44748737342 9.85835873984e-07 1.55 9.85867632114e-07 1.44748737341 9.85899390244e-07 1.2 9.85931148374e-07 0.952512626584 9.85962906504e-07 0.85 9.85994664634e-07 0.952512626585 9.86026422764e-07 1.2 9.86058180894e-07 1.44748737342 9.86089939024e-07 1.55 9.86121697154e-07 1.44748737342 9.86153455285e-07 1.2 9.86185213415e-07 0.952512626585 9.86216971545e-07 0.85 9.86248729675e-07 0.952512626584 9.86280487805e-07 1.2 9.86312245935e-07 1.44748737341 9.86344004065e-07 1.55 9.86375762195e-07 1.44748737342 9.86407520325e-07 1.2 9.86439278455e-07 0.952512626584 9.86471036585e-07 0.85 9.86502794715e-07 0.952512626585 9.86534552846e-07 1.2 9.86566310976e-07 1.44748737342 9.86598069106e-07 1.55 9.86629827236e-07 1.44748737342 9.86661585366e-07 1.2 9.86693343496e-07 0.952512626584 9.86725101626e-07 0.85 9.86756859756e-07 0.952512626584 9.86788617886e-07 1.2 9.86820376016e-07 1.44748737342 9.86852134146e-07 1.55 9.86883892276e-07 1.44748737342 9.86915650407e-07 1.2 9.86947408537e-07 0.952512626585 9.86979166667e-07 0.85 9.87010924797e-07 0.952512626584 9.87042682927e-07 1.2 9.87074441057e-07 1.44748737342 9.87106199187e-07 1.55 9.87137957317e-07 1.44748737341 9.87169715447e-07 1.2 9.87201473577e-07 0.952512626584 9.87233231707e-07 0.85 9.87264989837e-07 0.952512626585 9.87296747967e-07 1.2 9.87328506098e-07 1.44748737342 9.87360264228e-07 1.55 9.87392022358e-07 1.44748737342 9.87423780488e-07 1.2 9.87455538618e-07 0.952512626585 9.87487296748e-07 0.85 9.87519054878e-07 0.952512626585 9.87550813008e-07 1.2 9.87582571138e-07 1.44748737341 9.87614329268e-07 1.55 9.87646087398e-07 1.44748737342 9.87677845528e-07 1.2 9.87709603659e-07 0.952512626586 9.87741361789e-07 0.85 9.87773119919e-07 0.952512626585 9.87804878049e-07 1.2 9.87836636179e-07 1.44748737342 9.87868394309e-07 1.55 9.87900152439e-07 1.44748737342 9.87931910569e-07 1.2 9.87963668699e-07 0.952512626585 9.87995426829e-07 0.85 9.88027184959e-07 0.952512626584 9.88058943089e-07 1.2 9.8809070122e-07 1.44748737342 9.8812245935e-07 1.55 9.8815421748e-07 1.44748737342 9.8818597561e-07 1.2 9.8821773374e-07 0.952512626585 9.8824949187e-07 0.85 9.8828125e-07 0.952512626584 9.8831300813e-07 1.2 9.8834476626e-07 1.44748737341 9.8837652439e-07 1.55 9.8840828252e-07 1.44748737342 9.8844004065e-07 1.2 9.8847179878e-07 0.952512626584 9.88503556911e-07 0.85 9.88535315041e-07 0.952512626585 9.88567073171e-07 1.2 9.88598831301e-07 1.44748737342 9.88630589431e-07 1.55 9.88662347561e-07 1.44748737341 9.88694105691e-07 1.2 9.88725863821e-07 0.952512626585 9.88757621951e-07 0.85 9.88789380081e-07 0.952512626585 9.88821138211e-07 1.2 9.88852896341e-07 1.44748737341 9.88884654472e-07 1.55 9.88916412602e-07 1.44748737342 9.88948170732e-07 1.2 9.88979928862e-07 0.952512626586 9.89011686992e-07 0.85 9.89043445122e-07 0.952512626585 9.89075203252e-07 1.2 9.89106961382e-07 1.44748737342 9.89138719512e-07 1.55 9.89170477642e-07 1.44748737342 9.89202235772e-07 1.2 9.89233993902e-07 0.952512626585 9.89265752033e-07 0.85 9.89297510163e-07 0.952512626585 9.89329268293e-07 1.2 9.89361026423e-07 1.44748737342 9.89392784553e-07 1.55 9.89424542683e-07 1.44748737342 9.89456300813e-07 1.2 9.89488058943e-07 0.952512626585 9.89519817073e-07 0.85 9.89551575203e-07 0.952512626584 9.89583333333e-07 1.2 9.89615091463e-07 1.44748737341 9.89646849593e-07 1.55 9.89678607724e-07 1.44748737342 9.89710365854e-07 1.2 9.89742123984e-07 0.952512626584 9.89773882114e-07 0.85 9.89805640244e-07 0.952512626585 9.89837398374e-07 1.2 9.89869156504e-07 1.44748737342 9.89900914634e-07 1.55 9.89932672764e-07 1.44748737341 9.89964430894e-07 1.2 9.89996189024e-07 0.952512626585 9.90027947154e-07 0.85 9.90059705285e-07 0.952512626585 9.90091463415e-07 1.2 9.90123221545e-07 1.44748737341 9.90154979675e-07 1.55 9.90186737805e-07 1.44748737342 9.90218495935e-07 1.2 9.90250254065e-07 0.952512626585 9.90282012195e-07 0.85 9.90313770325e-07 0.952512626586 9.90345528455e-07 1.2 9.90377286585e-07 1.44748737342 9.90409044715e-07 1.55 9.90440802846e-07 1.44748737341 9.90472560976e-07 1.2 9.90504319106e-07 0.952512626585 9.90536077236e-07 0.85 9.90567835366e-07 0.952512626585 9.90599593496e-07 1.2 9.90631351626e-07 1.44748737341 9.90663109756e-07 1.55 9.90694867886e-07 1.44748737342 9.90726626016e-07 1.2 9.90758384146e-07 0.952512626585 9.90790142276e-07 0.85 9.90821900407e-07 0.952512626584 9.90853658537e-07 1.2 9.90885416667e-07 1.44748737342 9.90917174797e-07 1.55 9.90948932927e-07 1.44748737341 9.90980691057e-07 1.2 9.91012449187e-07 0.952512626584 9.91044207317e-07 0.85 9.91075965447e-07 0.952512626585 9.91107723577e-07 1.2 9.91139481707e-07 1.44748737342 9.91171239837e-07 1.55 9.91202997967e-07 1.44748737342 9.91234756098e-07 1.2 9.91266514228e-07 0.952512626585 9.91298272358e-07 0.85 9.91330030488e-07 0.952512626585 9.91361788618e-07 1.2 9.91393546748e-07 1.44748737342 9.91425304878e-07 1.55 9.91457063008e-07 1.44748737342 9.91488821138e-07 1.2 9.91520579268e-07 0.952512626585 9.91552337398e-07 0.85 9.91584095528e-07 0.952512626584 9.91615853659e-07 1.2 9.91647611789e-07 1.44748737342 9.91679369919e-07 1.55 9.91711128049e-07 1.44748737341 9.91742886179e-07 1.2 9.91774644309e-07 0.952512626585 9.91806402439e-07 0.85 9.91838160569e-07 0.952512626585 9.91869918699e-07 1.2 9.91901676829e-07 1.44748737341 9.91933434959e-07 1.55 9.91965193089e-07 1.44748737342 9.9199695122e-07 1.2 9.9202870935e-07 0.952512626585 9.9206046748e-07 0.85 9.9209222561e-07 0.952512626584 9.9212398374e-07 1.2 9.9215574187e-07 1.44748737342 9.921875e-07 1.55 9.9221925813e-07 1.44748737342 9.9225101626e-07 1.2 9.9228277439e-07 0.952512626584 9.9231453252e-07 0.85 9.9234629065e-07 0.952512626585 9.9237804878e-07 1.2 9.92409806911e-07 1.44748737342 9.92441565041e-07 1.55 9.92473323171e-07 1.44748737342 9.92505081301e-07 1.2 9.92536839431e-07 0.952512626584 9.92568597561e-07 0.85 9.92600355691e-07 0.952512626584 9.92632113821e-07 1.2 9.92663871951e-07 1.44748737342 9.92695630081e-07 1.55 9.92727388211e-07 1.44748737342 9.92759146341e-07 1.2 9.92790904472e-07 0.952512626585 9.92822662602e-07 0.85 9.92854420732e-07 0.952512626584 9.92886178862e-07 1.2 9.92917936992e-07 1.44748737342 9.92949695122e-07 1.55 9.92981453252e-07 1.44748737341 9.93013211382e-07 1.2 9.93044969512e-07 0.952512626585 9.93076727642e-07 0.85 9.93108485772e-07 0.952512626585 9.93140243902e-07 1.2 9.93172002033e-07 1.44748737342 9.93203760163e-07 1.55 9.93235518293e-07 1.44748737342 9.93267276423e-07 1.2 9.93299034553e-07 0.952512626585 9.93330792683e-07 0.85 9.93362550813e-07 0.952512626584 9.93394308943e-07 1.2 9.93426067073e-07 1.44748737341 9.93457825203e-07 1.55 9.93489583333e-07 1.44748737342 9.93521341463e-07 1.2 9.93553099593e-07 0.952512626585 9.93584857724e-07 0.85 9.93616615854e-07 0.952512626585 9.93648373984e-07 1.2 9.93680132114e-07 1.44748737342 9.93711890244e-07 1.55 9.93743648374e-07 1.44748737342 9.93775406504e-07 1.2 9.93807164634e-07 0.952512626584 9.93838922764e-07 0.85 9.93870680894e-07 0.952512626584 9.93902439024e-07 1.2 9.93934197154e-07 1.44748737342 9.93965955285e-07 1.55 9.93997713415e-07 1.44748737342 9.94029471545e-07 1.2 9.94061229675e-07 0.952512626585 9.94092987805e-07 0.85 9.94124745935e-07 0.952512626584 9.94156504065e-07 1.2 9.94188262195e-07 1.44748737342 9.94220020325e-07 1.55 9.94251778455e-07 1.44748737341 9.94283536585e-07 1.2 9.94315294715e-07 0.952512626584 9.94347052846e-07 0.85 9.94378810976e-07 0.952512626585 9.94410569106e-07 1.2 9.94442327236e-07 1.44748737342 9.94474085366e-07 1.55 9.94505843496e-07 1.44748737342 9.94537601626e-07 1.2 9.94569359756e-07 0.952512626585 9.94601117886e-07 0.85 9.94632876016e-07 0.952512626584 9.94664634146e-07 1.2 9.94696392276e-07 1.44748737341 9.94728150407e-07 1.55 9.94759908537e-07 1.44748737342 9.94791666667e-07 1.2 9.94823424797e-07 0.952512626584 9.94855182927e-07 0.85 9.94886941057e-07 0.952512626585 9.94918699187e-07 1.2 9.94950457317e-07 1.44748737342 9.94982215447e-07 1.55 9.95013973577e-07 1.44748737342 9.95045731707e-07 1.2 9.95077489837e-07 0.952512626584 9.95109247967e-07 0.85 9.95141006098e-07 0.952512626584 9.95172764228e-07 1.2 9.95204522358e-07 1.44748737342 9.95236280488e-07 1.55 9.95268038618e-07 1.44748737342 9.95299796748e-07 1.2 9.95331554878e-07 0.952512626585 9.95363313008e-07 0.85 9.95395071138e-07 0.952512626584 9.95426829268e-07 1.2 9.95458587398e-07 1.44748737341 9.95490345528e-07 1.55 9.95522103659e-07 1.44748737341 9.95553861789e-07 1.2 9.95585619919e-07 0.952512626584 9.95617378049e-07 0.85 9.95649136179e-07 0.952512626585 9.95680894309e-07 1.2 9.95712652439e-07 1.44748737342 9.95744410569e-07 1.55 9.95776168699e-07 1.44748737342 9.95807926829e-07 1.2 9.95839684959e-07 0.952512626585 9.95871443089e-07 0.85 9.9590320122e-07 0.952512626585 9.9593495935e-07 1.2 9.9596671748e-07 1.44748737341 9.9599847561e-07 1.55 9.9603023374e-07 1.44748737342 9.9606199187e-07 1.2 9.9609375e-07 0.952512626586 9.9612550813e-07 0.85 9.9615726626e-07 0.952512626585 9.9618902439e-07 1.2 9.9622078252e-07 1.44748737342 9.9625254065e-07 1.55 9.9628429878e-07 1.44748737342 9.96316056911e-07 1.2 9.96347815041e-07 0.952512626585 9.96379573171e-07 0.85 9.96411331301e-07 0.952512626585 9.96443089431e-07 1.2 9.96474847561e-07 1.44748737342 9.96506605691e-07 1.55 9.96538363821e-07 1.44748737342 9.96570121951e-07 1.2 9.96601880081e-07 0.952512626585 9.96633638211e-07 0.85 9.96665396341e-07 0.952512626584 9.96697154472e-07 1.2 9.96728912602e-07 1.44748737341 9.96760670732e-07 1.55 9.96792428862e-07 1.44748737342 9.96824186992e-07 1.2 9.96855945122e-07 0.952512626584 9.96887703252e-07 0.85 9.96919461382e-07 0.952512626585 9.96951219512e-07 1.2 9.96982977642e-07 1.44748737342 9.97014735772e-07 1.55 9.97046493902e-07 1.44748737341 9.97078252033e-07 1.2 9.97110010163e-07 0.952512626585 9.97141768293e-07 0.85 9.97173526423e-07 0.952512626585 9.97205284553e-07 1.2 9.97237042683e-07 1.44748737341 9.97268800813e-07 1.55 9.97300558943e-07 1.44748737342 9.97332317073e-07 1.2 9.97364075203e-07 0.952512626586 9.97395833333e-07 0.85 9.97427591463e-07 0.952512626585 9.97459349593e-07 1.2 9.97491107724e-07 1.44748737342 9.97522865854e-07 1.55 9.97554623984e-07 1.44748737341 9.97586382114e-07 1.2 9.97618140244e-07 0.952512626585 9.97649898374e-07 0.85 9.97681656504e-07 0.952512626585 9.97713414634e-07 1.2 9.97745172764e-07 1.44748737342 9.97776930894e-07 1.55 9.97808689024e-07 1.44748737342 9.97840447154e-07 1.2 9.97872205285e-07 0.952512626585 9.97903963415e-07 0.85 9.97935721545e-07 0.952512626584 9.97967479675e-07 1.2 9.97999237805e-07 1.44748737341 9.98030995935e-07 1.55 9.98062754065e-07 1.44748737342 9.98094512195e-07 1.2 9.98126270325e-07 0.952512626584 9.98158028455e-07 0.85 9.98189786585e-07 0.952512626585 9.98221544715e-07 1.2 9.98253302846e-07 1.44748737342 9.98285060976e-07 1.55 9.98316819106e-07 1.44748737341 9.98348577236e-07 1.2 9.98380335366e-07 0.952512626585 9.98412093496e-07 0.85 9.98443851626e-07 0.952512626585 9.98475609756e-07 1.2 9.98507367886e-07 1.44748737341 9.98539126016e-07 1.55 9.98570884146e-07 1.44748737342 9.98602642276e-07 1.2 9.98634400407e-07 0.952512626585 9.98666158537e-07 0.85 9.98697916667e-07 0.952512626586 9.98729674797e-07 1.2 9.98761432927e-07 1.44748737342 9.98793191057e-07 1.55 9.98824949187e-07 1.44748737341 9.98856707317e-07 1.2 9.98888465447e-07 0.952512626585 9.98920223577e-07 0.85 9.98951981707e-07 0.952512626585 9.98983739837e-07 1.2 9.99015497967e-07 1.44748737341 9.99047256098e-07 1.55 9.99079014228e-07 1.44748737342 9.99110772358e-07 1.2 9.99142530488e-07 0.952512626585 9.99174288618e-07 0.85 9.99206046748e-07 0.952512626584 9.99237804878e-07 1.2 9.99269563008e-07 1.44748737342 9.99301321138e-07 1.55 9.99333079268e-07 1.44748737342 9.99364837398e-07 1.2 9.99396595528e-07 0.952512626584 9.99428353659e-07 0.85 9.99460111789e-07 0.952512626585 9.99491869919e-07 1.2 9.99523628049e-07 1.44748737342 9.99555386179e-07 1.55 9.99587144309e-07 1.44748737342 9.99618902439e-07 1.2 9.99650660569e-07 0.952512626585 9.99682418699e-07 0.85 9.99714176829e-07 0.952512626585 9.99745934959e-07 1.2 9.99777693089e-07 1.44748737342 9.9980945122e-07 1.55 9.9984120935e-07 1.44748737342 9.9987296748e-07 1.2 9.9990472561e-07 0.952512626585 9.9993648374e-07 0.85 9.9996824187e-07 0.952512626584 1e-06 1.2 1.00003175813e-06 1.44748737342 1.00006351626e-06 1.55 1.00009527439e-06 1.44748737341 1.00012703252e-06 1.2 1.00015879065e-06 0.952512626585 1.00019054878e-06 0.85 1.00022230691e-06 0.952512626585 1.00025406504e-06 1.2 1.00028582317e-06 1.44748737341 1.0003175813e-06 1.55 1.00034933943e-06 1.44748737342 1.00038109756e-06 1.2 1.00041285569e-06 0.952512626585 1.00044461382e-06 0.85 1.00047637195e-06 0.952512626584 1.00050813008e-06 1.2 1.00053988821e-06 1.44748737342 1.00057164634e-06 1.55 1.00060340447e-06 1.44748737342 1.0006351626e-06 1.2 1.00066692073e-06 0.952512626584 1.00069867886e-06 0.85 1.00073043699e-06 0.952512626585 1.00076219512e-06 1.2 1.00079395325e-06 1.44748737342 1.00082571138e-06 1.55 1.00085746951e-06 1.44748737342 1.00088922764e-06 1.2 1.00092098577e-06 0.952512626584 1.0009527439e-06 0.85 1.00098450203e-06 0.952512626584 1.00101626016e-06 1.2 1.00104801829e-06 1.44748737342 1.00107977642e-06 1.55 1.00111153455e-06 1.44748737342 1.00114329268e-06 1.2 1.00117505081e-06 0.952512626585 1.00120680894e-06 0.85 1.00123856707e-06 0.952512626584 1.0012703252e-06 1.2 1.00130208333e-06 1.44748737342 1.00133384146e-06 1.55 1.00136559959e-06 1.44748737341 1.00139735772e-06 1.2 1.00142911585e-06 0.952512626585 1.00146087398e-06 0.85 1.00149263211e-06 0.952512626585 1.00152439024e-06 1.2 1.00155614837e-06 1.44748737342 1.0015879065e-06 1.55 1.00161966463e-06 1.44748737342 1.00165142276e-06 1.2 1.00168318089e-06 0.952512626585 1.00171493902e-06 0.85 1.00174669715e-06 0.952512626584 1.00177845528e-06 1.2 1.00181021341e-06 1.44748737341 1.00184197154e-06 1.55 1.00187372967e-06 1.44748737342 1.0019054878e-06 1.2 1.00193724593e-06 0.952512626585 1.00196900407e-06 0.85 1.0020007622e-06 0.952512626585 1.00203252033e-06 1.2 1.00206427846e-06 1.44748737342 1.00209603659e-06 1.55 1.00212779472e-06 1.44748737342 1.00215955285e-06 1.2 1.00219131098e-06 0.952512626584 1.00222306911e-06 0.85 1.00225482724e-06 0.952512626584 1.00228658537e-06 1.2 1.0023183435e-06 1.44748737342 1.00235010163e-06 1.55 1.00238185976e-06 1.44748737342 1.00241361789e-06 1.2 1.00244537602e-06 0.952512626585 1.00247713415e-06 0.85 1.00250889228e-06 0.952512626585 1.00254065041e-06 1.2 1.00257240854e-06 1.44748737342 1.00260416667e-06 1.55 1.0026359248e-06 1.44748737341 1.00266768293e-06 1.2 1.00269944106e-06 0.952512626584 1.00273119919e-06 0.85 1.00276295732e-06 0.952512626585 1.00279471545e-06 1.2 1.00282647358e-06 1.44748737342 1.00285823171e-06 1.55 1.00288998984e-06 1.44748737342 1.00292174797e-06 1.2 1.0029535061e-06 0.952512626585 1.00298526423e-06 0.85 1.00301702236e-06 0.952512626584 1.00304878049e-06 1.2 1.00308053862e-06 1.44748737341 1.00311229675e-06 1.55 1.00314405488e-06 1.44748737342 1.00317581301e-06 1.2 1.00320757114e-06 0.952512626586 1.00323932927e-06 0.85 1.0032710874e-06 0.952512626585 1.00330284553e-06 1.2 1.00333460366e-06 1.44748737342 1.00336636179e-06 1.55 1.00339811992e-06 1.44748737342 1.00342987805e-06 1.2 1.00346163618e-06 0.952512626584 1.00349339431e-06 0.85 1.00352515244e-06 0.952512626584 1.00355691057e-06 1.2 1.0035886687e-06 1.44748737342 1.00362042683e-06 1.55 1.00365218496e-06 1.44748737342 1.00368394309e-06 1.2 1.00371570122e-06 0.952512626585 1.00374745935e-06 0.85 1.00377921748e-06 0.952512626584 1.00381097561e-06 1.2 1.00384273374e-06 1.44748737341 1.00387449187e-06 1.55 1.00390625e-06 1.44748737341 1.00393800813e-06 1.2 1.00396976626e-06 0.952512626584 1.00400152439e-06 0.85 1.00403328252e-06 0.952512626585 1.00406504065e-06 1.2 1.00409679878e-06 1.44748737342 1.00412855691e-06 1.55 1.00416031504e-06 1.44748737342 1.00419207317e-06 1.2 1.0042238313e-06 0.952512626585 1.00425558943e-06 0.85 1.00428734756e-06 0.952512626585 1.00431910569e-06 1.2 1.00435086382e-06 1.44748737341 1.00438262195e-06 1.55 1.00441438008e-06 1.44748737342 1.00444613821e-06 1.2 1.00447789634e-06 0.952512626586 1.00450965447e-06 0.85 1.0045414126e-06 0.952512626585 1.00457317073e-06 1.2 1.00460492886e-06 1.44748737342 1.00463668699e-06 1.55 1.00466844512e-06 1.44748737342 1.00470020325e-06 1.2 1.00473196138e-06 0.952512626585 1.00476371951e-06 0.85 1.00479547764e-06 0.952512626585 1.00482723577e-06 1.2 1.0048589939e-06 1.44748737342 1.00489075203e-06 1.55 1.00492251016e-06 1.44748737342 1.00495426829e-06 1.2 1.00498602642e-06 0.952512626585 1.00501778455e-06 0.85 1.00504954268e-06 0.952512626584 1.00508130081e-06 1.2 1.00511305894e-06 1.44748737341 1.00514481707e-06 1.55 1.0051765752e-06 1.44748737342 1.00520833333e-06 1.2 1.00524009146e-06 0.952512626584 1.00527184959e-06 0.85 1.00530360772e-06 0.952512626585 1.00533536585e-06 1.2 1.00536712398e-06 1.44748737342 1.00539888211e-06 1.55 1.00543064024e-06 1.44748737341 1.00546239837e-06 1.2 1.0054941565e-06 0.952512626585 1.00552591463e-06 0.85 1.00555767276e-06 0.952512626585 1.00558943089e-06 1.2 1.00562118902e-06 1.44748737341 1.00565294715e-06 1.55 1.00568470528e-06 1.44748737342 1.00571646341e-06 1.2 1.00574822154e-06 0.952512626586 1.00577997967e-06 0.85 1.0058117378e-06 0.952512626585 1.00584349593e-06 1.2 1.00587525407e-06 1.44748737342 1.0059070122e-06 1.55 1.00593877033e-06 1.44748737341 1.00597052846e-06 1.2 1.00600228659e-06 0.952512626585 1.00603404472e-06 0.85 1.00606580285e-06 0.952512626585 1.00609756098e-06 1.2 1.00612931911e-06 1.44748737342 1.00616107724e-06 1.55 1.00619283537e-06 1.44748737342 1.0062245935e-06 1.2 1.00625635163e-06 0.952512626585 1.00628810976e-06 0.85 1.00631986789e-06 0.952512626584 1.00635162602e-06 1.2 1.00638338415e-06 1.44748737341 1.00641514228e-06 1.55 1.00644690041e-06 1.44748737342 1.00647865854e-06 1.2 1.00651041667e-06 0.952512626584 1.0065421748e-06 0.85 1.00657393293e-06 0.952512626585 1.00660569106e-06 1.2 1.00663744919e-06 1.44748737342 1.00666920732e-06 1.55 1.00670096545e-06 1.44748737341 1.00673272358e-06 1.2 1.00676448171e-06 0.952512626585 1.00679623984e-06 0.85 1.00682799797e-06 0.952512626585 1.0068597561e-06 1.2 1.00689151423e-06 1.44748737341 1.00692327236e-06 1.55 1.00695503049e-06 1.44748737342 1.00698678862e-06 1.2 1.00701854675e-06 0.952512626585 1.00705030488e-06 0.85 1.00708206301e-06 0.952512626586 1.00711382114e-06 1.2 1.00714557927e-06 1.44748737342 1.0071773374e-06 1.55 1.00720909553e-06 1.44748737341 1.00724085366e-06 1.2 1.00727261179e-06 0.952512626585 1.00730436992e-06 0.85 1.00733612805e-06 0.952512626585 1.00736788618e-06 1.2 1.00739964431e-06 1.44748737341 1.00743140244e-06 1.55 1.00746316057e-06 1.44748737342 1.0074949187e-06 1.2 1.00752667683e-06 0.952512626585 1.00755843496e-06 0.85 1.00759019309e-06 0.952512626584 1.00762195122e-06 1.2 1.00765370935e-06 1.44748737342 1.00768546748e-06 1.55 1.00771722561e-06 1.44748737342 1.00774898374e-06 1.2 1.00778074187e-06 0.952512626584 1.0078125e-06 0.85 1.00784425813e-06 0.952512626585 1.00787601626e-06 1.2 1.00790777439e-06 1.44748737342 1.00793953252e-06 1.55 1.00797129065e-06 1.44748737342 1.00800304878e-06 1.2 1.00803480691e-06 0.952512626585 1.00806656504e-06 0.85 1.00809832317e-06 0.952512626585 1.0081300813e-06 1.2 1.00816183943e-06 1.44748737342 1.00819359756e-06 1.55 1.00822535569e-06 1.44748737342 1.00825711382e-06 1.2 1.00828887195e-06 0.952512626585 1.00832063008e-06 0.85 1.00835238821e-06 0.952512626584 1.00838414634e-06 1.2 1.00841590447e-06 1.44748737342 1.0084476626e-06 1.55 1.00847942073e-06 1.44748737341 1.00851117886e-06 1.2 1.00854293699e-06 0.952512626585 1.00857469512e-06 0.85 1.00860645325e-06 0.952512626585 1.00863821138e-06 1.2 1.00866996951e-06 1.44748737342 1.00870172764e-06 1.55 1.00873348577e-06 1.44748737342 1.0087652439e-06 1.2 1.00879700203e-06 0.952512626585 1.00882876016e-06 0.85 1.00886051829e-06 0.952512626584 1.00889227642e-06 1.2 1.00892403455e-06 1.44748737341 1.00895579268e-06 1.55 1.00898755081e-06 1.44748737342 1.00901930894e-06 1.2 1.00905106707e-06 0.952512626584 1.0090828252e-06 0.85 1.00911458333e-06 0.952512626585 1.00914634146e-06 1.2 1.00917809959e-06 1.44748737342 1.00920985772e-06 1.55 1.00924161585e-06 1.44748737342 1.00927337398e-06 1.2 1.00930513211e-06 0.952512626584 1.00933689024e-06 0.85 1.00936864837e-06 0.952512626584 1.0094004065e-06 1.2 1.00943216463e-06 1.44748737342 1.00946392276e-06 1.55 1.00949568089e-06 1.44748737342 1.00952743902e-06 1.2 1.00955919715e-06 0.952512626585 1.00959095528e-06 0.85 1.00962271341e-06 0.952512626584 1.00965447154e-06 1.2 1.00968622967e-06 1.44748737342 1.0097179878e-06 1.55 1.00974974593e-06 1.44748737341 1.00978150407e-06 1.2 1.0098132622e-06 0.952512626584 1.00984502033e-06 0.85 1.00987677846e-06 0.952512626585 1.00990853659e-06 1.2 1.00994029472e-06 1.44748737342 1.00997205285e-06 1.55 1.01000381098e-06 1.44748737342 1.01003556911e-06 1.2 1.01006732724e-06 0.952512626585 1.01009908537e-06 0.85 1.0101308435e-06 0.952512626584 1.01016260163e-06 1.2 1.01019435976e-06 1.44748737341 1.01022611789e-06 1.55 1.01025787602e-06 1.44748737342 1.01028963415e-06 1.2 1.01032139228e-06 0.952512626585 1.01035315041e-06 0.85 1.01038490854e-06 0.952512626585 1.01041666667e-06 1.2 1.0104484248e-06 1.44748737342 1.01048018293e-06 1.55 1.01051194106e-06 1.44748737342 1.01054369919e-06 1.2 1.01057545732e-06 0.952512626584 1.01060721545e-06 0.85 1.01063897358e-06 0.952512626584 1.01067073171e-06 1.2 1.01070248984e-06 1.44748737342 1.01073424797e-06 1.55 1.0107660061e-06 1.44748737342 1.01079776423e-06 1.2 1.01082952236e-06 0.952512626585 1.01086128049e-06 0.85 1.01089303862e-06 0.952512626585 1.01092479675e-06 1.2 1.01095655488e-06 1.44748737342 1.01098831301e-06 1.55 1.01102007114e-06 1.44748737341 1.01105182927e-06 1.2 1.0110835874e-06 0.952512626584 1.01111534553e-06 0.85 1.01114710366e-06 0.952512626585 1.01117886179e-06 1.2 1.01121061992e-06 1.44748737342 1.01124237805e-06 1.55 1.01127413618e-06 1.44748737342 1.01130589431e-06 1.2 1.01133765244e-06 0.952512626585 1.01136941057e-06 0.85 1.0114011687e-06 0.952512626584 1.01143292683e-06 1.2 1.01146468496e-06 1.44748737341 1.01149644309e-06 1.55 1.01152820122e-06 1.44748737342 1.01155995935e-06 1.2 1.01159171748e-06 0.952512626586 1.01162347561e-06 0.85 1.01165523374e-06 0.952512626585 1.01168699187e-06 1.2 1.01171875e-06 1.44748737342 1.01175050813e-06 1.55 1.01178226626e-06 1.44748737342 1.01181402439e-06 1.2 1.01184578252e-06 0.952512626584 1.01187754065e-06 0.85 1.01190929878e-06 0.952512626584 1.01194105691e-06 1.2 1.01197281504e-06 1.44748737342 1.01200457317e-06 1.55 1.0120363313e-06 1.44748737342 1.01206808943e-06 1.2 1.01209984756e-06 0.952512626585 1.01213160569e-06 0.85 1.01216336382e-06 0.952512626584 1.01219512195e-06 1.2 1.01222688008e-06 1.44748737341 1.01225863821e-06 1.55 1.01229039634e-06 1.44748737341 1.01232215447e-06 1.2 1.0123539126e-06 0.952512626584 1.01238567073e-06 0.85 1.01241742886e-06 0.952512626585 1.01244918699e-06 1.2 1.01248094512e-06 1.44748737342 1.01251270325e-06 1.55 1.01254446138e-06 1.44748737342 1.01257621951e-06 1.2 1.01260797764e-06 0.952512626585 1.01263973577e-06 0.85 1.0126714939e-06 0.952512626585 1.01270325203e-06 1.2 1.01273501016e-06 1.44748737341 1.01276676829e-06 1.55 1.01279852642e-06 1.44748737342 1.01283028455e-06 1.2 1.01286204268e-06 0.952512626586 1.01289380081e-06 0.85 1.01292555894e-06 0.952512626585 1.01295731707e-06 1.2 1.0129890752e-06 1.44748737342 1.01302083333e-06 1.55 1.01305259146e-06 1.44748737342 1.01308434959e-06 1.2 1.01311610772e-06 0.952512626585 1.01314786585e-06 0.85 1.01317962398e-06 0.952512626585 1.01321138211e-06 1.2 1.01324314024e-06 1.44748737342 1.01327489837e-06 1.55 1.0133066565e-06 1.44748737342 1.01333841463e-06 1.2 1.01337017276e-06 0.952512626585 1.01340193089e-06 0.85 1.01343368902e-06 0.952512626584 1.01346544715e-06 1.2 1.01349720528e-06 1.44748737341 1.01352896341e-06 1.55 1.01356072154e-06 1.44748737342 1.01359247967e-06 1.2 1.0136242378e-06 0.952512626584 1.01365599593e-06 0.85 1.01368775407e-06 0.952512626585 1.0137195122e-06 1.2 1.01375127033e-06 1.44748737342 1.01378302846e-06 1.55 1.01381478659e-06 1.44748737341 1.01384654472e-06 1.2 1.01387830285e-06 0.952512626585 1.01391006098e-06 0.85 1.01394181911e-06 0.952512626585 1.01397357724e-06 1.2 1.01400533537e-06 1.44748737341 1.0140370935e-06 1.55 1.01406885163e-06 1.44748737342 1.01410060976e-06 1.2 1.01413236789e-06 0.952512626586 1.01416412602e-06 0.85 1.01419588415e-06 0.952512626585 1.01422764228e-06 1.2 1.01425940041e-06 1.44748737342 1.01429115854e-06 1.55 1.01432291667e-06 1.44748737341 1.0143546748e-06 1.2 1.01438643293e-06 0.952512626585 1.01441819106e-06 0.85 1.01444994919e-06 0.952512626585 1.01448170732e-06 1.2 1.01451346545e-06 1.44748737341 1.01454522358e-06 1.55 1.01457698171e-06 1.44748737342 1.01460873984e-06 1.2 1.01464049797e-06 0.952512626585 1.0146722561e-06 0.85 1.01470401423e-06 0.952512626584 1.01473577236e-06 1.2 1.01476753049e-06 1.44748737342 1.01479928862e-06 1.55 1.01483104675e-06 1.44748737341 1.01486280488e-06 1.2 1.01489456301e-06 0.952512626584 1.01492632114e-06 0.85 1.01495807927e-06 0.952512626585 1.0149898374e-06 1.2 1.01502159553e-06 1.44748737342 1.01505335366e-06 1.55 1.01508511179e-06 1.44748737341 1.01511686992e-06 1.2 1.01514862805e-06 0.952512626585 1.01518038618e-06 0.85 1.01521214431e-06 0.952512626585 1.01524390244e-06 1.2 1.01527566057e-06 1.44748737341 1.0153074187e-06 1.55 1.01533917683e-06 1.44748737342 1.01537093496e-06 1.2 1.01540269309e-06 0.952512626585 1.01543445122e-06 0.85 1.01546620935e-06 0.952512626584 1.01549796748e-06 1.2 1.01552972561e-06 1.44748737342 1.01556148374e-06 1.55 1.01559324187e-06 1.44748737341 1.015625e-06 1.2 1.01565675813e-06 0.952512626585 1.01568851626e-06 0.85 1.01572027439e-06 0.952512626585 1.01575203252e-06 1.2 1.01578379065e-06 1.44748737341 1.01581554878e-06 1.55 1.01584730691e-06 1.44748737342 1.01587906504e-06 1.2 1.01591082317e-06 0.952512626585 1.0159425813e-06 0.85 1.01597433943e-06 0.952512626584 1.01600609756e-06 1.2 1.01603785569e-06 1.44748737342 1.01606961382e-06 1.55 1.01610137195e-06 1.44748737342 1.01613313008e-06 1.2 1.01616488821e-06 0.952512626584 1.01619664634e-06 0.85 1.01622840447e-06 0.952512626585 1.0162601626e-06 1.2 1.01629192073e-06 1.44748737342 1.01632367886e-06 1.55 1.01635543699e-06 1.44748737342 1.01638719512e-06 1.2 1.01641895325e-06 0.952512626585 1.01645071138e-06 0.85 1.01648246951e-06 0.952512626585 1.01651422764e-06 1.2 1.01654598577e-06 1.44748737342 1.0165777439e-06 1.55 1.01660950203e-06 1.44748737342 1.01664126016e-06 1.2 1.01667301829e-06 0.952512626585 1.01670477642e-06 0.85 1.01673653455e-06 0.952512626584 1.01676829268e-06 1.2 1.01680005081e-06 1.44748737342 1.01683180894e-06 1.55 1.01686356707e-06 1.44748737341 1.0168953252e-06 1.2 1.01692708333e-06 0.952512626585 1.01695884146e-06 0.85 1.01699059959e-06 0.952512626585 1.01702235772e-06 1.2 1.01705411585e-06 1.44748737342 1.01708587398e-06 1.55 1.01711763211e-06 1.44748737342 1.01714939024e-06 1.2 1.01718114837e-06 0.952512626585 1.0172129065e-06 0.85 1.01724466463e-06 0.952512626584 1.01727642276e-06 1.2 1.01730818089e-06 1.44748737341 1.01733993902e-06 1.55 1.01737169715e-06 1.44748737342 1.01740345528e-06 1.2 1.01743521341e-06 0.952512626584 1.01746697154e-06 0.85 1.01749872967e-06 0.952512626585 1.0175304878e-06 1.2 1.01756224593e-06 1.44748737342 1.01759400407e-06 1.55 1.0176257622e-06 1.44748737342 1.01765752033e-06 1.2 1.01768927846e-06 0.952512626584 1.01772103659e-06 0.85 1.01775279472e-06 0.952512626584 1.01778455285e-06 1.2 1.01781631098e-06 1.44748737342 1.01784806911e-06 1.55 1.01787982724e-06 1.44748737342 1.01791158537e-06 1.2 1.0179433435e-06 0.952512626585 1.01797510163e-06 0.85 1.01800685976e-06 0.952512626584 1.01803861789e-06 1.2 1.01807037602e-06 1.44748737342 1.01810213415e-06 1.55 1.01813389228e-06 1.44748737341 1.01816565041e-06 1.2 1.01819740854e-06 0.952512626584 1.01822916667e-06 0.85 1.0182609248e-06 0.952512626585 1.01829268293e-06 1.2 1.01832444106e-06 1.44748737342 1.01835619919e-06 1.55 1.01838795732e-06 1.44748737342 1.01841971545e-06 1.2 1.01845147358e-06 0.952512626585 1.01848323171e-06 0.85 1.01851498984e-06 0.952512626584 1.01854674797e-06 1.2 1.0185785061e-06 1.44748737341 1.01861026423e-06 1.55 1.01864202236e-06 1.44748737342 1.01867378049e-06 1.2 1.01870553862e-06 0.952512626585 1.01873729675e-06 0.85 1.01876905488e-06 0.952512626585 1.01880081301e-06 1.2 1.01883257114e-06 1.44748737342 1.01886432927e-06 1.55 1.0188960874e-06 1.44748737342 1.01892784553e-06 1.2 1.01895960366e-06 0.952512626584 1.01899136179e-06 0.85 1.01902311992e-06 0.952512626584 1.01905487805e-06 1.2 1.01908663618e-06 1.44748737342 1.01911839431e-06 1.55 1.01915015244e-06 1.44748737342 1.01918191057e-06 1.2 1.0192136687e-06 0.952512626585 1.01924542683e-06 0.85 1.01927718496e-06 0.952512626585 1.01930894309e-06 1.2 1.01934070122e-06 1.44748737341 1.01937245935e-06 1.55 1.01940421748e-06 1.44748737341 1.01943597561e-06 1.2 1.01946773374e-06 0.952512626584 1.01949949187e-06 0.85 1.01953125e-06 0.952512626585 1.01956300813e-06 1.2 1.01959476626e-06 1.44748737342 1.01962652439e-06 1.55 1.01965828252e-06 1.44748737342 1.01969004065e-06 1.2 1.01972179878e-06 0.952512626585 1.01975355691e-06 0.85 1.01978531504e-06 0.952512626585 1.01981707317e-06 1.2 1.0198488313e-06 1.44748737341 1.01988058943e-06 1.55 1.01991234756e-06 1.44748737342 1.01994410569e-06 1.2 1.01997586382e-06 0.952512626586 1.02000762195e-06 0.85 1.02003938008e-06 0.952512626585 1.02007113821e-06 1.2 1.02010289634e-06 1.44748737342 1.02013465447e-06 1.55 1.0201664126e-06 1.44748737342 1.02019817073e-06 1.2 1.02022992886e-06 0.952512626584 1.02026168699e-06 0.85 1.02029344512e-06 0.952512626584 1.02032520325e-06 1.2 1.02035696138e-06 1.44748737342 1.02038871951e-06 1.55 1.02042047764e-06 1.44748737342 1.02045223577e-06 1.2 1.0204839939e-06 0.952512626585 1.02051575203e-06 0.85 1.02054751016e-06 0.952512626584 1.02057926829e-06 1.2 1.02061102642e-06 1.44748737341 1.02064278455e-06 1.55 1.02067454268e-06 1.44748737342 1.02070630081e-06 1.2 1.02073805894e-06 0.952512626584 1.02076981707e-06 0.85 1.0208015752e-06 0.952512626585 1.02083333333e-06 1.2 1.02086509146e-06 1.44748737342 1.02089684959e-06 1.55 1.02092860772e-06 1.44748737341 1.02096036585e-06 1.2 1.02099212398e-06 0.952512626585 1.02102388211e-06 0.85 1.02105564024e-06 0.952512626585 1.02108739837e-06 1.2 1.0211191565e-06 1.44748737341 1.02115091463e-06 1.55 1.02118267276e-06 1.44748737342 1.02121443089e-06 1.2 1.02124618902e-06 0.952512626586 1.02127794715e-06 0.85 1.02130970528e-06 0.952512626585 1.02134146341e-06 1.2 1.02137322154e-06 1.44748737342 1.02140497967e-06 1.55 1.0214367378e-06 1.44748737342 1.02146849593e-06 1.2 1.02150025407e-06 0.952512626585 1.0215320122e-06 0.85 1.02156377033e-06 0.952512626585 1.02159552846e-06 1.2 1.02162728659e-06 1.44748737342 1.02165904472e-06 1.55 1.02169080285e-06 1.44748737342 1.02172256098e-06 1.2 1.02175431911e-06 0.952512626585 1.02178607724e-06 0.85 1.02181783537e-06 0.952512626584 1.0218495935e-06 1.2 1.02188135163e-06 1.44748737341 1.02191310976e-06 1.55 1.02194486789e-06 1.44748737342 1.02197662602e-06 1.2 1.02200838415e-06 0.952512626584 1.02204014228e-06 0.85 1.02207190041e-06 0.952512626585 1.02210365854e-06 1.2 1.02213541667e-06 1.44748737342 1.0221671748e-06 1.55 1.02219893293e-06 1.44748737341 1.02223069106e-06 1.2 1.02226244919e-06 0.952512626585 1.02229420732e-06 0.85 1.02232596545e-06 0.952512626585 1.02235772358e-06 1.2 1.02238948171e-06 1.44748737341 1.02242123984e-06 1.55 1.02245299797e-06 1.44748737342 1.0224847561e-06 1.2 1.02251651423e-06 0.952512626586 1.02254827236e-06 0.85 1.02258003049e-06 0.952512626585 1.02261178862e-06 1.2 1.02264354675e-06 1.44748737342 1.02267530488e-06 1.55 1.02270706301e-06 1.44748737341 1.02273882114e-06 1.2 1.02277057927e-06 0.952512626585 1.0228023374e-06 0.85 1.02283409553e-06 0.952512626585 1.02286585366e-06 1.2 1.02289761179e-06 1.44748737341 1.02292936992e-06 1.55 1.02296112805e-06 1.44748737342 1.02299288618e-06 1.2 1.02302464431e-06 0.952512626585 1.02305640244e-06 0.85 1.02308816057e-06 0.952512626584 1.0231199187e-06 1.2 1.02315167683e-06 1.44748737342 1.02318343496e-06 1.55 1.02321519309e-06 1.44748737342 1.02324695122e-06 1.2 1.02327870935e-06 0.952512626584 1.02331046748e-06 0.85 1.02334222561e-06 0.952512626585 1.02337398374e-06 1.2 1.02340574187e-06 1.44748737342 1.0234375e-06 1.55 1.02346925813e-06 1.44748737342 1.02350101626e-06 1.2 1.02353277439e-06 0.952512626585 1.02356453252e-06 0.85 1.02359629065e-06 0.952512626585 1.02362804878e-06 1.2 1.02365980691e-06 1.44748737341 1.02369156504e-06 1.55 1.02372332317e-06 1.44748737342 1.0237550813e-06 1.2 1.02378683943e-06 0.952512626585 1.02381859756e-06 0.85 1.02385035569e-06 0.952512626584 1.02388211382e-06 1.2 1.02391387195e-06 1.44748737342 1.02394563008e-06 1.55 1.02397738821e-06 1.44748737341 1.02400914634e-06 1.2 1.02404090447e-06 0.952512626585 1.0240726626e-06 0.85 1.02410442073e-06 0.952512626585 1.02413617886e-06 1.2 1.02416793699e-06 1.44748737341 1.02419969512e-06 1.55 1.02423145325e-06 1.44748737342 1.02426321138e-06 1.2 1.02429496951e-06 0.952512626585 1.02432672764e-06 0.85 1.02435848577e-06 0.952512626584 1.0243902439e-06 1.2 1.02442200203e-06 1.44748737342 1.02445376016e-06 1.55 1.02448551829e-06 1.44748737342 1.02451727642e-06 1.2 1.02454903455e-06 0.952512626584 1.02458079268e-06 0.85 1.02461255081e-06 0.952512626585 1.02464430894e-06 1.2 1.02467606707e-06 1.44748737342 1.0247078252e-06 1.55 1.02473958333e-06 1.44748737342 1.02477134146e-06 1.2 1.02480309959e-06 0.952512626585 1.02483485772e-06 0.85 1.02486661585e-06 0.952512626585 1.02489837398e-06 1.2 1.02493013211e-06 1.44748737342 1.02496189024e-06 1.55 1.02499364837e-06 1.44748737342 1.0250254065e-06 1.2 1.02505716463e-06 0.952512626585 1.02508892276e-06 0.85 1.02512068089e-06 0.952512626584 1.02515243902e-06 1.2 1.02518419715e-06 1.44748737342 1.02521595528e-06 1.55 1.02524771341e-06 1.44748737341 1.02527947154e-06 1.2 1.02531122967e-06 0.952512626585 1.0253429878e-06 0.85 1.02537474593e-06 0.952512626585 1.02540650407e-06 1.2 1.0254382622e-06 1.44748737342 1.02547002033e-06 1.55 1.02550177846e-06 1.44748737342 1.02553353659e-06 1.2 1.02556529472e-06 0.952512626585 1.02559705285e-06 0.85 1.02562881098e-06 0.952512626584 1.02566056911e-06 1.2 1.02569232724e-06 1.44748737341 1.02572408537e-06 1.55 1.0257558435e-06 1.44748737342 1.02578760163e-06 1.2 1.02581935976e-06 0.952512626584 1.02585111789e-06 0.85 1.02588287602e-06 0.952512626585 1.02591463415e-06 1.2 1.02594639228e-06 1.44748737342 1.02597815041e-06 1.55 1.02600990854e-06 1.44748737342 1.02604166667e-06 1.2 1.0260734248e-06 0.952512626584 1.02610518293e-06 0.85 1.02613694106e-06 0.952512626584 1.02616869919e-06 1.2 1.02620045732e-06 1.44748737342 1.02623221545e-06 1.55 1.02626397358e-06 1.44748737342 1.02629573171e-06 1.2 1.02632748984e-06 0.952512626585 1.02635924797e-06 0.85 1.0263910061e-06 0.952512626584 1.02642276423e-06 1.2 1.02645452236e-06 1.44748737342 1.02648628049e-06 1.55 1.02651803862e-06 1.44748737341 1.02654979675e-06 1.2 1.02658155488e-06 0.952512626584 1.02661331301e-06 0.85 1.02664507114e-06 0.952512626585 1.02667682927e-06 1.2 1.0267085874e-06 1.44748737342 1.02674034553e-06 1.55 1.02677210366e-06 1.44748737342 1.02680386179e-06 1.2 1.02683561992e-06 0.952512626585 1.02686737805e-06 0.85 1.02689913618e-06 0.952512626584 1.02693089431e-06 1.2 1.02696265244e-06 1.44748737341 1.02699441057e-06 1.55 1.0270261687e-06 1.44748737342 1.02705792683e-06 1.2 1.02708968496e-06 0.952512626585 1.02712144309e-06 0.85 1.02715320122e-06 0.952512626585 1.02718495935e-06 1.2 1.02721671748e-06 1.44748737342 1.02724847561e-06 1.55 1.02728023374e-06 1.44748737342 1.02731199187e-06 1.2 1.02734375e-06 0.952512626584 1.02737550813e-06 0.85 1.02740726626e-06 0.952512626584 1.02743902439e-06 1.2 1.02747078252e-06 1.44748737342 1.02750254065e-06 1.55 1.02753429878e-06 1.44748737342 1.02756605691e-06 1.2 1.02759781504e-06 0.952512626585 1.02762957317e-06 0.85 1.0276613313e-06 0.952512626585 1.02769308943e-06 1.2 1.02772484756e-06 1.44748737341 1.02775660569e-06 1.55 1.02778836382e-06 1.44748737341 1.02782012195e-06 1.2 1.02785188008e-06 0.952512626584 1.02788363821e-06 0.85 1.02791539634e-06 0.952512626585 1.02794715447e-06 1.2 1.0279789126e-06 1.44748737342 1.02801067073e-06 1.55 1.02804242886e-06 1.44748737342 1.02807418699e-06 1.2 1.02810594512e-06 0.952512626585 1.02813770325e-06 0.85 1.02816946138e-06 0.952512626585 1.02820121951e-06 1.2 1.02823297764e-06 1.44748737341 1.02826473577e-06 1.55 1.0282964939e-06 1.44748737342 1.02832825203e-06 1.2 1.02836001016e-06 0.952512626586 1.02839176829e-06 0.85 1.02842352642e-06 0.952512626585 1.02845528455e-06 1.2 1.02848704268e-06 1.44748737342 1.02851880081e-06 1.55 1.02855055894e-06 1.44748737342 1.02858231707e-06 1.2 1.0286140752e-06 0.952512626584 1.02864583333e-06 0.85 1.02867759146e-06 0.952512626584 1.02870934959e-06 1.2 1.02874110772e-06 1.44748737342 1.02877286585e-06 1.55 1.02880462398e-06 1.44748737342 1.02883638211e-06 1.2 1.02886814024e-06 0.952512626585 1.02889989837e-06 0.85 1.0289316565e-06 0.952512626584 1.02896341463e-06 1.2 1.02899517276e-06 1.44748737341 1.02902693089e-06 1.55 1.02905868902e-06 1.44748737342 1.02909044715e-06 1.2 1.02912220528e-06 0.952512626584 1.02915396341e-06 0.85 1.02918572154e-06 0.952512626585 1.02921747967e-06 1.2 1.0292492378e-06 1.44748737342 1.02928099593e-06 1.55 1.02931275407e-06 1.44748737341 1.0293445122e-06 1.2 1.02937627033e-06 0.952512626585 1.02940802846e-06 0.85 1.02943978659e-06 0.952512626585 1.02947154472e-06 1.2 1.02950330285e-06 1.44748737341 1.02953506098e-06 1.55 1.02956681911e-06 1.44748737342 1.02959857724e-06 1.2 1.02963033537e-06 0.952512626586 1.0296620935e-06 0.85 1.02969385163e-06 0.952512626585 1.02972560976e-06 1.2 1.02975736789e-06 1.44748737342 1.02978912602e-06 1.55 1.02982088415e-06 1.44748737342 1.02985264228e-06 1.2 1.02988440041e-06 0.952512626585 1.02991615854e-06 0.85 1.02994791667e-06 0.952512626585 1.0299796748e-06 1.2 1.03001143293e-06 1.44748737342 1.03004319106e-06 1.55 1.03007494919e-06 1.44748737342 1.03010670732e-06 1.2 1.03013846545e-06 0.952512626585 1.03017022358e-06 0.85 1.03020198171e-06 0.952512626584 1.03023373984e-06 1.2 1.03026549797e-06 1.44748737341 1.0302972561e-06 1.55 1.03032901423e-06 1.44748737342 1.03036077236e-06 1.2 1.03039253049e-06 0.952512626584 1.03042428862e-06 0.85 1.03045604675e-06 0.952512626585 1.03048780488e-06 1.2 1.03051956301e-06 1.44748737342 1.03055132114e-06 1.55 1.03058307927e-06 1.44748737341 1.0306148374e-06 1.2 1.03064659553e-06 0.952512626585 1.03067835366e-06 0.85 1.03071011179e-06 0.952512626585 1.03074186992e-06 1.2 1.03077362805e-06 1.44748737341 1.03080538618e-06 1.55 1.03083714431e-06 1.44748737342 1.03086890244e-06 1.2 1.03090066057e-06 0.952512626586 1.0309324187e-06 0.85 1.03096417683e-06 0.952512626584 1.03099593496e-06 1.2 1.03102769309e-06 1.44748737342 1.03105945122e-06 1.55 1.03109120935e-06 1.44748737341 1.03112296748e-06 1.2 1.03115472561e-06 0.952512626585 1.03118648374e-06 0.85 1.03121824187e-06 0.952512626585 1.03125e-06 1.2 1.03128175813e-06 1.44748737341 1.03131351626e-06 1.55 1.03134527439e-06 1.44748737342 1.03137703252e-06 1.2 1.03140879065e-06 0.952512626585 1.03144054878e-06 0.85 1.03147230691e-06 0.952512626584 1.03150406504e-06 1.2 1.03153582317e-06 1.44748737342 1.0315675813e-06 1.55 1.03159933943e-06 1.44748737342 1.03163109756e-06 1.2 1.03166285569e-06 0.952512626584 1.03169461382e-06 0.85 1.03172637195e-06 0.952512626585 1.03175813008e-06 1.2 1.03178988821e-06 1.44748737342 1.03182164634e-06 1.55 1.03185340447e-06 1.44748737342 1.0318851626e-06 1.2 1.03191692073e-06 0.952512626585 1.03194867886e-06 0.85 1.03198043699e-06 0.952512626585 1.03201219512e-06 1.2 1.03204395325e-06 1.44748737342 1.03207571138e-06 1.55 1.03210746951e-06 1.44748737342 1.03213922764e-06 1.2 1.03217098577e-06 0.952512626585 1.0322027439e-06 0.85 1.03223450203e-06 0.952512626584 1.03226626016e-06 1.2 1.03229801829e-06 1.44748737342 1.03232977642e-06 1.55 1.03236153455e-06 1.44748737341 1.03239329268e-06 1.2 1.03242505081e-06 0.952512626585 1.03245680894e-06 0.85 1.03248856707e-06 0.952512626585 1.0325203252e-06 1.2 1.03255208333e-06 1.44748737341 1.03258384146e-06 1.55 1.03261559959e-06 1.44748737342 1.03264735772e-06 1.2 1.03267911585e-06 0.952512626585 1.03271087398e-06 0.85 1.03274263211e-06 0.952512626584 1.03277439024e-06 1.2 1.03280614837e-06 1.44748737342 1.0328379065e-06 1.55 1.03286966463e-06 1.44748737342 1.03290142276e-06 1.2 1.03293318089e-06 0.952512626584 1.03296493902e-06 0.85 1.03299669715e-06 0.952512626585 1.03302845528e-06 1.2 1.03306021341e-06 1.44748737342 1.03309197154e-06 1.55 1.03312372967e-06 1.44748737342 1.0331554878e-06 1.2 1.03318724593e-06 0.952512626584 1.03321900407e-06 0.85 1.0332507622e-06 0.952512626585 1.03328252033e-06 1.2 1.03331427846e-06 1.44748737342 1.03334603659e-06 1.55 1.03337779472e-06 1.44748737342 1.03340955285e-06 1.2 1.03344131098e-06 0.952512626585 1.03347306911e-06 0.85 1.03350482724e-06 0.952512626584 1.03353658537e-06 1.2 1.0335683435e-06 1.44748737342 1.03360010163e-06 1.55 1.03363185976e-06 1.44748737341 1.03366361789e-06 1.2 1.03369537602e-06 0.952512626585 1.03372713415e-06 0.85 1.03375889228e-06 0.952512626585 1.03379065041e-06 1.2 1.03382240854e-06 1.44748737342 1.03385416667e-06 1.55 1.0338859248e-06 1.44748737342 1.03391768293e-06 1.2 1.03394944106e-06 0.952512626585 1.03398119919e-06 0.85 1.03401295732e-06 0.952512626584 1.03404471545e-06 1.2 1.03407647358e-06 1.44748737341 1.03410823171e-06 1.55 1.03413998984e-06 1.44748737342 1.03417174797e-06 1.2 1.0342035061e-06 0.952512626584 1.03423526423e-06 0.85 1.03426702236e-06 0.952512626585 1.03429878049e-06 1.2 1.03433053862e-06 1.44748737342 1.03436229675e-06 1.55 1.03439405488e-06 1.44748737342 1.03442581301e-06 1.2 1.03445757114e-06 0.952512626584 1.03448932927e-06 0.85 1.0345210874e-06 0.952512626584 1.03455284553e-06 1.2 1.03458460366e-06 1.44748737342 1.03461636179e-06 1.55 1.03464811992e-06 1.44748737342 1.03467987805e-06 1.2 1.03471163618e-06 0.952512626585 1.03474339431e-06 0.85 1.03477515244e-06 0.952512626584 1.03480691057e-06 1.2 1.0348386687e-06 1.44748737341 1.03487042683e-06 1.55 1.03490218496e-06 1.44748737341 1.03493394309e-06 1.2 1.03496570122e-06 0.952512626584 1.03499745935e-06 0.85 1.03502921748e-06 0.952512626585 1.03506097561e-06 1.2 1.03509273374e-06 1.44748737342 1.03512449187e-06 1.55 1.03515625e-06 1.44748737342 1.03518800813e-06 1.2 1.03521976626e-06 0.952512626585 1.03525152439e-06 0.85 1.03528328252e-06 0.952512626584 1.03531504065e-06 1.2 1.03534679878e-06 1.44748737341 1.03537855691e-06 1.55 1.03541031504e-06 1.44748737342 1.03544207317e-06 1.2 1.0354738313e-06 0.952512626585 1.03550558943e-06 0.85 1.03553734756e-06 0.952512626585 1.03556910569e-06 1.2 1.03560086382e-06 1.44748737342 1.03563262195e-06 1.55 1.03566438008e-06 1.44748737342 1.03569613821e-06 1.2 1.03572789634e-06 0.952512626584 1.03575965447e-06 0.85 1.0357914126e-06 0.952512626584 1.03582317073e-06 1.2 1.03585492886e-06 1.44748737342 1.03588668699e-06 1.55 1.03591844512e-06 1.44748737342 1.03595020325e-06 1.2 1.03598196138e-06 0.952512626585 1.03601371951e-06 0.85 1.03604547764e-06 0.952512626585 1.03607723577e-06 1.2 1.0361089939e-06 1.44748737341 1.03614075203e-06 1.55 1.03617251016e-06 1.44748737341 1.03620426829e-06 1.2 1.03623602642e-06 0.952512626584 1.03626778455e-06 0.85 1.03629954268e-06 0.952512626585 1.03633130081e-06 1.2 1.03636305894e-06 1.44748737342 1.03639481707e-06 1.55 1.0364265752e-06 1.44748737342 1.03645833333e-06 1.2 1.03649009146e-06 0.952512626585 1.03652184959e-06 0.85 1.03655360772e-06 0.952512626585 1.03658536585e-06 1.2 1.03661712398e-06 1.44748737341 1.03664888211e-06 1.55 1.03668064024e-06 1.44748737342 1.03671239837e-06 1.2 1.0367441565e-06 0.952512626586 1.03677591463e-06 0.85 1.03680767276e-06 0.952512626585 1.03683943089e-06 1.2 1.03687118902e-06 1.44748737342 1.03690294715e-06 1.55 1.03693470528e-06 1.44748737342 1.03696646341e-06 1.2 1.03699822154e-06 0.952512626584 1.03702997967e-06 0.85 1.0370617378e-06 0.952512626584 1.03709349593e-06 1.2 1.03712525407e-06 1.44748737342 1.0371570122e-06 1.55 1.03718877033e-06 1.44748737342 1.03722052846e-06 1.2 1.03725228659e-06 0.952512626585 1.03728404472e-06 0.85 1.03731580285e-06 0.952512626584 1.03734756098e-06 1.2 1.03737931911e-06 1.44748737341 1.03741107724e-06 1.55 1.03744283537e-06 1.44748737342 1.0374745935e-06 1.2 1.03750635163e-06 0.952512626584 1.03753810976e-06 0.85 1.03756986789e-06 0.952512626585 1.03760162602e-06 1.2 1.03763338415e-06 1.44748737342 1.03766514228e-06 1.55 1.03769690041e-06 1.44748737341 1.03772865854e-06 1.2 1.03776041667e-06 0.952512626585 1.0377921748e-06 0.85 1.03782393293e-06 0.952512626585 1.03785569106e-06 1.2 1.03788744919e-06 1.44748737341 1.03791920732e-06 1.55 1.03795096545e-06 1.44748737342 1.03798272358e-06 1.2 1.03801448171e-06 0.952512626586 1.03804623984e-06 0.85 1.03807799797e-06 0.952512626585 1.0381097561e-06 1.2 1.03814151423e-06 1.44748737342 1.03817327236e-06 1.55 1.03820503049e-06 1.44748737341 1.03823678862e-06 1.2 1.03826854675e-06 0.952512626585 1.03830030488e-06 0.85 1.03833206301e-06 0.952512626585 1.03836382114e-06 1.2 1.03839557927e-06 1.44748737342 1.0384273374e-06 1.55 1.03845909553e-06 1.44748737342 1.03849085366e-06 1.2 1.03852261179e-06 0.952512626585 1.03855436992e-06 0.85 1.03858612805e-06 0.952512626584 1.03861788618e-06 1.2 1.03864964431e-06 1.44748737341 1.03868140244e-06 1.55 1.03871316057e-06 1.44748737342 1.0387449187e-06 1.2 1.03877667683e-06 0.952512626584 1.03880843496e-06 0.85 1.03884019309e-06 0.952512626585 1.03887195122e-06 1.2 1.03890370935e-06 1.44748737342 1.03893546748e-06 1.55 1.03896722561e-06 1.44748737341 1.03899898374e-06 1.2 1.03903074187e-06 0.952512626585 1.0390625e-06 0.85 1.03909425813e-06 0.952512626585 1.03912601626e-06 1.2 1.03915777439e-06 1.44748737341 1.03918953252e-06 1.55 1.03922129065e-06 1.44748737342 1.03925304878e-06 1.2 1.03928480691e-06 0.952512626585 1.03931656504e-06 0.85 1.03934832317e-06 0.952512626584 1.0393800813e-06 1.2 1.03941183943e-06 1.44748737342 1.03944359756e-06 1.55 1.03947535569e-06 1.44748737341 1.03950711382e-06 1.2 1.03953887195e-06 0.952512626585 1.03957063008e-06 0.85 1.03960238821e-06 0.952512626585 1.03963414634e-06 1.2 1.03966590447e-06 1.44748737341 1.0396976626e-06 1.55 1.03972942073e-06 1.44748737342 1.03976117886e-06 1.2 1.03979293699e-06 0.952512626585 1.03982469512e-06 0.85 1.03985645325e-06 0.952512626584 1.03988821138e-06 1.2 1.03991996951e-06 1.44748737342 1.03995172764e-06 1.55 1.03998348577e-06 1.44748737342 1.0400152439e-06 1.2 1.04004700203e-06 0.952512626584 1.04007876016e-06 0.85 1.04011051829e-06 0.952512626585 1.04014227642e-06 1.2 1.04017403455e-06 1.44748737342 1.04020579268e-06 1.55 1.04023755081e-06 1.44748737342 1.04026930894e-06 1.2 1.04030106707e-06 0.952512626585 1.0403328252e-06 0.85 1.04036458333e-06 0.952512626585 1.04039634146e-06 1.2 1.04042809959e-06 1.44748737342 1.04045985772e-06 1.55 1.04049161585e-06 1.44748737342 1.04052337398e-06 1.2 1.04055513211e-06 0.952512626585 1.04058689024e-06 0.85 1.04061864837e-06 0.952512626584 1.0406504065e-06 1.2 1.04068216463e-06 1.44748737342 1.04071392276e-06 1.55 1.04074568089e-06 1.44748737341 1.04077743902e-06 1.2 1.04080919715e-06 0.952512626585 1.04084095528e-06 0.85 1.04087271341e-06 0.952512626585 1.04090447154e-06 1.2 1.04093622967e-06 1.44748737341 1.0409679878e-06 1.55 1.04099974593e-06 1.44748737342 1.04103150407e-06 1.2 1.0410632622e-06 0.952512626585 1.04109502033e-06 0.85 1.04112677846e-06 0.952512626584 1.04115853659e-06 1.2 1.04119029472e-06 1.44748737342 1.04122205285e-06 1.55 1.04125381098e-06 1.44748737342 1.04128556911e-06 1.2 1.04131732724e-06 0.952512626584 1.04134908537e-06 0.85 1.0413808435e-06 0.952512626585 1.04141260163e-06 1.2 1.04144435976e-06 1.44748737342 1.04147611789e-06 1.55 1.04150787602e-06 1.44748737342 1.04153963415e-06 1.2 1.04157139228e-06 0.952512626584 1.04160315041e-06 0.85 1.04163490854e-06 0.952512626585 1.04166666667e-06 1.2 1.0416984248e-06 1.44748737342 1.04173018293e-06 1.55 1.04176194106e-06 1.44748737342 1.04179369919e-06 1.2 1.04182545732e-06 0.952512626585 1.04185721545e-06 0.85 1.04188897358e-06 0.952512626584 1.04192073171e-06 1.2 1.04195248984e-06 1.44748737342 1.04198424797e-06 1.55 1.0420160061e-06 1.44748737341 1.04204776423e-06 1.2 1.04207952236e-06 0.952512626585 1.04211128049e-06 0.85 1.04214303862e-06 0.952512626585 1.04217479675e-06 1.2 1.04220655488e-06 1.44748737342 1.04223831301e-06 1.55 1.04227007114e-06 1.44748737342 1.04230182927e-06 1.2 1.0423335874e-06 0.952512626585 1.04236534553e-06 0.85 1.04239710366e-06 0.952512626584 1.04242886179e-06 1.2 1.04246061992e-06 1.44748737341 1.04249237805e-06 1.55 1.04252413618e-06 1.44748737342 1.04255589431e-06 1.2 1.04258765244e-06 0.952512626584 1.04261941057e-06 0.85 1.0426511687e-06 0.952512626585 1.04268292683e-06 1.2 1.04271468496e-06 1.44748737342 1.04274644309e-06 1.55 1.04277820122e-06 1.44748737342 1.04280995935e-06 1.2 1.04284171748e-06 0.952512626584 1.04287347561e-06 0.85 1.04290523374e-06 0.952512626584 1.04293699187e-06 1.2 1.04296875e-06 1.44748737342 1.04300050813e-06 1.55 1.04303226626e-06 1.44748737342 1.04306402439e-06 1.2 1.04309578252e-06 0.952512626585 1.04312754065e-06 0.85 1.04315929878e-06 0.952512626585 1.04319105691e-06 1.2 1.04322281504e-06 1.44748737341 1.04325457317e-06 1.55 1.0432863313e-06 1.44748737341 1.04331808943e-06 1.2 1.04334984756e-06 0.952512626584 1.04338160569e-06 0.85 1.04341336382e-06 0.952512626585 1.04344512195e-06 1.2 1.04347688008e-06 1.44748737342 1.04350863821e-06 1.55 1.04354039634e-06 1.44748737342 1.04357215447e-06 1.2 1.0436039126e-06 0.952512626585 1.04363567073e-06 0.85 1.04366742886e-06 0.952512626584 1.04369918699e-06 1.2 1.04373094512e-06 1.44748737341 1.04376270325e-06 1.55 1.04379446138e-06 1.44748737342 1.04382621951e-06 1.2 1.04385797764e-06 0.952512626585 1.04388973577e-06 0.85 1.0439214939e-06 0.952512626585 1.04395325203e-06 1.2 1.04398501016e-06 1.44748737342 1.04401676829e-06 1.55 1.04404852642e-06 1.44748737342 1.04408028455e-06 1.2 1.04411204268e-06 0.952512626584 1.04414380081e-06 0.85 1.04417555894e-06 0.952512626584 1.04420731707e-06 1.2 1.0442390752e-06 1.44748737342 1.04427083333e-06 1.55 1.04430259146e-06 1.44748737342 1.04433434959e-06 1.2 1.04436610772e-06 0.952512626585 1.04439786585e-06 0.85 1.04442962398e-06 0.952512626585 1.04446138211e-06 1.2 1.04449314024e-06 1.44748737341 1.04452489837e-06 1.55 1.0445566565e-06 1.44748737341 1.04458841463e-06 1.2 1.04462017276e-06 0.952512626584 1.04465193089e-06 0.85 1.04468368902e-06 0.952512626585 1.04471544715e-06 1.2 1.04474720528e-06 1.44748737342 1.04477896341e-06 1.55 1.04481072154e-06 1.44748737342 1.04484247967e-06 1.2 1.0448742378e-06 0.952512626585 1.04490599593e-06 0.85 1.04493775407e-06 0.952512626585 1.0449695122e-06 1.2 1.04500127033e-06 1.44748737341 1.04503302846e-06 1.55 1.04506478659e-06 1.44748737342 1.04509654472e-06 1.2 1.04512830285e-06 0.952512626586 1.04516006098e-06 0.85 1.04519181911e-06 0.952512626585 1.04522357724e-06 1.2 1.04525533537e-06 1.44748737342 1.0452870935e-06 1.55 1.04531885163e-06 1.44748737342 1.04535060976e-06 1.2 1.04538236789e-06 0.952512626585 1.04541412602e-06 0.85 1.04544588415e-06 0.952512626585 1.04547764228e-06 1.2 1.04550940041e-06 1.44748737342 1.04554115854e-06 1.55 1.04557291667e-06 1.44748737342 1.0456046748e-06 1.2 1.04563643293e-06 0.952512626585 1.04566819106e-06 0.85 1.04569994919e-06 0.952512626584 1.04573170732e-06 1.2 1.04576346545e-06 1.44748737341 1.04579522358e-06 1.55 1.04582698171e-06 1.44748737342 1.04585873984e-06 1.2 1.04589049797e-06 0.952512626584 1.0459222561e-06 0.85 1.04595401423e-06 0.952512626585 1.04598577236e-06 1.2 1.04601753049e-06 1.44748737342 1.04604928862e-06 1.55 1.04608104675e-06 1.44748737341 1.04611280488e-06 1.2 1.04614456301e-06 0.952512626585 1.04617632114e-06 0.85 1.04620807927e-06 0.952512626585 1.0462398374e-06 1.2 1.04627159553e-06 1.44748737341 1.04630335366e-06 1.55 1.04633511179e-06 1.44748737342 1.04636686992e-06 1.2 1.04639862805e-06 0.952512626586 1.04643038618e-06 0.85 1.04646214431e-06 0.952512626585 1.04649390244e-06 1.2 1.04652566057e-06 1.44748737342 1.0465574187e-06 1.55 1.04658917683e-06 1.44748737341 1.04662093496e-06 1.2 1.04665269309e-06 0.952512626585 1.04668445122e-06 0.85 1.04671620935e-06 0.952512626585 1.04674796748e-06 1.2 1.04677972561e-06 1.44748737342 1.04681148374e-06 1.55 1.04684324187e-06 1.44748737342 1.046875e-06 1.2 1.04690675813e-06 0.952512626585 1.04693851626e-06 0.85 1.04697027439e-06 0.952512626584 1.04700203252e-06 1.2 1.04703379065e-06 1.44748737341 1.04706554878e-06 1.55 1.04709730691e-06 1.44748737342 1.04712906504e-06 1.2 1.04716082317e-06 0.952512626584 1.0471925813e-06 0.85 1.04722433943e-06 0.952512626585 1.04725609756e-06 1.2 1.04728785569e-06 1.44748737342 1.04731961382e-06 1.55 1.04735137195e-06 1.44748737341 1.04738313008e-06 1.2 1.04741488821e-06 0.952512626585 1.04744664634e-06 0.85 1.04747840447e-06 0.952512626585 1.0475101626e-06 1.2 1.04754192073e-06 1.44748737341 1.04757367886e-06 1.55 1.04760543699e-06 1.44748737342 1.04763719512e-06 1.2 1.04766895325e-06 0.952512626585 1.04770071138e-06 0.85 1.04773246951e-06 0.952512626584 1.04776422764e-06 1.2 1.04779598577e-06 1.44748737342 1.0478277439e-06 1.55 1.04785950203e-06 1.44748737341 1.04789126016e-06 1.2 1.04792301829e-06 0.952512626585 1.04795477642e-06 0.85 1.04798653455e-06 0.952512626585 1.04801829268e-06 1.2 1.04805005081e-06 1.44748737341 1.04808180894e-06 1.55 1.04811356707e-06 1.44748737342 1.0481453252e-06 1.2 1.04817708333e-06 0.952512626585 1.04820884146e-06 0.85 1.04824059959e-06 0.952512626584 1.04827235772e-06 1.2 1.04830411585e-06 1.44748737342 1.04833587398e-06 1.55 1.04836763211e-06 1.44748737342 1.04839939024e-06 1.2 1.04843114837e-06 0.952512626584 1.0484629065e-06 0.85 1.04849466463e-06 0.952512626585 1.04852642276e-06 1.2 1.04855818089e-06 1.44748737342 1.04858993902e-06 1.55 1.04862169715e-06 1.44748737342 1.04865345528e-06 1.2 1.04868521341e-06 0.952512626585 1.04871697154e-06 0.85 1.04874872967e-06 0.952512626585 1.0487804878e-06 1.2 1.04881224593e-06 1.44748737342 1.04884400407e-06 1.55 1.0488757622e-06 1.44748737342 1.04890752033e-06 1.2 1.04893927846e-06 0.952512626585 1.04897103659e-06 0.85 1.04900279472e-06 0.952512626584 1.04903455285e-06 1.2 1.04906631098e-06 1.44748737342 1.04909806911e-06 1.55 1.04912982724e-06 1.44748737341 1.04916158537e-06 1.2 1.0491933435e-06 0.952512626585 1.04922510163e-06 0.85 1.04925685976e-06 0.952512626585 1.04928861789e-06 1.2 1.04932037602e-06 1.44748737342 1.04935213415e-06 1.55 1.04938389228e-06 1.44748737342 1.04941565041e-06 1.2 1.04944740854e-06 0.952512626585 1.04947916667e-06 0.85 1.0495109248e-06 0.952512626584 1.04954268293e-06 1.2 1.04957444106e-06 1.44748737342 1.04960619919e-06 1.55 1.04963795732e-06 1.44748737342 1.04966971545e-06 1.2 1.04970147358e-06 0.952512626584 1.04973323171e-06 0.85 1.04976498984e-06 0.952512626585 1.04979674797e-06 1.2 1.0498285061e-06 1.44748737342 1.04986026423e-06 1.55 1.04989202236e-06 1.44748737342 1.04992378049e-06 1.2 1.04995553862e-06 0.952512626584 1.04998729675e-06 0.85 1.05001905488e-06 0.952512626585 1.05005081301e-06 1.2 1.05008257114e-06 1.44748737342 1.05011432927e-06 1.55 1.0501460874e-06 1.44748737342 1.05017784553e-06 1.2 1.05020960366e-06 0.952512626585 1.05024136179e-06 0.85 1.05027311992e-06 0.952512626584 1.05030487805e-06 1.2 1.05033663618e-06 1.44748737342 1.05036839431e-06 1.55 1.05040015244e-06 1.44748737341 1.05043191057e-06 1.2 1.0504636687e-06 0.952512626584 1.05049542683e-06 0.85 1.05052718496e-06 0.952512626585 1.05055894309e-06 1.2 1.05059070122e-06 1.44748737342 1.05062245935e-06 1.55 1.05065421748e-06 1.44748737342 1.05068597561e-06 1.2 1.05071773374e-06 0.952512626585 1.05074949187e-06 0.85 1.05078125e-06 0.952512626584 1.05081300813e-06 1.2 1.05084476626e-06 1.44748737341 1.05087652439e-06 1.55 1.05090828252e-06 1.44748737342 1.05094004065e-06 1.2 1.05097179878e-06 0.952512626585 1.05100355691e-06 0.85 1.05103531504e-06 0.952512626585 1.05106707317e-06 1.2 1.0510988313e-06 1.44748737342 1.05113058943e-06 1.55 1.05116234756e-06 1.44748737342 1.05119410569e-06 1.2 1.05122586382e-06 0.952512626584 1.05125762195e-06 0.85 1.05128938008e-06 0.952512626584 1.05132113821e-06 1.2 1.05135289634e-06 1.44748737342 1.05138465447e-06 1.55 1.0514164126e-06 1.44748737342 1.05144817073e-06 1.2 1.05147992886e-06 0.952512626585 1.05151168699e-06 0.85 1.05154344512e-06 0.952512626585 1.05157520325e-06 1.2 1.05160696138e-06 1.44748737341 1.05163871951e-06 1.55 1.05167047764e-06 1.44748737341 1.05170223577e-06 1.2 1.0517339939e-06 0.952512626584 1.05176575203e-06 0.85 1.05179751016e-06 0.952512626585 1.05182926829e-06 1.2 1.05186102642e-06 1.44748737342 1.05189278455e-06 1.55 1.05192454268e-06 1.44748737342 1.05195630081e-06 1.2 1.05198805894e-06 0.952512626585 1.05201981707e-06 0.85 1.0520515752e-06 0.952512626584 1.05208333333e-06 1.2 1.05211509146e-06 1.44748737341 1.05214684959e-06 1.55 1.05217860772e-06 1.44748737342 1.05221036585e-06 1.2 1.05224212398e-06 0.952512626585 1.05227388211e-06 0.85 1.05230564024e-06 0.952512626585 1.05233739837e-06 1.2 1.0523691565e-06 1.44748737342 1.05240091463e-06 1.55 1.05243267276e-06 1.44748737342 1.05246443089e-06 1.2 1.05249618902e-06 0.952512626584 1.05252794715e-06 0.85 1.05255970528e-06 0.952512626584 1.05259146341e-06 1.2 1.05262322154e-06 1.44748737342 1.05265497967e-06 1.55 1.0526867378e-06 1.44748737342 1.05271849593e-06 1.2 1.05275025407e-06 0.952512626585 1.0527820122e-06 0.85 1.05281377033e-06 0.952512626585 1.05284552846e-06 1.2 1.05287728659e-06 1.44748737341 1.05290904472e-06 1.55 1.05294080285e-06 1.44748737341 1.05297256098e-06 1.2 1.05300431911e-06 0.952512626584 1.05303607724e-06 0.85 1.05306783537e-06 0.952512626585 1.0530995935e-06 1.2 1.05313135163e-06 1.44748737342 1.05316310976e-06 1.55 1.05319486789e-06 1.44748737342 1.05322662602e-06 1.2 1.05325838415e-06 0.952512626585 1.05329014228e-06 0.85 1.05332190041e-06 0.952512626585 1.05335365854e-06 1.2 1.05338541667e-06 1.44748737341 1.0534171748e-06 1.55 1.05344893293e-06 1.44748737342 1.05348069106e-06 1.2 1.05351244919e-06 0.952512626586 1.05354420732e-06 0.85 1.05357596545e-06 0.952512626585 1.05360772358e-06 1.2 1.05363948171e-06 1.44748737342 1.05367123984e-06 1.55 1.05370299797e-06 1.44748737342 1.0537347561e-06 1.2 1.05376651423e-06 0.952512626585 1.05379827236e-06 0.85 1.05383003049e-06 0.952512626585 1.05386178862e-06 1.2 1.05389354675e-06 1.44748737342 1.05392530488e-06 1.55 1.05395706301e-06 1.44748737342 1.05398882114e-06 1.2 1.05402057927e-06 0.952512626585 1.0540523374e-06 0.85 1.05408409553e-06 0.952512626584 1.05411585366e-06 1.2 1.05414761179e-06 1.44748737341 1.05417936992e-06 1.55 1.05421112805e-06 1.44748737342 1.05424288618e-06 1.2 1.05427464431e-06 0.952512626584 1.05430640244e-06 0.85 1.05433816057e-06 0.952512626585 1.0543699187e-06 1.2 1.05440167683e-06 1.44748737342 1.05443343496e-06 1.55 1.05446519309e-06 1.44748737341 1.05449695122e-06 1.2 1.05452870935e-06 0.952512626585 1.05456046748e-06 0.85 1.05459222561e-06 0.952512626585 1.05462398374e-06 1.2 1.05465574187e-06 1.44748737341 1.0546875e-06 1.55 1.05471925813e-06 1.44748737342 1.05475101626e-06 1.2 1.05478277439e-06 0.952512626586 1.05481453252e-06 0.85 1.05484629065e-06 0.952512626584 1.05487804878e-06 1.2 1.05490980691e-06 1.44748737342 1.05494156504e-06 1.55 1.05497332317e-06 1.44748737341 1.0550050813e-06 1.2 1.05503683943e-06 0.952512626585 1.05506859756e-06 0.85 1.05510035569e-06 0.952512626585 1.05513211382e-06 1.2 1.05516387195e-06 1.44748737342 1.05519563008e-06 1.55 1.05522738821e-06 1.44748737342 1.05525914634e-06 1.2 1.05529090447e-06 0.952512626585 1.0553226626e-06 0.85 1.05535442073e-06 0.952512626584 1.05538617886e-06 1.2 1.05541793699e-06 1.44748737342 1.05544969512e-06 1.55 1.05548145325e-06 1.44748737342 1.05551321138e-06 1.2 1.05554496951e-06 0.952512626584 1.05557672764e-06 0.85 1.05560848577e-06 0.952512626585 1.0556402439e-06 1.2 1.05567200203e-06 1.44748737342 1.05570376016e-06 1.55 1.05573551829e-06 1.44748737341 1.05576727642e-06 1.2 1.05579903455e-06 0.952512626585 1.05583079268e-06 0.85 1.05586255081e-06 0.952512626585 1.05589430894e-06 1.2 1.05592606707e-06 1.44748737341 1.0559578252e-06 1.55 1.05598958333e-06 1.44748737342 1.05602134146e-06 1.2 1.05605309959e-06 0.952512626585 1.05608485772e-06 0.85 1.05611661585e-06 0.952512626584 1.05614837398e-06 1.2 1.05618013211e-06 1.44748737342 1.05621189024e-06 1.55 1.05624364837e-06 1.44748737341 1.0562754065e-06 1.2 1.05630716463e-06 0.952512626585 1.05633892276e-06 0.85 1.05637068089e-06 0.952512626585 1.05640243902e-06 1.2 1.05643419715e-06 1.44748737341 1.05646595528e-06 1.55 1.05649771341e-06 1.44748737342 1.05652947154e-06 1.2 1.05656122967e-06 0.952512626585 1.0565929878e-06 0.85 1.05662474593e-06 0.952512626584 1.05665650407e-06 1.2 1.0566882622e-06 1.44748737342 1.05672002033e-06 1.55 1.05675177846e-06 1.44748737342 1.05678353659e-06 1.2 1.05681529472e-06 0.952512626584 1.05684705285e-06 0.85 1.05687881098e-06 0.952512626585 1.05691056911e-06 1.2 1.05694232724e-06 1.44748737342 1.05697408537e-06 1.55 1.0570058435e-06 1.44748737342 1.05703760163e-06 1.2 1.05706935976e-06 0.952512626585 1.05710111789e-06 0.85 1.05713287602e-06 0.952512626585 1.05716463415e-06 1.2 1.05719639228e-06 1.44748737342 1.05722815041e-06 1.55 1.05725990854e-06 1.44748737342 1.05729166667e-06 1.2 1.0573234248e-06 0.952512626585 1.05735518293e-06 0.85 1.05738694106e-06 0.952512626584 1.05741869919e-06 1.2 1.05745045732e-06 1.44748737342 1.05748221545e-06 1.55 1.05751397358e-06 1.44748737341 1.05754573171e-06 1.2 1.05757748984e-06 0.952512626585 1.05760924797e-06 0.85 1.0576410061e-06 0.952512626585 1.05767276423e-06 1.2 1.05770452236e-06 1.44748737342 1.05773628049e-06 1.55 1.05776803862e-06 1.44748737342 1.05779979675e-06 1.2 1.05783155488e-06 0.952512626585 1.05786331301e-06 0.85 1.05789507114e-06 0.952512626584 1.05792682927e-06 1.2 1.0579585874e-06 1.44748737342 1.05799034553e-06 1.55 1.05802210366e-06 1.44748737342 1.05805386179e-06 1.2 1.05808561992e-06 0.952512626584 1.05811737805e-06 0.85 1.05814913618e-06 0.952512626585 1.05818089431e-06 1.2 1.05821265244e-06 1.44748737342 1.05824441057e-06 1.55 1.0582761687e-06 1.44748737342 1.05830792683e-06 1.2 1.05833968496e-06 0.952512626584 1.05837144309e-06 0.85 1.05840320122e-06 0.952512626585 1.05843495935e-06 1.2 1.05846671748e-06 1.44748737342 1.05849847561e-06 1.55 1.05853023374e-06 1.44748737342 1.05856199187e-06 1.2 1.05859375e-06 0.952512626585 1.05862550813e-06 0.85 1.05865726626e-06 0.952512626584 1.05868902439e-06 1.2 1.05872078252e-06 1.44748737341 1.05875254065e-06 1.55 1.05878429878e-06 1.44748737341 1.05881605691e-06 1.2 1.05884781504e-06 0.952512626584 1.05887957317e-06 0.85 1.0589113313e-06 0.952512626585 1.05894308943e-06 1.2 1.05897484756e-06 1.44748737342 1.05900660569e-06 1.55 1.05903836382e-06 1.44748737342 1.05907012195e-06 1.2 1.05910188008e-06 0.952512626585 1.05913363821e-06 0.85 1.05916539634e-06 0.952512626584 1.05919715447e-06 1.2 1.0592289126e-06 1.44748737341 1.05926067073e-06 1.55 1.05929242886e-06 1.44748737342 1.05932418699e-06 1.2 1.05935594512e-06 0.952512626585 1.05938770325e-06 0.85 1.05941946138e-06 0.952512626585 1.05945121951e-06 1.2 1.05948297764e-06 1.44748737342 1.05951473577e-06 1.55 1.0595464939e-06 1.44748737342 1.05957825203e-06 1.2 1.05961001016e-06 0.952512626584 1.05964176829e-06 0.85 1.05967352642e-06 0.952512626584 1.05970528455e-06 1.2 1.05973704268e-06 1.44748737342 1.05976880081e-06 1.55 1.05980055894e-06 1.44748737342 1.05983231707e-06 1.2 1.0598640752e-06 0.952512626585 1.05989583333e-06 0.85 1.05992759146e-06 0.952512626585 1.05995934959e-06 1.2 1.05999110772e-06 1.44748737341 1.06002286585e-06 1.55 1.06005462398e-06 1.44748737341 1.06008638211e-06 1.2 1.06011814024e-06 0.952512626584 1.06014989837e-06 0.85 1.0601816565e-06 0.952512626585 1.06021341463e-06 1.2 1.06024517276e-06 1.44748737342 1.06027693089e-06 1.55 1.06030868902e-06 1.44748737342 1.06034044715e-06 1.2 1.06037220528e-06 0.952512626585 1.06040396341e-06 0.85 1.06043572154e-06 0.952512626584 1.06046747967e-06 1.2 1.0604992378e-06 1.44748737341 1.06053099593e-06 1.55 1.06056275407e-06 1.44748737342 1.0605945122e-06 1.2 1.06062627033e-06 0.952512626585 1.06065802846e-06 0.85 1.06068978659e-06 0.952512626585 1.06072154472e-06 1.2 1.06075330285e-06 1.44748737342 1.06078506098e-06 1.55 1.06081681911e-06 1.44748737342 1.06084857724e-06 1.2 1.06088033537e-06 0.952512626584 1.0609120935e-06 0.85 1.06094385163e-06 0.952512626584 1.06097560976e-06 1.2 1.06100736789e-06 1.44748737342 1.06103912602e-06 1.55 1.06107088415e-06 1.44748737342 1.06110264228e-06 1.2 1.06113440041e-06 0.952512626585 1.06116615854e-06 0.85 1.06119791667e-06 0.952512626585 1.0612296748e-06 1.2 1.06126143293e-06 1.44748737341 1.06129319106e-06 1.55 1.06132494919e-06 1.44748737341 1.06135670732e-06 1.2 1.06138846545e-06 0.952512626584 1.06142022358e-06 0.85 1.06145198171e-06 0.952512626585 1.06148373984e-06 1.2 1.06151549797e-06 1.44748737342 1.0615472561e-06 1.55 1.06157901423e-06 1.44748737341 1.06161077236e-06 1.2 1.06164253049e-06 0.952512626585 1.06167428862e-06 0.85 1.06170604675e-06 0.952512626585 1.06173780488e-06 1.2 1.06176956301e-06 1.44748737341 1.06180132114e-06 1.55 1.06183307927e-06 1.44748737342 1.0618648374e-06 1.2 1.06189659553e-06 0.952512626586 1.06192835366e-06 0.85 1.06196011179e-06 0.952512626585 1.06199186992e-06 1.2 1.06202362805e-06 1.44748737342 1.06205538618e-06 1.55 1.06208714431e-06 1.44748737342 1.06211890244e-06 1.2 1.06215066057e-06 0.952512626585 1.0621824187e-06 0.85 1.06221417683e-06 0.952512626585 1.06224593496e-06 1.2 1.06227769309e-06 1.44748737342 1.06230945122e-06 1.55 1.06234120935e-06 1.44748737342 1.06237296748e-06 1.2 1.06240472561e-06 0.952512626585 1.06243648374e-06 0.85 1.06246824187e-06 0.952512626584 1.0625e-06 1.2 1.06253175813e-06 1.44748737341 1.06256351626e-06 1.55 1.06259527439e-06 1.44748737342 1.06262703252e-06 1.2 1.06265879065e-06 0.952512626584 1.06269054878e-06 0.85 1.06272230691e-06 0.952512626585 1.06275406504e-06 1.2 1.06278582317e-06 1.44748737342 1.0628175813e-06 1.55 1.06284933943e-06 1.44748737341 1.06288109756e-06 1.2 1.06291285569e-06 0.952512626585 1.06294461382e-06 0.85 1.06297637195e-06 0.952512626585 1.06300813008e-06 1.2 1.06303988821e-06 1.44748737341 1.06307164634e-06 1.55 1.06310340447e-06 1.44748737342 1.0631351626e-06 1.2 1.06316692073e-06 0.952512626586 1.06319867886e-06 0.85 1.06323043699e-06 0.952512626584 1.06326219512e-06 1.2 1.06329395325e-06 1.44748737342 1.06332571138e-06 1.55 1.06335746951e-06 1.44748737341 1.06338922764e-06 1.2 1.06342098577e-06 0.952512626585 1.0634527439e-06 0.85 1.06348450203e-06 0.952512626585 1.06351626016e-06 1.2 1.06354801829e-06 1.44748737342 1.06357977642e-06 1.55 1.06361153455e-06 1.44748737342 1.06364329268e-06 1.2 1.06367505081e-06 0.952512626585 1.06370680894e-06 0.85 1.06373856707e-06 0.952512626584 1.0637703252e-06 1.2 1.06380208333e-06 1.44748737342 1.06383384146e-06 1.55 1.06386559959e-06 1.44748737342 1.06389735772e-06 1.2 1.06392911585e-06 0.952512626584 1.06396087398e-06 0.85 1.06399263211e-06 0.952512626585 1.06402439024e-06 1.2 1.06405614837e-06 1.44748737342 1.0640879065e-06 1.55 1.06411966463e-06 1.44748737341 1.06415142276e-06 1.2 1.06418318089e-06 0.952512626585 1.06421493902e-06 0.85 1.06424669715e-06 0.952512626585 1.06427845528e-06 1.2 1.06431021341e-06 1.44748737341 1.06434197154e-06 1.55 1.06437372967e-06 1.44748737342 1.0644054878e-06 1.2 1.06443724593e-06 0.952512626585 1.06446900407e-06 0.85 1.0645007622e-06 0.952512626584 1.06453252033e-06 1.2 1.06456427846e-06 1.44748737342 1.06459603659e-06 1.55 1.06462779472e-06 1.44748737341 1.06465955285e-06 1.2 1.06469131098e-06 0.952512626585 1.06472306911e-06 0.85 1.06475482724e-06 0.952512626585 1.06478658537e-06 1.2 1.0648183435e-06 1.44748737341 1.06485010163e-06 1.55 1.06488185976e-06 1.44748737342 1.06491361789e-06 1.2 1.06494537602e-06 0.952512626585 1.06497713415e-06 0.85 1.06500889228e-06 0.952512626584 1.06504065041e-06 1.2 1.06507240854e-06 1.44748737342 1.06510416667e-06 1.55 1.0651359248e-06 1.44748737342 1.06516768293e-06 1.2 1.06519944106e-06 0.952512626584 1.06523119919e-06 0.85 1.06526295732e-06 0.952512626585 1.06529471545e-06 1.2 1.06532647358e-06 1.44748737342 1.06535823171e-06 1.55 1.06538998984e-06 1.44748737342 1.06542174797e-06 1.2 1.0654535061e-06 0.952512626585 1.06548526423e-06 0.85 1.06551702236e-06 0.952512626585 1.06554878049e-06 1.2 1.06558053862e-06 1.44748737342 1.06561229675e-06 1.55 1.06564405488e-06 1.44748737342 1.06567581301e-06 1.2 1.06570757114e-06 0.952512626585 1.06573932927e-06 0.85 1.0657710874e-06 0.952512626584 1.06580284553e-06 1.2 1.06583460366e-06 1.44748737342 1.06586636179e-06 1.55 1.06589811992e-06 1.44748737341 1.06592987805e-06 1.2 1.06596163618e-06 0.952512626585 1.06599339431e-06 0.85 1.06602515244e-06 0.952512626585 1.06605691057e-06 1.2 1.0660886687e-06 1.44748737342 1.06612042683e-06 1.55 1.06615218496e-06 1.44748737342 1.06618394309e-06 1.2 1.06621570122e-06 0.952512626585 1.06624745935e-06 0.85 1.06627921748e-06 0.952512626584 1.06631097561e-06 1.2 1.06634273374e-06 1.44748737342 1.06637449187e-06 1.55 1.06640625e-06 1.44748737342 1.06643800813e-06 1.2 1.06646976626e-06 0.952512626585 1.06650152439e-06 0.85 1.06653328252e-06 0.952512626585 1.06656504065e-06 1.2 1.06659679878e-06 1.44748737342 1.06662855691e-06 1.55 1.06666031504e-06 1.44748737342 1.06669207317e-06 1.2 1.0667238313e-06 0.952512626584 1.06675558943e-06 0.85 1.06678734756e-06 0.952512626585 1.06681910569e-06 1.2 1.06685086382e-06 1.44748737342 1.06688262195e-06 1.55 1.06691438008e-06 1.44748737342 1.06694613821e-06 1.2 1.06697789634e-06 0.952512626585 1.06700965447e-06 0.85 1.0670414126e-06 0.952512626584 1.06707317073e-06 1.2 1.06710492886e-06 1.44748737341 1.06713668699e-06 1.55 1.06716844512e-06 1.44748737341 1.06720020325e-06 1.2 1.06723196138e-06 0.952512626584 1.06726371951e-06 0.85 1.06729547764e-06 0.952512626585 1.06732723577e-06 1.2 1.0673589939e-06 1.44748737342 1.06739075203e-06 1.55 1.06742251016e-06 1.44748737342 1.06745426829e-06 1.2 1.06748602642e-06 0.952512626585 1.06751778455e-06 0.85 1.06754954268e-06 0.952512626584 1.06758130081e-06 1.2 1.06761305894e-06 1.44748737341 1.06764481707e-06 1.55 1.0676765752e-06 1.44748737342 1.06770833333e-06 1.2 1.06774009146e-06 0.952512626585 1.06777184959e-06 0.85 1.06780360772e-06 0.952512626585 1.06783536585e-06 1.2 1.06786712398e-06 1.44748737342 1.06789888211e-06 1.55 1.06793064024e-06 1.44748737342 1.06796239837e-06 1.2 1.0679941565e-06 0.952512626584 1.06802591463e-06 0.85 1.06805767276e-06 0.952512626584 1.06808943089e-06 1.2 1.06812118902e-06 1.44748737342 1.06815294715e-06 1.55 1.06818470528e-06 1.44748737342 1.06821646341e-06 1.2 1.06824822154e-06 0.952512626585 1.06827997967e-06 0.85 1.0683117378e-06 0.952512626585 1.06834349593e-06 1.2 1.06837525407e-06 1.44748737341 1.0684070122e-06 1.55 1.06843877033e-06 1.44748737341 1.06847052846e-06 1.2 1.06850228659e-06 0.952512626584 1.06853404472e-06 0.85 1.06856580285e-06 0.952512626585 1.06859756098e-06 1.2 1.06862931911e-06 1.44748737342 1.06866107724e-06 1.55 1.06869283537e-06 1.44748737342 1.0687245935e-06 1.2 1.06875635163e-06 0.952512626585 1.06878810976e-06 0.85 1.06881986789e-06 0.952512626585 1.06885162602e-06 1.2 1.06888338415e-06 1.44748737341 1.06891514228e-06 1.55 1.06894690041e-06 1.44748737342 1.06897865854e-06 1.2 1.06901041667e-06 0.952512626586 1.0690421748e-06 0.85 1.06907393293e-06 0.952512626585 1.06910569106e-06 1.2 1.06913744919e-06 1.44748737342 1.06916920732e-06 1.55 1.06920096545e-06 1.44748737342 1.06923272358e-06 1.2 1.06926448171e-06 0.952512626584 1.06929623984e-06 0.85 1.06932799797e-06 0.952512626584 1.0693597561e-06 1.2 1.06939151423e-06 1.44748737342 1.06942327236e-06 1.55 1.06945503049e-06 1.44748737342 1.06948678862e-06 1.2 1.06951854675e-06 0.952512626585 1.06955030488e-06 0.85 1.06958206301e-06 0.952512626585 1.06961382114e-06 1.2 1.06964557927e-06 1.44748737341 1.0696773374e-06 1.55 1.06970909553e-06 1.44748737341 1.06974085366e-06 1.2 1.06977261179e-06 0.952512626584 1.06980436992e-06 0.85 1.06983612805e-06 0.952512626585 1.06986788618e-06 1.2 1.06989964431e-06 1.44748737342 1.06993140244e-06 1.55 1.06996316057e-06 1.44748737341 1.0699949187e-06 1.2 1.07002667683e-06 0.952512626585 1.07005843496e-06 0.85 1.07009019309e-06 0.952512626585 1.07012195122e-06 1.2 1.07015370935e-06 1.44748737341 1.07018546748e-06 1.55 1.07021722561e-06 1.44748737342 1.07024898374e-06 1.2 1.07028074187e-06 0.952512626586 1.0703125e-06 0.85 1.07034425813e-06 0.952512626584 1.07037601626e-06 1.2 1.07040777439e-06 1.44748737342 1.07043953252e-06 1.55 1.07047129065e-06 1.44748737342 1.07050304878e-06 1.2 1.07053480691e-06 0.952512626585 1.07056656504e-06 0.85 1.07059832317e-06 0.952512626585 1.0706300813e-06 1.2 1.07066183943e-06 1.44748737342 1.07069359756e-06 1.55 1.07072535569e-06 1.44748737342 1.07075711382e-06 1.2 1.07078887195e-06 0.952512626585 1.07082063008e-06 0.85 1.07085238821e-06 0.952512626584 1.07088414634e-06 1.2 1.07091590447e-06 1.44748737341 1.0709476626e-06 1.55 1.07097942073e-06 1.44748737342 1.07101117886e-06 1.2 1.07104293699e-06 0.952512626584 1.07107469512e-06 0.85 1.07110645325e-06 0.952512626585 1.07113821138e-06 1.2 1.07116996951e-06 1.44748737342 1.07120172764e-06 1.55 1.07123348577e-06 1.44748737341 1.0712652439e-06 1.2 1.07129700203e-06 0.952512626585 1.07132876016e-06 0.85 1.07136051829e-06 0.952512626585 1.07139227642e-06 1.2 1.07142403455e-06 1.44748737341 1.07145579268e-06 1.55 1.07148755081e-06 1.44748737342 1.07151930894e-06 1.2 1.07155106707e-06 0.952512626586 1.0715828252e-06 0.85 1.07161458333e-06 0.952512626584 1.07164634146e-06 1.2 1.07167809959e-06 1.44748737342 1.07170985772e-06 1.55 1.07174161585e-06 1.44748737341 1.07177337398e-06 1.2 1.07180513211e-06 0.952512626585 1.07183689024e-06 0.85 1.07186864837e-06 0.952512626585 1.0719004065e-06 1.2 1.07193216463e-06 1.44748737342 1.07196392276e-06 1.55 1.07199568089e-06 1.44748737342 1.07202743902e-06 1.2 1.07205919715e-06 0.952512626585 1.07209095528e-06 0.85 1.07212271341e-06 0.952512626584 1.07215447154e-06 1.2 1.07218622967e-06 1.44748737342 1.0722179878e-06 1.55 1.07224974593e-06 1.44748737342 1.07228150407e-06 1.2 1.0723132622e-06 0.952512626584 1.07234502033e-06 0.85 1.07237677846e-06 0.952512626585 1.07240853659e-06 1.2 1.07244029472e-06 1.44748737342 1.07247205285e-06 1.55 1.07250381098e-06 1.44748737341 1.07253556911e-06 1.2 1.07256732724e-06 0.952512626585 1.07259908537e-06 0.85 1.0726308435e-06 0.952512626585 1.07266260163e-06 1.2 1.07269435976e-06 1.44748737341 1.07272611789e-06 1.55 1.07275787602e-06 1.44748737342 1.07278963415e-06 1.2 1.07282139228e-06 0.952512626585 1.07285315041e-06 0.85 1.07288490854e-06 0.952512626584 1.07291666667e-06 1.2 1.0729484248e-06 1.44748737342 1.07298018293e-06 1.55 1.07301194106e-06 1.44748737341 1.07304369919e-06 1.2 1.07307545732e-06 0.952512626585 1.07310721545e-06 0.85 1.07313897358e-06 0.952512626585 1.07317073171e-06 1.2 1.07320248984e-06 1.44748737341 1.07323424797e-06 1.55 1.0732660061e-06 1.44748737342 1.07329776423e-06 1.2 1.07332952236e-06 0.952512626585 1.07336128049e-06 0.85 1.07339303862e-06 0.952512626584 1.07342479675e-06 1.2 1.07345655488e-06 1.44748737342 1.07348831301e-06 1.55 1.07352007114e-06 1.44748737342 1.07355182927e-06 1.2 1.0735835874e-06 0.952512626584 1.07361534553e-06 0.85 1.07364710366e-06 0.952512626585 1.07367886179e-06 1.2 1.07371061992e-06 1.44748737342 1.07374237805e-06 1.55 1.07377413618e-06 1.44748737342 1.07380589431e-06 1.2 1.07383765244e-06 0.952512626584 1.07386941057e-06 0.85 1.0739011687e-06 0.952512626585 1.07393292683e-06 1.2 1.07396468496e-06 1.44748737342 1.07399644309e-06 1.55 1.07402820122e-06 1.44748737342 1.07405995935e-06 1.2 1.07409171748e-06 0.952512626585 1.07412347561e-06 0.85 1.07415523374e-06 0.952512626584 1.07418699187e-06 1.2 1.07421875e-06 1.44748737341 1.07425050813e-06 1.55 1.07428226626e-06 1.44748737341 1.07431402439e-06 1.2 1.07434578252e-06 0.952512626585 1.07437754065e-06 0.85 1.07440929878e-06 0.952512626585 1.07444105691e-06 1.2 1.07447281504e-06 1.44748737342 1.07450457317e-06 1.55 1.0745363313e-06 1.44748737342 1.07456808943e-06 1.2 1.07459984756e-06 0.952512626585 1.07463160569e-06 0.85 1.07466336382e-06 0.952512626584 1.07469512195e-06 1.2 1.07472688008e-06 1.44748737342 1.07475863821e-06 1.55 1.07479039634e-06 1.44748737342 1.07482215447e-06 1.2 1.0748539126e-06 0.952512626585 1.07488567073e-06 0.85 1.07491742886e-06 0.952512626585 1.07494918699e-06 1.2 1.07498094512e-06 1.44748737342 1.07501270325e-06 1.55 1.07504446138e-06 1.44748737342 1.07507621951e-06 1.2 1.07510797764e-06 0.952512626584 1.07513973577e-06 0.85 1.0751714939e-06 0.952512626585 1.07520325203e-06 1.2 1.07523501016e-06 1.44748737342 1.07526676829e-06 1.55 1.07529852642e-06 1.44748737342 1.07533028455e-06 1.2 1.07536204268e-06 0.952512626585 1.07539380081e-06 0.85 1.07542555894e-06 0.952512626584 1.07545731707e-06 1.2 1.0754890752e-06 1.44748737341 1.07552083333e-06 1.55 1.07555259146e-06 1.44748737341 1.07558434959e-06 1.2 1.07561610772e-06 0.952512626584 1.07564786585e-06 0.85 1.07567962398e-06 0.952512626585 1.07571138211e-06 1.2 1.07574314024e-06 1.44748737342 1.07577489837e-06 1.55 1.0758066565e-06 1.44748737342 1.07583841463e-06 1.2 1.07587017276e-06 0.952512626585 1.07590193089e-06 0.85 1.07593368902e-06 0.952512626584 1.07596544715e-06 1.2 1.07599720528e-06 1.44748737341 1.07602896341e-06 1.55 1.07606072154e-06 1.44748737342 1.07609247967e-06 1.2 1.0761242378e-06 0.952512626585 1.07615599593e-06 0.85 1.07618775407e-06 0.952512626585 1.0762195122e-06 1.2 1.07625127033e-06 1.44748737342 1.07628302846e-06 1.55 1.07631478659e-06 1.44748737342 1.07634654472e-06 1.2 1.07637830285e-06 0.952512626584 1.07641006098e-06 0.85 1.07644181911e-06 0.952512626584 1.07647357724e-06 1.2 1.07650533537e-06 1.44748737342 1.0765370935e-06 1.55 1.07656885163e-06 1.44748737342 1.07660060976e-06 1.2 1.07663236789e-06 0.952512626585 1.07666412602e-06 0.85 1.07669588415e-06 0.952512626585 1.07672764228e-06 1.2 1.07675940041e-06 1.44748737341 1.07679115854e-06 1.55 1.07682291667e-06 1.44748737341 1.0768546748e-06 1.2 1.07688643293e-06 0.952512626584 1.07691819106e-06 0.85 1.07694994919e-06 0.952512626585 1.07698170732e-06 1.2 1.07701346545e-06 1.44748737342 1.07704522358e-06 1.55 1.07707698171e-06 1.44748737342 1.07710873984e-06 1.2 1.07714049797e-06 0.952512626585 1.0771722561e-06 0.85 1.07720401423e-06 0.952512626585 1.07723577236e-06 1.2 1.07726753049e-06 1.44748737341 1.07729928862e-06 1.55 1.07733104675e-06 1.44748737342 1.07736280488e-06 1.2 1.07739456301e-06 0.952512626586 1.07742632114e-06 0.85 1.07745807927e-06 0.952512626585 1.0774898374e-06 1.2 1.07752159553e-06 1.44748737342 1.07755335366e-06 1.55 1.07758511179e-06 1.44748737342 1.07761686992e-06 1.2 1.07764862805e-06 0.952512626584 1.07768038618e-06 0.85 1.07771214431e-06 0.952512626584 1.07774390244e-06 1.2 1.07777566057e-06 1.44748737342 1.0778074187e-06 1.55 1.07783917683e-06 1.44748737342 1.07787093496e-06 1.2 1.07790269309e-06 0.952512626585 1.07793445122e-06 0.85 1.07796620935e-06 0.952512626584 1.07799796748e-06 1.2 1.07802972561e-06 1.44748737341 1.07806148374e-06 1.55 1.07809324187e-06 1.44748737341 1.078125e-06 1.2 1.07815675813e-06 0.952512626584 1.07818851626e-06 0.85 1.07822027439e-06 0.952512626585 1.07825203252e-06 1.2 1.07828379065e-06 1.44748737342 1.07831554878e-06 1.55 1.07834730691e-06 1.44748737341 1.07837906504e-06 1.2 1.07841082317e-06 0.952512626585 1.0784425813e-06 0.85 1.07847433943e-06 0.952512626585 1.07850609756e-06 1.2 1.07853785569e-06 1.44748737341 1.07856961382e-06 1.55 1.07860137195e-06 1.44748737342 1.07863313008e-06 1.2 1.07866488821e-06 0.952512626586 1.07869664634e-06 0.85 1.07872840447e-06 0.952512626584 1.0787601626e-06 1.2 1.07879192073e-06 1.44748737342 1.07882367886e-06 1.55 1.07885543699e-06 1.44748737341 1.07888719512e-06 1.2 1.07891895325e-06 0.952512626585 1.07895071138e-06 0.85 1.07898246951e-06 0.952512626585 1.07901422764e-06 1.2 1.07904598577e-06 1.44748737342 1.0790777439e-06 1.55 1.07910950203e-06 1.44748737342 1.07914126016e-06 1.2 1.07917301829e-06 0.952512626585 1.07920477642e-06 0.85 1.07923653455e-06 0.952512626584 1.07926829268e-06 1.2 1.07930005081e-06 1.44748737341 1.07933180894e-06 1.55 1.07936356707e-06 1.44748737342 1.0793953252e-06 1.2 1.07942708333e-06 0.952512626584 1.07945884146e-06 0.85 1.07949059959e-06 0.952512626585 1.07952235772e-06 1.2 1.07955411585e-06 1.44748737342 1.07958587398e-06 1.55 1.07961763211e-06 1.44748737341 1.07964939024e-06 1.2 1.07968114837e-06 0.952512626585 1.0797129065e-06 0.85 1.07974466463e-06 0.952512626585 1.07977642276e-06 1.2 1.07980818089e-06 1.44748737341 1.07983993902e-06 1.55 1.07987169715e-06 1.44748737342 1.07990345528e-06 1.2 1.07993521341e-06 0.952512626585 1.07996697154e-06 0.85 1.07999872967e-06 0.952512626584 1.0800304878e-06 1.2 1.08006224593e-06 1.44748737342 1.08009400407e-06 1.55 1.0801257622e-06 1.44748737341 1.08015752033e-06 1.2 1.08018927846e-06 0.952512626585 1.08022103659e-06 0.85 1.08025279472e-06 0.952512626585 1.08028455285e-06 1.2 1.08031631098e-06 1.44748737342 1.08034806911e-06 1.55 1.08037982724e-06 1.44748737342 1.08041158537e-06 1.2 1.0804433435e-06 0.952512626585 1.08047510163e-06 0.85 1.08050685976e-06 0.952512626584 1.08053861789e-06 1.2 1.08057037602e-06 1.44748737342 1.08060213415e-06 1.55 1.08063389228e-06 1.44748737342 1.08066565041e-06 1.2 1.08069740854e-06 0.952512626584 1.08072916667e-06 0.85 1.0807609248e-06 0.952512626585 1.08079268293e-06 1.2 1.08082444106e-06 1.44748737342 1.08085619919e-06 1.55 1.08088795732e-06 1.44748737341 1.08091971545e-06 1.2 1.08095147358e-06 0.952512626585 1.08098323171e-06 0.85 1.08101498984e-06 0.952512626585 1.08104674797e-06 1.2 1.0810785061e-06 1.44748737342 1.08111026423e-06 1.55 1.08114202236e-06 1.44748737342 1.08117378049e-06 1.2 1.08120553862e-06 0.952512626585 1.08123729675e-06 0.85 1.08126905488e-06 0.952512626584 1.08130081301e-06 1.2 1.08133257114e-06 1.44748737342 1.08136432927e-06 1.55 1.0813960874e-06 1.44748737341 1.08142784553e-06 1.2 1.08145960366e-06 0.952512626585 1.08149136179e-06 0.85 1.08152311992e-06 0.952512626585 1.08155487805e-06 1.2 1.08158663618e-06 1.44748737341 1.08161839431e-06 1.55 1.08165015244e-06 1.44748737342 1.08168191057e-06 1.2 1.0817136687e-06 0.952512626585 1.08174542683e-06 0.85 1.08177718496e-06 0.952512626584 1.08180894309e-06 1.2 1.08184070122e-06 1.44748737342 1.08187245935e-06 1.55 1.08190421748e-06 1.44748737342 1.08193597561e-06 1.2 1.08196773374e-06 0.952512626584 1.08199949187e-06 0.85 1.08203125e-06 0.952512626585 1.08206300813e-06 1.2 1.08209476626e-06 1.44748737342 1.08212652439e-06 1.55 1.08215828252e-06 1.44748737342 1.08219004065e-06 1.2 1.08222179878e-06 0.952512626584 1.08225355691e-06 0.85 1.08228531504e-06 0.952512626585 1.08231707317e-06 1.2 1.0823488313e-06 1.44748737342 1.08238058943e-06 1.55 1.08241234756e-06 1.44748737342 1.08244410569e-06 1.2 1.08247586382e-06 0.952512626585 1.08250762195e-06 0.85 1.08253938008e-06 0.952512626584 1.08257113821e-06 1.2 1.08260289634e-06 1.44748737341 1.08263465447e-06 1.55 1.0826664126e-06 1.44748737341 1.08269817073e-06 1.2 1.08272992886e-06 0.952512626585 1.08276168699e-06 0.85 1.08279344512e-06 0.952512626585 1.08282520325e-06 1.2 1.08285696138e-06 1.44748737342 1.08288871951e-06 1.55 1.08292047764e-06 1.44748737342 1.08295223577e-06 1.2 1.0829839939e-06 0.952512626585 1.08301575203e-06 0.85 1.08304751016e-06 0.952512626584 1.08307926829e-06 1.2 1.08311102642e-06 1.44748737342 1.08314278455e-06 1.55 1.08317454268e-06 1.44748737342 1.08320630081e-06 1.2 1.08323805894e-06 0.952512626585 1.08326981707e-06 0.85 1.0833015752e-06 0.952512626585 1.08333333333e-06 1.2 1.08336509146e-06 1.44748737342 1.08339684959e-06 1.55 1.08342860772e-06 1.44748737342 1.08346036585e-06 1.2 1.08349212398e-06 0.952512626584 1.08352388211e-06 0.85 1.08355564024e-06 0.952512626584 1.08358739837e-06 1.2 1.0836191565e-06 1.44748737342 1.08365091463e-06 1.55 1.08368267276e-06 1.44748737342 1.08371443089e-06 1.2 1.08374618902e-06 0.952512626585 1.08377794715e-06 0.85 1.08380970528e-06 0.952512626584 1.08384146341e-06 1.2 1.08387322154e-06 1.44748737341 1.08390497967e-06 1.55 1.0839367378e-06 1.44748737341 1.08396849593e-06 1.2 1.08400025407e-06 0.952512626584 1.0840320122e-06 0.85 1.08406377033e-06 0.952512626585 1.08409552846e-06 1.2 1.08412728659e-06 1.44748737342 1.08415904472e-06 1.55 1.08419080285e-06 1.44748737342 1.08422256098e-06 1.2 1.08425431911e-06 0.952512626585 1.08428607724e-06 0.85 1.08431783537e-06 0.952512626584 1.0843495935e-06 1.2 1.08438135163e-06 1.44748737341 1.08441310976e-06 1.55 1.08444486789e-06 1.44748737342 1.08447662602e-06 1.2 1.08450838415e-06 0.952512626585 1.08454014228e-06 0.85 1.08457190041e-06 0.952512626585 1.08460365854e-06 1.2 1.08463541667e-06 1.44748737342 1.0846671748e-06 1.55 1.08469893293e-06 1.44748737342 1.08473069106e-06 1.2 1.08476244919e-06 0.952512626584 1.08479420732e-06 0.85 1.08482596545e-06 0.952512626584 1.08485772358e-06 1.2 1.08488948171e-06 1.44748737342 1.08492123984e-06 1.55 1.08495299797e-06 1.44748737342 1.0849847561e-06 1.2 1.08501651423e-06 0.952512626585 1.08504827236e-06 0.85 1.08508003049e-06 0.952512626585 1.08511178862e-06 1.2 1.08514354675e-06 1.44748737341 1.08517530488e-06 1.55 1.08520706301e-06 1.44748737341 1.08523882114e-06 1.2 1.08527057927e-06 0.952512626584 1.0853023374e-06 0.85 1.08533409553e-06 0.952512626585 1.08536585366e-06 1.2 1.08539761179e-06 1.44748737342 1.08542936992e-06 1.55 1.08546112805e-06 1.44748737342 1.08549288618e-06 1.2 1.08552464431e-06 0.952512626585 1.08555640244e-06 0.85 1.08558816057e-06 0.952512626585 1.0856199187e-06 1.2 1.08565167683e-06 1.44748737341 1.08568343496e-06 1.55 1.08571519309e-06 1.44748737342 1.08574695122e-06 1.2 1.08577870935e-06 0.952512626586 1.08581046748e-06 0.85 1.08584222561e-06 0.952512626585 1.08587398374e-06 1.2 1.08590574187e-06 1.44748737342 1.0859375e-06 1.55 1.08596925813e-06 1.44748737342 1.08600101626e-06 1.2 1.08603277439e-06 0.952512626584 1.08606453252e-06 0.85 1.08609629065e-06 0.952512626585 1.08612804878e-06 1.2 1.08615980691e-06 1.44748737342 1.08619156504e-06 1.55 1.08622332317e-06 1.44748737342 1.0862550813e-06 1.2 1.08628683943e-06 0.952512626585 1.08631859756e-06 0.85 1.08635035569e-06 0.952512626584 1.08638211382e-06 1.2 1.08641387195e-06 1.44748737341 1.08644563008e-06 1.55 1.08647738821e-06 1.44748737342 1.08650914634e-06 1.2 1.08654090447e-06 0.952512626584 1.0865726626e-06 0.85 1.08660442073e-06 0.952512626585 1.08663617886e-06 1.2 1.08666793699e-06 1.44748737342 1.08669969512e-06 1.55 1.08673145325e-06 1.44748737341 1.08676321138e-06 1.2 1.08679496951e-06 0.952512626585 1.08682672764e-06 0.85 1.08685848577e-06 0.952512626585 1.0868902439e-06 1.2 1.08692200203e-06 1.44748737341 1.08695376016e-06 1.55 1.08698551829e-06 1.44748737342 1.08701727642e-06 1.2 1.08704903455e-06 0.952512626586 1.08708079268e-06 0.85 1.08711255081e-06 0.952512626584 1.08714430894e-06 1.2 1.08717606707e-06 1.44748737342 1.0872078252e-06 1.55 1.08723958333e-06 1.44748737341 1.08727134146e-06 1.2 1.08730309959e-06 0.952512626585 1.08733485772e-06 0.85 1.08736661585e-06 0.952512626585 1.08739837398e-06 1.2 1.08743013211e-06 1.44748737342 1.08746189024e-06 1.55 1.08749364837e-06 1.44748737342 1.0875254065e-06 1.2 1.08755716463e-06 0.952512626585 1.08758892276e-06 0.85 1.08762068089e-06 0.952512626584 1.08765243902e-06 1.2 1.08768419715e-06 1.44748737341 1.08771595528e-06 1.55 1.08774771341e-06 1.44748737342 1.08777947154e-06 1.2 1.08781122967e-06 0.952512626584 1.0878429878e-06 0.85 1.08787474593e-06 0.952512626585 1.08790650407e-06 1.2 1.0879382622e-06 1.44748737342 1.08797002033e-06 1.55 1.08800177846e-06 1.44748737341 1.08803353659e-06 1.2 1.08806529472e-06 0.952512626585 1.08809705285e-06 0.85 1.08812881098e-06 0.952512626585 1.08816056911e-06 1.2 1.08819232724e-06 1.44748737341 1.08822408537e-06 1.55 1.0882558435e-06 1.44748737342 1.08828760163e-06 1.2 1.08831935976e-06 0.952512626585 1.08835111789e-06 0.85 1.08838287602e-06 0.952512626584 1.08841463415e-06 1.2 1.08844639228e-06 1.44748737342 1.08847815041e-06 1.55 1.08850990854e-06 1.44748737341 1.08854166667e-06 1.2 1.0885734248e-06 0.952512626585 1.08860518293e-06 0.85 1.08863694106e-06 0.952512626585 1.08866869919e-06 1.2 1.08870045732e-06 1.44748737342 1.08873221545e-06 1.55 1.08876397358e-06 1.44748737342 1.08879573171e-06 1.2 1.08882748984e-06 0.952512626585 1.08885924797e-06 0.85 1.0888910061e-06 0.952512626584 1.08892276423e-06 1.2 1.08895452236e-06 1.44748737342 1.08898628049e-06 1.55 1.08901803862e-06 1.44748737342 1.08904979675e-06 1.2 1.08908155488e-06 0.952512626584 1.08911331301e-06 0.85 1.08914507114e-06 0.952512626585 1.08917682927e-06 1.2 1.0892085874e-06 1.44748737342 1.08924034553e-06 1.55 1.08927210366e-06 1.44748737341 1.08930386179e-06 1.2 1.08933561992e-06 0.952512626585 1.08936737805e-06 0.85 1.08939913618e-06 0.952512626585 1.08943089431e-06 1.2 1.08946265244e-06 1.44748737342 1.08949441057e-06 1.55 1.0895261687e-06 1.44748737342 1.08955792683e-06 1.2 1.08958968496e-06 0.952512626585 1.08962144309e-06 0.85 1.08965320122e-06 0.952512626584 1.08968495935e-06 1.2 1.08971671748e-06 1.44748737342 1.08974847561e-06 1.55 1.08978023374e-06 1.44748737341 1.08981199187e-06 1.2 1.08984375e-06 0.952512626585 1.08987550813e-06 0.85 1.08990726626e-06 0.952512626585 1.08993902439e-06 1.2 1.08997078252e-06 1.44748737341 1.09000254065e-06 1.55 1.09003429878e-06 1.44748737342 1.09006605691e-06 1.2 1.09009781504e-06 0.952512626585 1.09012957317e-06 0.85 1.0901613313e-06 0.952512626584 1.09019308943e-06 1.2 1.09022484756e-06 1.44748737342 1.09025660569e-06 1.55 1.09028836382e-06 1.44748737342 1.09032012195e-06 1.2 1.09035188008e-06 0.952512626585 1.09038363821e-06 0.85 1.09041539634e-06 0.952512626585 1.09044715447e-06 1.2 1.0904789126e-06 1.44748737342 1.09051067073e-06 1.55 1.09054242886e-06 1.44748737342 1.09057418699e-06 1.2 1.09060594512e-06 0.952512626584 1.09063770325e-06 0.85 1.09066946138e-06 0.952512626585 1.09070121951e-06 1.2 1.09073297764e-06 1.44748737342 1.09076473577e-06 1.55 1.0907964939e-06 1.44748737342 1.09082825203e-06 1.2 1.09086001016e-06 0.952512626585 1.09089176829e-06 0.85 1.09092352642e-06 0.952512626584 1.09095528455e-06 1.2 1.09098704268e-06 1.44748737341 1.09101880081e-06 1.55 1.09105055894e-06 1.44748737341 1.09108231707e-06 1.2 1.0911140752e-06 0.952512626584 1.09114583333e-06 0.85 1.09117759146e-06 0.952512626585 1.09120934959e-06 1.2 1.09124110772e-06 1.44748737342 1.09127286585e-06 1.55 1.09130462398e-06 1.44748737342 1.09133638211e-06 1.2 1.09136814024e-06 0.952512626585 1.09139989837e-06 0.85 1.0914316565e-06 0.952512626584 1.09146341463e-06 1.2 1.09149517276e-06 1.44748737342 1.09152693089e-06 1.55 1.09155868902e-06 1.44748737342 1.09159044715e-06 1.2 1.09162220528e-06 0.952512626585 1.09165396341e-06 0.85 1.09168572154e-06 0.952512626585 1.09171747967e-06 1.2 1.0917492378e-06 1.44748737342 1.09178099593e-06 1.55 1.09181275407e-06 1.44748737342 1.0918445122e-06 1.2 1.09187627033e-06 0.952512626584 1.09190802846e-06 0.85 1.09193978659e-06 0.952512626584 1.09197154472e-06 1.2 1.09200330285e-06 1.44748737342 1.09203506098e-06 1.55 1.09206681911e-06 1.44748737342 1.09209857724e-06 1.2 1.09213033537e-06 0.952512626585 1.0921620935e-06 0.85 1.09219385163e-06 0.952512626585 1.09222560976e-06 1.2 1.09225736789e-06 1.44748737341 1.09228912602e-06 1.55 1.09232088415e-06 1.44748737341 1.09235264228e-06 1.2 1.09238440041e-06 0.952512626584 1.09241615854e-06 0.85 1.09244791667e-06 0.952512626585 1.0924796748e-06 1.2 1.09251143293e-06 1.44748737342 1.09254319106e-06 1.55 1.09257494919e-06 1.44748737342 1.09260670732e-06 1.2 1.09263846545e-06 0.952512626585 1.09267022358e-06 0.85 1.09270198171e-06 0.952512626584 1.09273373984e-06 1.2 1.09276549797e-06 1.44748737341 1.0927972561e-06 1.55 1.09282901423e-06 1.44748737342 1.09286077236e-06 1.2 1.09289253049e-06 0.952512626585 1.09292428862e-06 0.85 1.09295604675e-06 0.952512626585 1.09298780488e-06 1.2 1.09301956301e-06 1.44748737342 1.09305132114e-06 1.55 1.09308307927e-06 1.44748737342 1.0931148374e-06 1.2 1.09314659553e-06 0.952512626584 1.09317835366e-06 0.85 1.09321011179e-06 0.952512626584 1.09324186992e-06 1.2 1.09327362805e-06 1.44748737342 1.09330538618e-06 1.55 1.09333714431e-06 1.44748737342 1.09336890244e-06 1.2 1.09340066057e-06 0.952512626585 1.0934324187e-06 0.85 1.09346417683e-06 0.952512626585 1.09349593496e-06 1.2 1.09352769309e-06 1.44748737341 1.09355945122e-06 1.55 1.09359120935e-06 1.44748737341 1.09362296748e-06 1.2 1.09365472561e-06 0.952512626584 1.09368648374e-06 0.85 1.09371824187e-06 0.952512626585 1.09375e-06 1.2 1.09378175813e-06 1.44748737342 1.09381351626e-06 1.55 1.09384527439e-06 1.44748737342 1.09387703252e-06 1.2 1.09390879065e-06 0.952512626585 1.09394054878e-06 0.85 1.09397230691e-06 0.952512626585 1.09400406504e-06 1.2 1.09403582317e-06 1.44748737341 1.0940675813e-06 1.55 1.09409933943e-06 1.44748737342 1.09413109756e-06 1.2 1.09416285569e-06 0.952512626586 1.09419461382e-06 0.85 1.09422637195e-06 0.952512626584 1.09425813008e-06 1.2 1.09428988821e-06 1.44748737342 1.09432164634e-06 1.55 1.09435340447e-06 1.44748737342 1.0943851626e-06 1.2 1.09441692073e-06 0.952512626584 1.09444867886e-06 0.85 1.09448043699e-06 0.952512626585 1.09451219512e-06 1.2 1.09454395325e-06 1.44748737342 1.09457571138e-06 1.55 1.09460746951e-06 1.44748737342 1.09463922764e-06 1.2 1.09467098577e-06 0.952512626585 1.0947027439e-06 0.85 1.09473450203e-06 0.952512626584 1.09476626016e-06 1.2 1.09479801829e-06 1.44748737341 1.09482977642e-06 1.55 1.09486153455e-06 1.44748737342 1.09489329268e-06 1.2 1.09492505081e-06 0.952512626584 1.09495680894e-06 0.85 1.09498856707e-06 0.952512626585 1.0950203252e-06 1.2 1.09505208333e-06 1.44748737342 1.09508384146e-06 1.55 1.09511559959e-06 1.44748737341 1.09514735772e-06 1.2 1.09517911585e-06 0.952512626585 1.09521087398e-06 0.85 1.09524263211e-06 0.952512626585 1.09527439024e-06 1.2 1.09530614837e-06 1.44748737341 1.0953379065e-06 1.55 1.09536966463e-06 1.44748737342 1.09540142276e-06 1.2 1.09543318089e-06 0.952512626586 1.09546493902e-06 0.85 1.09549669715e-06 0.952512626584 1.09552845528e-06 1.2 1.09556021341e-06 1.44748737342 1.09559197154e-06 1.55 1.09562372967e-06 1.44748737341 1.0956554878e-06 1.2 1.09568724593e-06 0.952512626585 1.09571900407e-06 0.85 1.0957507622e-06 0.952512626585 1.09578252033e-06 1.2 1.09581427846e-06 1.44748737342 1.09584603659e-06 1.55 1.09587779472e-06 1.44748737342 1.09590955285e-06 1.2 1.09594131098e-06 0.952512626585 1.09597306911e-06 0.85 1.09600482724e-06 0.952512626584 1.09603658537e-06 1.2 1.0960683435e-06 1.44748737341 1.09610010163e-06 1.55 1.09613185976e-06 1.44748737342 1.09616361789e-06 1.2 1.09619537602e-06 0.952512626584 1.09622713415e-06 0.85 1.09625889228e-06 0.952512626585 1.09629065041e-06 1.2 1.09632240854e-06 1.44748737342 1.09635416667e-06 1.55 1.0963859248e-06 1.44748737341 1.09641768293e-06 1.2 1.09644944106e-06 0.952512626585 1.09648119919e-06 0.85 1.09651295732e-06 0.952512626585 1.09654471545e-06 1.2 1.09657647358e-06 1.44748737341 1.09660823171e-06 1.55 1.09663998984e-06 1.44748737342 1.09667174797e-06 1.2 1.0967035061e-06 0.952512626585 1.09673526423e-06 0.85 1.09676702236e-06 0.952512626584 1.09679878049e-06 1.2 1.09683053862e-06 1.44748737342 1.09686229675e-06 1.55 1.09689405488e-06 1.44748737341 1.09692581301e-06 1.2 1.09695757114e-06 0.952512626585 1.09698932927e-06 0.85 1.0970210874e-06 0.952512626585 1.09705284553e-06 1.2 1.09708460366e-06 1.44748737342 1.09711636179e-06 1.55 1.09714811992e-06 1.44748737342 1.09717987805e-06 1.2 1.09721163618e-06 0.952512626584 1.09724339431e-06 0.85 1.09727515244e-06 0.952512626584 1.09730691057e-06 1.2 1.0973386687e-06 1.44748737342 1.09737042683e-06 1.55 1.09740218496e-06 1.44748737342 1.09743394309e-06 1.2 1.09746570122e-06 0.952512626584 1.09749745935e-06 0.85 1.09752921748e-06 0.952512626585 1.09756097561e-06 1.2 1.09759273374e-06 1.44748737342 1.09762449187e-06 1.55 1.09765625e-06 1.44748737341 1.09768800813e-06 1.2 1.09771976626e-06 0.952512626585 1.09775152439e-06 0.85 1.09778328252e-06 0.952512626585 1.09781504065e-06 1.2 1.09784679878e-06 1.44748737342 1.09787855691e-06 1.55 1.09791031504e-06 1.44748737342 1.09794207317e-06 1.2 1.0979738313e-06 0.952512626585 1.09800558943e-06 0.85 1.09803734756e-06 0.952512626584 1.09806910569e-06 1.2 1.09810086382e-06 1.44748737341 1.09813262195e-06 1.55 1.09816438008e-06 1.44748737341 1.09819613821e-06 1.2 1.09822789634e-06 0.952512626585 1.09825965447e-06 0.85 1.0982914126e-06 0.952512626585 1.09832317073e-06 1.2 1.09835492886e-06 1.44748737342 1.09838668699e-06 1.55 1.09841844512e-06 1.44748737342 1.09845020325e-06 1.2 1.09848196138e-06 0.952512626585 1.09851371951e-06 0.85 1.09854547764e-06 0.952512626584 1.09857723577e-06 1.2 1.0986089939e-06 1.44748737342 1.09864075203e-06 1.55 1.09867251016e-06 1.44748737342 1.09870426829e-06 1.2 1.09873602642e-06 0.952512626585 1.09876778455e-06 0.85 1.09879954268e-06 0.952512626585 1.09883130081e-06 1.2 1.09886305894e-06 1.44748737342 1.09889481707e-06 1.55 1.0989265752e-06 1.44748737342 1.09895833333e-06 1.2 1.09899009146e-06 0.952512626584 1.09902184959e-06 0.85 1.09905360772e-06 0.952512626585 1.09908536585e-06 1.2 1.09911712398e-06 1.44748737342 1.09914888211e-06 1.55 1.09918064024e-06 1.44748737342 1.09921239837e-06 1.2 1.0992441565e-06 0.952512626585 1.09927591463e-06 0.85 1.09930767276e-06 0.952512626584 1.09933943089e-06 1.2 1.09937118902e-06 1.44748737341 1.09940294715e-06 1.55 1.09943470528e-06 1.44748737341 1.09946646341e-06 1.2 1.09949822154e-06 0.952512626584 1.09952997967e-06 0.85 1.0995617378e-06 0.952512626585 1.09959349593e-06 1.2 1.09962525407e-06 1.44748737342 1.0996570122e-06 1.55 1.09968877033e-06 1.44748737342 1.09972052846e-06 1.2 1.09975228659e-06 0.952512626585 1.09978404472e-06 0.85 1.09981580285e-06 0.952512626584 1.09984756098e-06 1.2 1.09987931911e-06 1.44748737342 1.09991107724e-06 1.55 1.09994283537e-06 1.44748737342 1.0999745935e-06 1.2 1.10000635163e-06 0.952512626585 1.10003810976e-06 0.85 1.10006986789e-06 0.952512626585 1.10010162602e-06 1.2 1.10013338415e-06 1.44748737342 1.10016514228e-06 1.55 1.10019690041e-06 1.44748737342 1.10022865854e-06 1.2 1.10026041667e-06 0.952512626584 1.1002921748e-06 0.85 1.10032393293e-06 0.952512626584 1.10035569106e-06 1.2 1.10038744919e-06 1.44748737342 1.10041920732e-06 1.55 1.10045096545e-06 1.44748737342 1.10048272358e-06 1.2 1.10051448171e-06 0.952512626585 1.10054623984e-06 0.85 1.10057799797e-06 0.952512626585 1.1006097561e-06 1.2 1.10064151423e-06 1.44748737341 1.10067327236e-06 1.55 1.10070503049e-06 1.44748737341 1.10073678862e-06 1.2 1.10076854675e-06 0.952512626584 1.10080030488e-06 0.85 1.10083206301e-06 0.952512626585 1.10086382114e-06 1.2 1.10089557927e-06 1.44748737342 1.1009273374e-06 1.55 1.10095909553e-06 1.44748737342 1.10099085366e-06 1.2 1.10102261179e-06 0.952512626585 1.10105436992e-06 0.85 1.10108612805e-06 0.952512626584 1.10111788618e-06 1.2 1.10114964431e-06 1.44748737341 1.10118140244e-06 1.55 1.10121316057e-06 1.44748737342 1.1012449187e-06 1.2 1.10127667683e-06 0.952512626585 1.10130843496e-06 0.85 1.10134019309e-06 0.952512626585 1.10137195122e-06 1.2 1.10140370935e-06 1.44748737342 1.10143546748e-06 1.55 1.10146722561e-06 1.44748737342 1.10149898374e-06 1.2 1.10153074187e-06 0.952512626584 1.1015625e-06 0.85 1.10159425813e-06 0.952512626584 1.10162601626e-06 1.2 1.10165777439e-06 1.44748737342 1.10168953252e-06 1.55 1.10172129065e-06 1.44748737342 1.10175304878e-06 1.2 1.10178480691e-06 0.952512626585 1.10181656504e-06 0.85 1.10184832317e-06 0.952512626585 1.1018800813e-06 1.2 1.10191183943e-06 1.44748737341 1.10194359756e-06 1.55 1.10197535569e-06 1.44748737342 1.10200711382e-06 1.2 1.10203887195e-06 0.952512626584 1.10207063008e-06 0.85 1.10210238821e-06 0.952512626585 1.10213414634e-06 1.2 1.10216590447e-06 1.44748737342 1.1021976626e-06 1.55 1.10222942073e-06 1.44748737342 1.10226117886e-06 1.2 1.10229293699e-06 0.952512626585 1.10232469512e-06 0.85 1.10235645325e-06 0.952512626585 1.10238821138e-06 1.2 1.10241996951e-06 1.44748737341 1.10245172764e-06 1.55 1.10248348577e-06 1.44748737342 1.1025152439e-06 1.2 1.10254700203e-06 0.952512626586 1.10257876016e-06 0.85 1.10261051829e-06 0.952512626584 1.10264227642e-06 1.2 1.10267403455e-06 1.44748737342 1.10270579268e-06 1.55 1.10273755081e-06 1.44748737342 1.10276930894e-06 1.2 1.10280106707e-06 0.952512626584 1.1028328252e-06 0.85 1.10286458333e-06 0.952512626585 1.10289634146e-06 1.2 1.10292809959e-06 1.44748737342 1.10295985772e-06 1.55 1.10299161585e-06 1.44748737342 1.10302337398e-06 1.2 1.10305513211e-06 0.952512626585 1.10308689024e-06 0.85 1.10311864837e-06 0.952512626584 1.1031504065e-06 1.2 1.10318216463e-06 1.44748737341 1.10321392276e-06 1.55 1.10324568089e-06 1.44748737342 1.10327743902e-06 1.2 1.10330919715e-06 0.952512626584 1.10334095528e-06 0.85 1.10337271341e-06 0.952512626586 1.10340447154e-06 1.2 1.10343622967e-06 1.44748737342 1.1034679878e-06 1.55 1.10349974593e-06 1.44748737341 1.10353150407e-06 1.2 1.1035632622e-06 0.952512626585 1.10359502033e-06 0.85 1.10362677846e-06 0.952512626585 1.10365853659e-06 1.2 1.10369029472e-06 1.44748737341 1.10372205285e-06 1.55 1.10375381098e-06 1.44748737342 1.10378556911e-06 1.2 1.10381732724e-06 0.952512626586 1.10384908537e-06 0.85 1.1038808435e-06 0.952512626584 1.10391260163e-06 1.2 1.10394435976e-06 1.44748737342 1.10397611789e-06 1.55 1.10400787602e-06 1.44748737341 1.10403963415e-06 1.2 1.10407139228e-06 0.952512626585 1.10410315041e-06 0.85 1.10413490854e-06 0.952512626585 1.10416666667e-06 1.2 1.1041984248e-06 1.44748737342 1.10423018293e-06 1.55 1.10426194106e-06 1.44748737342 1.10429369919e-06 1.2 1.10432545732e-06 0.952512626585 1.10435721545e-06 0.85 1.10438897358e-06 0.952512626584 1.10442073171e-06 1.2 1.10445248984e-06 1.44748737342 1.10448424797e-06 1.55 1.1045160061e-06 1.44748737342 1.10454776423e-06 1.2 1.10457952236e-06 0.952512626584 1.10461128049e-06 0.85 1.10464303862e-06 0.952512626585 1.10467479675e-06 1.2 1.10470655488e-06 1.44748737342 1.10473831301e-06 1.55 1.10477007114e-06 1.44748737341 1.10480182927e-06 1.2 1.1048335874e-06 0.952512626585 1.10486534553e-06 0.85 1.10489710366e-06 0.952512626585 1.10492886179e-06 1.2 1.10496061992e-06 1.44748737341 1.10499237805e-06 1.55 1.10502413618e-06 1.44748737342 1.10505589431e-06 1.2 1.10508765244e-06 0.952512626585 1.10511941057e-06 0.85 1.1051511687e-06 0.952512626584 1.10518292683e-06 1.2 1.10521468496e-06 1.44748737342 1.10524644309e-06 1.55 1.10527820122e-06 1.44748737341 1.10530995935e-06 1.2 1.10534171748e-06 0.952512626585 1.10537347561e-06 0.85 1.10540523374e-06 0.952512626585 1.10543699187e-06 1.2 1.10546875e-06 1.44748737341 1.10550050813e-06 1.55 1.10553226626e-06 1.44748737342 1.10556402439e-06 1.2 1.10559578252e-06 0.952512626584 1.10562754065e-06 0.85 1.10565929878e-06 0.952512626584 1.10569105691e-06 1.2 1.10572281504e-06 1.44748737342 1.10575457317e-06 1.55 1.1057863313e-06 1.44748737342 1.10581808943e-06 1.2 1.10584984756e-06 0.952512626585 1.10588160569e-06 0.85 1.10591336382e-06 0.952512626585 1.10594512195e-06 1.2 1.10597688008e-06 1.44748737342 1.10600863821e-06 1.55 1.10604039634e-06 1.44748737341 1.10607215447e-06 1.2 1.1061039126e-06 0.952512626585 1.10613567073e-06 0.85 1.10616742886e-06 0.952512626585 1.10619918699e-06 1.2 1.10623094512e-06 1.44748737342 1.10626270325e-06 1.55 1.10629446138e-06 1.44748737342 1.10632621951e-06 1.2 1.10635797764e-06 0.952512626585 1.10638973577e-06 0.85 1.1064214939e-06 0.952512626584 1.10645325203e-06 1.2 1.10648501016e-06 1.44748737341 1.10651676829e-06 1.55 1.10654852642e-06 1.44748737341 1.10658028455e-06 1.2 1.10661204268e-06 0.952512626585 1.10664380081e-06 0.85 1.10667555894e-06 0.952512626585 1.10670731707e-06 1.2 1.1067390752e-06 1.44748737342 1.10677083333e-06 1.55 1.10680259146e-06 1.44748737342 1.10683434959e-06 1.2 1.10686610772e-06 0.952512626585 1.10689786585e-06 0.85 1.10692962398e-06 0.952512626584 1.10696138211e-06 1.2 1.10699314024e-06 1.44748737342 1.10702489837e-06 1.55 1.1070566565e-06 1.44748737342 1.10708841463e-06 1.2 1.10712017276e-06 0.952512626585 1.10715193089e-06 0.85 1.10718368902e-06 0.952512626585 1.10721544715e-06 1.2 1.10724720528e-06 1.44748737342 1.10727896341e-06 1.55 1.10731072154e-06 1.44748737342 1.10734247967e-06 1.2 1.1073742378e-06 0.952512626584 1.10740599593e-06 0.85 1.10743775407e-06 0.952512626585 1.1074695122e-06 1.2 1.10750127033e-06 1.44748737342 1.10753302846e-06 1.55 1.10756478659e-06 1.44748737342 1.10759654472e-06 1.2 1.10762830285e-06 0.952512626585 1.10766006098e-06 0.85 1.10769181911e-06 0.952512626584 1.10772357724e-06 1.2 1.10775533537e-06 1.44748737341 1.1077870935e-06 1.55 1.10781885163e-06 1.44748737341 1.10785060976e-06 1.2 1.10788236789e-06 0.952512626584 1.10791412602e-06 0.85 1.10794588415e-06 0.952512626585 1.10797764228e-06 1.2 1.10800940041e-06 1.44748737342 1.10804115854e-06 1.55 1.10807291667e-06 1.44748737342 1.1081046748e-06 1.2 1.10813643293e-06 0.952512626585 1.10816819106e-06 0.85 1.10819994919e-06 0.952512626584 1.10823170732e-06 1.2 1.10826346545e-06 1.44748737341 1.10829522358e-06 1.55 1.10832698171e-06 1.44748737342 1.10835873984e-06 1.2 1.10839049797e-06 0.952512626585 1.1084222561e-06 0.85 1.10845401423e-06 0.952512626585 1.10848577236e-06 1.2 1.10851753049e-06 1.44748737342 1.10854928862e-06 1.55 1.10858104675e-06 1.44748737342 1.10861280488e-06 1.2 1.10864456301e-06 0.952512626584 1.10867632114e-06 0.85 1.10870807927e-06 0.952512626584 1.1087398374e-06 1.2 1.10877159553e-06 1.44748737342 1.10880335366e-06 1.55 1.10883511179e-06 1.44748737342 1.10886686992e-06 1.2 1.10889862805e-06 0.952512626585 1.10893038618e-06 0.85 1.10896214431e-06 0.952512626585 1.10899390244e-06 1.2 1.10902566057e-06 1.44748737341 1.1090574187e-06 1.55 1.10908917683e-06 1.44748737341 1.10912093496e-06 1.2 1.10915269309e-06 0.952512626584 1.10918445122e-06 0.85 1.10921620935e-06 0.952512626585 1.10924796748e-06 1.2 1.10927972561e-06 1.44748737342 1.10931148374e-06 1.55 1.10934324187e-06 1.44748737342 1.109375e-06 1.2 1.10940675813e-06 0.952512626585 1.10943851626e-06 0.85 1.10947027439e-06 0.952512626585 1.10950203252e-06 1.2 1.10953379065e-06 1.44748737341 1.10956554878e-06 1.55 1.10959730691e-06 1.44748737342 1.10962906504e-06 1.2 1.10966082317e-06 0.952512626585 1.1096925813e-06 0.85 1.10972433943e-06 0.952512626584 1.10975609756e-06 1.2 1.10978785569e-06 1.44748737342 1.10981961382e-06 1.55 1.10985137195e-06 1.44748737342 1.10988313008e-06 1.2 1.10991488821e-06 0.952512626584 1.10994664634e-06 0.85 1.10997840447e-06 0.952512626584 1.1100101626e-06 1.2 1.11004192073e-06 1.44748737342 1.11007367886e-06 1.55 1.11010543699e-06 1.44748737342 1.11013719512e-06 1.2 1.11016895325e-06 0.952512626585 1.11020071138e-06 0.85 1.11023246951e-06 0.952512626585 1.11026422764e-06 1.2 1.11029598577e-06 1.44748737341 1.1103277439e-06 1.55 1.11035950203e-06 1.44748737342 1.11039126016e-06 1.2 1.11042301829e-06 0.952512626584 1.11045477642e-06 0.85 1.11048653455e-06 0.952512626585 1.11051829268e-06 1.2 1.11055005081e-06 1.44748737342 1.11058180894e-06 1.55 1.11061356707e-06 1.44748737341 1.1106453252e-06 1.2 1.11067708333e-06 0.952512626585 1.11070884146e-06 0.85 1.11074059959e-06 0.952512626585 1.11077235772e-06 1.2 1.11080411585e-06 1.44748737341 1.11083587398e-06 1.55 1.11086763211e-06 1.44748737342 1.11089939024e-06 1.2 1.11093114837e-06 0.952512626586 1.1109629065e-06 0.85 1.11099466463e-06 0.952512626584 1.11102642276e-06 1.2 1.11105818089e-06 1.44748737342 1.11108993902e-06 1.55 1.11112169715e-06 1.44748737342 1.11115345528e-06 1.2 1.11118521341e-06 0.952512626584 1.11121697154e-06 0.85 1.11124872967e-06 0.952512626585 1.1112804878e-06 1.2 1.11131224593e-06 1.44748737342 1.11134400407e-06 1.55 1.1113757622e-06 1.44748737342 1.11140752033e-06 1.2 1.11143927846e-06 0.952512626585 1.11147103659e-06 0.85 1.11150279472e-06 0.952512626584 1.11153455285e-06 1.2 1.11156631098e-06 1.44748737341 1.11159806911e-06 1.55 1.11162982724e-06 1.44748737342 1.11166158537e-06 1.2 1.1116933435e-06 0.952512626584 1.11172510163e-06 0.85 1.11175685976e-06 0.952512626586 1.11178861789e-06 1.2 1.11182037602e-06 1.44748737342 1.11185213415e-06 1.55 1.11188389228e-06 1.44748737341 1.11191565041e-06 1.2 1.11194740854e-06 0.952512626585 1.11197916667e-06 0.85 1.1120109248e-06 0.952512626585 1.11204268293e-06 1.2 1.11207444106e-06 1.44748737341 1.11210619919e-06 1.55 1.11213795732e-06 1.44748737342 1.11216971545e-06 1.2 1.11220147358e-06 0.952512626586 1.11223323171e-06 0.85 1.11226498984e-06 0.952512626584 1.11229674797e-06 1.2 1.1123285061e-06 1.44748737342 1.11236026423e-06 1.55 1.11239202236e-06 1.44748737341 1.11242378049e-06 1.2 1.11245553862e-06 0.952512626585 1.11248729675e-06 0.85 1.11251905488e-06 0.952512626585 1.11255081301e-06 1.2 1.11258257114e-06 1.44748737342 1.11261432927e-06 1.55 1.1126460874e-06 1.44748737342 1.11267784553e-06 1.2 1.11270960366e-06 0.952512626585 1.11274136179e-06 0.85 1.11277311992e-06 0.952512626584 1.11280487805e-06 1.2 1.11283663618e-06 1.44748737342 1.11286839431e-06 1.55 1.11290015244e-06 1.44748737342 1.11293191057e-06 1.2 1.1129636687e-06 0.952512626584 1.11299542683e-06 0.85 1.11302718496e-06 0.952512626585 1.11305894309e-06 1.2 1.11309070122e-06 1.44748737342 1.11312245935e-06 1.55 1.11315421748e-06 1.44748737341 1.11318597561e-06 1.2 1.11321773374e-06 0.952512626585 1.11324949187e-06 0.85 1.11328125e-06 0.952512626585 1.11331300813e-06 1.2 1.11334476626e-06 1.44748737341 1.11337652439e-06 1.55 1.11340828252e-06 1.44748737342 1.11344004065e-06 1.2 1.11347179878e-06 0.952512626585 1.11350355691e-06 0.85 1.11353531504e-06 0.952512626584 1.11356707317e-06 1.2 1.1135988313e-06 1.44748737341 1.11363058943e-06 1.55 1.11366234756e-06 1.44748737341 1.11369410569e-06 1.2 1.11372586382e-06 0.952512626585 1.11375762195e-06 0.85 1.11378938008e-06 0.952512626585 1.11382113821e-06 1.2 1.11385289634e-06 1.44748737341 1.11388465447e-06 1.55 1.1139164126e-06 1.44748737342 1.11394817073e-06 1.2 1.11397992886e-06 0.952512626584 1.11401168699e-06 0.85 1.11404344512e-06 0.952512626584 1.11407520325e-06 1.2 1.11410696138e-06 1.44748737342 1.11413871951e-06 1.55 1.11417047764e-06 1.44748737342 1.11420223577e-06 1.2 1.1142339939e-06 0.952512626585 1.11426575203e-06 0.85 1.11429751016e-06 0.952512626585 1.11432926829e-06 1.2 1.11436102642e-06 1.44748737342 1.11439278455e-06 1.55 1.11442454268e-06 1.44748737342 1.11445630081e-06 1.2 1.11448805894e-06 0.952512626584 1.11451981707e-06 0.85 1.1145515752e-06 0.952512626585 1.11458333333e-06 1.2 1.11461509146e-06 1.44748737342 1.11464684959e-06 1.55 1.11467860772e-06 1.44748737342 1.11471036585e-06 1.2 1.11474212398e-06 0.952512626585 1.11477388211e-06 0.85 1.11480564024e-06 0.952512626584 1.11483739837e-06 1.2 1.1148691565e-06 1.44748737341 1.11490091463e-06 1.55 1.11493267276e-06 1.44748737341 1.11496443089e-06 1.2 1.11499618902e-06 0.952512626585 1.11502794715e-06 0.85 1.11505970528e-06 0.952512626585 1.11509146341e-06 1.2 1.11512322154e-06 1.44748737342 1.11515497967e-06 1.55 1.1151867378e-06 1.44748737342 1.11521849593e-06 1.2 1.11525025407e-06 0.952512626585 1.1152820122e-06 0.85 1.11531377033e-06 0.952512626584 1.11534552846e-06 1.2 1.11537728659e-06 1.44748737342 1.11540904472e-06 1.55 1.11544080285e-06 1.44748737342 1.11547256098e-06 1.2 1.11550431911e-06 0.952512626585 1.11553607724e-06 0.85 1.11556783537e-06 0.952512626585 1.1155995935e-06 1.2 1.11563135163e-06 1.44748737342 1.11566310976e-06 1.55 1.11569486789e-06 1.44748737342 1.11572662602e-06 1.2 1.11575838415e-06 0.952512626584 1.11579014228e-06 0.85 1.11582190041e-06 0.952512626585 1.11585365854e-06 1.2 1.11588541667e-06 1.44748737342 1.1159171748e-06 1.55 1.11594893293e-06 1.44748737342 1.11598069106e-06 1.2 1.11601244919e-06 0.952512626585 1.11604420732e-06 0.85 1.11607596545e-06 0.952512626584 1.11610772358e-06 1.2 1.11613948171e-06 1.44748737341 1.11617123984e-06 1.55 1.11620299797e-06 1.44748737341 1.1162347561e-06 1.2 1.11626651423e-06 0.952512626584 1.11629827236e-06 0.85 1.11633003049e-06 0.952512626585 1.11636178862e-06 1.2 1.11639354675e-06 1.44748737342 1.11642530488e-06 1.55 1.11645706301e-06 1.44748737342 1.11648882114e-06 1.2 1.11652057927e-06 0.952512626585 1.1165523374e-06 0.85 1.11658409553e-06 0.952512626584 1.11661585366e-06 1.2 1.11664761179e-06 1.44748737341 1.11667936992e-06 1.55 1.11671112805e-06 1.44748737342 1.11674288618e-06 1.2 1.11677464431e-06 0.952512626585 1.11680640244e-06 0.85 1.11683816057e-06 0.952512626585 1.1168699187e-06 1.2 1.11690167683e-06 1.44748737342 1.11693343496e-06 1.55 1.11696519309e-06 1.44748737342 1.11699695122e-06 1.2 1.11702870935e-06 0.952512626584 1.11706046748e-06 0.85 1.11709222561e-06 0.952512626584 1.11712398374e-06 1.2 1.11715574187e-06 1.44748737342 1.1171875e-06 1.55 1.11721925813e-06 1.44748737342 1.11725101626e-06 1.2 1.11728277439e-06 0.952512626585 1.11731453252e-06 0.85 1.11734629065e-06 0.952512626585 1.11737804878e-06 1.2 1.11740980691e-06 1.44748737341 1.11744156504e-06 1.55 1.11747332317e-06 1.44748737341 1.1175050813e-06 1.2 1.11753683943e-06 0.952512626584 1.11756859756e-06 0.85 1.11760035569e-06 0.952512626585 1.11763211382e-06 1.2 1.11766387195e-06 1.44748737342 1.11769563008e-06 1.55 1.11772738821e-06 1.44748737342 1.11775914634e-06 1.2 1.11779090447e-06 0.952512626585 1.1178226626e-06 0.85 1.11785442073e-06 0.952512626585 1.11788617886e-06 1.2 1.11791793699e-06 1.44748737341 1.11794969512e-06 1.55 1.11798145325e-06 1.44748737342 1.11801321138e-06 1.2 1.11804496951e-06 0.952512626585 1.11807672764e-06 0.85 1.11810848577e-06 0.952512626584 1.1181402439e-06 1.2 1.11817200203e-06 1.44748737342 1.11820376016e-06 1.55 1.11823551829e-06 1.44748737342 1.11826727642e-06 1.2 1.11829903455e-06 0.952512626584 1.11833079268e-06 0.85 1.11836255081e-06 0.952512626584 1.11839430894e-06 1.2 1.11842606707e-06 1.44748737342 1.1184578252e-06 1.55 1.11848958333e-06 1.44748737342 1.11852134146e-06 1.2 1.11855309959e-06 0.952512626585 1.11858485772e-06 0.85 1.11861661585e-06 0.952512626585 1.11864837398e-06 1.2 1.11868013211e-06 1.44748737341 1.11871189024e-06 1.55 1.11874364837e-06 1.44748737342 1.1187754065e-06 1.2 1.11880716463e-06 0.952512626584 1.11883892276e-06 0.85 1.11887068089e-06 0.952512626585 1.11890243902e-06 1.2 1.11893419715e-06 1.44748737342 1.11896595528e-06 1.55 1.11899771341e-06 1.44748737341 1.11902947154e-06 1.2 1.11906122967e-06 0.952512626585 1.1190929878e-06 0.85 1.11912474593e-06 0.952512626585 1.11915650407e-06 1.2 1.1191882622e-06 1.44748737341 1.11922002033e-06 1.55 1.11925177846e-06 1.44748737342 1.11928353659e-06 1.2 1.11931529472e-06 0.952512626586 1.11934705285e-06 0.85 1.11937881098e-06 0.952512626584 1.11941056911e-06 1.2 1.11944232724e-06 1.44748737342 1.11947408537e-06 1.55 1.1195058435e-06 1.44748737342 1.11953760163e-06 1.2 1.11956935976e-06 0.952512626584 1.11960111789e-06 0.85 1.11963287602e-06 0.952512626585 1.11966463415e-06 1.2 1.11969639228e-06 1.44748737342 1.11972815041e-06 1.55 1.11975990854e-06 1.44748737342 1.11979166667e-06 1.2 1.1198234248e-06 0.952512626585 1.11985518293e-06 0.85 1.11988694106e-06 0.952512626584 1.11991869919e-06 1.2 1.11995045732e-06 1.44748737341 1.11998221545e-06 1.55 1.12001397358e-06 1.44748737342 1.12004573171e-06 1.2 1.12007748984e-06 0.952512626584 1.12010924797e-06 0.85 1.1201410061e-06 0.952512626586 1.12017276423e-06 1.2 1.12020452236e-06 1.44748737342 1.12023628049e-06 1.55 1.12026803862e-06 1.44748737341 1.12029979675e-06 1.2 1.12033155488e-06 0.952512626585 1.12036331301e-06 0.85 1.12039507114e-06 0.952512626585 1.12042682927e-06 1.2 1.1204585874e-06 1.44748737341 1.12049034553e-06 1.55 1.12052210366e-06 1.44748737342 1.12055386179e-06 1.2 1.12058561992e-06 0.952512626585 1.12061737805e-06 0.85 1.12064913618e-06 0.952512626584 1.12068089431e-06 1.2 1.12071265244e-06 1.44748737342 1.12074441057e-06 1.55 1.1207761687e-06 1.44748737341 1.12080792683e-06 1.2 1.12083968496e-06 0.952512626585 1.12087144309e-06 0.85 1.12090320122e-06 0.952512626585 1.12093495935e-06 1.2 1.12096671748e-06 1.44748737342 1.12099847561e-06 1.55 1.12103023374e-06 1.44748737342 1.12106199187e-06 1.2 1.12109375e-06 0.952512626585 1.12112550813e-06 0.85 1.12115726626e-06 0.952512626584 1.12118902439e-06 1.2 1.12122078252e-06 1.44748737342 1.12125254065e-06 1.55 1.12128429878e-06 1.44748737342 1.12131605691e-06 1.2 1.12134781504e-06 0.952512626584 1.12137957317e-06 0.85 1.1214113313e-06 0.952512626585 1.12144308943e-06 1.2 1.12147484756e-06 1.44748737342 1.12150660569e-06 1.55 1.12153836382e-06 1.44748737341 1.12157012195e-06 1.2 1.12160188008e-06 0.952512626585 1.12163363821e-06 0.85 1.12166539634e-06 0.952512626585 1.12169715447e-06 1.2 1.1217289126e-06 1.44748737342 1.12176067073e-06 1.55 1.12179242886e-06 1.44748737342 1.12182418699e-06 1.2 1.12185594512e-06 0.952512626585 1.12188770325e-06 0.85 1.12191946138e-06 0.952512626584 1.12195121951e-06 1.2 1.12198297764e-06 1.44748737341 1.12201473577e-06 1.55 1.1220464939e-06 1.44748737341 1.12207825203e-06 1.2 1.12211001016e-06 0.952512626585 1.12214176829e-06 0.85 1.12217352642e-06 0.952512626585 1.12220528455e-06 1.2 1.12223704268e-06 1.44748737341 1.12226880081e-06 1.55 1.12230055894e-06 1.44748737342 1.12233231707e-06 1.2 1.1223640752e-06 0.952512626584 1.12239583333e-06 0.85 1.12242759146e-06 0.952512626584 1.12245934959e-06 1.2 1.12249110772e-06 1.44748737342 1.12252286585e-06 1.55 1.12255462398e-06 1.44748737342 1.12258638211e-06 1.2 1.12261814024e-06 0.952512626585 1.12264989837e-06 0.85 1.1226816565e-06 0.952512626585 1.12271341463e-06 1.2 1.12274517276e-06 1.44748737342 1.12277693089e-06 1.55 1.12280868902e-06 1.44748737342 1.12284044715e-06 1.2 1.12287220528e-06 0.952512626584 1.12290396341e-06 0.85 1.12293572154e-06 0.952512626585 1.12296747967e-06 1.2 1.1229992378e-06 1.44748737342 1.12303099593e-06 1.55 1.12306275407e-06 1.44748737342 1.1230945122e-06 1.2 1.12312627033e-06 0.952512626585 1.12315802846e-06 0.85 1.12318978659e-06 0.952512626584 1.12322154472e-06 1.2 1.12325330285e-06 1.44748737341 1.12328506098e-06 1.55 1.12331681911e-06 1.44748737341 1.12334857724e-06 1.2 1.12338033537e-06 0.952512626585 1.1234120935e-06 0.85 1.12344385163e-06 0.952512626585 1.12347560976e-06 1.2 1.12350736789e-06 1.44748737342 1.12353912602e-06 1.55 1.12357088415e-06 1.44748737342 1.12360264228e-06 1.2 1.12363440041e-06 0.952512626585 1.12366615854e-06 0.85 1.12369791667e-06 0.952512626584 1.1237296748e-06 1.2 1.12376143293e-06 1.44748737342 1.12379319106e-06 1.55 1.12382494919e-06 1.44748737342 1.12385670732e-06 1.2 1.12388846545e-06 0.952512626585 1.12392022358e-06 0.85 1.12395198171e-06 0.952512626585 1.12398373984e-06 1.2 1.12401549797e-06 1.44748737342 1.1240472561e-06 1.55 1.12407901423e-06 1.44748737342 1.12411077236e-06 1.2 1.12414253049e-06 0.952512626584 1.12417428862e-06 0.85 1.12420604675e-06 0.952512626585 1.12423780488e-06 1.2 1.12426956301e-06 1.44748737342 1.12430132114e-06 1.55 1.12433307927e-06 1.44748737342 1.1243648374e-06 1.2 1.12439659553e-06 0.952512626585 1.12442835366e-06 0.85 1.12446011179e-06 0.952512626584 1.12449186992e-06 1.2 1.12452362805e-06 1.44748737341 1.12455538618e-06 1.55 1.12458714431e-06 1.44748737341 1.12461890244e-06 1.2 1.12465066057e-06 0.952512626584 1.1246824187e-06 0.85 1.12471417683e-06 0.952512626585 1.12474593496e-06 1.2 1.12477769309e-06 1.44748737342 1.12480945122e-06 1.55 1.12484120935e-06 1.44748737342 1.12487296748e-06 1.2 1.12490472561e-06 0.952512626585 1.12493648374e-06 0.85 1.12496824187e-06 0.952512626584 1.125e-06 1.2 1.12503175813e-06 1.44748737341 1.12506351626e-06 1.55 1.12509527439e-06 1.44748737342 1.12512703252e-06 1.2 1.12515879065e-06 0.952512626585 1.12519054878e-06 0.85 1.12522230691e-06 0.952512626585 1.12525406504e-06 1.2 1.12528582317e-06 1.44748737342 1.1253175813e-06 1.55 1.12534933943e-06 1.44748737342 1.12538109756e-06 1.2 1.12541285569e-06 0.952512626584 1.12544461382e-06 0.85 1.12547637195e-06 0.952512626584 1.12550813008e-06 1.2 1.12553988821e-06 1.44748737342 1.12557164634e-06 1.55 1.12560340447e-06 1.44748737342 1.1256351626e-06 1.2 1.12566692073e-06 0.952512626585 1.12569867886e-06 0.85 1.12573043699e-06 0.952512626585 1.12576219512e-06 1.2 1.12579395325e-06 1.44748737341 1.12582571138e-06 1.55 1.12585746951e-06 1.44748737342 1.12588922764e-06 1.2 1.12592098577e-06 0.952512626584 1.1259527439e-06 0.85 1.12598450203e-06 0.952512626585 1.12601626016e-06 1.2 1.12604801829e-06 1.44748737342 1.12607977642e-06 1.55 1.12611153455e-06 1.44748737342 1.12614329268e-06 1.2 1.12617505081e-06 0.952512626585 1.12620680894e-06 0.85 1.12623856707e-06 0.952512626585 1.1262703252e-06 1.2 1.12630208333e-06 1.44748737341 1.12633384146e-06 1.55 1.12636559959e-06 1.44748737342 1.12639735772e-06 1.2 1.12642911585e-06 0.952512626585 1.12646087398e-06 0.85 1.12649263211e-06 0.952512626584 1.12652439024e-06 1.2 1.12655614837e-06 1.44748737342 1.1265879065e-06 1.55 1.12661966463e-06 1.44748737342 1.12665142276e-06 1.2 1.12668318089e-06 0.952512626584 1.12671493902e-06 0.85 1.12674669715e-06 0.952512626585 1.12677845528e-06 1.2 1.12681021341e-06 1.44748737342 1.12684197154e-06 1.55 1.12687372967e-06 1.44748737342 1.1269054878e-06 1.2 1.12693724593e-06 0.952512626585 1.12696900407e-06 0.85 1.1270007622e-06 0.952512626585 1.12703252033e-06 1.2 1.12706427846e-06 1.44748737341 1.12709603659e-06 1.55 1.12712779472e-06 1.44748737342 1.12715955285e-06 1.2 1.12719131098e-06 0.952512626584 1.12722306911e-06 0.85 1.12725482724e-06 0.952512626585 1.12728658537e-06 1.2 1.1273183435e-06 1.44748737342 1.12735010163e-06 1.55 1.12738185976e-06 1.44748737341 1.12741361789e-06 1.2 1.12744537602e-06 0.952512626585 1.12747713415e-06 0.85 1.12750889228e-06 0.952512626585 1.12754065041e-06 1.2 1.12757240854e-06 1.44748737341 1.12760416667e-06 1.55 1.1276359248e-06 1.44748737342 1.12766768293e-06 1.2 1.12769944106e-06 0.952512626586 1.12773119919e-06 0.85 1.12776295732e-06 0.952512626584 1.12779471545e-06 1.2 1.12782647358e-06 1.44748737342 1.12785823171e-06 1.55 1.12788998984e-06 1.44748737341 1.12792174797e-06 1.2 1.1279535061e-06 0.952512626584 1.12798526423e-06 0.85 1.12801702236e-06 0.952512626585 1.12804878049e-06 1.2 1.12808053862e-06 1.44748737342 1.12811229675e-06 1.55 1.12814405488e-06 1.44748737342 1.12817581301e-06 1.2 1.12820757114e-06 0.952512626585 1.12823932927e-06 0.85 1.1282710874e-06 0.952512626584 1.12830284553e-06 1.2 1.12833460366e-06 1.44748737341 1.12836636179e-06 1.55 1.12839811992e-06 1.44748737342 1.12842987805e-06 1.2 1.12846163618e-06 0.952512626584 1.12849339431e-06 0.85 1.12852515244e-06 0.952512626586 1.12855691057e-06 1.2 1.1285886687e-06 1.44748737342 1.12862042683e-06 1.55 1.12865218496e-06 1.44748737341 1.12868394309e-06 1.2 1.12871570122e-06 0.952512626585 1.12874745935e-06 0.85 1.12877921748e-06 0.952512626585 1.12881097561e-06 1.2 1.12884273374e-06 1.44748737341 1.12887449187e-06 1.55 1.12890625e-06 1.44748737342 1.12893800813e-06 1.2 1.12896976626e-06 0.952512626585 1.12900152439e-06 0.85 1.12903328252e-06 0.952512626584 1.12906504065e-06 1.2 1.12909679878e-06 1.44748737342 1.12912855691e-06 1.55 1.12916031504e-06 1.44748737341 1.12919207317e-06 1.2 1.1292238313e-06 0.952512626585 1.12925558943e-06 0.85 1.12928734756e-06 0.952512626585 1.12931910569e-06 1.2 1.12935086382e-06 1.44748737342 1.12938262195e-06 1.55 1.12941438008e-06 1.44748737342 1.12944613821e-06 1.2 1.12947789634e-06 0.952512626585 1.12950965447e-06 0.85 1.1295414126e-06 0.952512626584 1.12957317073e-06 1.2 1.12960492886e-06 1.44748737342 1.12963668699e-06 1.55 1.12966844512e-06 1.44748737342 1.12970020325e-06 1.2 1.12973196138e-06 0.952512626585 1.12976371951e-06 0.85 1.12979547764e-06 0.952512626585 1.12982723577e-06 1.2 1.1298589939e-06 1.44748737342 1.12989075203e-06 1.55 1.12992251016e-06 1.44748737341 1.12995426829e-06 1.2 1.12998602642e-06 0.952512626585 1.13001778455e-06 0.85 1.13004954268e-06 0.952512626585 1.13008130081e-06 1.2 1.13011305894e-06 1.44748737342 1.13014481707e-06 1.55 1.1301765752e-06 1.44748737342 1.13020833333e-06 1.2 1.13024009146e-06 0.952512626585 1.13027184959e-06 0.85 1.13030360772e-06 0.952512626584 1.13033536585e-06 1.2 1.13036712398e-06 1.44748737341 1.13039888211e-06 1.55 1.13043064024e-06 1.44748737341 1.13046239837e-06 1.2 1.1304941565e-06 0.952512626585 1.13052591463e-06 0.85 1.13055767276e-06 0.952512626585 1.13058943089e-06 1.2 1.13062118902e-06 1.44748737341 1.13065294715e-06 1.55 1.13068470528e-06 1.44748737342 1.13071646341e-06 1.2 1.13074822154e-06 0.952512626584 1.13077997967e-06 0.85 1.1308117378e-06 0.952512626584 1.13084349593e-06 1.2 1.13087525407e-06 1.44748737342 1.1309070122e-06 1.55 1.13093877033e-06 1.44748737342 1.13097052846e-06 1.2 1.13100228659e-06 0.952512626585 1.13103404472e-06 0.85 1.13106580285e-06 0.952512626585 1.13109756098e-06 1.2 1.13112931911e-06 1.44748737342 1.13116107724e-06 1.55 1.13119283537e-06 1.44748737342 1.1312245935e-06 1.2 1.13125635163e-06 0.952512626584 1.13128810976e-06 0.85 1.13131986789e-06 0.952512626585 1.13135162602e-06 1.2 1.13138338415e-06 1.44748737342 1.13141514228e-06 1.55 1.13144690041e-06 1.44748737342 1.13147865854e-06 1.2 1.13151041667e-06 0.952512626585 1.1315421748e-06 0.85 1.13157393293e-06 0.952512626584 1.13160569106e-06 1.2 1.13163744919e-06 1.44748737341 1.13166920732e-06 1.55 1.13170096545e-06 1.44748737341 1.13173272358e-06 1.2 1.13176448171e-06 0.952512626585 1.13179623984e-06 0.85 1.13182799797e-06 0.952512626585 1.1318597561e-06 1.2 1.13189151423e-06 1.44748737342 1.13192327236e-06 1.55 1.13195503049e-06 1.44748737342 1.13198678862e-06 1.2 1.13201854675e-06 0.952512626585 1.13205030488e-06 0.85 1.13208206301e-06 0.952512626584 1.13211382114e-06 1.2 1.13214557927e-06 1.44748737342 1.1321773374e-06 1.55 1.13220909553e-06 1.44748737342 1.13224085366e-06 1.2 1.13227261179e-06 0.952512626585 1.13230436992e-06 0.85 1.13233612805e-06 0.952512626585 1.13236788618e-06 1.2 1.13239964431e-06 1.44748737342 1.13243140244e-06 1.55 1.13246316057e-06 1.44748737342 1.1324949187e-06 1.2 1.13252667683e-06 0.952512626584 1.13255843496e-06 0.85 1.13259019309e-06 0.952512626585 1.13262195122e-06 1.2 1.13265370935e-06 1.44748737342 1.13268546748e-06 1.55 1.13271722561e-06 1.44748737342 1.13274898374e-06 1.2 1.13278074187e-06 0.952512626585 1.1328125e-06 0.85 1.13284425813e-06 0.952512626585 1.13287601626e-06 1.2 1.13290777439e-06 1.44748737341 1.13293953252e-06 1.55 1.13297129065e-06 1.44748737341 1.13300304878e-06 1.2 1.13303480691e-06 0.952512626584 1.13306656504e-06 0.85 1.13309832317e-06 0.952512626585 1.1331300813e-06 1.2 1.13316183943e-06 1.44748737342 1.13319359756e-06 1.55 1.13322535569e-06 1.44748737342 1.13325711382e-06 1.2 1.13328887195e-06 0.952512626585 1.13332063008e-06 0.85 1.13335238821e-06 0.952512626584 1.13338414634e-06 1.2 1.13341590447e-06 1.44748737341 1.1334476626e-06 1.55 1.13347942073e-06 1.44748737342 1.13351117886e-06 1.2 1.13354293699e-06 0.952512626585 1.13357469512e-06 0.85 1.13360645325e-06 0.952512626584 1.13363821138e-06 1.2 1.13366996951e-06 1.44748737342 1.13370172764e-06 1.55 1.13373348577e-06 1.44748737342 1.1337652439e-06 1.2 1.13379700203e-06 0.952512626584 1.13382876016e-06 0.85 1.13386051829e-06 0.952512626584 1.13389227642e-06 1.2 1.13392403455e-06 1.44748737342 1.13395579268e-06 1.55 1.13398755081e-06 1.44748737342 1.13401930894e-06 1.2 1.13405106707e-06 0.952512626585 1.1340828252e-06 0.85 1.13411458333e-06 0.952512626585 1.13414634146e-06 1.2 1.13417809959e-06 1.44748737341 1.13420985772e-06 1.55 1.13424161585e-06 1.44748737342 1.13427337398e-06 1.2 1.13430513211e-06 0.952512626584 1.13433689024e-06 0.85 1.13436864837e-06 0.952512626585 1.1344004065e-06 1.2 1.13443216463e-06 1.44748737342 1.13446392276e-06 1.55 1.13449568089e-06 1.44748737342 1.13452743902e-06 1.2 1.13455919715e-06 0.952512626585 1.13459095528e-06 0.85 1.13462271341e-06 0.952512626585 1.13465447154e-06 1.2 1.13468622967e-06 1.44748737341 1.1347179878e-06 1.55 1.13474974593e-06 1.44748737342 1.13478150407e-06 1.2 1.1348132622e-06 0.952512626585 1.13484502033e-06 0.85 1.13487677846e-06 0.952512626584 1.13490853659e-06 1.2 1.13494029472e-06 1.44748737342 1.13497205285e-06 1.55 1.13500381098e-06 1.44748737342 1.13503556911e-06 1.2 1.13506732724e-06 0.952512626584 1.13509908537e-06 0.85 1.1351308435e-06 0.952512626585 1.13516260163e-06 1.2 1.13519435976e-06 1.44748737342 1.13522611789e-06 1.55 1.13525787602e-06 1.44748737342 1.13528963415e-06 1.2 1.13532139228e-06 0.952512626585 1.13535315041e-06 0.85 1.13538490854e-06 0.952512626585 1.13541666667e-06 1.2 1.1354484248e-06 1.44748737341 1.13548018293e-06 1.55 1.13551194106e-06 1.44748737342 1.13554369919e-06 1.2 1.13557545732e-06 0.952512626584 1.13560721545e-06 0.85 1.13563897358e-06 0.952512626585 1.13567073171e-06 1.2 1.13570248984e-06 1.44748737342 1.13573424797e-06 1.55 1.1357660061e-06 1.44748737341 1.13579776423e-06 1.2 1.13582952236e-06 0.952512626585 1.13586128049e-06 0.85 1.13589303862e-06 0.952512626585 1.13592479675e-06 1.2 1.13595655488e-06 1.44748737341 1.13598831301e-06 1.55 1.13602007114e-06 1.44748737342 1.13605182927e-06 1.2 1.1360835874e-06 0.952512626586 1.13611534553e-06 0.85 1.13614710366e-06 0.952512626584 1.13617886179e-06 1.2 1.13621061992e-06 1.44748737342 1.13624237805e-06 1.55 1.13627413618e-06 1.44748737341 1.13630589431e-06 1.2 1.13633765244e-06 0.952512626584 1.13636941057e-06 0.85 1.1364011687e-06 0.952512626585 1.13643292683e-06 1.2 1.13646468496e-06 1.44748737342 1.13649644309e-06 1.55 1.13652820122e-06 1.44748737342 1.13655995935e-06 1.2 1.13659171748e-06 0.952512626585 1.13662347561e-06 0.85 1.13665523374e-06 0.952512626584 1.13668699187e-06 1.2 1.13671875e-06 1.44748737341 1.13675050813e-06 1.55 1.13678226626e-06 1.44748737342 1.13681402439e-06 1.2 1.13684578252e-06 0.952512626584 1.13687754065e-06 0.85 1.13690929878e-06 0.952512626586 1.13694105691e-06 1.2 1.13697281504e-06 1.44748737342 1.13700457317e-06 1.55 1.1370363313e-06 1.44748737341 1.13706808943e-06 1.2 1.13709984756e-06 0.952512626585 1.13713160569e-06 0.85 1.13716336382e-06 0.952512626585 1.13719512195e-06 1.2 1.13722688008e-06 1.44748737341 1.13725863821e-06 1.55 1.13729039634e-06 1.44748737342 1.13732215447e-06 1.2 1.1373539126e-06 0.952512626585 1.13738567073e-06 0.85 1.13741742886e-06 0.952512626584 1.13744918699e-06 1.2 1.13748094512e-06 1.44748737341 1.13751270325e-06 1.55 1.13754446138e-06 1.44748737341 1.13757621951e-06 1.2 1.13760797764e-06 0.952512626585 1.13763973577e-06 0.85 1.1376714939e-06 0.952512626585 1.13770325203e-06 1.2 1.13773501016e-06 1.44748737342 1.13776676829e-06 1.55 1.13779852642e-06 1.44748737342 1.13783028455e-06 1.2 1.13786204268e-06 0.952512626585 1.13789380081e-06 0.85 1.13792555894e-06 0.952512626584 1.13795731707e-06 1.2 1.1379890752e-06 1.44748737342 1.13802083333e-06 1.55 1.13805259146e-06 1.44748737342 1.13808434959e-06 1.2 1.13811610772e-06 0.952512626585 1.13814786585e-06 0.85 1.13817962398e-06 0.952512626585 1.13821138211e-06 1.2 1.13824314024e-06 1.44748737342 1.13827489837e-06 1.55 1.1383066565e-06 1.44748737341 1.13833841463e-06 1.2 1.13837017276e-06 0.952512626585 1.13840193089e-06 0.85 1.13843368902e-06 0.952512626585 1.13846544715e-06 1.2 1.13849720528e-06 1.44748737342 1.13852896341e-06 1.55 1.13856072154e-06 1.44748737342 1.13859247967e-06 1.2 1.1386242378e-06 0.952512626585 1.13865599593e-06 0.85 1.13868775407e-06 0.952512626584 1.1387195122e-06 1.2 1.13875127033e-06 1.44748737341 1.13878302846e-06 1.55 1.13881478659e-06 1.44748737341 1.13884654472e-06 1.2 1.13887830285e-06 0.952512626585 1.13891006098e-06 0.85 1.13894181911e-06 0.952512626585 1.13897357724e-06 1.2 1.13900533537e-06 1.44748737342 1.1390370935e-06 1.55 1.13906885163e-06 1.44748737342 1.13910060976e-06 1.2 1.13913236789e-06 0.952512626584 1.13916412602e-06 0.85 1.13919588415e-06 0.952512626584 1.13922764228e-06 1.2 1.13925940041e-06 1.44748737342 1.13929115854e-06 1.55 1.13932291667e-06 1.44748737342 1.1393546748e-06 1.2 1.13938643293e-06 0.952512626585 1.13941819106e-06 0.85 1.13944994919e-06 0.952512626585 1.13948170732e-06 1.2 1.13951346545e-06 1.44748737342 1.13954522358e-06 1.55 1.13957698171e-06 1.44748737342 1.13960873984e-06 1.2 1.13964049797e-06 0.952512626584 1.1396722561e-06 0.85 1.13970401423e-06 0.952512626585 1.13973577236e-06 1.2 1.13976753049e-06 1.44748737342 1.13979928862e-06 1.55 1.13983104675e-06 1.44748737342 1.13986280488e-06 1.2 1.13989456301e-06 0.952512626585 1.13992632114e-06 0.85 1.13995807927e-06 0.952512626584 1.1399898374e-06 1.2 1.14002159553e-06 1.44748737341 1.14005335366e-06 1.55 1.14008511179e-06 1.44748737341 1.14011686992e-06 1.2 1.14014862805e-06 0.952512626584 1.14018038618e-06 0.85 1.14021214431e-06 0.952512626585 1.14024390244e-06 1.2 1.14027566057e-06 1.44748737342 1.1403074187e-06 1.55 1.14033917683e-06 1.44748737342 1.14037093496e-06 1.2 1.14040269309e-06 0.952512626585 1.14043445122e-06 0.85 1.14046620935e-06 0.952512626584 1.14049796748e-06 1.2 1.14052972561e-06 1.44748737342 1.14056148374e-06 1.55 1.14059324187e-06 1.44748737342 1.140625e-06 1.2 1.14065675813e-06 0.952512626585 1.14068851626e-06 0.85 1.14072027439e-06 0.952512626585 1.14075203252e-06 1.2 1.14078379065e-06 1.44748737342 1.14081554878e-06 1.55 1.14084730691e-06 1.44748737342 1.14087906504e-06 1.2 1.14091082317e-06 0.952512626584 1.1409425813e-06 0.85 1.14097433943e-06 0.952512626585 1.14100609756e-06 1.2 1.14103785569e-06 1.44748737342 1.14106961382e-06 1.55 1.14110137195e-06 1.44748737342 1.14113313008e-06 1.2 1.14116488821e-06 0.952512626585 1.14119664634e-06 0.85 1.14122840447e-06 0.952512626585 1.1412601626e-06 1.2 1.14129192073e-06 1.44748737341 1.14132367886e-06 1.55 1.14135543699e-06 1.44748737342 1.14138719512e-06 1.2 1.14141895325e-06 0.952512626584 1.14145071138e-06 0.85 1.14148246951e-06 0.952512626585 1.14151422764e-06 1.2 1.14154598577e-06 1.44748737342 1.1415777439e-06 1.55 1.14160950203e-06 1.44748737342 1.14164126016e-06 1.2 1.14167301829e-06 0.952512626585 1.14170477642e-06 0.85 1.14173653455e-06 0.952512626584 1.14176829268e-06 1.2 1.14180005081e-06 1.44748737341 1.14183180894e-06 1.55 1.14186356707e-06 1.44748737342 1.1418953252e-06 1.2 1.14192708333e-06 0.952512626585 1.14195884146e-06 0.85 1.14199059959e-06 0.952512626584 1.14202235772e-06 1.2 1.14205411585e-06 1.44748737342 1.14208587398e-06 1.55 1.14211763211e-06 1.44748737342 1.14214939024e-06 1.2 1.14218114837e-06 0.952512626584 1.1422129065e-06 0.85 1.14224466463e-06 0.952512626584 1.14227642276e-06 1.2 1.14230818089e-06 1.44748737342 1.14233993902e-06 1.55 1.14237169715e-06 1.44748737342 1.14240345528e-06 1.2 1.14243521341e-06 0.952512626585 1.14246697154e-06 0.85 1.14249872967e-06 0.952512626585 1.1425304878e-06 1.2 1.14256224593e-06 1.44748737341 1.14259400407e-06 1.55 1.1426257622e-06 1.44748737342 1.14265752033e-06 1.2 1.14268927846e-06 0.952512626584 1.14272103659e-06 0.85 1.14275279472e-06 0.952512626585 1.14278455285e-06 1.2 1.14281631098e-06 1.44748737342 1.14284806911e-06 1.55 1.14287982724e-06 1.44748737342 1.14291158537e-06 1.2 1.1429433435e-06 0.952512626585 1.14297510163e-06 0.85 1.14300685976e-06 0.952512626585 1.14303861789e-06 1.2 1.14307037602e-06 1.44748737341 1.14310213415e-06 1.55 1.14313389228e-06 1.44748737342 1.14316565041e-06 1.2 1.14319740854e-06 0.952512626585 1.14322916667e-06 0.85 1.1432609248e-06 0.952512626584 1.14329268293e-06 1.2 1.14332444106e-06 1.44748737342 1.14335619919e-06 1.55 1.14338795732e-06 1.44748737342 1.14341971545e-06 1.2 1.14345147358e-06 0.952512626584 1.14348323171e-06 0.85 1.14351498984e-06 0.952512626585 1.14354674797e-06 1.2 1.1435785061e-06 1.44748737342 1.14361026423e-06 1.55 1.14364202236e-06 1.44748737342 1.14367378049e-06 1.2 1.14370553862e-06 0.952512626585 1.14373729675e-06 0.85 1.14376905488e-06 0.952512626585 1.14380081301e-06 1.2 1.14383257114e-06 1.44748737341 1.14386432927e-06 1.55 1.1438960874e-06 1.44748737342 1.14392784553e-06 1.2 1.14395960366e-06 0.952512626584 1.14399136179e-06 0.85 1.14402311992e-06 0.952512626586 1.14405487805e-06 1.2 1.14408663618e-06 1.44748737342 1.14411839431e-06 1.55 1.14415015244e-06 1.44748737341 1.14418191057e-06 1.2 1.1442136687e-06 0.952512626585 1.14424542683e-06 0.85 1.14427718496e-06 0.952512626585 1.14430894309e-06 1.2 1.14434070122e-06 1.44748737341 1.14437245935e-06 1.55 1.14440421748e-06 1.44748737342 1.14443597561e-06 1.2 1.14446773374e-06 0.952512626586 1.14449949187e-06 0.85 1.14453125e-06 0.952512626584 1.14456300813e-06 1.2 1.14459476626e-06 1.44748737342 1.14462652439e-06 1.55 1.14465828252e-06 1.44748737341 1.14469004065e-06 1.2 1.14472179878e-06 0.952512626585 1.14475355691e-06 0.85 1.14478531504e-06 0.952512626585 1.14481707317e-06 1.2 1.1448488313e-06 1.44748737342 1.14488058943e-06 1.55 1.14491234756e-06 1.44748737342 1.14494410569e-06 1.2 1.14497586382e-06 0.952512626585 1.14500762195e-06 0.85 1.14503938008e-06 0.952512626584 1.14507113821e-06 1.2 1.14510289634e-06 1.44748737342 1.14513465447e-06 1.55 1.1451664126e-06 1.44748737342 1.14519817073e-06 1.2 1.14522992886e-06 0.952512626585 1.14526168699e-06 0.85 1.14529344512e-06 0.952512626586 1.14532520325e-06 1.2 1.14535696138e-06 1.44748737342 1.14538871951e-06 1.55 1.14542047764e-06 1.44748737341 1.14545223577e-06 1.2 1.1454839939e-06 0.952512626585 1.14551575203e-06 0.85 1.14554751016e-06 0.952512626585 1.14557926829e-06 1.2 1.14561102642e-06 1.44748737341 1.14564278455e-06 1.55 1.14567454268e-06 1.44748737342 1.14570630081e-06 1.2 1.14573805894e-06 0.952512626585 1.14576981707e-06 0.85 1.1458015752e-06 0.952512626584 1.14583333333e-06 1.2 1.14586509146e-06 1.44748737341 1.14589684959e-06 1.55 1.14592860772e-06 1.44748737341 1.14596036585e-06 1.2 1.14599212398e-06 0.952512626585 1.14602388211e-06 0.85 1.14605564024e-06 0.952512626585 1.14608739837e-06 1.2 1.1461191565e-06 1.44748737342 1.14615091463e-06 1.55 1.14618267276e-06 1.44748737342 1.14621443089e-06 1.2 1.14624618902e-06 0.952512626584 1.14627794715e-06 0.85 1.14630970528e-06 0.952512626584 1.14634146341e-06 1.2 1.14637322154e-06 1.44748737342 1.14640497967e-06 1.55 1.1464367378e-06 1.44748737342 1.14646849593e-06 1.2 1.14650025407e-06 0.952512626585 1.1465320122e-06 0.85 1.14656377033e-06 0.952512626585 1.14659552846e-06 1.2 1.14662728659e-06 1.44748737342 1.14665904472e-06 1.55 1.14669080285e-06 1.44748737341 1.14672256098e-06 1.2 1.14675431911e-06 0.952512626585 1.14678607724e-06 0.85 1.14681783537e-06 0.952512626585 1.1468495935e-06 1.2 1.14688135163e-06 1.44748737342 1.14691310976e-06 1.55 1.14694486789e-06 1.44748737342 1.14697662602e-06 1.2 1.14700838415e-06 0.952512626585 1.14704014228e-06 0.85 1.14707190041e-06 0.952512626584 1.14710365854e-06 1.2 1.14713541667e-06 1.44748737341 1.1471671748e-06 1.55 1.14719893293e-06 1.44748737341 1.14723069106e-06 1.2 1.14726244919e-06 0.952512626585 1.14729420732e-06 0.85 1.14732596545e-06 0.952512626585 1.14735772358e-06 1.2 1.14738948171e-06 1.44748737342 1.14742123984e-06 1.55 1.14745299797e-06 1.44748737342 1.1474847561e-06 1.2 1.14751651423e-06 0.952512626585 1.14754827236e-06 0.85 1.14758003049e-06 0.952512626584 1.14761178862e-06 1.2 1.14764354675e-06 1.44748737342 1.14767530488e-06 1.55 1.14770706301e-06 1.44748737342 1.14773882114e-06 1.2 1.14777057927e-06 0.952512626585 1.1478023374e-06 0.85 1.14783409553e-06 0.952512626585 1.14786585366e-06 1.2 1.14789761179e-06 1.44748737342 1.14792936992e-06 1.55 1.14796112805e-06 1.44748737342 1.14799288618e-06 1.2 1.14802464431e-06 0.952512626584 1.14805640244e-06 0.85 1.14808816057e-06 0.952512626585 1.1481199187e-06 1.2 1.14815167683e-06 1.44748737342 1.14818343496e-06 1.55 1.14821519309e-06 1.44748737342 1.14824695122e-06 1.2 1.14827870935e-06 0.952512626585 1.14831046748e-06 0.85 1.14834222561e-06 0.952512626584 1.14837398374e-06 1.2 1.14840574187e-06 1.44748737341 1.1484375e-06 1.55 1.14846925813e-06 1.44748737341 1.14850101626e-06 1.2 1.14853277439e-06 0.952512626584 1.14856453252e-06 0.85 1.14859629065e-06 0.952512626585 1.14862804878e-06 1.2 1.14865980691e-06 1.44748737342 1.14869156504e-06 1.55 1.14872332317e-06 1.44748737342 1.1487550813e-06 1.2 1.14878683943e-06 0.952512626585 1.14881859756e-06 0.85 1.14885035569e-06 0.952512626584 1.14888211382e-06 1.2 1.14891387195e-06 1.44748737342 1.14894563008e-06 1.55 1.14897738821e-06 1.44748737342 1.14900914634e-06 1.2 1.14904090447e-06 0.952512626585 1.1490726626e-06 0.85 1.14910442073e-06 0.952512626584 1.14913617886e-06 1.2 1.14916793699e-06 1.44748737342 1.14919969512e-06 1.55 1.14923145325e-06 1.44748737342 1.14926321138e-06 1.2 1.14929496951e-06 0.952512626584 1.14932672764e-06 0.85 1.14935848577e-06 0.952512626585 1.1493902439e-06 1.2 1.14942200203e-06 1.44748737342 1.14945376016e-06 1.55 1.14948551829e-06 1.44748737342 1.14951727642e-06 1.2 1.14954903455e-06 0.952512626585 1.14958079268e-06 0.85 1.14961255081e-06 0.952512626585 1.14964430894e-06 1.2 1.14967606707e-06 1.44748737341 1.1497078252e-06 1.55 1.14973958333e-06 1.44748737342 1.14977134146e-06 1.2 1.14980309959e-06 0.952512626584 1.14983485772e-06 0.85 1.14986661585e-06 0.952512626585 1.14989837398e-06 1.2 1.14993013211e-06 1.44748737342 1.14996189024e-06 1.55 1.14999364837e-06 1.44748737342 1.1500254065e-06 1.2 1.15005716463e-06 0.952512626585 1.15008892276e-06 0.85 1.15012068089e-06 0.952512626585 1.15015243902e-06 1.2 1.15018419715e-06 1.44748737341 1.15021595528e-06 1.55 1.15024771341e-06 1.44748737342 1.15027947154e-06 1.2 1.15031122967e-06 0.952512626585 1.1503429878e-06 0.85 1.15037474593e-06 0.952512626584 1.15040650407e-06 1.2 1.1504382622e-06 1.44748737342 1.15047002033e-06 1.55 1.15050177846e-06 1.44748737342 1.15053353659e-06 1.2 1.15056529472e-06 0.952512626584 1.15059705285e-06 0.85 1.15062881098e-06 0.952512626584 1.15066056911e-06 1.2 1.15069232724e-06 1.44748737342 1.15072408537e-06 1.55 1.1507558435e-06 1.44748737342 1.15078760163e-06 1.2 1.15081935976e-06 0.952512626585 1.15085111789e-06 0.85 1.15088287602e-06 0.952512626585 1.15091463415e-06 1.2 1.15094639228e-06 1.44748737341 1.15097815041e-06 1.55 1.15100990854e-06 1.44748737342 1.15104166667e-06 1.2 1.1510734248e-06 0.952512626584 1.15110518293e-06 0.85 1.15113694106e-06 0.952512626585 1.15116869919e-06 1.2 1.15120045732e-06 1.44748737342 1.15123221545e-06 1.55 1.15126397358e-06 1.44748737341 1.15129573171e-06 1.2 1.15132748984e-06 0.952512626585 1.15135924797e-06 0.85 1.1513910061e-06 0.952512626585 1.15142276423e-06 1.2 1.15145452236e-06 1.44748737341 1.15148628049e-06 1.55 1.15151803862e-06 1.44748737342 1.15154979675e-06 1.2 1.15158155488e-06 0.952512626585 1.15161331301e-06 0.85 1.15164507114e-06 0.952512626584 1.15167682927e-06 1.2 1.1517085874e-06 1.44748737342 1.15174034553e-06 1.55 1.15177210366e-06 1.44748737342 1.15180386179e-06 1.2 1.15183561992e-06 0.952512626584 1.15186737805e-06 0.85 1.15189913618e-06 0.952512626585 1.15193089431e-06 1.2 1.15196265244e-06 1.44748737342 1.15199441057e-06 1.55 1.1520261687e-06 1.44748737342 1.15205792683e-06 1.2 1.15208968496e-06 0.952512626585 1.15212144309e-06 0.85 1.15215320122e-06 0.952512626585 1.15218495935e-06 1.2 1.15221671748e-06 1.44748737341 1.15224847561e-06 1.55 1.15228023374e-06 1.44748737342 1.15231199187e-06 1.2 1.15234375e-06 0.952512626584 1.15237550813e-06 0.85 1.15240726626e-06 0.952512626586 1.15243902439e-06 1.2 1.15247078252e-06 1.44748737342 1.15250254065e-06 1.55 1.15253429878e-06 1.44748737341 1.15256605691e-06 1.2 1.15259781504e-06 0.952512626585 1.15262957317e-06 0.85 1.1526613313e-06 0.952512626585 1.15269308943e-06 1.2 1.15272484756e-06 1.44748737341 1.15275660569e-06 1.55 1.15278836382e-06 1.44748737342 1.15282012195e-06 1.2 1.15285188008e-06 0.952512626586 1.15288363821e-06 0.85 1.15291539634e-06 0.952512626584 1.15294715447e-06 1.2 1.1529789126e-06 1.44748737342 1.15301067073e-06 1.55 1.15304242886e-06 1.44748737341 1.15307418699e-06 1.2 1.15310594512e-06 0.952512626585 1.15313770325e-06 0.85 1.15316946138e-06 0.952512626585 1.15320121951e-06 1.2 1.15323297764e-06 1.44748737342 1.15326473577e-06 1.55 1.1532964939e-06 1.44748737342 1.15332825203e-06 1.2 1.15336001016e-06 0.952512626585 1.15339176829e-06 0.85 1.15342352642e-06 0.952512626584 1.15345528455e-06 1.2 1.15348704268e-06 1.44748737342 1.15351880081e-06 1.55 1.15355055894e-06 1.44748737342 1.15358231707e-06 1.2 1.1536140752e-06 0.952512626585 1.15364583333e-06 0.85 1.15367759146e-06 0.952512626585 1.15370934959e-06 1.2 1.15374110772e-06 1.44748737342 1.15377286585e-06 1.55 1.15380462398e-06 1.44748737341 1.15383638211e-06 1.2 1.15386814024e-06 0.952512626585 1.15389989837e-06 0.85 1.1539316565e-06 0.952512626585 1.15396341463e-06 1.2 1.15399517276e-06 1.44748737341 1.15402693089e-06 1.55 1.15405868902e-06 1.44748737342 1.15409044715e-06 1.2 1.15412220528e-06 0.952512626585 1.15415396341e-06 0.85 1.15418572154e-06 0.952512626584 1.15421747967e-06 1.2 1.1542492378e-06 1.44748737341 1.15428099593e-06 1.55 1.15431275407e-06 1.44748737341 1.1543445122e-06 1.2 1.15437627033e-06 0.952512626585 1.15440802846e-06 0.85 1.15443978659e-06 0.952512626585 1.15447154472e-06 1.2 1.15450330285e-06 1.44748737342 1.15453506098e-06 1.55 1.15456681911e-06 1.44748737342 1.15459857724e-06 1.2 1.15463033537e-06 0.952512626584 1.1546620935e-06 0.85 1.15469385163e-06 0.952512626584 1.15472560976e-06 1.2 1.15475736789e-06 1.44748737342 1.15478912602e-06 1.55 1.15482088415e-06 1.44748737342 1.15485264228e-06 1.2 1.15488440041e-06 0.952512626585 1.15491615854e-06 0.85 1.15494791667e-06 0.952512626585 1.1549796748e-06 1.2 1.15501143293e-06 1.44748737342 1.15504319106e-06 1.55 1.15507494919e-06 1.44748737341 1.15510670732e-06 1.2 1.15513846545e-06 0.952512626585 1.15517022358e-06 0.85 1.15520198171e-06 0.952512626585 1.15523373984e-06 1.2 1.15526549797e-06 1.44748737342 1.1552972561e-06 1.55 1.15532901423e-06 1.44748737342 1.15536077236e-06 1.2 1.15539253049e-06 0.952512626585 1.15542428862e-06 0.85 1.15545604675e-06 0.952512626584 1.15548780488e-06 1.2 1.15551956301e-06 1.44748737341 1.15555132114e-06 1.55 1.15558307927e-06 1.44748737341 1.1556148374e-06 1.2 1.15564659553e-06 0.952512626585 1.15567835366e-06 0.85 1.15571011179e-06 0.952512626585 1.15574186992e-06 1.2 1.15577362805e-06 1.44748737342 1.15580538618e-06 1.55 1.15583714431e-06 1.44748737342 1.15586890244e-06 1.2 1.15590066057e-06 0.952512626585 1.1559324187e-06 0.85 1.15596417683e-06 0.952512626584 1.15599593496e-06 1.2 1.15602769309e-06 1.44748737342 1.15605945122e-06 1.55 1.15609120935e-06 1.44748737342 1.15612296748e-06 1.2 1.15615472561e-06 0.952512626585 1.15618648374e-06 0.85 1.15621824187e-06 0.952512626585 1.15625e-06 1.2 1.15628175813e-06 1.44748737342 1.15631351626e-06 1.55 1.15634527439e-06 1.44748737342 1.15637703252e-06 1.2 1.15640879065e-06 0.952512626584 1.15644054878e-06 0.85 1.15647230691e-06 0.952512626585 1.15650406504e-06 1.2 1.15653582317e-06 1.44748737342 1.1565675813e-06 1.55 1.15659933943e-06 1.44748737342 1.15663109756e-06 1.2 1.15666285569e-06 0.952512626585 1.15669461382e-06 0.85 1.15672637195e-06 0.952512626584 1.15675813008e-06 1.2 1.15678988821e-06 1.44748737341 1.15682164634e-06 1.55 1.15685340447e-06 1.44748737341 1.1568851626e-06 1.2 1.15691692073e-06 0.952512626584 1.15694867886e-06 0.85 1.15698043699e-06 0.952512626585 1.15701219512e-06 1.2 1.15704395325e-06 1.44748737342 1.15707571138e-06 1.55 1.15710746951e-06 1.44748737342 1.15713922764e-06 1.2 1.15717098577e-06 0.952512626585 1.1572027439e-06 0.85 1.15723450203e-06 0.952512626584 1.15726626016e-06 1.2 1.15729801829e-06 1.44748737342 1.15732977642e-06 1.55 1.15736153455e-06 1.44748737342 1.15739329268e-06 1.2 1.15742505081e-06 0.952512626585 1.15745680894e-06 0.85 1.15748856707e-06 0.952512626584 1.1575203252e-06 1.2 1.15755208333e-06 1.44748737342 1.15758384146e-06 1.55 1.15761559959e-06 1.44748737342 1.15764735772e-06 1.2 1.15767911585e-06 0.952512626584 1.15771087398e-06 0.85 1.15774263211e-06 0.952512626585 1.15777439024e-06 1.2 1.15780614837e-06 1.44748737342 1.1578379065e-06 1.55 1.15786966463e-06 1.44748737342 1.15790142276e-06 1.2 1.15793318089e-06 0.952512626585 1.15796493902e-06 0.85 1.15799669715e-06 0.952512626585 1.15802845528e-06 1.2 1.15806021341e-06 1.44748737341 1.15809197154e-06 1.55 1.15812372967e-06 1.44748737342 1.1581554878e-06 1.2 1.15818724593e-06 0.952512626584 1.15821900407e-06 0.85 1.1582507622e-06 0.952512626585 1.15828252033e-06 1.2 1.15831427846e-06 1.44748737342 1.15834603659e-06 1.55 1.15837779472e-06 1.44748737342 1.15840955285e-06 1.2 1.15844131098e-06 0.952512626585 1.15847306911e-06 0.85 1.15850482724e-06 0.952512626585 1.15853658537e-06 1.2 1.1585683435e-06 1.44748737341 1.15860010163e-06 1.55 1.15863185976e-06 1.44748737342 1.15866361789e-06 1.2 1.15869537602e-06 0.952512626585 1.15872713415e-06 0.85 1.15875889228e-06 0.952512626584 1.15879065041e-06 1.2 1.15882240854e-06 1.44748737342 1.15885416667e-06 1.55 1.1588859248e-06 1.44748737342 1.15891768293e-06 1.2 1.15894944106e-06 0.952512626584 1.15898119919e-06 0.85 1.15901295732e-06 0.952512626584 1.15904471545e-06 1.2 1.15907647358e-06 1.44748737342 1.15910823171e-06 1.55 1.15913998984e-06 1.44748737342 1.15917174797e-06 1.2 1.1592035061e-06 0.952512626585 1.15923526423e-06 0.85 1.15926702236e-06 0.952512626585 1.15929878049e-06 1.2 1.15933053862e-06 1.44748737341 1.15936229675e-06 1.55 1.15939405488e-06 1.44748737342 1.15942581301e-06 1.2 1.15945757114e-06 0.952512626584 1.15948932927e-06 0.85 1.1595210874e-06 0.952512626585 1.15955284553e-06 1.2 1.15958460366e-06 1.44748737342 1.15961636179e-06 1.55 1.15964811992e-06 1.44748737341 1.15967987805e-06 1.2 1.15971163618e-06 0.952512626585 1.15974339431e-06 0.85 1.15977515244e-06 0.952512626585 1.15980691057e-06 1.2 1.1598386687e-06 1.44748737341 1.15987042683e-06 1.55 1.15990218496e-06 1.44748737342 1.15993394309e-06 1.2 1.15996570122e-06 0.952512626586 1.15999745935e-06 0.85 1.16002921748e-06 0.952512626584 1.16006097561e-06 1.2 1.16009273374e-06 1.44748737342 1.16012449187e-06 1.55 1.16015625e-06 1.44748737342 1.16018800813e-06 1.2 1.16021976626e-06 0.952512626584 1.16025152439e-06 0.85 1.16028328252e-06 0.952512626585 1.16031504065e-06 1.2 1.16034679878e-06 1.44748737342 1.16037855691e-06 1.55 1.16041031504e-06 1.44748737342 1.16044207317e-06 1.2 1.1604738313e-06 0.952512626585 1.16050558943e-06 0.85 1.16053734756e-06 0.952512626585 1.16056910569e-06 1.2 1.16060086382e-06 1.44748737341 1.16063262195e-06 1.55 1.16066438008e-06 1.44748737342 1.16069613821e-06 1.2 1.16072789634e-06 0.952512626584 1.16075965447e-06 0.85 1.1607914126e-06 0.952512626586 1.16082317073e-06 1.2 1.16085492886e-06 1.44748737342 1.16088668699e-06 1.55 1.16091844512e-06 1.44748737341 1.16095020325e-06 1.2 1.16098196138e-06 0.952512626585 1.16101371951e-06 0.85 1.16104547764e-06 0.952512626585 1.16107723577e-06 1.2 1.1611089939e-06 1.44748737341 1.16114075203e-06 1.55 1.16117251016e-06 1.44748737342 1.16120426829e-06 1.2 1.16123602642e-06 0.952512626586 1.16126778455e-06 0.85 1.16129954268e-06 0.952512626584 1.16133130081e-06 1.2 1.16136305894e-06 1.44748737341 1.16139481707e-06 1.55 1.1614265752e-06 1.44748737341 1.16145833333e-06 1.2 1.16149009146e-06 0.952512626585 1.16152184959e-06 0.85 1.16155360772e-06 0.952512626585 1.16158536585e-06 1.2 1.16161712398e-06 1.44748737342 1.16164888211e-06 1.55 1.16168064024e-06 1.44748737342 1.16171239837e-06 1.2 1.1617441565e-06 0.952512626585 1.16177591463e-06 0.85 1.16180767276e-06 0.952512626584 1.16183943089e-06 1.2 1.16187118902e-06 1.44748737342 1.16190294715e-06 1.55 1.16193470528e-06 1.44748737342 1.16196646341e-06 1.2 1.16199822154e-06 0.952512626585 1.16202997967e-06 0.85 1.1620617378e-06 0.952512626585 1.16209349593e-06 1.2 1.16212525407e-06 1.44748737342 1.1621570122e-06 1.55 1.16218877033e-06 1.44748737341 1.16222052846e-06 1.2 1.16225228659e-06 0.952512626585 1.16228404472e-06 0.85 1.16231580285e-06 0.952512626585 1.16234756098e-06 1.2 1.16237931911e-06 1.44748737342 1.16241107724e-06 1.55 1.16244283537e-06 1.44748737342 1.1624745935e-06 1.2 1.16250635163e-06 0.952512626585 1.16253810976e-06 0.85 1.16256986789e-06 0.952512626584 1.16260162602e-06 1.2 1.16263338415e-06 1.44748737341 1.16266514228e-06 1.55 1.16269690041e-06 1.44748737341 1.16272865854e-06 1.2 1.16276041667e-06 0.952512626585 1.1627921748e-06 0.85 1.16282393293e-06 0.952512626585 1.16285569106e-06 1.2 1.16288744919e-06 1.44748737342 1.16291920732e-06 1.55 1.16295096545e-06 1.44748737342 1.16298272358e-06 1.2 1.16301448171e-06 0.952512626584 1.16304623984e-06 0.85 1.16307799797e-06 0.952512626584 1.1631097561e-06 1.2 1.16314151423e-06 1.44748737342 1.16317327236e-06 1.55 1.16320503049e-06 1.44748737342 1.16323678862e-06 1.2 1.16326854675e-06 0.952512626585 1.16330030488e-06 0.85 1.16333206301e-06 0.952512626585 1.16336382114e-06 1.2 1.16339557927e-06 1.44748737342 1.1634273374e-06 1.55 1.16345909553e-06 1.44748737341 1.16349085366e-06 1.2 1.16352261179e-06 0.952512626584 1.16355436992e-06 0.85 1.16358612805e-06 0.952512626585 1.16361788618e-06 1.2 1.16364964431e-06 1.44748737342 1.16368140244e-06 1.55 1.16371316057e-06 1.44748737342 1.1637449187e-06 1.2 1.16377667683e-06 0.952512626585 1.16380843496e-06 0.85 1.16384019309e-06 0.952512626584 1.16387195122e-06 1.2 1.16390370935e-06 1.44748737341 1.16393546748e-06 1.55 1.16396722561e-06 1.44748737341 1.16399898374e-06 1.2 1.16403074187e-06 0.952512626585 1.1640625e-06 0.85 1.16409425813e-06 0.952512626585 1.16412601626e-06 1.2 1.16415777439e-06 1.44748737342 1.16418953252e-06 1.55 1.16422129065e-06 1.44748737342 1.16425304878e-06 1.2 1.16428480691e-06 0.952512626585 1.16431656504e-06 0.85 1.16434832317e-06 0.952512626584 1.1643800813e-06 1.2 1.16441183943e-06 1.44748737342 1.16444359756e-06 1.55 1.16447535569e-06 1.44748737342 1.16450711382e-06 1.2 1.16453887195e-06 0.952512626585 1.16457063008e-06 0.85 1.16460238821e-06 0.952512626585 1.16463414634e-06 1.2 1.16466590447e-06 1.44748737342 1.1646976626e-06 1.55 1.16472942073e-06 1.44748737342 1.16476117886e-06 1.2 1.16479293699e-06 0.952512626584 1.16482469512e-06 0.85 1.16485645325e-06 0.952512626585 1.16488821138e-06 1.2 1.16491996951e-06 1.44748737342 1.16495172764e-06 1.55 1.16498348577e-06 1.44748737342 1.1650152439e-06 1.2 1.16504700203e-06 0.952512626585 1.16507876016e-06 0.85 1.16511051829e-06 0.952512626584 1.16514227642e-06 1.2 1.16517403455e-06 1.44748737341 1.16520579268e-06 1.55 1.16523755081e-06 1.44748737342 1.16526930894e-06 1.2 1.16530106707e-06 0.952512626584 1.1653328252e-06 0.85 1.16536458333e-06 0.952512626585 1.16539634146e-06 1.2 1.16542809959e-06 1.44748737342 1.16545985772e-06 1.55 1.16549161585e-06 1.44748737342 1.16552337398e-06 1.2 1.16555513211e-06 0.952512626585 1.16558689024e-06 0.85 1.16561864837e-06 0.952512626584 1.1656504065e-06 1.2 1.16568216463e-06 1.44748737342 1.16571392276e-06 1.55 1.16574568089e-06 1.44748737342 1.16577743902e-06 1.2 1.16580919715e-06 0.952512626585 1.16584095528e-06 0.85 1.16587271341e-06 0.952512626584 1.16590447154e-06 1.2 1.16593622967e-06 1.44748737342 1.1659679878e-06 1.55 1.16599974593e-06 1.44748737342 1.16603150407e-06 1.2 1.1660632622e-06 0.952512626584 1.16609502033e-06 0.85 1.16612677846e-06 0.952512626585 1.16615853659e-06 1.2 1.16619029472e-06 1.44748737342 1.16622205285e-06 1.55 1.16625381098e-06 1.44748737342 1.16628556911e-06 1.2 1.16631732724e-06 0.952512626585 1.16634908537e-06 0.85 1.1663808435e-06 0.952512626585 1.16641260163e-06 1.2 1.16644435976e-06 1.44748737341 1.16647611789e-06 1.55 1.16650787602e-06 1.44748737342 1.16653963415e-06 1.2 1.16657139228e-06 0.952512626584 1.16660315041e-06 0.85 1.16663490854e-06 0.952512626585 1.16666666667e-06 1.2 1.1666984248e-06 1.44748737342 1.16673018293e-06 1.55 1.16676194106e-06 1.44748737342 1.16679369919e-06 1.2 1.16682545732e-06 0.952512626585 1.16685721545e-06 0.85 1.16688897358e-06 0.952512626585 1.16692073171e-06 1.2 1.16695248984e-06 1.44748737341 1.16698424797e-06 1.55 1.1670160061e-06 1.44748737342 1.16704776423e-06 1.2 1.16707952236e-06 0.952512626585 1.16711128049e-06 0.85 1.16714303862e-06 0.952512626584 1.16717479675e-06 1.2 1.16720655488e-06 1.44748737342 1.16723831301e-06 1.55 1.16727007114e-06 1.44748737342 1.16730182927e-06 1.2 1.1673335874e-06 0.952512626584 1.16736534553e-06 0.85 1.16739710366e-06 0.952512626584 1.16742886179e-06 1.2 1.16746061992e-06 1.44748737342 1.16749237805e-06 1.55 1.16752413618e-06 1.44748737342 1.16755589431e-06 1.2 1.16758765244e-06 0.952512626585 1.16761941057e-06 0.85 1.1676511687e-06 0.952512626585 1.16768292683e-06 1.2 1.16771468496e-06 1.44748737341 1.16774644309e-06 1.55 1.16777820122e-06 1.44748737342 1.16780995935e-06 1.2 1.16784171748e-06 0.952512626584 1.16787347561e-06 0.85 1.16790523374e-06 0.952512626585 1.16793699187e-06 1.2 1.16796875e-06 1.44748737342 1.16800050813e-06 1.55 1.16803226626e-06 1.44748737341 1.16806402439e-06 1.2 1.16809578252e-06 0.952512626585 1.16812754065e-06 0.85 1.16815929878e-06 0.952512626585 1.16819105691e-06 1.2 1.16822281504e-06 1.44748737341 1.16825457317e-06 1.55 1.1682863313e-06 1.44748737342 1.16831808943e-06 1.2 1.16834984756e-06 0.952512626586 1.16838160569e-06 0.85 1.16841336382e-06 0.952512626584 1.16844512195e-06 1.2 1.16847688008e-06 1.44748737342 1.16850863821e-06 1.55 1.16854039634e-06 1.44748737341 1.16857215447e-06 1.2 1.1686039126e-06 0.952512626584 1.16863567073e-06 0.85 1.16866742886e-06 0.952512626585 1.16869918699e-06 1.2 1.16873094512e-06 1.44748737342 1.16876270325e-06 1.55 1.16879446138e-06 1.44748737342 1.16882621951e-06 1.2 1.16885797764e-06 0.952512626585 1.16888973577e-06 0.85 1.1689214939e-06 0.952512626585 1.16895325203e-06 1.2 1.16898501016e-06 1.44748737341 1.16901676829e-06 1.55 1.16904852642e-06 1.44748737342 1.16908028455e-06 1.2 1.16911204268e-06 0.952512626585 1.16914380081e-06 0.85 1.16917555894e-06 0.952512626586 1.16920731707e-06 1.2 1.1692390752e-06 1.44748737342 1.16927083333e-06 1.55 1.16930259146e-06 1.44748737341 1.16933434959e-06 1.2 1.16936610772e-06 0.952512626585 1.16939786585e-06 0.85 1.16942962398e-06 0.952512626585 1.16946138211e-06 1.2 1.16949314024e-06 1.44748737341 1.16952489837e-06 1.55 1.1695566565e-06 1.44748737342 1.16958841463e-06 1.2 1.16962017276e-06 0.952512626585 1.16965193089e-06 0.85 1.16968368902e-06 0.952512626584 1.16971544715e-06 1.2 1.16974720528e-06 1.44748737341 1.16977896341e-06 1.55 1.16981072154e-06 1.44748737341 1.16984247967e-06 1.2 1.1698742378e-06 0.952512626585 1.16990599593e-06 0.85 1.16993775407e-06 0.952512626585 1.1699695122e-06 1.2 1.17000127033e-06 1.44748737342 1.17003302846e-06 1.55 1.17006478659e-06 1.44748737342 1.17009654472e-06 1.2 1.17012830285e-06 0.952512626585 1.17016006098e-06 0.85 1.17019181911e-06 0.952512626584 1.17022357724e-06 1.2 1.17025533537e-06 1.44748737342 1.1702870935e-06 1.55 1.17031885163e-06 1.44748737342 1.17035060976e-06 1.2 1.17038236789e-06 0.952512626585 1.17041412602e-06 0.85 1.17044588415e-06 0.952512626585 1.17047764228e-06 1.2 1.17050940041e-06 1.44748737342 1.17054115854e-06 1.55 1.17057291667e-06 1.44748737341 1.1706046748e-06 1.2 1.17063643293e-06 0.952512626585 1.17066819106e-06 0.85 1.17069994919e-06 0.952512626585 1.17073170732e-06 1.2 1.17076346545e-06 1.44748737342 1.17079522358e-06 1.55 1.17082698171e-06 1.44748737342 1.17085873984e-06 1.2 1.17089049797e-06 0.952512626585 1.1709222561e-06 0.85 1.17095401423e-06 0.952512626584 1.17098577236e-06 1.2 1.17101753049e-06 1.44748737341 1.17104928862e-06 1.55 1.17108104675e-06 1.44748737341 1.17111280488e-06 1.2 1.17114456301e-06 0.952512626585 1.17117632114e-06 0.85 1.17120807927e-06 0.952512626585 1.1712398374e-06 1.2 1.17127159553e-06 1.44748737342 1.17130335366e-06 1.55 1.17133511179e-06 1.44748737342 1.17136686992e-06 1.2 1.17139862805e-06 0.952512626584 1.17143038618e-06 0.85 1.17146214431e-06 0.952512626584 1.17149390244e-06 1.2 1.17152566057e-06 1.44748737342 1.1715574187e-06 1.55 1.17158917683e-06 1.44748737342 1.17162093496e-06 1.2 1.17165269309e-06 0.952512626585 1.17168445122e-06 0.85 1.17171620935e-06 0.952512626585 1.17174796748e-06 1.2 1.17177972561e-06 1.44748737342 1.17181148374e-06 1.55 1.17184324187e-06 1.44748737341 1.171875e-06 1.2 1.17190675813e-06 0.952512626584 1.17193851626e-06 0.85 1.17197027439e-06 0.952512626585 1.17200203252e-06 1.2 1.17203379065e-06 1.44748737342 1.17206554878e-06 1.55 1.17209730691e-06 1.44748737342 1.17212906504e-06 1.2 1.17216082317e-06 0.952512626585 1.1721925813e-06 0.85 1.17222433943e-06 0.952512626584 1.17225609756e-06 1.2 1.17228785569e-06 1.44748737341 1.17231961382e-06 1.55 1.17235137195e-06 1.44748737341 1.17238313008e-06 1.2 1.17241488821e-06 0.952512626585 1.17244664634e-06 0.85 1.17247840447e-06 0.952512626585 1.1725101626e-06 1.2 1.17254192073e-06 1.44748737342 1.17257367886e-06 1.55 1.17260543699e-06 1.44748737342 1.17263719512e-06 1.2 1.17266895325e-06 0.952512626585 1.17270071138e-06 0.85 1.17273246951e-06 0.952512626584 1.17276422764e-06 1.2 1.17279598577e-06 1.44748737342 1.1728277439e-06 1.55 1.17285950203e-06 1.44748737342 1.17289126016e-06 1.2 1.17292301829e-06 0.952512626585 1.17295477642e-06 0.85 1.17298653455e-06 0.952512626584 1.17301829268e-06 1.2 1.17305005081e-06 1.44748737342 1.17308180894e-06 1.55 1.17311356707e-06 1.44748737342 1.1731453252e-06 1.2 1.17317708333e-06 0.952512626584 1.17320884146e-06 0.85 1.17324059959e-06 0.952512626585 1.17327235772e-06 1.2 1.17330411585e-06 1.44748737342 1.17333587398e-06 1.55 1.17336763211e-06 1.44748737342 1.17339939024e-06 1.2 1.17343114837e-06 0.952512626585 1.1734629065e-06 0.85 1.17349466463e-06 0.952512626584 1.17352642276e-06 1.2 1.17355818089e-06 1.44748737341 1.17358993902e-06 1.55 1.17362169715e-06 1.44748737342 1.17365345528e-06 1.2 1.17368521341e-06 0.952512626584 1.17371697154e-06 0.85 1.17374872967e-06 0.952512626585 1.1737804878e-06 1.2 1.17381224593e-06 1.44748737342 1.17384400407e-06 1.55 1.1738757622e-06 1.44748737342 1.17390752033e-06 1.2 1.17393927846e-06 0.952512626585 1.17397103659e-06 0.85 1.17400279472e-06 0.952512626584 1.17403455285e-06 1.2 1.17406631098e-06 1.44748737342 1.17409806911e-06 1.55 1.17412982724e-06 1.44748737342 1.17416158537e-06 1.2 1.1741933435e-06 0.952512626585 1.17422510163e-06 0.85 1.17425685976e-06 0.952512626584 1.17428861789e-06 1.2 1.17432037602e-06 1.44748737342 1.17435213415e-06 1.55 1.17438389228e-06 1.44748737342 1.17441565041e-06 1.2 1.17444740854e-06 0.952512626584 1.17447916667e-06 0.85 1.1745109248e-06 0.952512626584 1.17454268293e-06 1.2 1.17457444106e-06 1.44748737342 1.17460619919e-06 1.55 1.17463795732e-06 1.44748737341 1.17466971545e-06 1.2 1.17470147358e-06 0.952512626585 1.17473323171e-06 0.85 1.17476498984e-06 0.952512626585 1.17479674797e-06 1.2 1.1748285061e-06 1.44748737341 1.17486026423e-06 1.55 1.17489202236e-06 1.44748737342 1.17492378049e-06 1.2 1.17495553862e-06 0.952512626584 1.17498729675e-06 0.85 1.17501905488e-06 0.952512626585 1.17505081301e-06 1.2 1.17508257114e-06 1.44748737342 1.17511432927e-06 1.55 1.1751460874e-06 1.44748737342 1.17517784553e-06 1.2 1.17520960366e-06 0.952512626585 1.17524136179e-06 0.85 1.17527311992e-06 0.952512626585 1.17530487805e-06 1.2 1.17533663618e-06 1.44748737341 1.17536839431e-06 1.55 1.17540015244e-06 1.44748737342 1.17543191057e-06 1.2 1.1754636687e-06 0.952512626585 1.17549542683e-06 0.85 1.17552718496e-06 0.952512626584 1.17555894309e-06 1.2 1.17559070122e-06 1.44748737342 1.17562245935e-06 1.55 1.17565421748e-06 1.44748737342 1.17568597561e-06 1.2 1.17571773374e-06 0.952512626584 1.17574949187e-06 0.85 1.17578125e-06 0.952512626585 1.17581300813e-06 1.2 1.17584476626e-06 1.44748737342 1.17587652439e-06 1.55 1.17590828252e-06 1.44748737342 1.17594004065e-06 1.2 1.17597179878e-06 0.952512626585 1.17600355691e-06 0.85 1.17603531504e-06 0.952512626585 1.17606707317e-06 1.2 1.1760988313e-06 1.44748737341 1.17613058943e-06 1.55 1.17616234756e-06 1.44748737342 1.17619410569e-06 1.2 1.17622586382e-06 0.952512626584 1.17625762195e-06 0.85 1.17628938008e-06 0.952512626585 1.17632113821e-06 1.2 1.17635289634e-06 1.44748737342 1.17638465447e-06 1.55 1.1764164126e-06 1.44748737341 1.17644817073e-06 1.2 1.17647992886e-06 0.952512626585 1.17651168699e-06 0.85 1.17654344512e-06 0.952512626585 1.17657520325e-06 1.2 1.17660696138e-06 1.44748737341 1.17663871951e-06 1.55 1.17667047764e-06 1.44748737342 1.17670223577e-06 1.2 1.1767339939e-06 0.952512626586 1.17676575203e-06 0.85 1.17679751016e-06 0.952512626584 1.17682926829e-06 1.2 1.17686102642e-06 1.44748737342 1.17689278455e-06 1.55 1.17692454268e-06 1.44748737341 1.17695630081e-06 1.2 1.17698805894e-06 0.952512626584 1.17701981707e-06 0.85 1.1770515752e-06 0.952512626585 1.17708333333e-06 1.2 1.17711509146e-06 1.44748737342 1.17714684959e-06 1.55 1.17717860772e-06 1.44748737342 1.17721036585e-06 1.2 1.17724212398e-06 0.952512626585 1.17727388211e-06 0.85 1.17730564024e-06 0.952512626584 1.17733739837e-06 1.2 1.1773691565e-06 1.44748737341 1.17740091463e-06 1.55 1.17743267276e-06 1.44748737342 1.17746443089e-06 1.2 1.17749618902e-06 0.952512626585 1.17752794715e-06 0.85 1.17755970528e-06 0.952512626586 1.17759146341e-06 1.2 1.17762322154e-06 1.44748737342 1.17765497967e-06 1.55 1.1776867378e-06 1.44748737341 1.17771849593e-06 1.2 1.17775025407e-06 0.952512626585 1.1777820122e-06 0.85 1.17781377033e-06 0.952512626585 1.17784552846e-06 1.2 1.17787728659e-06 1.44748737341 1.17790904472e-06 1.55 1.17794080285e-06 1.44748737342 1.17797256098e-06 1.2 1.17800431911e-06 0.952512626585 1.17803607724e-06 0.85 1.17806783537e-06 0.952512626584 1.1780995935e-06 1.2 1.17813135163e-06 1.44748737341 1.17816310976e-06 1.55 1.17819486789e-06 1.44748737341 1.17822662602e-06 1.2 1.17825838415e-06 0.952512626585 1.17829014228e-06 0.85 1.17832190041e-06 0.952512626585 1.17835365854e-06 1.2 1.17838541667e-06 1.44748737342 1.1784171748e-06 1.55 1.17844893293e-06 1.44748737342 1.17848069106e-06 1.2 1.17851244919e-06 0.952512626585 1.17854420732e-06 0.85 1.17857596545e-06 0.952512626584 1.17860772358e-06 1.2 1.17863948171e-06 1.44748737342 1.17867123984e-06 1.55 1.17870299797e-06 1.44748737342 1.1787347561e-06 1.2 1.17876651423e-06 0.952512626585 1.17879827236e-06 0.85 1.17883003049e-06 0.952512626585 1.17886178862e-06 1.2 1.17889354675e-06 1.44748737342 1.17892530488e-06 1.55 1.17895706301e-06 1.44748737341 1.17898882114e-06 1.2 1.17902057927e-06 0.952512626585 1.1790523374e-06 0.85 1.17908409553e-06 0.952512626585 1.17911585366e-06 1.2 1.17914761179e-06 1.44748737342 1.17917936992e-06 1.55 1.17921112805e-06 1.44748737342 1.17924288618e-06 1.2 1.17927464431e-06 0.952512626585 1.17930640244e-06 0.85 1.17933816057e-06 0.952512626584 1.1793699187e-06 1.2 1.17940167683e-06 1.44748737341 1.17943343496e-06 1.55 1.17946519309e-06 1.44748737341 1.17949695122e-06 1.2 1.17952870935e-06 0.952512626585 1.17956046748e-06 0.85 1.17959222561e-06 0.952512626585 1.17962398374e-06 1.2 1.17965574187e-06 1.44748737342 1.1796875e-06 1.55 1.17971925813e-06 1.44748737342 1.17975101626e-06 1.2 1.17978277439e-06 0.952512626584 1.17981453252e-06 0.85 1.17984629065e-06 0.952512626584 1.17987804878e-06 1.2 1.17990980691e-06 1.44748737342 1.17994156504e-06 1.55 1.17997332317e-06 1.44748737342 1.1800050813e-06 1.2 1.18003683943e-06 0.952512626585 1.18006859756e-06 0.85 1.18010035569e-06 0.952512626585 1.18013211382e-06 1.2 1.18016387195e-06 1.44748737342 1.18019563008e-06 1.55 1.18022738821e-06 1.44748737341 1.18025914634e-06 1.2 1.18029090447e-06 0.952512626584 1.1803226626e-06 0.85 1.18035442073e-06 0.952512626585 1.18038617886e-06 1.2 1.18041793699e-06 1.44748737342 1.18044969512e-06 1.55 1.18048145325e-06 1.44748737342 1.18051321138e-06 1.2 1.18054496951e-06 0.952512626585 1.18057672764e-06 0.85 1.18060848577e-06 0.952512626584 1.1806402439e-06 1.2 1.18067200203e-06 1.44748737341 1.18070376016e-06 1.55 1.18073551829e-06 1.44748737342 1.18076727642e-06 1.2 1.18079903455e-06 0.952512626584 1.18083079268e-06 0.85 1.18086255081e-06 0.952512626585 1.18089430894e-06 1.2 1.18092606707e-06 1.44748737342 1.1809578252e-06 1.55 1.18098958333e-06 1.44748737342 1.18102134146e-06 1.2 1.18105309959e-06 0.952512626585 1.18108485772e-06 0.85 1.18111661585e-06 0.952512626584 1.18114837398e-06 1.2 1.18118013211e-06 1.44748737342 1.18121189024e-06 1.55 1.18124364837e-06 1.44748737342 1.1812754065e-06 1.2 1.18130716463e-06 0.952512626585 1.18133892276e-06 0.85 1.18137068089e-06 0.952512626584 1.18140243902e-06 1.2 1.18143419715e-06 1.44748737342 1.18146595528e-06 1.55 1.18149771341e-06 1.44748737342 1.18152947154e-06 1.2 1.18156122967e-06 0.952512626584 1.1815929878e-06 0.85 1.18162474593e-06 0.952512626585 1.18165650407e-06 1.2 1.1816882622e-06 1.44748737342 1.18172002033e-06 1.55 1.18175177846e-06 1.44748737342 1.18178353659e-06 1.2 1.18181529472e-06 0.952512626585 1.18184705285e-06 0.85 1.18187881098e-06 0.952512626585 1.18191056911e-06 1.2 1.18194232724e-06 1.44748737341 1.18197408537e-06 1.55 1.1820058435e-06 1.44748737342 1.18203760163e-06 1.2 1.18206935976e-06 0.952512626584 1.18210111789e-06 0.85 1.18213287602e-06 0.952512626585 1.18216463415e-06 1.2 1.18219639228e-06 1.44748737342 1.18222815041e-06 1.55 1.18225990854e-06 1.44748737342 1.18229166667e-06 1.2 1.1823234248e-06 0.952512626585 1.18235518293e-06 0.85 1.18238694106e-06 0.952512626584 1.18241869919e-06 1.2 1.18245045732e-06 1.44748737342 1.18248221545e-06 1.55 1.18251397358e-06 1.44748737342 1.18254573171e-06 1.2 1.18257748984e-06 0.952512626585 1.18260924797e-06 0.85 1.1826410061e-06 0.952512626584 1.18267276423e-06 1.2 1.18270452236e-06 1.44748737342 1.18273628049e-06 1.55 1.18276803862e-06 1.44748737342 1.18279979675e-06 1.2 1.18283155488e-06 0.952512626584 1.18286331301e-06 0.85 1.18289507114e-06 0.952512626584 1.18292682927e-06 1.2 1.1829585874e-06 1.44748737342 1.18299034553e-06 1.55 1.18302210366e-06 1.44748737341 1.18305386179e-06 1.2 1.18308561992e-06 0.952512626585 1.18311737805e-06 0.85 1.18314913618e-06 0.952512626585 1.18318089431e-06 1.2 1.18321265244e-06 1.44748737341 1.18324441057e-06 1.55 1.1832761687e-06 1.44748737342 1.18330792683e-06 1.2 1.18333968496e-06 0.952512626584 1.18337144309e-06 0.85 1.18340320122e-06 0.952512626585 1.18343495935e-06 1.2 1.18346671748e-06 1.44748737342 1.18349847561e-06 1.55 1.18353023374e-06 1.44748737342 1.18356199187e-06 1.2 1.18359375e-06 0.952512626585 1.18362550813e-06 0.85 1.18365726626e-06 0.952512626585 1.18368902439e-06 1.2 1.18372078252e-06 1.44748737341 1.18375254065e-06 1.55 1.18378429878e-06 1.44748737342 1.18381605691e-06 1.2 1.18384781504e-06 0.952512626585 1.18387957317e-06 0.85 1.1839113313e-06 0.952512626584 1.18394308943e-06 1.2 1.18397484756e-06 1.44748737342 1.18400660569e-06 1.55 1.18403836382e-06 1.44748737342 1.18407012195e-06 1.2 1.18410188008e-06 0.952512626584 1.18413363821e-06 0.85 1.18416539634e-06 0.952512626585 1.18419715447e-06 1.2 1.1842289126e-06 1.44748737342 1.18426067073e-06 1.55 1.18429242886e-06 1.44748737342 1.18432418699e-06 1.2 1.18435594512e-06 0.952512626585 1.18438770325e-06 0.85 1.18441946138e-06 0.952512626585 1.18445121951e-06 1.2 1.18448297764e-06 1.44748737341 1.18451473577e-06 1.55 1.1845464939e-06 1.44748737342 1.18457825203e-06 1.2 1.18461001016e-06 0.952512626586 1.18464176829e-06 0.85 1.18467352642e-06 0.952512626585 1.18470528455e-06 1.2 1.18473704268e-06 1.44748737342 1.18476880081e-06 1.55 1.18480055894e-06 1.44748737341 1.18483231707e-06 1.2 1.1848640752e-06 0.952512626585 1.18489583333e-06 0.85 1.18492759146e-06 0.952512626585 1.18495934959e-06 1.2 1.18499110772e-06 1.44748737341 1.18502286585e-06 1.55 1.18505462398e-06 1.44748737342 1.18508638211e-06 1.2 1.18511814024e-06 0.952512626586 1.18514989837e-06 0.85 1.1851816565e-06 0.952512626584 1.18521341463e-06 1.2 1.18524517276e-06 1.44748737342 1.18527693089e-06 1.55 1.18530868902e-06 1.44748737341 1.18534044715e-06 1.2 1.18537220528e-06 0.952512626584 1.18540396341e-06 0.85 1.18543572154e-06 0.952512626585 1.18546747967e-06 1.2 1.1854992378e-06 1.44748737342 1.18553099593e-06 1.55 1.18556275407e-06 1.44748737342 1.1855945122e-06 1.2 1.18562627033e-06 0.952512626585 1.18565802846e-06 0.85 1.18568978659e-06 0.952512626584 1.18572154472e-06 1.2 1.18575330285e-06 1.44748737342 1.18578506098e-06 1.55 1.18581681911e-06 1.44748737342 1.18584857724e-06 1.2 1.18588033537e-06 0.952512626585 1.1859120935e-06 0.85 1.18594385163e-06 0.952512626586 1.18597560976e-06 1.2 1.18600736789e-06 1.44748737342 1.18603912602e-06 1.55 1.18607088415e-06 1.44748737341 1.18610264228e-06 1.2 1.18613440041e-06 0.952512626585 1.18616615854e-06 0.85 1.18619791667e-06 0.952512626585 1.1862296748e-06 1.2 1.18626143293e-06 1.44748737341 1.18629319106e-06 1.55 1.18632494919e-06 1.44748737342 1.18635670732e-06 1.2 1.18638846545e-06 0.952512626585 1.18642022358e-06 0.85 1.18645198171e-06 0.952512626584 1.18648373984e-06 1.2 1.18651549797e-06 1.44748737341 1.1865472561e-06 1.55 1.18657901423e-06 1.44748737341 1.18661077236e-06 1.2 1.18664253049e-06 0.952512626585 1.18667428862e-06 0.85 1.18670604675e-06 0.952512626585 1.18673780488e-06 1.2 1.18676956301e-06 1.44748737342 1.18680132114e-06 1.55 1.18683307927e-06 1.44748737342 1.1868648374e-06 1.2 1.18689659553e-06 0.952512626584 1.18692835366e-06 0.85 1.18696011179e-06 0.952512626584 1.18699186992e-06 1.2 1.18702362805e-06 1.44748737342 1.18705538618e-06 1.55 1.18708714431e-06 1.44748737342 1.18711890244e-06 1.2 1.18715066057e-06 0.952512626585 1.1871824187e-06 0.85 1.18721417683e-06 0.952512626585 1.18724593496e-06 1.2 1.18727769309e-06 1.44748737342 1.18730945122e-06 1.55 1.18734120935e-06 1.44748737341 1.18737296748e-06 1.2 1.18740472561e-06 0.952512626585 1.18743648374e-06 0.85 1.18746824187e-06 0.952512626585 1.1875e-06 1.2 1.18753175813e-06 1.44748737342 1.18756351626e-06 1.55 1.18759527439e-06 1.44748737342 1.18762703252e-06 1.2 1.18765879065e-06 0.952512626585 1.18769054878e-06 0.85 1.18772230691e-06 0.952512626584 1.18775406504e-06 1.2 1.18778582317e-06 1.44748737341 1.1878175813e-06 1.55 1.18784933943e-06 1.44748737341 1.18788109756e-06 1.2 1.18791285569e-06 0.952512626585 1.18794461382e-06 0.85 1.18797637195e-06 0.952512626585 1.18800813008e-06 1.2 1.18803988821e-06 1.44748737342 1.18807164634e-06 1.55 1.18810340447e-06 1.44748737342 1.1881351626e-06 1.2 1.18816692073e-06 0.952512626584 1.18819867886e-06 0.85 1.18823043699e-06 0.952512626584 1.18826219512e-06 1.2 1.18829395325e-06 1.44748737342 1.18832571138e-06 1.55 1.18835746951e-06 1.44748737342 1.18838922764e-06 1.2 1.18842098577e-06 0.952512626585 1.1884527439e-06 0.85 1.18848450203e-06 0.952512626584 1.18851626016e-06 1.2 1.18854801829e-06 1.44748737342 1.18857977642e-06 1.55 1.18861153455e-06 1.44748737341 1.18864329268e-06 1.2 1.18867505081e-06 0.952512626584 1.18870680894e-06 0.85 1.18873856707e-06 0.952512626585 1.1887703252e-06 1.2 1.18880208333e-06 1.44748737342 1.18883384146e-06 1.55 1.18886559959e-06 1.44748737342 1.18889735772e-06 1.2 1.18892911585e-06 0.952512626585 1.18896087398e-06 0.85 1.18899263211e-06 0.952512626584 1.18902439024e-06 1.2 1.18905614837e-06 1.44748737341 1.1890879065e-06 1.55 1.18911966463e-06 1.44748737342 1.18915142276e-06 1.2 1.18918318089e-06 0.952512626584 1.18921493902e-06 0.85 1.18924669715e-06 0.952512626585 1.18927845528e-06 1.2 1.18931021341e-06 1.44748737342 1.18934197154e-06 1.55 1.18937372967e-06 1.44748737342 1.1894054878e-06 1.2 1.18943724593e-06 0.952512626585 1.18946900407e-06 0.85 1.1895007622e-06 0.952512626584 1.18953252033e-06 1.2 1.18956427846e-06 1.44748737342 1.18959603659e-06 1.55 1.18962779472e-06 1.44748737342 1.18965955285e-06 1.2 1.18969131098e-06 0.952512626585 1.18972306911e-06 0.85 1.18975482724e-06 0.952512626584 1.18978658537e-06 1.2 1.1898183435e-06 1.44748737342 1.18985010163e-06 1.55 1.18988185976e-06 1.44748737342 1.18991361789e-06 1.2 1.18994537602e-06 0.952512626584 1.18997713415e-06 0.85 1.19000889228e-06 0.952512626585 1.19004065041e-06 1.2 1.19007240854e-06 1.44748737342 1.19010416667e-06 1.55 1.1901359248e-06 1.44748737342 1.19016768293e-06 1.2 1.19019944106e-06 0.952512626585 1.19023119919e-06 0.85 1.19026295732e-06 0.952512626585 1.19029471545e-06 1.2 1.19032647358e-06 1.44748737341 1.19035823171e-06 1.55 1.19038998984e-06 1.44748737342 1.19042174797e-06 1.2 1.1904535061e-06 0.952512626584 1.19048526423e-06 0.85 1.19051702236e-06 0.952512626585 1.19054878049e-06 1.2 1.19058053862e-06 1.44748737342 1.19061229675e-06 1.55 1.19064405488e-06 1.44748737342 1.19067581301e-06 1.2 1.19070757114e-06 0.952512626585 1.19073932927e-06 0.85 1.1907710874e-06 0.952512626584 1.19080284553e-06 1.2 1.19083460366e-06 1.44748737342 1.19086636179e-06 1.55 1.19089811992e-06 1.44748737342 1.19092987805e-06 1.2 1.19096163618e-06 0.952512626585 1.19099339431e-06 0.85 1.19102515244e-06 0.952512626584 1.19105691057e-06 1.2 1.1910886687e-06 1.44748737342 1.19112042683e-06 1.55 1.19115218496e-06 1.44748737342 1.19118394309e-06 1.2 1.19121570122e-06 0.952512626584 1.19124745935e-06 0.85 1.19127921748e-06 0.952512626584 1.19131097561e-06 1.2 1.19134273374e-06 1.44748737342 1.19137449187e-06 1.55 1.19140625e-06 1.44748737341 1.19143800813e-06 1.2 1.19146976626e-06 0.952512626585 1.19150152439e-06 0.85 1.19153328252e-06 0.952512626585 1.19156504065e-06 1.2 1.19159679878e-06 1.44748737341 1.19162855691e-06 1.55 1.19166031504e-06 1.44748737342 1.19169207317e-06 1.2 1.1917238313e-06 0.952512626584 1.19175558943e-06 0.85 1.19178734756e-06 0.952512626585 1.19181910569e-06 1.2 1.19185086382e-06 1.44748737342 1.19188262195e-06 1.55 1.19191438008e-06 1.44748737341 1.19194613821e-06 1.2 1.19197789634e-06 0.952512626585 1.19200965447e-06 0.85 1.1920414126e-06 0.952512626585 1.19207317073e-06 1.2 1.19210492886e-06 1.44748737341 1.19213668699e-06 1.55 1.19216844512e-06 1.44748737342 1.19220020325e-06 1.2 1.19223196138e-06 0.952512626585 1.19226371951e-06 0.85 1.19229547764e-06 0.952512626584 1.19232723577e-06 1.2 1.1923589939e-06 1.44748737342 1.19239075203e-06 1.55 1.19242251016e-06 1.44748737342 1.19245426829e-06 1.2 1.19248602642e-06 0.952512626584 1.19251778455e-06 0.85 1.19254954268e-06 0.952512626585 1.19258130081e-06 1.2 1.19261305894e-06 1.44748737342 1.19264481707e-06 1.55 1.1926765752e-06 1.44748737342 1.19270833333e-06 1.2 1.19274009146e-06 0.952512626585 1.19277184959e-06 0.85 1.19280360772e-06 0.952512626585 1.19283536585e-06 1.2 1.19286712398e-06 1.44748737341 1.19289888211e-06 1.55 1.19293064024e-06 1.44748737342 1.19296239837e-06 1.2 1.1929941565e-06 0.952512626585 1.19302591463e-06 0.85 1.19305767276e-06 0.952512626586 1.19308943089e-06 1.2 1.19312118902e-06 1.44748737342 1.19315294715e-06 1.55 1.19318470528e-06 1.44748737341 1.19321646341e-06 1.2 1.19324822154e-06 0.952512626585 1.19327997967e-06 0.85 1.1933117378e-06 0.952512626585 1.19334349593e-06 1.2 1.19337525407e-06 1.44748737341 1.1934070122e-06 1.55 1.19343877033e-06 1.44748737342 1.19347052846e-06 1.2 1.19350228659e-06 0.952512626586 1.19353404472e-06 0.85 1.19356580285e-06 0.952512626584 1.19359756098e-06 1.2 1.19362931911e-06 1.44748737342 1.19366107724e-06 1.55 1.19369283537e-06 1.44748737341 1.1937245935e-06 1.2 1.19375635163e-06 0.952512626584 1.19378810976e-06 0.85 1.19381986789e-06 0.952512626585 1.19385162602e-06 1.2 1.19388338415e-06 1.44748737342 1.19391514228e-06 1.55 1.19394690041e-06 1.44748737342 1.19397865854e-06 1.2 1.19401041667e-06 0.952512626585 1.1940421748e-06 0.85 1.19407393293e-06 0.952512626584 1.19410569106e-06 1.2 1.19413744919e-06 1.44748737342 1.19416920732e-06 1.55 1.19420096545e-06 1.44748737342 1.19423272358e-06 1.2 1.19426448171e-06 0.952512626585 1.19429623984e-06 0.85 1.19432799797e-06 0.952512626586 1.1943597561e-06 1.2 1.19439151423e-06 1.44748737342 1.19442327236e-06 1.55 1.19445503049e-06 1.44748737341 1.19448678862e-06 1.2 1.19451854675e-06 0.952512626585 1.19455030488e-06 0.85 1.19458206301e-06 0.952512626585 1.19461382114e-06 1.2 1.19464557927e-06 1.44748737341 1.1946773374e-06 1.55 1.19470909553e-06 1.44748737342 1.19474085366e-06 1.2 1.19477261179e-06 0.952512626585 1.19480436992e-06 0.85 1.19483612805e-06 0.952512626584 1.19486788618e-06 1.2 1.19489964431e-06 1.44748737341 1.19493140244e-06 1.55 1.19496316057e-06 1.44748737341 1.1949949187e-06 1.2 1.19502667683e-06 0.952512626585 1.19505843496e-06 0.85 1.19509019309e-06 0.952512626585 1.19512195122e-06 1.2 1.19515370935e-06 1.44748737342 1.19518546748e-06 1.55 1.19521722561e-06 1.44748737342 1.19524898374e-06 1.2 1.19528074187e-06 0.952512626584 1.1953125e-06 0.85 1.19534425813e-06 0.952512626584 1.19537601626e-06 1.2 1.19540777439e-06 1.44748737342 1.19543953252e-06 1.55 1.19547129065e-06 1.44748737342 1.19550304878e-06 1.2 1.19553480691e-06 0.952512626585 1.19556656504e-06 0.85 1.19559832317e-06 0.952512626585 1.1956300813e-06 1.2 1.19566183943e-06 1.44748737342 1.19569359756e-06 1.55 1.19572535569e-06 1.44748737341 1.19575711382e-06 1.2 1.19578887195e-06 0.952512626585 1.19582063008e-06 0.85 1.19585238821e-06 0.952512626585 1.19588414634e-06 1.2 1.19591590447e-06 1.44748737342 1.1959476626e-06 1.55 1.19597942073e-06 1.44748737342 1.19601117886e-06 1.2 1.19604293699e-06 0.952512626585 1.19607469512e-06 0.85 1.19610645325e-06 0.952512626584 1.19613821138e-06 1.2 1.19616996951e-06 1.44748737341 1.19620172764e-06 1.55 1.19623348577e-06 1.44748737341 1.1962652439e-06 1.2 1.19629700203e-06 0.952512626585 1.19632876016e-06 0.85 1.19636051829e-06 0.952512626585 1.19639227642e-06 1.2 1.19642403455e-06 1.44748737342 1.19645579268e-06 1.55 1.19648755081e-06 1.44748737342 1.19651930894e-06 1.2 1.19655106707e-06 0.952512626584 1.1965828252e-06 0.85 1.19661458333e-06 0.952512626584 1.19664634146e-06 1.2 1.19667809959e-06 1.44748737342 1.19670985772e-06 1.55 1.19674161585e-06 1.44748737342 1.19677337398e-06 1.2 1.19680513211e-06 0.952512626585 1.19683689024e-06 0.85 1.19686864837e-06 0.952512626584 1.1969004065e-06 1.2 1.19693216463e-06 1.44748737342 1.19696392276e-06 1.55 1.19699568089e-06 1.44748737341 1.19702743902e-06 1.2 1.19705919715e-06 0.952512626584 1.19709095528e-06 0.85 1.19712271341e-06 0.952512626585 1.19715447154e-06 1.2 1.19718622967e-06 1.44748737342 1.1972179878e-06 1.55 1.19724974593e-06 1.44748737342 1.19728150407e-06 1.2 1.1973132622e-06 0.952512626585 1.19734502033e-06 0.85 1.19737677846e-06 0.952512626584 1.19740853659e-06 1.2 1.19744029472e-06 1.44748737341 1.19747205285e-06 1.55 1.19750381098e-06 1.44748737342 1.19753556911e-06 1.2 1.19756732724e-06 0.952512626584 1.19759908537e-06 0.85 1.1976308435e-06 0.952512626585 1.19766260163e-06 1.2 1.19769435976e-06 1.44748737342 1.19772611789e-06 1.55 1.19775787602e-06 1.44748737342 1.19778963415e-06 1.2 1.19782139228e-06 0.952512626585 1.19785315041e-06 0.85 1.19788490854e-06 0.952512626584 1.19791666667e-06 1.2 1.1979484248e-06 1.44748737342 1.19798018293e-06 1.55 1.19801194106e-06 1.44748737342 1.19804369919e-06 1.2 1.19807545732e-06 0.952512626585 1.19810721545e-06 0.85 1.19813897358e-06 0.952512626584 1.19817073171e-06 1.2 1.19820248984e-06 1.44748737342 1.19823424797e-06 1.55 1.1982660061e-06 1.44748737342 1.19829776423e-06 1.2 1.19832952236e-06 0.952512626584 1.19836128049e-06 0.85 1.19839303862e-06 0.952512626585 1.19842479675e-06 1.2 1.19845655488e-06 1.44748737342 1.19848831301e-06 1.55 1.19852007114e-06 1.44748737342 1.19855182927e-06 1.2 1.1985835874e-06 0.952512626585 1.19861534553e-06 0.85 1.19864710366e-06 0.952512626585 1.19867886179e-06 1.2 1.19871061992e-06 1.44748737341 1.19874237805e-06 1.55 1.19877413618e-06 1.44748737342 1.19880589431e-06 1.2 1.19883765244e-06 0.952512626584 1.19886941057e-06 0.85 1.1989011687e-06 0.952512626585 1.19893292683e-06 1.2 1.19896468496e-06 1.44748737342 1.19899644309e-06 1.55 1.19902820122e-06 1.44748737342 1.19905995935e-06 1.2 1.19909171748e-06 0.952512626585 1.19912347561e-06 0.85 1.19915523374e-06 0.952512626585 1.19918699187e-06 1.2 1.19921875e-06 1.44748737341 1.19925050813e-06 1.55 1.19928226626e-06 1.44748737342 1.19931402439e-06 1.2 1.19934578252e-06 0.952512626585 1.19937754065e-06 0.85 1.19940929878e-06 0.952512626584 1.19944105691e-06 1.2 1.19947281504e-06 1.44748737342 1.19950457317e-06 1.55 1.1995363313e-06 1.44748737342 1.19956808943e-06 1.2 1.19959984756e-06 0.952512626584 1.19963160569e-06 0.85 1.19966336382e-06 0.952512626584 1.19969512195e-06 1.2 1.19972688008e-06 1.44748737342 1.19975863821e-06 1.55 1.19979039634e-06 1.44748737341 1.19982215447e-06 1.2 1.1998539126e-06 0.952512626585 1.19988567073e-06 0.85 1.19991742886e-06 0.952512626585 1.19994918699e-06 1.2 1.19998094512e-06 1.44748737341 1.20001270325e-06 1.2 1.20004446138e-06 1.2 1.20007621951e-06 1.2 1.20010797764e-06 1.2 1.20013973577e-06 1.2 1.2001714939e-06 1.2 1.20020325203e-06 1.2 1.20023501016e-06 1.2 1.20026676829e-06 1.2 1.20029852642e-06 1.2 1.20033028455e-06 1.2 1.20036204268e-06 1.2 1.20039380081e-06 1.2 1.20042555894e-06 1.2 1.20045731707e-06 1.2 1.2004890752e-06 1.2 1.20052083333e-06 1.2 1.20055259146e-06 1.2 1.20058434959e-06 1.2 1.20061610772e-06 1.2 1.20064786585e-06 1.2 1.20067962398e-06 1.2 1.20071138211e-06 1.2 1.20074314024e-06 1.2 1.20077489837e-06 1.2 1.2008066565e-06 1.2 1.20083841463e-06 1.2 1.20087017276e-06 1.2 1.20090193089e-06 1.2 1.20093368902e-06 1.2 1.20096544715e-06 1.2 1.20099720528e-06 1.2 1.20102896341e-06 1.2 1.20106072154e-06 1.2 1.20109247967e-06 1.2 1.2011242378e-06 1.2 1.20115599593e-06 1.2 1.20118775407e-06 1.2 1.2012195122e-06 1.2 1.20125127033e-06 1.2 1.20128302846e-06 1.2 1.20131478659e-06 1.2 1.20134654472e-06 1.2 1.20137830285e-06 1.2 1.20141006098e-06 1.2 1.20144181911e-06 1.2 1.20147357724e-06 1.2 1.20150533537e-06 1.2 1.2015370935e-06 1.2 1.20156885163e-06 1.2 1.20160060976e-06 1.2 1.20163236789e-06 1.2 1.20166412602e-06 1.2 1.20169588415e-06 1.2 1.20172764228e-06 1.2 1.20175940041e-06 1.2 1.20179115854e-06 1.2 1.20182291667e-06 1.2 1.2018546748e-06 1.2 1.20188643293e-06 1.2 1.20191819106e-06 1.2 1.20194994919e-06 1.2 1.20198170732e-06 1.2 1.20201346545e-06 1.2 1.20204522358e-06 1.2 1.20207698171e-06 1.2 1.20210873984e-06 1.2 1.20214049797e-06 1.2 1.2021722561e-06 1.2 1.20220401423e-06 1.2 1.20223577236e-06 1.2 1.20226753049e-06 1.2 1.20229928862e-06 1.2 1.20233104675e-06 1.2 1.20236280488e-06 1.2 1.20239456301e-06 1.2 1.20242632114e-06 1.2 1.20245807927e-06 1.2 1.2024898374e-06 1.2 1.20252159553e-06 1.2 1.20255335366e-06 1.2 1.20258511179e-06 1.2 1.20261686992e-06 1.2 1.20264862805e-06 1.2 1.20268038618e-06 1.2 1.20271214431e-06 1.2 1.20274390244e-06 1.2 1.20277566057e-06 1.2 1.2028074187e-06 1.2 1.20283917683e-06 1.2 1.20287093496e-06 1.2 1.20290269309e-06 1.2 1.20293445122e-06 1.2 1.20296620935e-06 1.2 1.20299796748e-06 1.2 1.20302972561e-06 1.2 1.20306148374e-06 1.2 1.20309324187e-06 1.2 1.203125e-06 1.2 1.20315675813e-06 1.2 1.20318851626e-06 1.2 1.20322027439e-06 1.2 1.20325203252e-06 1.2 1.20328379065e-06 1.2 1.20331554878e-06 1.2 1.20334730691e-06 1.2 1.20337906504e-06 1.2 1.20341082317e-06 1.2 1.2034425813e-06 1.2 1.20347433943e-06 1.2 1.20350609756e-06 1.2 1.20353785569e-06 1.2 1.20356961382e-06 1.2 1.20360137195e-06 1.2 1.20363313008e-06 1.2 1.20366488821e-06 1.2 1.20369664634e-06 1.2 1.20372840447e-06 1.2 1.2037601626e-06 1.2 1.20379192073e-06 1.2 1.20382367886e-06 1.2 1.20385543699e-06 1.2 1.20388719512e-06 1.2 1.20391895325e-06 1.2 1.20395071138e-06 1.2 1.20398246951e-06 1.2 1.20401422764e-06 1.2 1.20404598577e-06 1.2 1.2040777439e-06 1.2 1.20410950203e-06 1.2 1.20414126016e-06 1.2 1.20417301829e-06 1.2 1.20420477642e-06 1.2 1.20423653455e-06 1.2 1.20426829268e-06 1.2 1.20430005081e-06 1.2 1.20433180894e-06 1.2 1.20436356707e-06 1.2 1.2043953252e-06 1.2 1.20442708333e-06 1.2 1.20445884146e-06 1.2 1.20449059959e-06 1.2 1.20452235772e-06 1.2 1.20455411585e-06 1.2 1.20458587398e-06 1.2 1.20461763211e-06 1.2 1.20464939024e-06 1.2 1.20468114837e-06 1.2 1.2047129065e-06 1.2 1.20474466463e-06 1.2 1.20477642276e-06 1.2 1.20480818089e-06 1.2 1.20483993902e-06 1.2 1.20487169715e-06 1.2 1.20490345528e-06 1.2 1.20493521341e-06 1.2 1.20496697154e-06 1.2 1.20499872967e-06 1.2 1.2050304878e-06 1.2 1.20506224593e-06 1.2 1.20509400407e-06 1.2 1.2051257622e-06 1.2 1.20515752033e-06 1.2 1.20518927846e-06 1.2 1.20522103659e-06 1.2 1.20525279472e-06 1.2 1.20528455285e-06 1.2 1.20531631098e-06 1.2 1.20534806911e-06 1.2 1.20537982724e-06 1.2 1.20541158537e-06 1.2 1.2054433435e-06 1.2 1.20547510163e-06 1.2 1.20550685976e-06 1.2 1.20553861789e-06 1.2 1.20557037602e-06 1.2 1.20560213415e-06 1.2 1.20563389228e-06 1.2 1.20566565041e-06 1.2 1.20569740854e-06 1.2 1.20572916667e-06 1.2 1.2057609248e-06 1.2 1.20579268293e-06 1.2 1.20582444106e-06 1.2 1.20585619919e-06 1.2 1.20588795732e-06 1.2 1.20591971545e-06 1.2 1.20595147358e-06 1.2 1.20598323171e-06 1.2 1.20601498984e-06 1.2 1.20604674797e-06 1.2 1.2060785061e-06 1.2 1.20611026423e-06 1.2 1.20614202236e-06 1.2 1.20617378049e-06 1.2 1.20620553862e-06 1.2 1.20623729675e-06 1.2 1.20626905488e-06 1.2 1.20630081301e-06 1.2 1.20633257114e-06 1.2 1.20636432927e-06 1.2 1.2063960874e-06 1.2 1.20642784553e-06 1.2 1.20645960366e-06 1.2 1.20649136179e-06 1.2 1.20652311992e-06 1.2 1.20655487805e-06 1.2 1.20658663618e-06 1.2 1.20661839431e-06 1.2 1.20665015244e-06 1.2 1.20668191057e-06 1.2 1.2067136687e-06 1.2 1.20674542683e-06 1.2 1.20677718496e-06 1.2 1.20680894309e-06 1.2 1.20684070122e-06 1.2 1.20687245935e-06 1.2 1.20690421748e-06 1.2 1.20693597561e-06 1.2 1.20696773374e-06 1.2 1.20699949187e-06 1.2 1.20703125e-06 1.2 1.20706300813e-06 1.2 1.20709476626e-06 1.2 1.20712652439e-06 1.2 1.20715828252e-06 1.2 1.20719004065e-06 1.2 1.20722179878e-06 1.2 1.20725355691e-06 1.2 1.20728531504e-06 1.2 1.20731707317e-06 1.2 1.2073488313e-06 1.2 1.20738058943e-06 1.2 1.20741234756e-06 1.2 1.20744410569e-06 1.2 1.20747586382e-06 1.2 1.20750762195e-06 1.2 1.20753938008e-06 1.2 1.20757113821e-06 1.2 1.20760289634e-06 1.2 1.20763465447e-06 1.2 1.2076664126e-06 1.2 1.20769817073e-06 1.2 1.20772992886e-06 1.2 1.20776168699e-06 1.2 1.20779344512e-06 1.2 1.20782520325e-06 1.2 1.20785696138e-06 1.2 1.20788871951e-06 1.2 1.20792047764e-06 1.2 1.20795223577e-06 1.2 1.2079839939e-06 1.2 1.20801575203e-06 1.2 1.20804751016e-06 1.2 1.20807926829e-06 1.2 1.20811102642e-06 1.2 1.20814278455e-06 1.2 1.20817454268e-06 1.2 1.20820630081e-06 1.2 1.20823805894e-06 1.2 1.20826981707e-06 1.2 1.2083015752e-06 1.2 1.20833333333e-06 1.2 1.20836509146e-06 1.2 1.20839684959e-06 1.2 1.20842860772e-06 1.2 1.20846036585e-06 1.2 1.20849212398e-06 1.2 1.20852388211e-06 1.2 1.20855564024e-06 1.2 1.20858739837e-06 1.2 1.2086191565e-06 1.2 1.20865091463e-06 1.2 1.20868267276e-06 1.2 1.20871443089e-06 1.2 1.20874618902e-06 1.2 1.20877794715e-06 1.2 1.20880970528e-06 1.2 1.20884146341e-06 1.2 1.20887322154e-06 1.2 1.20890497967e-06 1.2 1.2089367378e-06 1.2 1.20896849593e-06 1.2 1.20900025407e-06 1.2 1.2090320122e-06 1.2 1.20906377033e-06 1.2 1.20909552846e-06 1.2 1.20912728659e-06 1.2 1.20915904472e-06 1.2 1.20919080285e-06 1.2 1.20922256098e-06 1.2 1.20925431911e-06 1.2 1.20928607724e-06 1.2 1.20931783537e-06 1.2 1.2093495935e-06 1.2 1.20938135163e-06 1.2 1.20941310976e-06 1.2 1.20944486789e-06 1.2 1.20947662602e-06 1.2 1.20950838415e-06 1.2 1.20954014228e-06 1.2 1.20957190041e-06 1.2 1.20960365854e-06 1.2 1.20963541667e-06 1.2 1.2096671748e-06 1.2 1.20969893293e-06 1.2 1.20973069106e-06 1.2 1.20976244919e-06 1.2 1.20979420732e-06 1.2 1.20982596545e-06 1.2 1.20985772358e-06 1.2 1.20988948171e-06 1.2 1.20992123984e-06 1.2 1.20995299797e-06 1.2 1.2099847561e-06 1.2 1.21001651423e-06 1.2 1.21004827236e-06 1.2 1.21008003049e-06 1.2 1.21011178862e-06 1.2 1.21014354675e-06 1.2 1.21017530488e-06 1.2 1.21020706301e-06 1.2 1.21023882114e-06 1.2 1.21027057927e-06 1.2 1.2103023374e-06 1.2 1.21033409553e-06 1.2 1.21036585366e-06 1.2 1.21039761179e-06 1.2 1.21042936992e-06 1.2 1.21046112805e-06 1.2 1.21049288618e-06 1.2 1.21052464431e-06 1.2 1.21055640244e-06 1.2 1.21058816057e-06 1.2 1.2106199187e-06 1.2 1.21065167683e-06 1.2 1.21068343496e-06 1.2 1.21071519309e-06 1.2 1.21074695122e-06 1.2 1.21077870935e-06 1.2 1.21081046748e-06 1.2 1.21084222561e-06 1.2 1.21087398374e-06 1.2 1.21090574187e-06 1.2 1.2109375e-06 1.2 1.21096925813e-06 1.2 1.21100101626e-06 1.2 1.21103277439e-06 1.2 1.21106453252e-06 1.2 1.21109629065e-06 1.2 1.21112804878e-06 1.2 1.21115980691e-06 1.2 1.21119156504e-06 1.2 1.21122332317e-06 1.2 1.2112550813e-06 1.2 1.21128683943e-06 1.2 1.21131859756e-06 1.2 1.21135035569e-06 1.2 1.21138211382e-06 1.2 1.21141387195e-06 1.2 1.21144563008e-06 1.2 1.21147738821e-06 1.2 1.21150914634e-06 1.2 1.21154090447e-06 1.2 1.2115726626e-06 1.2 1.21160442073e-06 1.2 1.21163617886e-06 1.2 1.21166793699e-06 1.2 1.21169969512e-06 1.2 1.21173145325e-06 1.2 1.21176321138e-06 1.2 1.21179496951e-06 1.2 1.21182672764e-06 1.2 1.21185848577e-06 1.2 1.2118902439e-06 1.2 1.21192200203e-06 1.2 1.21195376016e-06 1.2 1.21198551829e-06 1.2 1.21201727642e-06 1.2 1.21204903455e-06 1.2 1.21208079268e-06 1.2 1.21211255081e-06 1.2 1.21214430894e-06 1.2 1.21217606707e-06 1.2 1.2122078252e-06 1.2 1.21223958333e-06 1.2 1.21227134146e-06 1.2 1.21230309959e-06 1.2 1.21233485772e-06 1.2 1.21236661585e-06 1.2 1.21239837398e-06 1.2 1.21243013211e-06 1.2 1.21246189024e-06 1.2 1.21249364837e-06 1.2 1.2125254065e-06 1.2 1.21255716463e-06 1.2 1.21258892276e-06 1.2 1.21262068089e-06 1.2 1.21265243902e-06 1.2 1.21268419715e-06 1.2 1.21271595528e-06 1.2 1.21274771341e-06 1.2 1.21277947154e-06 1.2 1.21281122967e-06 1.2 1.2128429878e-06 1.2 1.21287474593e-06 1.2 1.21290650407e-06 1.2 1.2129382622e-06 1.2 1.21297002033e-06 1.2 1.21300177846e-06 1.2 1.21303353659e-06 1.2 1.21306529472e-06 1.2 1.21309705285e-06 1.2 1.21312881098e-06 1.2 1.21316056911e-06 1.2 1.21319232724e-06 1.2 1.21322408537e-06 1.2 1.2132558435e-06 1.2 1.21328760163e-06 1.2 1.21331935976e-06 1.2 1.21335111789e-06 1.2 1.21338287602e-06 1.2 1.21341463415e-06 1.2 1.21344639228e-06 1.2 1.21347815041e-06 1.2 1.21350990854e-06 1.2 1.21354166667e-06 1.2 1.2135734248e-06 1.2 1.21360518293e-06 1.2 1.21363694106e-06 1.2 1.21366869919e-06 1.2 1.21370045732e-06 1.2 1.21373221545e-06 1.2 1.21376397358e-06 1.2 1.21379573171e-06 1.2 1.21382748984e-06 1.2 1.21385924797e-06 1.2 1.2138910061e-06 1.2 1.21392276423e-06 1.2 1.21395452236e-06 1.2 1.21398628049e-06 1.2 1.21401803862e-06 1.2 1.21404979675e-06 1.2 1.21408155488e-06 1.2 1.21411331301e-06 1.2 1.21414507114e-06 1.2 1.21417682927e-06 1.2 1.2142085874e-06 1.2 1.21424034553e-06 1.2 1.21427210366e-06 1.2 1.21430386179e-06 1.2 1.21433561992e-06 1.2 1.21436737805e-06 1.2 1.21439913618e-06 1.2 1.21443089431e-06 1.2 1.21446265244e-06 1.2 1.21449441057e-06 1.2 1.2145261687e-06 1.2 1.21455792683e-06 1.2 1.21458968496e-06 1.2 1.21462144309e-06 1.2 1.21465320122e-06 1.2 1.21468495935e-06 1.2 1.21471671748e-06 1.2 1.21474847561e-06 1.2 1.21478023374e-06 1.2 1.21481199187e-06 1.2 1.21484375e-06 1.2 1.21487550813e-06 1.2 1.21490726626e-06 1.2 1.21493902439e-06 1.2 1.21497078252e-06 1.2 1.21500254065e-06 1.2 1.21503429878e-06 1.2 1.21506605691e-06 1.2 1.21509781504e-06 1.2 1.21512957317e-06 1.2 1.2151613313e-06 1.2 1.21519308943e-06 1.2 1.21522484756e-06 1.2 1.21525660569e-06 1.2 1.21528836382e-06 1.2 1.21532012195e-06 1.2 1.21535188008e-06 1.2 1.21538363821e-06 1.2 1.21541539634e-06 1.2 1.21544715447e-06 1.2 1.2154789126e-06 1.2 1.21551067073e-06 1.2 1.21554242886e-06 1.2 1.21557418699e-06 1.2 1.21560594512e-06 1.2 1.21563770325e-06 1.2 1.21566946138e-06 1.2 1.21570121951e-06 1.2 1.21573297764e-06 1.2 1.21576473577e-06 1.2 1.2157964939e-06 1.2 1.21582825203e-06 1.2 1.21586001016e-06 1.2 1.21589176829e-06 1.2 1.21592352642e-06 1.2 1.21595528455e-06 1.2 1.21598704268e-06 1.2 1.21601880081e-06 1.2 1.21605055894e-06 1.2 1.21608231707e-06 1.2 1.2161140752e-06 1.2 1.21614583333e-06 1.2 1.21617759146e-06 1.2 1.21620934959e-06 1.2 1.21624110772e-06 1.2 1.21627286585e-06 1.2 1.21630462398e-06 1.2 1.21633638211e-06 1.2 1.21636814024e-06 1.2 1.21639989837e-06 1.2 1.2164316565e-06 1.2 1.21646341463e-06 1.2 1.21649517276e-06 1.2 1.21652693089e-06 1.2 1.21655868902e-06 1.2 1.21659044715e-06 1.2 1.21662220528e-06 1.2 1.21665396341e-06 1.2 1.21668572154e-06 1.2 1.21671747967e-06 1.2 1.2167492378e-06 1.2 1.21678099593e-06 1.2 1.21681275407e-06 1.2 1.2168445122e-06 1.2 1.21687627033e-06 1.2 1.21690802846e-06 1.2 1.21693978659e-06 1.2 1.21697154472e-06 1.2 1.21700330285e-06 1.2 1.21703506098e-06 1.2 1.21706681911e-06 1.2 1.21709857724e-06 1.2 1.21713033537e-06 1.2 1.2171620935e-06 1.2 1.21719385163e-06 1.2 1.21722560976e-06 1.2 1.21725736789e-06 1.2 1.21728912602e-06 1.2 1.21732088415e-06 1.2 1.21735264228e-06 1.2 1.21738440041e-06 1.2 1.21741615854e-06 1.2 1.21744791667e-06 1.2 1.2174796748e-06 1.2 1.21751143293e-06 1.2 1.21754319106e-06 1.2 1.21757494919e-06 1.2 1.21760670732e-06 1.2 1.21763846545e-06 1.2 1.21767022358e-06 1.2 1.21770198171e-06 1.2 1.21773373984e-06 1.2 1.21776549797e-06 1.2 1.2177972561e-06 1.2 1.21782901423e-06 1.2 1.21786077236e-06 1.2 1.21789253049e-06 1.2 1.21792428862e-06 1.2 1.21795604675e-06 1.2 1.21798780488e-06 1.2 1.21801956301e-06 1.2 1.21805132114e-06 1.2 1.21808307927e-06 1.2 1.2181148374e-06 1.2 1.21814659553e-06 1.2 1.21817835366e-06 1.2 1.21821011179e-06 1.2 1.21824186992e-06 1.2 1.21827362805e-06 1.2 1.21830538618e-06 1.2 1.21833714431e-06 1.2 1.21836890244e-06 1.2 1.21840066057e-06 1.2 1.2184324187e-06 1.2 1.21846417683e-06 1.2 1.21849593496e-06 1.2 1.21852769309e-06 1.2 1.21855945122e-06 1.2 1.21859120935e-06 1.2 1.21862296748e-06 1.2 1.21865472561e-06 1.2 1.21868648374e-06 1.2 1.21871824187e-06 1.2 1.21875e-06 1.2 1.21878175813e-06 1.2 1.21881351626e-06 1.2 1.21884527439e-06 1.2 1.21887703252e-06 1.2 1.21890879065e-06 1.2 1.21894054878e-06 1.2 1.21897230691e-06 1.2 1.21900406504e-06 1.2 1.21903582317e-06 1.2 1.2190675813e-06 1.2 1.21909933943e-06 1.2 1.21913109756e-06 1.2 1.21916285569e-06 1.2 1.21919461382e-06 1.2 1.21922637195e-06 1.2 1.21925813008e-06 1.2 1.21928988821e-06 1.2 1.21932164634e-06 1.2 1.21935340447e-06 1.2 1.2193851626e-06 1.2 1.21941692073e-06 1.2 1.21944867886e-06 1.2 1.21948043699e-06 1.2 1.21951219512e-06 1.2 1.21954395325e-06 1.2 1.21957571138e-06 1.2 1.21960746951e-06 1.2 1.21963922764e-06 1.2 1.21967098577e-06 1.2 1.2197027439e-06 1.2 1.21973450203e-06 1.2 1.21976626016e-06 1.2 1.21979801829e-06 1.2 1.21982977642e-06 1.2 1.21986153455e-06 1.2 1.21989329268e-06 1.2 1.21992505081e-06 1.2 1.21995680894e-06 1.2 1.21998856707e-06 1.2 1.2200203252e-06 1.2 1.22005208333e-06 1.2 1.22008384146e-06 1.2 1.22011559959e-06 1.2 1.22014735772e-06 1.2 1.22017911585e-06 1.2 1.22021087398e-06 1.2 1.22024263211e-06 1.2 1.22027439024e-06 1.2 1.22030614837e-06 1.2 1.2203379065e-06 1.2 1.22036966463e-06 1.2 1.22040142276e-06 1.2 1.22043318089e-06 1.2 1.22046493902e-06 1.2 1.22049669715e-06 1.2 1.22052845528e-06 1.2 1.22056021341e-06 1.2 1.22059197154e-06 1.2 1.22062372967e-06 1.2 1.2206554878e-06 1.2 1.22068724593e-06 1.2 1.22071900407e-06 1.2 1.2207507622e-06 1.2 1.22078252033e-06 1.2 1.22081427846e-06 1.2 1.22084603659e-06 1.2 1.22087779472e-06 1.2 1.22090955285e-06 1.2 1.22094131098e-06 1.2 1.22097306911e-06 1.2 1.22100482724e-06 1.2 1.22103658537e-06 1.2 1.2210683435e-06 1.2 1.22110010163e-06 1.2 1.22113185976e-06 1.2 1.22116361789e-06 1.2 1.22119537602e-06 1.2 1.22122713415e-06 1.2 1.22125889228e-06 1.2 1.22129065041e-06 1.2 1.22132240854e-06 1.2 1.22135416667e-06 1.2 1.2213859248e-06 1.2 1.22141768293e-06 1.2 1.22144944106e-06 1.2 1.22148119919e-06 1.2 1.22151295732e-06 1.2 1.22154471545e-06 1.2 1.22157647358e-06 1.2 1.22160823171e-06 1.2 1.22163998984e-06 1.2 1.22167174797e-06 1.2 1.2217035061e-06 1.2 1.22173526423e-06 1.2 1.22176702236e-06 1.2 1.22179878049e-06 1.2 1.22183053862e-06 1.2 1.22186229675e-06 1.2 1.22189405488e-06 1.2 1.22192581301e-06 1.2 1.22195757114e-06 1.2 1.22198932927e-06 1.2 1.2220210874e-06 1.2 1.22205284553e-06 1.2 1.22208460366e-06 1.2 1.22211636179e-06 1.2 1.22214811992e-06 1.2 1.22217987805e-06 1.2 1.22221163618e-06 1.2 1.22224339431e-06 1.2 1.22227515244e-06 1.2 1.22230691057e-06 1.2 1.2223386687e-06 1.2 1.22237042683e-06 1.2 1.22240218496e-06 1.2 1.22243394309e-06 1.2 1.22246570122e-06 1.2 1.22249745935e-06 1.2 1.22252921748e-06 1.2 1.22256097561e-06 1.2 1.22259273374e-06 1.2 1.22262449187e-06 1.2 1.22265625e-06 1.2 1.22268800813e-06 1.2 1.22271976626e-06 1.2 1.22275152439e-06 1.2 1.22278328252e-06 1.2 1.22281504065e-06 1.2 1.22284679878e-06 1.2 1.22287855691e-06 1.2 1.22291031504e-06 1.2 1.22294207317e-06 1.2 1.2229738313e-06 1.2 1.22300558943e-06 1.2 1.22303734756e-06 1.2 1.22306910569e-06 1.2 1.22310086382e-06 1.2 1.22313262195e-06 1.2 1.22316438008e-06 1.2 1.22319613821e-06 1.2 1.22322789634e-06 1.2 1.22325965447e-06 1.2 1.2232914126e-06 1.2 1.22332317073e-06 1.2 1.22335492886e-06 1.2 1.22338668699e-06 1.2 1.22341844512e-06 1.2 1.22345020325e-06 1.2 1.22348196138e-06 1.2 1.22351371951e-06 1.2 1.22354547764e-06 1.2 1.22357723577e-06 1.2 1.2236089939e-06 1.2 1.22364075203e-06 1.2 1.22367251016e-06 1.2 1.22370426829e-06 1.2 1.22373602642e-06 1.2 1.22376778455e-06 1.2 1.22379954268e-06 1.2 1.22383130081e-06 1.2 1.22386305894e-06 1.2 1.22389481707e-06 1.2 1.2239265752e-06 1.2 1.22395833333e-06 1.2 1.22399009146e-06 1.2 1.22402184959e-06 1.2 1.22405360772e-06 1.2 1.22408536585e-06 1.2 1.22411712398e-06 1.2 1.22414888211e-06 1.2 1.22418064024e-06 1.2 1.22421239837e-06 1.2 1.2242441565e-06 1.2 1.22427591463e-06 1.2 1.22430767276e-06 1.2 1.22433943089e-06 1.2 1.22437118902e-06 1.2 1.22440294715e-06 1.2 1.22443470528e-06 1.2 1.22446646341e-06 1.2 1.22449822154e-06 1.2 1.22452997967e-06 1.2 1.2245617378e-06 1.2 1.22459349593e-06 1.2 1.22462525407e-06 1.2 1.2246570122e-06 1.2 1.22468877033e-06 1.2 1.22472052846e-06 1.2 1.22475228659e-06 1.2 1.22478404472e-06 1.2 1.22481580285e-06 1.2 1.22484756098e-06 1.2 1.22487931911e-06 1.2 1.22491107724e-06 1.2 1.22494283537e-06 1.2 1.2249745935e-06 1.2 1.22500635163e-06 1.2 1.22503810976e-06 1.2 1.22506986789e-06 1.2 1.22510162602e-06 1.2 1.22513338415e-06 1.2 1.22516514228e-06 1.2 1.22519690041e-06 1.2 1.22522865854e-06 1.2 1.22526041667e-06 1.2 1.2252921748e-06 1.2 1.22532393293e-06 1.2 1.22535569106e-06 1.2 1.22538744919e-06 1.2 1.22541920732e-06 1.2 1.22545096545e-06 1.2 1.22548272358e-06 1.2 1.22551448171e-06 1.2 1.22554623984e-06 1.2 1.22557799797e-06 1.2 1.2256097561e-06 1.2 1.22564151423e-06 1.2 1.22567327236e-06 1.2 1.22570503049e-06 1.2 1.22573678862e-06 1.2 1.22576854675e-06 1.2 1.22580030488e-06 1.2 1.22583206301e-06 1.2 1.22586382114e-06 1.2 1.22589557927e-06 1.2 1.2259273374e-06 1.2 1.22595909553e-06 1.2 1.22599085366e-06 1.2 1.22602261179e-06 1.2 1.22605436992e-06 1.2 1.22608612805e-06 1.2 1.22611788618e-06 1.2 1.22614964431e-06 1.2 1.22618140244e-06 1.2 1.22621316057e-06 1.2 1.2262449187e-06 1.2 1.22627667683e-06 1.2 1.22630843496e-06 1.2 1.22634019309e-06 1.2 1.22637195122e-06 1.2 1.22640370935e-06 1.2 1.22643546748e-06 1.2 1.22646722561e-06 1.2 1.22649898374e-06 1.2 1.22653074187e-06 1.2 1.2265625e-06 1.2 1.22659425813e-06 1.2 1.22662601626e-06 1.2 1.22665777439e-06 1.2 1.22668953252e-06 1.2 1.22672129065e-06 1.2 1.22675304878e-06 1.2 1.22678480691e-06 1.2 1.22681656504e-06 1.2 1.22684832317e-06 1.2 1.2268800813e-06 1.2 1.22691183943e-06 1.2 1.22694359756e-06 1.2 1.22697535569e-06 1.2 1.22700711382e-06 1.2 1.22703887195e-06 1.2 1.22707063008e-06 1.2 1.22710238821e-06 1.2 1.22713414634e-06 1.2 1.22716590447e-06 1.2 1.2271976626e-06 1.2 1.22722942073e-06 1.2 1.22726117886e-06 1.2 1.22729293699e-06 1.2 1.22732469512e-06 1.2 1.22735645325e-06 1.2 1.22738821138e-06 1.2 1.22741996951e-06 1.2 1.22745172764e-06 1.2 1.22748348577e-06 1.2 1.2275152439e-06 1.2 1.22754700203e-06 1.2 1.22757876016e-06 1.2 1.22761051829e-06 1.2 1.22764227642e-06 1.2 1.22767403455e-06 1.2 1.22770579268e-06 1.2 1.22773755081e-06 1.2 1.22776930894e-06 1.2 1.22780106707e-06 1.2 1.2278328252e-06 1.2 1.22786458333e-06 1.2 1.22789634146e-06 1.2 1.22792809959e-06 1.2 1.22795985772e-06 1.2 1.22799161585e-06 1.2 1.22802337398e-06 1.2 1.22805513211e-06 1.2 1.22808689024e-06 1.2 1.22811864837e-06 1.2 1.2281504065e-06 1.2 1.22818216463e-06 1.2 1.22821392276e-06 1.2 1.22824568089e-06 1.2 1.22827743902e-06 1.2 1.22830919715e-06 1.2 1.22834095528e-06 1.2 1.22837271341e-06 1.2 1.22840447154e-06 1.2 1.22843622967e-06 1.2 1.2284679878e-06 1.2 1.22849974593e-06 1.2 1.22853150407e-06 1.2 1.2285632622e-06 1.2 1.22859502033e-06 1.2 1.22862677846e-06 1.2 1.22865853659e-06 1.2 1.22869029472e-06 1.2 1.22872205285e-06 1.2 1.22875381098e-06 1.2 1.22878556911e-06 1.2 1.22881732724e-06 1.2 1.22884908537e-06 1.2 1.2288808435e-06 1.2 1.22891260163e-06 1.2 1.22894435976e-06 1.2 1.22897611789e-06 1.2 1.22900787602e-06 1.2 1.22903963415e-06 1.2 1.22907139228e-06 1.2 1.22910315041e-06 1.2 1.22913490854e-06 1.2 1.22916666667e-06 1.2 1.2291984248e-06 1.2 1.22923018293e-06 1.2 1.22926194106e-06 1.2 1.22929369919e-06 1.2 1.22932545732e-06 1.2 1.22935721545e-06 1.2 1.22938897358e-06 1.2 1.22942073171e-06 1.2 1.22945248984e-06 1.2 1.22948424797e-06 1.2 1.2295160061e-06 1.2 1.22954776423e-06 1.2 1.22957952236e-06 1.2 1.22961128049e-06 1.2 1.22964303862e-06 1.2 1.22967479675e-06 1.2 1.22970655488e-06 1.2 1.22973831301e-06 1.2 1.22977007114e-06 1.2 1.22980182927e-06 1.2 1.2298335874e-06 1.2 1.22986534553e-06 1.2 1.22989710366e-06 1.2 1.22992886179e-06 1.2 1.22996061992e-06 1.2 1.22999237805e-06 1.2 1.23002413618e-06 1.2 1.23005589431e-06 1.2 1.23008765244e-06 1.2 1.23011941057e-06 1.2 1.2301511687e-06 1.2 1.23018292683e-06 1.2 1.23021468496e-06 1.2 1.23024644309e-06 1.2 1.23027820122e-06 1.2 1.23030995935e-06 1.2 1.23034171748e-06 1.2 1.23037347561e-06 1.2 1.23040523374e-06 1.2 1.23043699187e-06 1.2 1.23046875e-06 1.2 1.23050050813e-06 1.2 1.23053226626e-06 1.2 1.23056402439e-06 1.2 1.23059578252e-06 1.2 1.23062754065e-06 1.2 1.23065929878e-06 1.2 1.23069105691e-06 1.2 1.23072281504e-06 1.2 1.23075457317e-06 1.2 1.2307863313e-06 1.2 1.23081808943e-06 1.2 1.23084984756e-06 1.2 1.23088160569e-06 1.2 1.23091336382e-06 1.2 1.23094512195e-06 1.2 1.23097688008e-06 1.2 1.23100863821e-06 1.2 1.23104039634e-06 1.2 1.23107215447e-06 1.2 1.2311039126e-06 1.2 1.23113567073e-06 1.2 1.23116742886e-06 1.2 1.23119918699e-06 1.2 1.23123094512e-06 1.2 1.23126270325e-06 1.2 1.23129446138e-06 1.2 1.23132621951e-06 1.2 1.23135797764e-06 1.2 1.23138973577e-06 1.2 1.2314214939e-06 1.2 1.23145325203e-06 1.2 1.23148501016e-06 1.2 1.23151676829e-06 1.2 1.23154852642e-06 1.2 1.23158028455e-06 1.2 1.23161204268e-06 1.2 1.23164380081e-06 1.2 1.23167555894e-06 1.2 1.23170731707e-06 1.2 1.2317390752e-06 1.2 1.23177083333e-06 1.2 1.23180259146e-06 1.2 1.23183434959e-06 1.2 1.23186610772e-06 1.2 1.23189786585e-06 1.2 1.23192962398e-06 1.2 1.23196138211e-06 1.2 1.23199314024e-06 1.2 1.23202489837e-06 1.2 1.2320566565e-06 1.2 1.23208841463e-06 1.2 1.23212017276e-06 1.2 1.23215193089e-06 1.2 1.23218368902e-06 1.2 1.23221544715e-06 1.2 1.23224720528e-06 1.2 1.23227896341e-06 1.2 1.23231072154e-06 1.2 1.23234247967e-06 1.2 1.2323742378e-06 1.2 1.23240599593e-06 1.2 1.23243775407e-06 1.2 1.2324695122e-06 1.2 1.23250127033e-06 1.2 1.23253302846e-06 1.2 1.23256478659e-06 1.2 1.23259654472e-06 1.2 1.23262830285e-06 1.2 1.23266006098e-06 1.2 1.23269181911e-06 1.2 1.23272357724e-06 1.2 1.23275533537e-06 1.2 1.2327870935e-06 1.2 1.23281885163e-06 1.2 1.23285060976e-06 1.2 1.23288236789e-06 1.2 1.23291412602e-06 1.2 1.23294588415e-06 1.2 1.23297764228e-06 1.2 1.23300940041e-06 1.2 1.23304115854e-06 1.2 1.23307291667e-06 1.2 1.2331046748e-06 1.2 1.23313643293e-06 1.2 1.23316819106e-06 1.2 1.23319994919e-06 1.2 1.23323170732e-06 1.2 1.23326346545e-06 1.2 1.23329522358e-06 1.2 1.23332698171e-06 1.2 1.23335873984e-06 1.2 1.23339049797e-06 1.2 1.2334222561e-06 1.2 1.23345401423e-06 1.2 1.23348577236e-06 1.2 1.23351753049e-06 1.2 1.23354928862e-06 1.2 1.23358104675e-06 1.2 1.23361280488e-06 1.2 1.23364456301e-06 1.2 1.23367632114e-06 1.2 1.23370807927e-06 1.2 1.2337398374e-06 1.2 1.23377159553e-06 1.2 1.23380335366e-06 1.2 1.23383511179e-06 1.2 1.23386686992e-06 1.2 1.23389862805e-06 1.2 1.23393038618e-06 1.2 1.23396214431e-06 1.2 1.23399390244e-06 1.2 1.23402566057e-06 1.2 1.2340574187e-06 1.2 1.23408917683e-06 1.2 1.23412093496e-06 1.2 1.23415269309e-06 1.2 1.23418445122e-06 1.2 1.23421620935e-06 1.2 1.23424796748e-06 1.2 1.23427972561e-06 1.2 1.23431148374e-06 1.2 1.23434324187e-06 1.2 1.234375e-06 1.2 1.23440675813e-06 1.2 1.23443851626e-06 1.2 1.23447027439e-06 1.2 1.23450203252e-06 1.2 1.23453379065e-06 1.2 1.23456554878e-06 1.2 1.23459730691e-06 1.2 1.23462906504e-06 1.2 1.23466082317e-06 1.2 1.2346925813e-06 1.2 1.23472433943e-06 1.2 1.23475609756e-06 1.2 1.23478785569e-06 1.2 1.23481961382e-06 1.2 1.23485137195e-06 1.2 1.23488313008e-06 1.2 1.23491488821e-06 1.2 1.23494664634e-06 1.2 1.23497840447e-06 1.2 1.2350101626e-06 1.2 1.23504192073e-06 1.2 1.23507367886e-06 1.2 1.23510543699e-06 1.2 1.23513719512e-06 1.2 1.23516895325e-06 1.2 1.23520071138e-06 1.2 1.23523246951e-06 1.2 1.23526422764e-06 1.2 1.23529598577e-06 1.2 1.2353277439e-06 1.2 1.23535950203e-06 1.2 1.23539126016e-06 1.2 1.23542301829e-06 1.2 1.23545477642e-06 1.2 1.23548653455e-06 1.2 1.23551829268e-06 1.2 1.23555005081e-06 1.2 1.23558180894e-06 1.2 1.23561356707e-06 1.2 1.2356453252e-06 1.2 1.23567708333e-06 1.2 1.23570884146e-06 1.2 1.23574059959e-06 1.2 1.23577235772e-06 1.2 1.23580411585e-06 1.2 1.23583587398e-06 1.2 1.23586763211e-06 1.2 1.23589939024e-06 1.2 1.23593114837e-06 1.2 1.2359629065e-06 1.2 1.23599466463e-06 1.2 1.23602642276e-06 1.2 1.23605818089e-06 1.2 1.23608993902e-06 1.2 1.23612169715e-06 1.2 1.23615345528e-06 1.2 1.23618521341e-06 1.2 1.23621697154e-06 1.2 1.23624872967e-06 1.2 1.2362804878e-06 1.2 1.23631224593e-06 1.2 1.23634400407e-06 1.2 1.2363757622e-06 1.2 1.23640752033e-06 1.2 1.23643927846e-06 1.2 1.23647103659e-06 1.2 1.23650279472e-06 1.2 1.23653455285e-06 1.2 1.23656631098e-06 1.2 1.23659806911e-06 1.2 1.23662982724e-06 1.2 1.23666158537e-06 1.2 1.2366933435e-06 1.2 1.23672510163e-06 1.2 1.23675685976e-06 1.2 1.23678861789e-06 1.2 1.23682037602e-06 1.2 1.23685213415e-06 1.2 1.23688389228e-06 1.2 1.23691565041e-06 1.2 1.23694740854e-06 1.2 1.23697916667e-06 1.2 1.2370109248e-06 1.2 1.23704268293e-06 1.2 1.23707444106e-06 1.2 1.23710619919e-06 1.2 1.23713795732e-06 1.2 1.23716971545e-06 1.2 1.23720147358e-06 1.2 1.23723323171e-06 1.2 1.23726498984e-06 1.2 1.23729674797e-06 1.2 1.2373285061e-06 1.2 1.23736026423e-06 1.2 1.23739202236e-06 1.2 1.23742378049e-06 1.2 1.23745553862e-06 1.2 1.23748729675e-06 1.2 1.23751905488e-06 1.2 1.23755081301e-06 1.2 1.23758257114e-06 1.2 1.23761432927e-06 1.2 1.2376460874e-06 1.2 1.23767784553e-06 1.2 1.23770960366e-06 1.2 1.23774136179e-06 1.2 1.23777311992e-06 1.2 1.23780487805e-06 1.2 1.23783663618e-06 1.2 1.23786839431e-06 1.2 1.23790015244e-06 1.2 1.23793191057e-06 1.2 1.2379636687e-06 1.2 1.23799542683e-06 1.2 1.23802718496e-06 1.2 1.23805894309e-06 1.2 1.23809070122e-06 1.2 1.23812245935e-06 1.2 1.23815421748e-06 1.2 1.23818597561e-06 1.2 1.23821773374e-06 1.2 1.23824949187e-06 1.2 1.23828125e-06 1.2 1.23831300813e-06 1.2 1.23834476626e-06 1.2 1.23837652439e-06 1.2 1.23840828252e-06 1.2 1.23844004065e-06 1.2 1.23847179878e-06 1.2 1.23850355691e-06 1.2 1.23853531504e-06 1.2 1.23856707317e-06 1.2 1.2385988313e-06 1.2 1.23863058943e-06 1.2 1.23866234756e-06 1.2 1.23869410569e-06 1.2 1.23872586382e-06 1.2 1.23875762195e-06 1.2 1.23878938008e-06 1.2 1.23882113821e-06 1.2 1.23885289634e-06 1.2 1.23888465447e-06 1.2 1.2389164126e-06 1.2 1.23894817073e-06 1.2 1.23897992886e-06 1.2 1.23901168699e-06 1.2 1.23904344512e-06 1.2 1.23907520325e-06 1.2 1.23910696138e-06 1.2 1.23913871951e-06 1.2 1.23917047764e-06 1.2 1.23920223577e-06 1.2 1.2392339939e-06 1.2 1.23926575203e-06 1.2 1.23929751016e-06 1.2 1.23932926829e-06 1.2 1.23936102642e-06 1.2 1.23939278455e-06 1.2 1.23942454268e-06 1.2 1.23945630081e-06 1.2 1.23948805894e-06 1.2 1.23951981707e-06 1.2 1.2395515752e-06 1.2 1.23958333333e-06 1.2 1.23961509146e-06 1.2 1.23964684959e-06 1.2 1.23967860772e-06 1.2 1.23971036585e-06 1.2 1.23974212398e-06 1.2 1.23977388211e-06 1.2 1.23980564024e-06 1.2 1.23983739837e-06 1.2 1.2398691565e-06 1.2 1.23990091463e-06 1.2 1.23993267276e-06 1.2 1.23996443089e-06 1.2 1.23999618902e-06 1.2 1.24002794715e-06 1.2 1.24005970528e-06 1.2 1.24009146341e-06 1.2 1.24012322154e-06 1.2 1.24015497967e-06 1.2 1.2401867378e-06 1.2 1.24021849593e-06 1.2 1.24025025407e-06 1.2 1.2402820122e-06 1.2 1.24031377033e-06 1.2 1.24034552846e-06 1.2 1.24037728659e-06 1.2 1.24040904472e-06 1.2 1.24044080285e-06 1.2 1.24047256098e-06 1.2 1.24050431911e-06 1.2 1.24053607724e-06 1.2 1.24056783537e-06 1.2 1.2405995935e-06 1.2 1.24063135163e-06 1.2 1.24066310976e-06 1.2 1.24069486789e-06 1.2 1.24072662602e-06 1.2 1.24075838415e-06 1.2 1.24079014228e-06 1.2 1.24082190041e-06 1.2 1.24085365854e-06 1.2 1.24088541667e-06 1.2 1.2409171748e-06 1.2 1.24094893293e-06 1.2 1.24098069106e-06 1.2 1.24101244919e-06 1.2 1.24104420732e-06 1.2 1.24107596545e-06 1.2 1.24110772358e-06 1.2 1.24113948171e-06 1.2 1.24117123984e-06 1.2 1.24120299797e-06 1.2 1.2412347561e-06 1.2 1.24126651423e-06 1.2 1.24129827236e-06 1.2 1.24133003049e-06 1.2 1.24136178862e-06 1.2 1.24139354675e-06 1.2 1.24142530488e-06 1.2 1.24145706301e-06 1.2 1.24148882114e-06 1.2 1.24152057927e-06 1.2 1.2415523374e-06 1.2 1.24158409553e-06 1.2 1.24161585366e-06 1.2 1.24164761179e-06 1.2 1.24167936992e-06 1.2 1.24171112805e-06 1.2 1.24174288618e-06 1.2 1.24177464431e-06 1.2 1.24180640244e-06 1.2 1.24183816057e-06 1.2 1.2418699187e-06 1.2 1.24190167683e-06 1.2 1.24193343496e-06 1.2 1.24196519309e-06 1.2 1.24199695122e-06 1.2 1.24202870935e-06 1.2 1.24206046748e-06 1.2 1.24209222561e-06 1.2 1.24212398374e-06 1.2 1.24215574187e-06 1.2 1.2421875e-06 1.2 1.24221925813e-06 1.2 1.24225101626e-06 1.2 1.24228277439e-06 1.2 1.24231453252e-06 1.2 1.24234629065e-06 1.2 1.24237804878e-06 1.2 1.24240980691e-06 1.2 1.24244156504e-06 1.2 1.24247332317e-06 1.2 1.2425050813e-06 1.2 1.24253683943e-06 1.2 1.24256859756e-06 1.2 1.24260035569e-06 1.2 1.24263211382e-06 1.2 1.24266387195e-06 1.2 1.24269563008e-06 1.2 1.24272738821e-06 1.2 1.24275914634e-06 1.2 1.24279090447e-06 1.2 1.2428226626e-06 1.2 1.24285442073e-06 1.2 1.24288617886e-06 1.2 1.24291793699e-06 1.2 1.24294969512e-06 1.2 1.24298145325e-06 1.2 1.24301321138e-06 1.2 1.24304496951e-06 1.2 1.24307672764e-06 1.2 1.24310848577e-06 1.2 1.2431402439e-06 1.2 1.24317200203e-06 1.2 1.24320376016e-06 1.2 1.24323551829e-06 1.2 1.24326727642e-06 1.2 1.24329903455e-06 1.2 1.24333079268e-06 1.2 1.24336255081e-06 1.2 1.24339430894e-06 1.2 1.24342606707e-06 1.2 1.2434578252e-06 1.2 1.24348958333e-06 1.2 1.24352134146e-06 1.2 1.24355309959e-06 1.2 1.24358485772e-06 1.2 1.24361661585e-06 1.2 1.24364837398e-06 1.2 1.24368013211e-06 1.2 1.24371189024e-06 1.2 1.24374364837e-06 1.2 1.2437754065e-06 1.2 1.24380716463e-06 1.2 1.24383892276e-06 1.2 1.24387068089e-06 1.2 1.24390243902e-06 1.2 1.24393419715e-06 1.2 1.24396595528e-06 1.2 1.24399771341e-06 1.2 1.24402947154e-06 1.2 1.24406122967e-06 1.2 1.2440929878e-06 1.2 1.24412474593e-06 1.2 1.24415650407e-06 1.2 1.2441882622e-06 1.2 1.24422002033e-06 1.2 1.24425177846e-06 1.2 1.24428353659e-06 1.2 1.24431529472e-06 1.2 1.24434705285e-06 1.2 1.24437881098e-06 1.2 1.24441056911e-06 1.2 1.24444232724e-06 1.2 1.24447408537e-06 1.2 1.2445058435e-06 1.2 1.24453760163e-06 1.2 1.24456935976e-06 1.2 1.24460111789e-06 1.2 1.24463287602e-06 1.2 1.24466463415e-06 1.2 1.24469639228e-06 1.2 1.24472815041e-06 1.2 1.24475990854e-06 1.2 1.24479166667e-06 1.2 1.2448234248e-06 1.2 1.24485518293e-06 1.2 1.24488694106e-06 1.2 1.24491869919e-06 1.2 1.24495045732e-06 1.2 1.24498221545e-06 1.2 1.24501397358e-06 1.2 1.24504573171e-06 1.2 1.24507748984e-06 1.2 1.24510924797e-06 1.2 1.2451410061e-06 1.2 1.24517276423e-06 1.2 1.24520452236e-06 1.2 1.24523628049e-06 1.2 1.24526803862e-06 1.2 1.24529979675e-06 1.2 1.24533155488e-06 1.2 1.24536331301e-06 1.2 1.24539507114e-06 1.2 1.24542682927e-06 1.2 1.2454585874e-06 1.2 1.24549034553e-06 1.2 1.24552210366e-06 1.2 1.24555386179e-06 1.2 1.24558561992e-06 1.2 1.24561737805e-06 1.2 1.24564913618e-06 1.2 1.24568089431e-06 1.2 1.24571265244e-06 1.2 1.24574441057e-06 1.2 1.2457761687e-06 1.2 1.24580792683e-06 1.2 1.24583968496e-06 1.2 1.24587144309e-06 1.2 1.24590320122e-06 1.2 1.24593495935e-06 1.2 1.24596671748e-06 1.2 1.24599847561e-06 1.2 1.24603023374e-06 1.2 1.24606199187e-06 1.2 1.24609375e-06 1.2 1.24612550813e-06 1.2 1.24615726626e-06 1.2 1.24618902439e-06 1.2 1.24622078252e-06 1.2 1.24625254065e-06 1.2 1.24628429878e-06 1.2 1.24631605691e-06 1.2 1.24634781504e-06 1.2 1.24637957317e-06 1.2 1.2464113313e-06 1.2 1.24644308943e-06 1.2 1.24647484756e-06 1.2 1.24650660569e-06 1.2 1.24653836382e-06 1.2 1.24657012195e-06 1.2 1.24660188008e-06 1.2 1.24663363821e-06 1.2 1.24666539634e-06 1.2 1.24669715447e-06 1.2 1.2467289126e-06 1.2 1.24676067073e-06 1.2 1.24679242886e-06 1.2 1.24682418699e-06 1.2 1.24685594512e-06 1.2 1.24688770325e-06 1.2 1.24691946138e-06 1.2 1.24695121951e-06 1.2 1.24698297764e-06 1.2 1.24701473577e-06 1.2 1.2470464939e-06 1.2 1.24707825203e-06 1.2 1.24711001016e-06 1.2 1.24714176829e-06 1.2 1.24717352642e-06 1.2 1.24720528455e-06 1.2 1.24723704268e-06 1.2 1.24726880081e-06 1.2 1.24730055894e-06 1.2 1.24733231707e-06 1.2 1.2473640752e-06 1.2 1.24739583333e-06 1.2 1.24742759146e-06 1.2 1.24745934959e-06 1.2 1.24749110772e-06 1.2 1.24752286585e-06 1.2 1.24755462398e-06 1.2 1.24758638211e-06 1.2 1.24761814024e-06 1.2 1.24764989837e-06 1.2 1.2476816565e-06 1.2 1.24771341463e-06 1.2 1.24774517276e-06 1.2 1.24777693089e-06 1.2 1.24780868902e-06 1.2 1.24784044715e-06 1.2 1.24787220528e-06 1.2 1.24790396341e-06 1.2 1.24793572154e-06 1.2 1.24796747967e-06 1.2 1.2479992378e-06 1.2 1.24803099593e-06 1.2 1.24806275407e-06 1.2 1.2480945122e-06 1.2 1.24812627033e-06 1.2 1.24815802846e-06 1.2 1.24818978659e-06 1.2 1.24822154472e-06 1.2 1.24825330285e-06 1.2 1.24828506098e-06 1.2 1.24831681911e-06 1.2 1.24834857724e-06 1.2 1.24838033537e-06 1.2 1.2484120935e-06 1.2 1.24844385163e-06 1.2 1.24847560976e-06 1.2 1.24850736789e-06 1.2 1.24853912602e-06 1.2 1.24857088415e-06 1.2 1.24860264228e-06 1.2 1.24863440041e-06 1.2 1.24866615854e-06 1.2 1.24869791667e-06 1.2 1.2487296748e-06 1.2 1.24876143293e-06 1.2 1.24879319106e-06 1.2 1.24882494919e-06 1.2 1.24885670732e-06 1.2 1.24888846545e-06 1.2 1.24892022358e-06 1.2 1.24895198171e-06 1.2 1.24898373984e-06 1.2 1.24901549797e-06 1.2 1.2490472561e-06 1.2 1.24907901423e-06 1.2 1.24911077236e-06 1.2 1.24914253049e-06 1.2 1.24917428862e-06 1.2 1.24920604675e-06 1.2 1.24923780488e-06 1.2 1.24926956301e-06 1.2 1.24930132114e-06 1.2 1.24933307927e-06 1.2 1.2493648374e-06 1.2 1.24939659553e-06 1.2 1.24942835366e-06 1.2 1.24946011179e-06 1.2 1.24949186992e-06 1.2 1.24952362805e-06 1.2 1.24955538618e-06 1.2 1.24958714431e-06 1.2 1.24961890244e-06 1.2 1.24965066057e-06 1.2 1.2496824187e-06 1.2 1.24971417683e-06 1.2 1.24974593496e-06 1.2 1.24977769309e-06 1.2 1.24980945122e-06 1.2 1.24984120935e-06 1.2 1.24987296748e-06 1.2 1.24990472561e-06 1.2 1.24993648374e-06 1.2 1.24996824187e-06 1.2 1.25e-06 1.2 1.25003175813e-06 1.2 1.25006351626e-06 1.2 1.25009527439e-06 1.2 1.25012703252e-06 1.2 1.25015879065e-06 1.2 1.25019054878e-06 1.2 1.25022230691e-06 1.2 1.25025406504e-06 1.2 1.25028582317e-06 1.2 1.2503175813e-06 1.2 1.25034933943e-06 1.2 1.25038109756e-06 1.2 1.25041285569e-06 1.2 1.25044461382e-06 1.2 1.25047637195e-06 1.2 1.25050813008e-06 1.2 1.25053988821e-06 1.2 1.25057164634e-06 1.2 1.25060340447e-06 1.2 1.2506351626e-06 1.2 1.25066692073e-06 1.2 1.25069867886e-06 1.2 1.25073043699e-06 1.2 1.25076219512e-06 1.2 1.25079395325e-06 1.2 1.25082571138e-06 1.2 1.25085746951e-06 1.2 1.25088922764e-06 1.2 1.25092098577e-06 1.2 1.2509527439e-06 1.2 1.25098450203e-06 1.2 1.25101626016e-06 1.2 1.25104801829e-06 1.2 1.25107977642e-06 1.2 1.25111153455e-06 1.2 1.25114329268e-06 1.2 1.25117505081e-06 1.2 1.25120680894e-06 1.2 1.25123856707e-06 1.2 1.2512703252e-06 1.2 1.25130208333e-06 1.2 1.25133384146e-06 1.2 1.25136559959e-06 1.2 1.25139735772e-06 1.2 1.25142911585e-06 1.2 1.25146087398e-06 1.2 1.25149263211e-06 1.2 1.25152439024e-06 1.2 1.25155614837e-06 1.2 1.2515879065e-06 1.2 1.25161966463e-06 1.2 1.25165142276e-06 1.2 1.25168318089e-06 1.2 1.25171493902e-06 1.2 1.25174669715e-06 1.2 1.25177845528e-06 1.2 1.25181021341e-06 1.2 1.25184197154e-06 1.2 1.25187372967e-06 1.2 1.2519054878e-06 1.2 1.25193724593e-06 1.2 1.25196900407e-06 1.2 1.2520007622e-06 1.2 1.25203252033e-06 1.2 1.25206427846e-06 1.2 1.25209603659e-06 1.2 1.25212779472e-06 1.2 1.25215955285e-06 1.2 1.25219131098e-06 1.2 1.25222306911e-06 1.2 1.25225482724e-06 1.2 1.25228658537e-06 1.2 1.2523183435e-06 1.2 1.25235010163e-06 1.2 1.25238185976e-06 1.2 1.25241361789e-06 1.2 1.25244537602e-06 1.2 1.25247713415e-06 1.2 1.25250889228e-06 1.2 1.25254065041e-06 1.2 1.25257240854e-06 1.2 1.25260416667e-06 1.2 1.2526359248e-06 1.2 1.25266768293e-06 1.2 1.25269944106e-06 1.2 1.25273119919e-06 1.2 1.25276295732e-06 1.2 1.25279471545e-06 1.2 1.25282647358e-06 1.2 1.25285823171e-06 1.2 1.25288998984e-06 1.2 1.25292174797e-06 1.2 1.2529535061e-06 1.2 1.25298526423e-06 1.2 1.25301702236e-06 1.2 1.25304878049e-06 1.2 1.25308053862e-06 1.2 1.25311229675e-06 1.2 1.25314405488e-06 1.2 1.25317581301e-06 1.2 1.25320757114e-06 1.2 1.25323932927e-06 1.2 1.2532710874e-06 1.2 1.25330284553e-06 1.2 1.25333460366e-06 1.2 1.25336636179e-06 1.2 1.25339811992e-06 1.2 1.25342987805e-06 1.2 1.25346163618e-06 1.2 1.25349339431e-06 1.2 1.25352515244e-06 1.2 1.25355691057e-06 1.2 1.2535886687e-06 1.2 1.25362042683e-06 1.2 1.25365218496e-06 1.2 1.25368394309e-06 1.2 1.25371570122e-06 1.2 1.25374745935e-06 1.2 1.25377921748e-06 1.2 1.25381097561e-06 1.2 1.25384273374e-06 1.2 1.25387449187e-06 1.2 1.25390625e-06 1.2 1.25393800813e-06 1.2 1.25396976626e-06 1.2 1.25400152439e-06 1.2 1.25403328252e-06 1.2 1.25406504065e-06 1.2 1.25409679878e-06 1.2 1.25412855691e-06 1.2 1.25416031504e-06 1.2 1.25419207317e-06 1.2 1.2542238313e-06 1.2 1.25425558943e-06 1.2 1.25428734756e-06 1.2 1.25431910569e-06 1.2 1.25435086382e-06 1.2 1.25438262195e-06 1.2 1.25441438008e-06 1.2 1.25444613821e-06 1.2 1.25447789634e-06 1.2 1.25450965447e-06 1.2 1.2545414126e-06 1.2 1.25457317073e-06 1.2 1.25460492886e-06 1.2 1.25463668699e-06 1.2 1.25466844512e-06 1.2 1.25470020325e-06 1.2 1.25473196138e-06 1.2 1.25476371951e-06 1.2 1.25479547764e-06 1.2 1.25482723577e-06 1.2 1.2548589939e-06 1.2 1.25489075203e-06 1.2 1.25492251016e-06 1.2 1.25495426829e-06 1.2 1.25498602642e-06 1.2 1.25501778455e-06 1.2 1.25504954268e-06 1.2 1.25508130081e-06 1.2 1.25511305894e-06 1.2 1.25514481707e-06 1.2 1.2551765752e-06 1.2 1.25520833333e-06 1.2 1.25524009146e-06 1.2 1.25527184959e-06 1.2 1.25530360772e-06 1.2 1.25533536585e-06 1.2 1.25536712398e-06 1.2 1.25539888211e-06 1.2 1.25543064024e-06 1.2 1.25546239837e-06 1.2 1.2554941565e-06 1.2 1.25552591463e-06 1.2 1.25555767276e-06 1.2 1.25558943089e-06 1.2 1.25562118902e-06 1.2 1.25565294715e-06 1.2 1.25568470528e-06 1.2 1.25571646341e-06 1.2 1.25574822154e-06 1.2 1.25577997967e-06 1.2 1.2558117378e-06 1.2 1.25584349593e-06 1.2 1.25587525407e-06 1.2 1.2559070122e-06 1.2 1.25593877033e-06 1.2 1.25597052846e-06 1.2 1.25600228659e-06 1.2 1.25603404472e-06 1.2 1.25606580285e-06 1.2 1.25609756098e-06 1.2 1.25612931911e-06 1.2 1.25616107724e-06 1.2 1.25619283537e-06 1.2 1.2562245935e-06 1.2 1.25625635163e-06 1.2 1.25628810976e-06 1.2 1.25631986789e-06 1.2 1.25635162602e-06 1.2 1.25638338415e-06 1.2 1.25641514228e-06 1.2 1.25644690041e-06 1.2 1.25647865854e-06 1.2 1.25651041667e-06 1.2 1.2565421748e-06 1.2 1.25657393293e-06 1.2 1.25660569106e-06 1.2 1.25663744919e-06 1.2 1.25666920732e-06 1.2 1.25670096545e-06 1.2 1.25673272358e-06 1.2 1.25676448171e-06 1.2 1.25679623984e-06 1.2 1.25682799797e-06 1.2 1.2568597561e-06 1.2 1.25689151423e-06 1.2 1.25692327236e-06 1.2 1.25695503049e-06 1.2 1.25698678862e-06 1.2 1.25701854675e-06 1.2 1.25705030488e-06 1.2 1.25708206301e-06 1.2 1.25711382114e-06 1.2 1.25714557927e-06 1.2 1.2571773374e-06 1.2 1.25720909553e-06 1.2 1.25724085366e-06 1.2 1.25727261179e-06 1.2 1.25730436992e-06 1.2 1.25733612805e-06 1.2 1.25736788618e-06 1.2 1.25739964431e-06 1.2 1.25743140244e-06 1.2 1.25746316057e-06 1.2 1.2574949187e-06 1.2 1.25752667683e-06 1.2 1.25755843496e-06 1.2 1.25759019309e-06 1.2 1.25762195122e-06 1.2 1.25765370935e-06 1.2 1.25768546748e-06 1.2 1.25771722561e-06 1.2 1.25774898374e-06 1.2 1.25778074187e-06 1.2 1.2578125e-06 1.2 1.25784425813e-06 1.2 1.25787601626e-06 1.2 1.25790777439e-06 1.2 1.25793953252e-06 1.2 1.25797129065e-06 1.2 1.25800304878e-06 1.2 1.25803480691e-06 1.2 1.25806656504e-06 1.2 1.25809832317e-06 1.2 1.2581300813e-06 1.2 1.25816183943e-06 1.2 1.25819359756e-06 1.2 1.25822535569e-06 1.2 1.25825711382e-06 1.2 1.25828887195e-06 1.2 1.25832063008e-06 1.2 1.25835238821e-06 1.2 1.25838414634e-06 1.2 1.25841590447e-06 1.2 1.2584476626e-06 1.2 1.25847942073e-06 1.2 1.25851117886e-06 1.2 1.25854293699e-06 1.2 1.25857469512e-06 1.2 1.25860645325e-06 1.2 1.25863821138e-06 1.2 1.25866996951e-06 1.2 1.25870172764e-06 1.2 1.25873348577e-06 1.2 1.2587652439e-06 1.2 1.25879700203e-06 1.2 1.25882876016e-06 1.2 1.25886051829e-06 1.2 1.25889227642e-06 1.2 1.25892403455e-06 1.2 1.25895579268e-06 1.2 1.25898755081e-06 1.2 1.25901930894e-06 1.2 1.25905106707e-06 1.2 1.2590828252e-06 1.2 1.25911458333e-06 1.2 1.25914634146e-06 1.2 1.25917809959e-06 1.2 1.25920985772e-06 1.2 1.25924161585e-06 1.2 1.25927337398e-06 1.2 1.25930513211e-06 1.2 1.25933689024e-06 1.2 1.25936864837e-06 1.2 1.2594004065e-06 1.2 1.25943216463e-06 1.2 1.25946392276e-06 1.2 1.25949568089e-06 1.2 1.25952743902e-06 1.2 1.25955919715e-06 1.2 1.25959095528e-06 1.2 1.25962271341e-06 1.2 1.25965447154e-06 1.2 1.25968622967e-06 1.2 1.2597179878e-06 1.2 1.25974974593e-06 1.2 1.25978150407e-06 1.2 1.2598132622e-06 1.2 1.25984502033e-06 1.2 1.25987677846e-06 1.2 1.25990853659e-06 1.2 1.25994029472e-06 1.2 1.25997205285e-06 1.2 1.26000381098e-06 1.2 1.26003556911e-06 1.2 1.26006732724e-06 1.2 1.26009908537e-06 1.2 1.2601308435e-06 1.2 1.26016260163e-06 1.2 1.26019435976e-06 1.2 1.26022611789e-06 1.2 1.26025787602e-06 1.2 1.26028963415e-06 1.2 1.26032139228e-06 1.2 1.26035315041e-06 1.2 1.26038490854e-06 1.2 1.26041666667e-06 1.2 1.2604484248e-06 1.2 1.26048018293e-06 1.2 1.26051194106e-06 1.2 1.26054369919e-06 1.2 1.26057545732e-06 1.2 1.26060721545e-06 1.2 1.26063897358e-06 1.2 1.26067073171e-06 1.2 1.26070248984e-06 1.2 1.26073424797e-06 1.2 1.2607660061e-06 1.2 1.26079776423e-06 1.2 1.26082952236e-06 1.2 1.26086128049e-06 1.2 1.26089303862e-06 1.2 1.26092479675e-06 1.2 1.26095655488e-06 1.2 1.26098831301e-06 1.2 1.26102007114e-06 1.2 1.26105182927e-06 1.2 1.2610835874e-06 1.2 1.26111534553e-06 1.2 1.26114710366e-06 1.2 1.26117886179e-06 1.2 1.26121061992e-06 1.2 1.26124237805e-06 1.2 1.26127413618e-06 1.2 1.26130589431e-06 1.2 1.26133765244e-06 1.2 1.26136941057e-06 1.2 1.2614011687e-06 1.2 1.26143292683e-06 1.2 1.26146468496e-06 1.2 1.26149644309e-06 1.2 1.26152820122e-06 1.2 1.26155995935e-06 1.2 1.26159171748e-06 1.2 1.26162347561e-06 1.2 1.26165523374e-06 1.2 1.26168699187e-06 1.2 1.26171875e-06 1.2 1.26175050813e-06 1.2 1.26178226626e-06 1.2 1.26181402439e-06 1.2 1.26184578252e-06 1.2 1.26187754065e-06 1.2 1.26190929878e-06 1.2 1.26194105691e-06 1.2 1.26197281504e-06 1.2 1.26200457317e-06 1.2 1.2620363313e-06 1.2 1.26206808943e-06 1.2 1.26209984756e-06 1.2 1.26213160569e-06 1.2 1.26216336382e-06 1.2 1.26219512195e-06 1.2 1.26222688008e-06 1.2 1.26225863821e-06 1.2 1.26229039634e-06 1.2 1.26232215447e-06 1.2 1.2623539126e-06 1.2 1.26238567073e-06 1.2 1.26241742886e-06 1.2 1.26244918699e-06 1.2 1.26248094512e-06 1.2 1.26251270325e-06 1.2 1.26254446138e-06 1.2 1.26257621951e-06 1.2 1.26260797764e-06 1.2 1.26263973577e-06 1.2 1.2626714939e-06 1.2 1.26270325203e-06 1.2 1.26273501016e-06 1.2 1.26276676829e-06 1.2 1.26279852642e-06 1.2 1.26283028455e-06 1.2 1.26286204268e-06 1.2 1.26289380081e-06 1.2 1.26292555894e-06 1.2 1.26295731707e-06 1.2 1.2629890752e-06 1.2 1.26302083333e-06 1.2 1.26305259146e-06 1.2 1.26308434959e-06 1.2 1.26311610772e-06 1.2 1.26314786585e-06 1.2 1.26317962398e-06 1.2 1.26321138211e-06 1.2 1.26324314024e-06 1.2 1.26327489837e-06 1.2 1.2633066565e-06 1.2 1.26333841463e-06 1.2 1.26337017276e-06 1.2 1.26340193089e-06 1.2 1.26343368902e-06 1.2 1.26346544715e-06 1.2 1.26349720528e-06 1.2 1.26352896341e-06 1.2 1.26356072154e-06 1.2 1.26359247967e-06 1.2 1.2636242378e-06 1.2 1.26365599593e-06 1.2 1.26368775407e-06 1.2 1.2637195122e-06 1.2 1.26375127033e-06 1.2 1.26378302846e-06 1.2 1.26381478659e-06 1.2 1.26384654472e-06 1.2 1.26387830285e-06 1.2 1.26391006098e-06 1.2 1.26394181911e-06 1.2 1.26397357724e-06 1.2 1.26400533537e-06 1.2 1.2640370935e-06 1.2 1.26406885163e-06 1.2 1.26410060976e-06 1.2 1.26413236789e-06 1.2 1.26416412602e-06 1.2 1.26419588415e-06 1.2 1.26422764228e-06 1.2 1.26425940041e-06 1.2 1.26429115854e-06 1.2 1.26432291667e-06 1.2 1.2643546748e-06 1.2 1.26438643293e-06 1.2 1.26441819106e-06 1.2 1.26444994919e-06 1.2 1.26448170732e-06 1.2 1.26451346545e-06 1.2 1.26454522358e-06 1.2 1.26457698171e-06 1.2 1.26460873984e-06 1.2 1.26464049797e-06 1.2 1.2646722561e-06 1.2 1.26470401423e-06 1.2 1.26473577236e-06 1.2 1.26476753049e-06 1.2 1.26479928862e-06 1.2 1.26483104675e-06 1.2 1.26486280488e-06 1.2 1.26489456301e-06 1.2 1.26492632114e-06 1.2 1.26495807927e-06 1.2 1.2649898374e-06 1.2 1.26502159553e-06 1.2 1.26505335366e-06 1.2 1.26508511179e-06 1.2 1.26511686992e-06 1.2 1.26514862805e-06 1.2 1.26518038618e-06 1.2 1.26521214431e-06 1.2 1.26524390244e-06 1.2 1.26527566057e-06 1.2 1.2653074187e-06 1.2 1.26533917683e-06 1.2 1.26537093496e-06 1.2 1.26540269309e-06 1.2 1.26543445122e-06 1.2 1.26546620935e-06 1.2 1.26549796748e-06 1.2 1.26552972561e-06 1.2 1.26556148374e-06 1.2 1.26559324187e-06 1.2 1.265625e-06 1.2 1.26565675813e-06 1.2 1.26568851626e-06 1.2 1.26572027439e-06 1.2 1.26575203252e-06 1.2 1.26578379065e-06 1.2 1.26581554878e-06 1.2 1.26584730691e-06 1.2 1.26587906504e-06 1.2 1.26591082317e-06 1.2 1.2659425813e-06 1.2 1.26597433943e-06 1.2 1.26600609756e-06 1.2 1.26603785569e-06 1.2 1.26606961382e-06 1.2 1.26610137195e-06 1.2 1.26613313008e-06 1.2 1.26616488821e-06 1.2 1.26619664634e-06 1.2 1.26622840447e-06 1.2 1.2662601626e-06 1.2 1.26629192073e-06 1.2 1.26632367886e-06 1.2 1.26635543699e-06 1.2 1.26638719512e-06 1.2 1.26641895325e-06 1.2 1.26645071138e-06 1.2 1.26648246951e-06 1.2 1.26651422764e-06 1.2 1.26654598577e-06 1.2 1.2665777439e-06 1.2 1.26660950203e-06 1.2 1.26664126016e-06 1.2 1.26667301829e-06 1.2 1.26670477642e-06 1.2 1.26673653455e-06 1.2 1.26676829268e-06 1.2 1.26680005081e-06 1.2 1.26683180894e-06 1.2 1.26686356707e-06 1.2 1.2668953252e-06 1.2 1.26692708333e-06 1.2 1.26695884146e-06 1.2 1.26699059959e-06 1.2 1.26702235772e-06 1.2 1.26705411585e-06 1.2 1.26708587398e-06 1.2 1.26711763211e-06 1.2 1.26714939024e-06 1.2 1.26718114837e-06 1.2 1.2672129065e-06 1.2 1.26724466463e-06 1.2 1.26727642276e-06 1.2 1.26730818089e-06 1.2 1.26733993902e-06 1.2 1.26737169715e-06 1.2 1.26740345528e-06 1.2 1.26743521341e-06 1.2 1.26746697154e-06 1.2 1.26749872967e-06 1.2 1.2675304878e-06 1.2 1.26756224593e-06 1.2 1.26759400407e-06 1.2 1.2676257622e-06 1.2 1.26765752033e-06 1.2 1.26768927846e-06 1.2 1.26772103659e-06 1.2 1.26775279472e-06 1.2 1.26778455285e-06 1.2 1.26781631098e-06 1.2 1.26784806911e-06 1.2 1.26787982724e-06 1.2 1.26791158537e-06 1.2 1.2679433435e-06 1.2 1.26797510163e-06 1.2 1.26800685976e-06 1.2 1.26803861789e-06 1.2 1.26807037602e-06 1.2 1.26810213415e-06 1.2 1.26813389228e-06 1.2 1.26816565041e-06 1.2 1.26819740854e-06 1.2 1.26822916667e-06 1.2 1.2682609248e-06 1.2 1.26829268293e-06 1.2 1.26832444106e-06 1.2 1.26835619919e-06 1.2 1.26838795732e-06 1.2 1.26841971545e-06 1.2 1.26845147358e-06 1.2 1.26848323171e-06 1.2 1.26851498984e-06 1.2 1.26854674797e-06 1.2 1.2685785061e-06 1.2 1.26861026423e-06 1.2 1.26864202236e-06 1.2 1.26867378049e-06 1.2 1.26870553862e-06 1.2 1.26873729675e-06 1.2 1.26876905488e-06 1.2 1.26880081301e-06 1.2 1.26883257114e-06 1.2 1.26886432927e-06 1.2 1.2688960874e-06 1.2 1.26892784553e-06 1.2 1.26895960366e-06 1.2 1.26899136179e-06 1.2 1.26902311992e-06 1.2 1.26905487805e-06 1.2 1.26908663618e-06 1.2 1.26911839431e-06 1.2 1.26915015244e-06 1.2 1.26918191057e-06 1.2 1.2692136687e-06 1.2 1.26924542683e-06 1.2 1.26927718496e-06 1.2 1.26930894309e-06 1.2 1.26934070122e-06 1.2 1.26937245935e-06 1.2 1.26940421748e-06 1.2 1.26943597561e-06 1.2 1.26946773374e-06 1.2 1.26949949187e-06 1.2 1.26953125e-06 1.2 1.26956300813e-06 1.2 1.26959476626e-06 1.2 1.26962652439e-06 1.2 1.26965828252e-06 1.2 1.26969004065e-06 1.2 1.26972179878e-06 1.2 1.26975355691e-06 1.2 1.26978531504e-06 1.2 1.26981707317e-06 1.2 1.2698488313e-06 1.2 1.26988058943e-06 1.2 1.26991234756e-06 1.2 1.26994410569e-06 1.2 1.26997586382e-06 1.2 1.27000762195e-06 1.2 1.27003938008e-06 1.2 1.27007113821e-06 1.2 1.27010289634e-06 1.2 1.27013465447e-06 1.2 1.2701664126e-06 1.2 1.27019817073e-06 1.2 1.27022992886e-06 1.2 1.27026168699e-06 1.2 1.27029344512e-06 1.2 1.27032520325e-06 1.2 1.27035696138e-06 1.2 1.27038871951e-06 1.2 1.27042047764e-06 1.2 1.27045223577e-06 1.2 1.2704839939e-06 1.2 1.27051575203e-06 1.2 1.27054751016e-06 1.2 1.27057926829e-06 1.2 1.27061102642e-06 1.2 1.27064278455e-06 1.2 1.27067454268e-06 1.2 1.27070630081e-06 1.2 1.27073805894e-06 1.2 1.27076981707e-06 1.2 1.2708015752e-06 1.2 1.27083333333e-06 1.2 1.27086509146e-06 1.2 1.27089684959e-06 1.2 1.27092860772e-06 1.2 1.27096036585e-06 1.2 1.27099212398e-06 1.2 1.27102388211e-06 1.2 1.27105564024e-06 1.2 1.27108739837e-06 1.2 1.2711191565e-06 1.2 1.27115091463e-06 1.2 1.27118267276e-06 1.2 1.27121443089e-06 1.2 1.27124618902e-06 1.2 1.27127794715e-06 1.2 1.27130970528e-06 1.2 1.27134146341e-06 1.2 1.27137322154e-06 1.2 1.27140497967e-06 1.2 1.2714367378e-06 1.2 1.27146849593e-06 1.2 1.27150025407e-06 1.2 1.2715320122e-06 1.2 1.27156377033e-06 1.2 1.27159552846e-06 1.2 1.27162728659e-06 1.2 1.27165904472e-06 1.2 1.27169080285e-06 1.2 1.27172256098e-06 1.2 1.27175431911e-06 1.2 1.27178607724e-06 1.2 1.27181783537e-06 1.2 1.2718495935e-06 1.2 1.27188135163e-06 1.2 1.27191310976e-06 1.2 1.27194486789e-06 1.2 1.27197662602e-06 1.2 1.27200838415e-06 1.2 1.27204014228e-06 1.2 1.27207190041e-06 1.2 1.27210365854e-06 1.2 1.27213541667e-06 1.2 1.2721671748e-06 1.2 1.27219893293e-06 1.2 1.27223069106e-06 1.2 1.27226244919e-06 1.2 1.27229420732e-06 1.2 1.27232596545e-06 1.2 1.27235772358e-06 1.2 1.27238948171e-06 1.2 1.27242123984e-06 1.2 1.27245299797e-06 1.2 1.2724847561e-06 1.2 1.27251651423e-06 1.2 1.27254827236e-06 1.2 1.27258003049e-06 1.2 1.27261178862e-06 1.2 1.27264354675e-06 1.2 1.27267530488e-06 1.2 1.27270706301e-06 1.2 1.27273882114e-06 1.2 1.27277057927e-06 1.2 1.2728023374e-06 1.2 1.27283409553e-06 1.2 1.27286585366e-06 1.2 1.27289761179e-06 1.2 1.27292936992e-06 1.2 1.27296112805e-06 1.2 1.27299288618e-06 1.2 1.27302464431e-06 1.2 1.27305640244e-06 1.2 1.27308816057e-06 1.2 1.2731199187e-06 1.2 1.27315167683e-06 1.2 1.27318343496e-06 1.2 1.27321519309e-06 1.2 1.27324695122e-06 1.2 1.27327870935e-06 1.2 1.27331046748e-06 1.2 1.27334222561e-06 1.2 1.27337398374e-06 1.2 1.27340574187e-06 1.2 1.2734375e-06 1.2 1.27346925813e-06 1.2 1.27350101626e-06 1.2 1.27353277439e-06 1.2 1.27356453252e-06 1.2 1.27359629065e-06 1.2 1.27362804878e-06 1.2 1.27365980691e-06 1.2 1.27369156504e-06 1.2 1.27372332317e-06 1.2 1.2737550813e-06 1.2 1.27378683943e-06 1.2 1.27381859756e-06 1.2 1.27385035569e-06 1.2 1.27388211382e-06 1.2 1.27391387195e-06 1.2 1.27394563008e-06 1.2 1.27397738821e-06 1.2 1.27400914634e-06 1.2 1.27404090447e-06 1.2 1.2740726626e-06 1.2 1.27410442073e-06 1.2 1.27413617886e-06 1.2 1.27416793699e-06 1.2 1.27419969512e-06 1.2 1.27423145325e-06 1.2 1.27426321138e-06 1.2 1.27429496951e-06 1.2 1.27432672764e-06 1.2 1.27435848577e-06 1.2 1.2743902439e-06 1.2 1.27442200203e-06 1.2 1.27445376016e-06 1.2 1.27448551829e-06 1.2 1.27451727642e-06 1.2 1.27454903455e-06 1.2 1.27458079268e-06 1.2 1.27461255081e-06 1.2 1.27464430894e-06 1.2 1.27467606707e-06 1.2 1.2747078252e-06 1.2 1.27473958333e-06 1.2 1.27477134146e-06 1.2 1.27480309959e-06 1.2 1.27483485772e-06 1.2 1.27486661585e-06 1.2 1.27489837398e-06 1.2 1.27493013211e-06 1.2 1.27496189024e-06 1.2 1.27499364837e-06 1.2 1.2750254065e-06 1.2 1.27505716463e-06 1.2 1.27508892276e-06 1.2 1.27512068089e-06 1.2 1.27515243902e-06 1.2 1.27518419715e-06 1.2 1.27521595528e-06 1.2 1.27524771341e-06 1.2 1.27527947154e-06 1.2 1.27531122967e-06 1.2 1.2753429878e-06 1.2 1.27537474593e-06 1.2 1.27540650407e-06 1.2 1.2754382622e-06 1.2 1.27547002033e-06 1.2 1.27550177846e-06 1.2 1.27553353659e-06 1.2 1.27556529472e-06 1.2 1.27559705285e-06 1.2 1.27562881098e-06 1.2 1.27566056911e-06 1.2 1.27569232724e-06 1.2 1.27572408537e-06 1.2 1.2757558435e-06 1.2 1.27578760163e-06 1.2 1.27581935976e-06 1.2 1.27585111789e-06 1.2 1.27588287602e-06 1.2 1.27591463415e-06 1.2 1.27594639228e-06 1.2 1.27597815041e-06 1.2 1.27600990854e-06 1.2 1.27604166667e-06 1.2 1.2760734248e-06 1.2 1.27610518293e-06 1.2 1.27613694106e-06 1.2 1.27616869919e-06 1.2 1.27620045732e-06 1.2 1.27623221545e-06 1.2 1.27626397358e-06 1.2 1.27629573171e-06 1.2 1.27632748984e-06 1.2 1.27635924797e-06 1.2 1.2763910061e-06 1.2 1.27642276423e-06 1.2 1.27645452236e-06 1.2 1.27648628049e-06 1.2 1.27651803862e-06 1.2 1.27654979675e-06 1.2 1.27658155488e-06 1.2 1.27661331301e-06 1.2 1.27664507114e-06 1.2 1.27667682927e-06 1.2 1.2767085874e-06 1.2 1.27674034553e-06 1.2 1.27677210366e-06 1.2 1.27680386179e-06 1.2 1.27683561992e-06 1.2 1.27686737805e-06 1.2 1.27689913618e-06 1.2 1.27693089431e-06 1.2 1.27696265244e-06 1.2 1.27699441057e-06 1.2 1.2770261687e-06 1.2 1.27705792683e-06 1.2 1.27708968496e-06 1.2 1.27712144309e-06 1.2 1.27715320122e-06 1.2 1.27718495935e-06 1.2 1.27721671748e-06 1.2 1.27724847561e-06 1.2 1.27728023374e-06 1.2 1.27731199187e-06 1.2 1.27734375e-06 1.2 1.27737550813e-06 1.2 1.27740726626e-06 1.2 1.27743902439e-06 1.2 1.27747078252e-06 1.2 1.27750254065e-06 1.2 1.27753429878e-06 1.2 1.27756605691e-06 1.2 1.27759781504e-06 1.2 1.27762957317e-06 1.2 1.2776613313e-06 1.2 1.27769308943e-06 1.2 1.27772484756e-06 1.2 1.27775660569e-06 1.2 1.27778836382e-06 1.2 1.27782012195e-06 1.2 1.27785188008e-06 1.2 1.27788363821e-06 1.2 1.27791539634e-06 1.2 1.27794715447e-06 1.2 1.2779789126e-06 1.2 1.27801067073e-06 1.2 1.27804242886e-06 1.2 1.27807418699e-06 1.2 1.27810594512e-06 1.2 1.27813770325e-06 1.2 1.27816946138e-06 1.2 1.27820121951e-06 1.2 1.27823297764e-06 1.2 1.27826473577e-06 1.2 1.2782964939e-06 1.2 1.27832825203e-06 1.2 1.27836001016e-06 1.2 1.27839176829e-06 1.2 1.27842352642e-06 1.2 1.27845528455e-06 1.2 1.27848704268e-06 1.2 1.27851880081e-06 1.2 1.27855055894e-06 1.2 1.27858231707e-06 1.2 1.2786140752e-06 1.2 1.27864583333e-06 1.2 1.27867759146e-06 1.2 1.27870934959e-06 1.2 1.27874110772e-06 1.2 1.27877286585e-06 1.2 1.27880462398e-06 1.2 1.27883638211e-06 1.2 1.27886814024e-06 1.2 1.27889989837e-06 1.2 1.2789316565e-06 1.2 1.27896341463e-06 1.2 1.27899517276e-06 1.2 1.27902693089e-06 1.2 1.27905868902e-06 1.2 1.27909044715e-06 1.2 1.27912220528e-06 1.2 1.27915396341e-06 1.2 1.27918572154e-06 1.2 1.27921747967e-06 1.2 1.2792492378e-06 1.2 1.27928099593e-06 1.2 1.27931275407e-06 1.2 1.2793445122e-06 1.2 1.27937627033e-06 1.2 1.27940802846e-06 1.2 1.27943978659e-06 1.2 1.27947154472e-06 1.2 1.27950330285e-06 1.2 1.27953506098e-06 1.2 1.27956681911e-06 1.2 1.27959857724e-06 1.2 1.27963033537e-06 1.2 1.2796620935e-06 1.2 1.27969385163e-06 1.2 1.27972560976e-06 1.2 1.27975736789e-06 1.2 1.27978912602e-06 1.2 1.27982088415e-06 1.2 1.27985264228e-06 1.2 1.27988440041e-06 1.2 1.27991615854e-06 1.2 1.27994791667e-06 1.2 1.2799796748e-06 1.2 1.28001143293e-06 1.2 1.28004319106e-06 1.2 1.28007494919e-06 1.2 1.28010670732e-06 1.2 1.28013846545e-06 1.2 1.28017022358e-06 1.2 1.28020198171e-06 1.2 1.28023373984e-06 1.2 1.28026549797e-06 1.2 1.2802972561e-06 1.2 1.28032901423e-06 1.2 1.28036077236e-06 1.2 1.28039253049e-06 1.2 1.28042428862e-06 1.2 1.28045604675e-06 1.2 1.28048780488e-06 1.2 1.28051956301e-06 1.2 1.28055132114e-06 1.2 1.28058307927e-06 1.2 1.2806148374e-06 1.2 1.28064659553e-06 1.2 1.28067835366e-06 1.2 1.28071011179e-06 1.2 1.28074186992e-06 1.2 1.28077362805e-06 1.2 1.28080538618e-06 1.2 1.28083714431e-06 1.2 1.28086890244e-06 1.2 1.28090066057e-06 1.2 1.2809324187e-06 1.2 1.28096417683e-06 1.2 1.28099593496e-06 1.2 1.28102769309e-06 1.2 1.28105945122e-06 1.2 1.28109120935e-06 1.2 1.28112296748e-06 1.2 1.28115472561e-06 1.2 1.28118648374e-06 1.2 1.28121824187e-06 1.2 1.28125e-06 1.2 1.28128175813e-06 1.2 1.28131351626e-06 1.2 1.28134527439e-06 1.2 1.28137703252e-06 1.2 1.28140879065e-06 1.2 1.28144054878e-06 1.2 1.28147230691e-06 1.2 1.28150406504e-06 1.2 1.28153582317e-06 1.2 1.2815675813e-06 1.2 1.28159933943e-06 1.2 1.28163109756e-06 1.2 1.28166285569e-06 1.2 1.28169461382e-06 1.2 1.28172637195e-06 1.2 1.28175813008e-06 1.2 1.28178988821e-06 1.2 1.28182164634e-06 1.2 1.28185340447e-06 1.2 1.2818851626e-06 1.2 1.28191692073e-06 1.2 1.28194867886e-06 1.2 1.28198043699e-06 1.2 1.28201219512e-06 1.2 1.28204395325e-06 1.2 1.28207571138e-06 1.2 1.28210746951e-06 1.2 1.28213922764e-06 1.2 1.28217098577e-06 1.2 1.2822027439e-06 1.2 1.28223450203e-06 1.2 1.28226626016e-06 1.2 1.28229801829e-06 1.2 1.28232977642e-06 1.2 1.28236153455e-06 1.2 1.28239329268e-06 1.2 1.28242505081e-06 1.2 1.28245680894e-06 1.2 1.28248856707e-06 1.2 1.2825203252e-06 1.2 1.28255208333e-06 1.2 1.28258384146e-06 1.2 1.28261559959e-06 1.2 1.28264735772e-06 1.2 1.28267911585e-06 1.2 1.28271087398e-06 1.2 1.28274263211e-06 1.2 1.28277439024e-06 1.2 1.28280614837e-06 1.2 1.2828379065e-06 1.2 1.28286966463e-06 1.2 1.28290142276e-06 1.2 1.28293318089e-06 1.2 1.28296493902e-06 1.2 1.28299669715e-06 1.2 1.28302845528e-06 1.2 1.28306021341e-06 1.2 1.28309197154e-06 1.2 1.28312372967e-06 1.2 1.2831554878e-06 1.2 1.28318724593e-06 1.2 1.28321900407e-06 1.2 1.2832507622e-06 1.2 1.28328252033e-06 1.2 1.28331427846e-06 1.2 1.28334603659e-06 1.2 1.28337779472e-06 1.2 1.28340955285e-06 1.2 1.28344131098e-06 1.2 1.28347306911e-06 1.2 1.28350482724e-06 1.2 1.28353658537e-06 1.2 1.2835683435e-06 1.2 1.28360010163e-06 1.2 1.28363185976e-06 1.2 1.28366361789e-06 1.2 1.28369537602e-06 1.2 1.28372713415e-06 1.2 1.28375889228e-06 1.2 1.28379065041e-06 1.2 1.28382240854e-06 1.2 1.28385416667e-06 1.2 1.2838859248e-06 1.2 1.28391768293e-06 1.2 1.28394944106e-06 1.2 1.28398119919e-06 1.2 1.28401295732e-06 1.2 1.28404471545e-06 1.2 1.28407647358e-06 1.2 1.28410823171e-06 1.2 1.28413998984e-06 1.2 1.28417174797e-06 1.2 1.2842035061e-06 1.2 1.28423526423e-06 1.2 1.28426702236e-06 1.2 1.28429878049e-06 1.2 1.28433053862e-06 1.2 1.28436229675e-06 1.2 1.28439405488e-06 1.2 1.28442581301e-06 1.2 1.28445757114e-06 1.2 1.28448932927e-06 1.2 1.2845210874e-06 1.2 1.28455284553e-06 1.2 1.28458460366e-06 1.2 1.28461636179e-06 1.2 1.28464811992e-06 1.2 1.28467987805e-06 1.2 1.28471163618e-06 1.2 1.28474339431e-06 1.2 1.28477515244e-06 1.2 1.28480691057e-06 1.2 1.2848386687e-06 1.2 1.28487042683e-06 1.2 1.28490218496e-06 1.2 1.28493394309e-06 1.2 1.28496570122e-06 1.2 1.28499745935e-06 1.2 1.28502921748e-06 1.2 1.28506097561e-06 1.2 1.28509273374e-06 1.2 1.28512449187e-06 1.2 1.28515625e-06 1.2 1.28518800813e-06 1.2 1.28521976626e-06 1.2 1.28525152439e-06 1.2 1.28528328252e-06 1.2 1.28531504065e-06 1.2 1.28534679878e-06 1.2 1.28537855691e-06 1.2 1.28541031504e-06 1.2 1.28544207317e-06 1.2 1.2854738313e-06 1.2 1.28550558943e-06 1.2 1.28553734756e-06 1.2 1.28556910569e-06 1.2 1.28560086382e-06 1.2 1.28563262195e-06 1.2 1.28566438008e-06 1.2 1.28569613821e-06 1.2 1.28572789634e-06 1.2 1.28575965447e-06 1.2 1.2857914126e-06 1.2 1.28582317073e-06 1.2 1.28585492886e-06 1.2 1.28588668699e-06 1.2 1.28591844512e-06 1.2 1.28595020325e-06 1.2 1.28598196138e-06 1.2 1.28601371951e-06 1.2 1.28604547764e-06 1.2 1.28607723577e-06 1.2 1.2861089939e-06 1.2 1.28614075203e-06 1.2 1.28617251016e-06 1.2 1.28620426829e-06 1.2 1.28623602642e-06 1.2 1.28626778455e-06 1.2 1.28629954268e-06 1.2 1.28633130081e-06 1.2 1.28636305894e-06 1.2 1.28639481707e-06 1.2 1.2864265752e-06 1.2 1.28645833333e-06 1.2 1.28649009146e-06 1.2 1.28652184959e-06 1.2 1.28655360772e-06 1.2 1.28658536585e-06 1.2 1.28661712398e-06 1.2 1.28664888211e-06 1.2 1.28668064024e-06 1.2 1.28671239837e-06 1.2 1.2867441565e-06 1.2 1.28677591463e-06 1.2 1.28680767276e-06 1.2 1.28683943089e-06 1.2 1.28687118902e-06 1.2 1.28690294715e-06 1.2 1.28693470528e-06 1.2 1.28696646341e-06 1.2 1.28699822154e-06 1.2 1.28702997967e-06 1.2 1.2870617378e-06 1.2 1.28709349593e-06 1.2 1.28712525407e-06 1.2 1.2871570122e-06 1.2 1.28718877033e-06 1.2 1.28722052846e-06 1.2 1.28725228659e-06 1.2 1.28728404472e-06 1.2 1.28731580285e-06 1.2 1.28734756098e-06 1.2 1.28737931911e-06 1.2 1.28741107724e-06 1.2 1.28744283537e-06 1.2 1.2874745935e-06 1.2 1.28750635163e-06 1.2 1.28753810976e-06 1.2 1.28756986789e-06 1.2 1.28760162602e-06 1.2 1.28763338415e-06 1.2 1.28766514228e-06 1.2 1.28769690041e-06 1.2 1.28772865854e-06 1.2 1.28776041667e-06 1.2 1.2877921748e-06 1.2 1.28782393293e-06 1.2 1.28785569106e-06 1.2 1.28788744919e-06 1.2 1.28791920732e-06 1.2 1.28795096545e-06 1.2 1.28798272358e-06 1.2 1.28801448171e-06 1.2 1.28804623984e-06 1.2 1.28807799797e-06 1.2 1.2881097561e-06 1.2 1.28814151423e-06 1.2 1.28817327236e-06 1.2 1.28820503049e-06 1.2 1.28823678862e-06 1.2 1.28826854675e-06 1.2 1.28830030488e-06 1.2 1.28833206301e-06 1.2 1.28836382114e-06 1.2 1.28839557927e-06 1.2 1.2884273374e-06 1.2 1.28845909553e-06 1.2 1.28849085366e-06 1.2 1.28852261179e-06 1.2 1.28855436992e-06 1.2 1.28858612805e-06 1.2 1.28861788618e-06 1.2 1.28864964431e-06 1.2 1.28868140244e-06 1.2 1.28871316057e-06 1.2 1.2887449187e-06 1.2 1.28877667683e-06 1.2 1.28880843496e-06 1.2 1.28884019309e-06 1.2 1.28887195122e-06 1.2 1.28890370935e-06 1.2 1.28893546748e-06 1.2 1.28896722561e-06 1.2 1.28899898374e-06 1.2 1.28903074187e-06 1.2 1.2890625e-06 1.2 1.28909425813e-06 1.2 1.28912601626e-06 1.2 1.28915777439e-06 1.2 1.28918953252e-06 1.2 1.28922129065e-06 1.2 1.28925304878e-06 1.2 1.28928480691e-06 1.2 1.28931656504e-06 1.2 1.28934832317e-06 1.2 1.2893800813e-06 1.2 1.28941183943e-06 1.2 1.28944359756e-06 1.2 1.28947535569e-06 1.2 1.28950711382e-06 1.2 1.28953887195e-06 1.2 1.28957063008e-06 1.2 1.28960238821e-06 1.2 1.28963414634e-06 1.2 1.28966590447e-06 1.2 1.2896976626e-06 1.2 1.28972942073e-06 1.2 1.28976117886e-06 1.2 1.28979293699e-06 1.2 1.28982469512e-06 1.2 1.28985645325e-06 1.2 1.28988821138e-06 1.2 1.28991996951e-06 1.2 1.28995172764e-06 1.2 1.28998348577e-06 1.2 1.2900152439e-06 1.2 1.29004700203e-06 1.2 1.29007876016e-06 1.2 1.29011051829e-06 1.2 1.29014227642e-06 1.2 1.29017403455e-06 1.2 1.29020579268e-06 1.2 1.29023755081e-06 1.2 1.29026930894e-06 1.2 1.29030106707e-06 1.2 1.2903328252e-06 1.2 1.29036458333e-06 1.2 1.29039634146e-06 1.2 1.29042809959e-06 1.2 1.29045985772e-06 1.2 1.29049161585e-06 1.2 1.29052337398e-06 1.2 1.29055513211e-06 1.2 1.29058689024e-06 1.2 1.29061864837e-06 1.2 1.2906504065e-06 1.2 1.29068216463e-06 1.2 1.29071392276e-06 1.2 1.29074568089e-06 1.2 1.29077743902e-06 1.2 1.29080919715e-06 1.2 1.29084095528e-06 1.2 1.29087271341e-06 1.2 1.29090447154e-06 1.2 1.29093622967e-06 1.2 1.2909679878e-06 1.2 1.29099974593e-06 1.2 1.29103150407e-06 1.2 1.2910632622e-06 1.2 1.29109502033e-06 1.2 1.29112677846e-06 1.2 1.29115853659e-06 1.2 1.29119029472e-06 1.2 1.29122205285e-06 1.2 1.29125381098e-06 1.2 1.29128556911e-06 1.2 1.29131732724e-06 1.2 1.29134908537e-06 1.2 1.2913808435e-06 1.2 1.29141260163e-06 1.2 1.29144435976e-06 1.2 1.29147611789e-06 1.2 1.29150787602e-06 1.2 1.29153963415e-06 1.2 1.29157139228e-06 1.2 1.29160315041e-06 1.2 1.29163490854e-06 1.2 1.29166666667e-06 1.2 1.2916984248e-06 1.2 1.29173018293e-06 1.2 1.29176194106e-06 1.2 1.29179369919e-06 1.2 1.29182545732e-06 1.2 1.29185721545e-06 1.2 1.29188897358e-06 1.2 1.29192073171e-06 1.2 1.29195248984e-06 1.2 1.29198424797e-06 1.2 1.2920160061e-06 1.2 1.29204776423e-06 1.2 1.29207952236e-06 1.2 1.29211128049e-06 1.2 1.29214303862e-06 1.2 1.29217479675e-06 1.2 1.29220655488e-06 1.2 1.29223831301e-06 1.2 1.29227007114e-06 1.2 1.29230182927e-06 1.2 1.2923335874e-06 1.2 1.29236534553e-06 1.2 1.29239710366e-06 1.2 1.29242886179e-06 1.2 1.29246061992e-06 1.2 1.29249237805e-06 1.2 1.29252413618e-06 1.2 1.29255589431e-06 1.2 1.29258765244e-06 1.2 1.29261941057e-06 1.2 1.2926511687e-06 1.2 1.29268292683e-06 1.2 1.29271468496e-06 1.2 1.29274644309e-06 1.2 1.29277820122e-06 1.2 1.29280995935e-06 1.2 1.29284171748e-06 1.2 1.29287347561e-06 1.2 1.29290523374e-06 1.2 1.29293699187e-06 1.2 1.29296875e-06 1.2 1.29300050813e-06 1.2 1.29303226626e-06 1.2 1.29306402439e-06 1.2 1.29309578252e-06 1.2 1.29312754065e-06 1.2 1.29315929878e-06 1.2 1.29319105691e-06 1.2 1.29322281504e-06 1.2 1.29325457317e-06 1.2 1.2932863313e-06 1.2 1.29331808943e-06 1.2 1.29334984756e-06 1.2 1.29338160569e-06 1.2 1.29341336382e-06 1.2 1.29344512195e-06 1.2 1.29347688008e-06 1.2 1.29350863821e-06 1.2 1.29354039634e-06 1.2 1.29357215447e-06 1.2 1.2936039126e-06 1.2 1.29363567073e-06 1.2 1.29366742886e-06 1.2 1.29369918699e-06 1.2 1.29373094512e-06 1.2 1.29376270325e-06 1.2 1.29379446138e-06 1.2 1.29382621951e-06 1.2 1.29385797764e-06 1.2 1.29388973577e-06 1.2 1.2939214939e-06 1.2 1.29395325203e-06 1.2 1.29398501016e-06 1.2 1.29401676829e-06 1.2 1.29404852642e-06 1.2 1.29408028455e-06 1.2 1.29411204268e-06 1.2 1.29414380081e-06 1.2 1.29417555894e-06 1.2 1.29420731707e-06 1.2 1.2942390752e-06 1.2 1.29427083333e-06 1.2 1.29430259146e-06 1.2 1.29433434959e-06 1.2 1.29436610772e-06 1.2 1.29439786585e-06 1.2 1.29442962398e-06 1.2 1.29446138211e-06 1.2 1.29449314024e-06 1.2 1.29452489837e-06 1.2 1.2945566565e-06 1.2 1.29458841463e-06 1.2 1.29462017276e-06 1.2 1.29465193089e-06 1.2 1.29468368902e-06 1.2 1.29471544715e-06 1.2 1.29474720528e-06 1.2 1.29477896341e-06 1.2 1.29481072154e-06 1.2 1.29484247967e-06 1.2 1.2948742378e-06 1.2 1.29490599593e-06 1.2 1.29493775407e-06 1.2 1.2949695122e-06 1.2 1.29500127033e-06 1.2 1.29503302846e-06 1.2 1.29506478659e-06 1.2 1.29509654472e-06 1.2 1.29512830285e-06 1.2 1.29516006098e-06 1.2 1.29519181911e-06 1.2 1.29522357724e-06 1.2 1.29525533537e-06 1.2 1.2952870935e-06 1.2 1.29531885163e-06 1.2 1.29535060976e-06 1.2 1.29538236789e-06 1.2 1.29541412602e-06 1.2 1.29544588415e-06 1.2 1.29547764228e-06 1.2 1.29550940041e-06 1.2 1.29554115854e-06 1.2 1.29557291667e-06 1.2 1.2956046748e-06 1.2 1.29563643293e-06 1.2 1.29566819106e-06 1.2 1.29569994919e-06 1.2 1.29573170732e-06 1.2 1.29576346545e-06 1.2 1.29579522358e-06 1.2 1.29582698171e-06 1.2 1.29585873984e-06 1.2 1.29589049797e-06 1.2 1.2959222561e-06 1.2 1.29595401423e-06 1.2 1.29598577236e-06 1.2 1.29601753049e-06 1.2 1.29604928862e-06 1.2 1.29608104675e-06 1.2 1.29611280488e-06 1.2 1.29614456301e-06 1.2 1.29617632114e-06 1.2 1.29620807927e-06 1.2 1.2962398374e-06 1.2 1.29627159553e-06 1.2 1.29630335366e-06 1.2 1.29633511179e-06 1.2 1.29636686992e-06 1.2 1.29639862805e-06 1.2 1.29643038618e-06 1.2 1.29646214431e-06 1.2 1.29649390244e-06 1.2 1.29652566057e-06 1.2 1.2965574187e-06 1.2 1.29658917683e-06 1.2 1.29662093496e-06 1.2 1.29665269309e-06 1.2 1.29668445122e-06 1.2 1.29671620935e-06 1.2 1.29674796748e-06 1.2 1.29677972561e-06 1.2 1.29681148374e-06 1.2 1.29684324187e-06 1.2 1.296875e-06 1.2 1.29690675813e-06 1.2 1.29693851626e-06 1.2 1.29697027439e-06 1.2 1.29700203252e-06 1.2 1.29703379065e-06 1.2 1.29706554878e-06 1.2 1.29709730691e-06 1.2 1.29712906504e-06 1.2 1.29716082317e-06 1.2 1.2971925813e-06 1.2 1.29722433943e-06 1.2 1.29725609756e-06 1.2 1.29728785569e-06 1.2 1.29731961382e-06 1.2 1.29735137195e-06 1.2 1.29738313008e-06 1.2 1.29741488821e-06 1.2 1.29744664634e-06 1.2 1.29747840447e-06 1.2 1.2975101626e-06 1.2 1.29754192073e-06 1.2 1.29757367886e-06 1.2 1.29760543699e-06 1.2 1.29763719512e-06 1.2 1.29766895325e-06 1.2 1.29770071138e-06 1.2 1.29773246951e-06 1.2 1.29776422764e-06 1.2 1.29779598577e-06 1.2 1.2978277439e-06 1.2 1.29785950203e-06 1.2 1.29789126016e-06 1.2 1.29792301829e-06 1.2 1.29795477642e-06 1.2 1.29798653455e-06 1.2 1.29801829268e-06 1.2 1.29805005081e-06 1.2 1.29808180894e-06 1.2 1.29811356707e-06 1.2 1.2981453252e-06 1.2 1.29817708333e-06 1.2 1.29820884146e-06 1.2 1.29824059959e-06 1.2 1.29827235772e-06 1.2 1.29830411585e-06 1.2 1.29833587398e-06 1.2 1.29836763211e-06 1.2 1.29839939024e-06 1.2 1.29843114837e-06 1.2 1.2984629065e-06 1.2 1.29849466463e-06 1.2 1.29852642276e-06 1.2 1.29855818089e-06 1.2 1.29858993902e-06 1.2 1.29862169715e-06 1.2 1.29865345528e-06 1.2 1.29868521341e-06 1.2 1.29871697154e-06 1.2 1.29874872967e-06 1.2 1.2987804878e-06 1.2 1.29881224593e-06 1.2 1.29884400407e-06 1.2 1.2988757622e-06 1.2 1.29890752033e-06 1.2 1.29893927846e-06 1.2 1.29897103659e-06 1.2 1.29900279472e-06 1.2 1.29903455285e-06 1.2 1.29906631098e-06 1.2 1.29909806911e-06 1.2 1.29912982724e-06 1.2 1.29916158537e-06 1.2 1.2991933435e-06 1.2 1.29922510163e-06 1.2 1.29925685976e-06 1.2 1.29928861789e-06 1.2 1.29932037602e-06 1.2 1.29935213415e-06 1.2 1.29938389228e-06 1.2 1.29941565041e-06 1.2 1.29944740854e-06 1.2 1.29947916667e-06 1.2 1.2995109248e-06 1.2 1.29954268293e-06 1.2 1.29957444106e-06 1.2 1.29960619919e-06 1.2 1.29963795732e-06 1.2 1.29966971545e-06 1.2 1.29970147358e-06 1.2 1.29973323171e-06 1.2 1.29976498984e-06 1.2 1.29979674797e-06 1.2 1.2998285061e-06 1.2 1.29986026423e-06 1.2 1.29989202236e-06 1.2 1.29992378049e-06 1.2 1.29995553862e-06 1.2 1.29998729675e-06 1.2 1.30001905488e-06 1.2 1.30005081301e-06 1.2 1.30008257114e-06 1.2 1.30011432927e-06 1.2 1.3001460874e-06 1.2 1.30017784553e-06 1.2 1.30020960366e-06 1.2 1.30024136179e-06 1.2 1.30027311992e-06 1.2 1.30030487805e-06 1.2 1.30033663618e-06 1.2 1.30036839431e-06 1.2 1.30040015244e-06 1.2 1.30043191057e-06 1.2 1.3004636687e-06 1.2 1.30049542683e-06 1.2 1.30052718496e-06 1.2 1.30055894309e-06 1.2 1.30059070122e-06 1.2 1.30062245935e-06 1.2 1.30065421748e-06 1.2 1.30068597561e-06 1.2 1.30071773374e-06 1.2 1.30074949187e-06 1.2 1.30078125e-06 1.2 1.30081300813e-06 1.2 1.30084476626e-06 1.2 1.30087652439e-06 1.2 1.30090828252e-06 1.2 1.30094004065e-06 1.2 1.30097179878e-06 1.2 1.30100355691e-06 1.2 1.30103531504e-06 1.2 1.30106707317e-06 1.2 1.3010988313e-06 1.2 1.30113058943e-06 1.2 1.30116234756e-06 1.2 1.30119410569e-06 1.2 1.30122586382e-06 1.2 1.30125762195e-06 1.2 1.30128938008e-06 1.2 1.30132113821e-06 1.2 1.30135289634e-06 1.2 1.30138465447e-06 1.2 1.3014164126e-06 1.2 1.30144817073e-06 1.2 1.30147992886e-06 1.2 1.30151168699e-06 1.2 1.30154344512e-06 1.2 1.30157520325e-06 1.2 1.30160696138e-06 1.2 1.30163871951e-06 1.2 1.30167047764e-06 1.2 1.30170223577e-06 1.2 1.3017339939e-06 1.2 1.30176575203e-06 1.2 1.30179751016e-06 1.2 1.30182926829e-06 1.2 1.30186102642e-06 1.2 1.30189278455e-06 1.2 1.30192454268e-06 1.2 1.30195630081e-06 1.2 1.30198805894e-06 1.2 1.30201981707e-06 1.2 1.3020515752e-06 1.2 1.30208333333e-06 1.2 1.30211509146e-06 1.2 1.30214684959e-06 1.2 1.30217860772e-06 1.2 1.30221036585e-06 1.2 1.30224212398e-06 1.2 1.30227388211e-06 1.2 1.30230564024e-06 1.2 1.30233739837e-06 1.2 1.3023691565e-06 1.2 1.30240091463e-06 1.2 1.30243267276e-06 1.2 1.30246443089e-06 1.2 1.30249618902e-06 1.2 1.30252794715e-06 1.2 1.30255970528e-06 1.2 1.30259146341e-06 1.2 1.30262322154e-06 1.2 1.30265497967e-06 1.2 1.3026867378e-06 1.2 1.30271849593e-06 1.2 1.30275025407e-06 1.2 1.3027820122e-06 1.2 1.30281377033e-06 1.2 1.30284552846e-06 1.2 1.30287728659e-06 1.2 1.30290904472e-06 1.2 1.30294080285e-06 1.2 1.30297256098e-06 1.2 1.30300431911e-06 1.2 1.30303607724e-06 1.2 1.30306783537e-06 1.2 1.3030995935e-06 1.2 1.30313135163e-06 1.2 1.30316310976e-06 1.2 1.30319486789e-06 1.2 1.30322662602e-06 1.2 1.30325838415e-06 1.2 1.30329014228e-06 1.2 1.30332190041e-06 1.2 1.30335365854e-06 1.2 1.30338541667e-06 1.2 1.3034171748e-06 1.2 1.30344893293e-06 1.2 1.30348069106e-06 1.2 1.30351244919e-06 1.2 1.30354420732e-06 1.2 1.30357596545e-06 1.2 1.30360772358e-06 1.2 1.30363948171e-06 1.2 1.30367123984e-06 1.2 1.30370299797e-06 1.2 1.3037347561e-06 1.2 1.30376651423e-06 1.2 1.30379827236e-06 1.2 1.30383003049e-06 1.2 1.30386178862e-06 1.2 1.30389354675e-06 1.2 1.30392530488e-06 1.2 1.30395706301e-06 1.2 1.30398882114e-06 1.2 1.30402057927e-06 1.2 1.3040523374e-06 1.2 1.30408409553e-06 1.2 1.30411585366e-06 1.2 1.30414761179e-06 1.2 1.30417936992e-06 1.2 1.30421112805e-06 1.2 1.30424288618e-06 1.2 1.30427464431e-06 1.2 1.30430640244e-06 1.2 1.30433816057e-06 1.2 1.3043699187e-06 1.2 1.30440167683e-06 1.2 1.30443343496e-06 1.2 1.30446519309e-06 1.2 1.30449695122e-06 1.2 1.30452870935e-06 1.2 1.30456046748e-06 1.2 1.30459222561e-06 1.2 1.30462398374e-06 1.2 1.30465574187e-06 1.2 1.3046875e-06 1.2 1.30471925813e-06 1.2 1.30475101626e-06 1.2 1.30478277439e-06 1.2 1.30481453252e-06 1.2 1.30484629065e-06 1.2 1.30487804878e-06 1.2 1.30490980691e-06 1.2 1.30494156504e-06 1.2 1.30497332317e-06 1.2 1.3050050813e-06 1.2 1.30503683943e-06 1.2 1.30506859756e-06 1.2 1.30510035569e-06 1.2 1.30513211382e-06 1.2 1.30516387195e-06 1.2 1.30519563008e-06 1.2 1.30522738821e-06 1.2 1.30525914634e-06 1.2 1.30529090447e-06 1.2 1.3053226626e-06 1.2 1.30535442073e-06 1.2 1.30538617886e-06 1.2 1.30541793699e-06 1.2 1.30544969512e-06 1.2 1.30548145325e-06 1.2 1.30551321138e-06 1.2 1.30554496951e-06 1.2 1.30557672764e-06 1.2 1.30560848577e-06 1.2 1.3056402439e-06 1.2 1.30567200203e-06 1.2 1.30570376016e-06 1.2 1.30573551829e-06 1.2 1.30576727642e-06 1.2 1.30579903455e-06 1.2 1.30583079268e-06 1.2 1.30586255081e-06 1.2 1.30589430894e-06 1.2 1.30592606707e-06 1.2 1.3059578252e-06 1.2 1.30598958333e-06 1.2 1.30602134146e-06 1.2 1.30605309959e-06 1.2 1.30608485772e-06 1.2 1.30611661585e-06 1.2 1.30614837398e-06 1.2 1.30618013211e-06 1.2 1.30621189024e-06 1.2 1.30624364837e-06 1.2 1.3062754065e-06 1.2 1.30630716463e-06 1.2 1.30633892276e-06 1.2 1.30637068089e-06 1.2 1.30640243902e-06 1.2 1.30643419715e-06 1.2 1.30646595528e-06 1.2 1.30649771341e-06 1.2 1.30652947154e-06 1.2 1.30656122967e-06 1.2 1.3065929878e-06 1.2 1.30662474593e-06 1.2 1.30665650407e-06 1.2 1.3066882622e-06 1.2 1.30672002033e-06 1.2 1.30675177846e-06 1.2 1.30678353659e-06 1.2 1.30681529472e-06 1.2 1.30684705285e-06 1.2 1.30687881098e-06 1.2 1.30691056911e-06 1.2 1.30694232724e-06 1.2 1.30697408537e-06 1.2 1.3070058435e-06 1.2 1.30703760163e-06 1.2 1.30706935976e-06 1.2 1.30710111789e-06 1.2 1.30713287602e-06 1.2 1.30716463415e-06 1.2 1.30719639228e-06 1.2 1.30722815041e-06 1.2 1.30725990854e-06 1.2 1.30729166667e-06 1.2 1.3073234248e-06 1.2 1.30735518293e-06 1.2 1.30738694106e-06 1.2 1.30741869919e-06 1.2 1.30745045732e-06 1.2 1.30748221545e-06 1.2 1.30751397358e-06 1.2 1.30754573171e-06 1.2 1.30757748984e-06 1.2 1.30760924797e-06 1.2 1.3076410061e-06 1.2 1.30767276423e-06 1.2 1.30770452236e-06 1.2 1.30773628049e-06 1.2 1.30776803862e-06 1.2 1.30779979675e-06 1.2 1.30783155488e-06 1.2 1.30786331301e-06 1.2 1.30789507114e-06 1.2 1.30792682927e-06 1.2 1.3079585874e-06 1.2 1.30799034553e-06 1.2 1.30802210366e-06 1.2 1.30805386179e-06 1.2 1.30808561992e-06 1.2 1.30811737805e-06 1.2 1.30814913618e-06 1.2 1.30818089431e-06 1.2 1.30821265244e-06 1.2 1.30824441057e-06 1.2 1.3082761687e-06 1.2 1.30830792683e-06 1.2 1.30833968496e-06 1.2 1.30837144309e-06 1.2 1.30840320122e-06 1.2 1.30843495935e-06 1.2 1.30846671748e-06 1.2 1.30849847561e-06 1.2 1.30853023374e-06 1.2 1.30856199187e-06 1.2 1.30859375e-06 1.2 1.30862550813e-06 1.2 1.30865726626e-06 1.2 1.30868902439e-06 1.2 1.30872078252e-06 1.2 1.30875254065e-06 1.2 1.30878429878e-06 1.2 1.30881605691e-06 1.2 1.30884781504e-06 1.2 1.30887957317e-06 1.2 1.3089113313e-06 1.2 1.30894308943e-06 1.2 1.30897484756e-06 1.2 1.30900660569e-06 1.2 1.30903836382e-06 1.2 1.30907012195e-06 1.2 1.30910188008e-06 1.2 1.30913363821e-06 1.2 1.30916539634e-06 1.2 1.30919715447e-06 1.2 1.3092289126e-06 1.2 1.30926067073e-06 1.2 1.30929242886e-06 1.2 1.30932418699e-06 1.2 1.30935594512e-06 1.2 1.30938770325e-06 1.2 1.30941946138e-06 1.2 1.30945121951e-06 1.2 1.30948297764e-06 1.2 1.30951473577e-06 1.2 1.3095464939e-06 1.2 1.30957825203e-06 1.2 1.30961001016e-06 1.2 1.30964176829e-06 1.2 1.30967352642e-06 1.2 1.30970528455e-06 1.2 1.30973704268e-06 1.2 1.30976880081e-06 1.2 1.30980055894e-06 1.2 1.30983231707e-06 1.2 1.3098640752e-06 1.2 1.30989583333e-06 1.2 1.30992759146e-06 1.2 1.30995934959e-06 1.2 1.30999110772e-06 1.2 1.31002286585e-06 1.2 1.31005462398e-06 1.2 1.31008638211e-06 1.2 1.31011814024e-06 1.2 1.31014989837e-06 1.2 1.3101816565e-06 1.2 1.31021341463e-06 1.2 1.31024517276e-06 1.2 1.31027693089e-06 1.2 1.31030868902e-06 1.2 1.31034044715e-06 1.2 1.31037220528e-06 1.2 1.31040396341e-06 1.2 1.31043572154e-06 1.2 1.31046747967e-06 1.2 1.3104992378e-06 1.2 1.31053099593e-06 1.2 1.31056275407e-06 1.2 1.3105945122e-06 1.2 1.31062627033e-06 1.2 1.31065802846e-06 1.2 1.31068978659e-06 1.2 1.31072154472e-06 1.2 1.31075330285e-06 1.2 1.31078506098e-06 1.2 1.31081681911e-06 1.2 1.31084857724e-06 1.2 1.31088033537e-06 1.2 1.3109120935e-06 1.2 1.31094385163e-06 1.2 1.31097560976e-06 1.2 1.31100736789e-06 1.2 1.31103912602e-06 1.2 1.31107088415e-06 1.2 1.31110264228e-06 1.2 1.31113440041e-06 1.2 1.31116615854e-06 1.2 1.31119791667e-06 1.2 1.3112296748e-06 1.2 1.31126143293e-06 1.2 1.31129319106e-06 1.2 1.31132494919e-06 1.2 1.31135670732e-06 1.2 1.31138846545e-06 1.2 1.31142022358e-06 1.2 1.31145198171e-06 1.2 1.31148373984e-06 1.2 1.31151549797e-06 1.2 1.3115472561e-06 1.2 1.31157901423e-06 1.2 1.31161077236e-06 1.2 1.31164253049e-06 1.2 1.31167428862e-06 1.2 1.31170604675e-06 1.2 1.31173780488e-06 1.2 1.31176956301e-06 1.2 1.31180132114e-06 1.2 1.31183307927e-06 1.2 1.3118648374e-06 1.2 1.31189659553e-06 1.2 1.31192835366e-06 1.2 1.31196011179e-06 1.2 1.31199186992e-06 1.2 1.31202362805e-06 1.2 1.31205538618e-06 1.2 1.31208714431e-06 1.2 1.31211890244e-06 1.2 1.31215066057e-06 1.2 1.3121824187e-06 1.2 1.31221417683e-06 1.2 1.31224593496e-06 1.2 1.31227769309e-06 1.2 1.31230945122e-06 1.2 1.31234120935e-06 1.2 1.31237296748e-06 1.2 1.31240472561e-06 1.2 1.31243648374e-06 1.2 1.31246824187e-06 1.2 1.3125e-06 1.2 1.31253175813e-06 1.2 1.31256351626e-06 1.2 1.31259527439e-06 1.2 1.31262703252e-06 1.2 1.31265879065e-06 1.2 1.31269054878e-06 1.2 1.31272230691e-06 1.2 1.31275406504e-06 1.2 1.31278582317e-06 1.2 1.3128175813e-06 1.2 1.31284933943e-06 1.2 1.31288109756e-06 1.2 1.31291285569e-06 1.2 1.31294461382e-06 1.2 1.31297637195e-06 1.2 1.31300813008e-06 1.2 1.31303988821e-06 1.2 1.31307164634e-06 1.2 1.31310340447e-06 1.2 1.3131351626e-06 1.2 1.31316692073e-06 1.2 1.31319867886e-06 1.2 1.31323043699e-06 1.2 1.31326219512e-06 1.2 1.31329395325e-06 1.2 1.31332571138e-06 1.2 1.31335746951e-06 1.2 1.31338922764e-06 1.2 1.31342098577e-06 1.2 1.3134527439e-06 1.2 1.31348450203e-06 1.2 1.31351626016e-06 1.2 1.31354801829e-06 1.2 1.31357977642e-06 1.2 1.31361153455e-06 1.2 1.31364329268e-06 1.2 1.31367505081e-06 1.2 1.31370680894e-06 1.2 1.31373856707e-06 1.2 1.3137703252e-06 1.2 1.31380208333e-06 1.2 1.31383384146e-06 1.2 1.31386559959e-06 1.2 1.31389735772e-06 1.2 1.31392911585e-06 1.2 1.31396087398e-06 1.2 1.31399263211e-06 1.2 1.31402439024e-06 1.2 1.31405614837e-06 1.2 1.3140879065e-06 1.2 1.31411966463e-06 1.2 1.31415142276e-06 1.2 1.31418318089e-06 1.2 1.31421493902e-06 1.2 1.31424669715e-06 1.2 1.31427845528e-06 1.2 1.31431021341e-06 1.2 1.31434197154e-06 1.2 1.31437372967e-06 1.2 1.3144054878e-06 1.2 1.31443724593e-06 1.2 1.31446900407e-06 1.2 1.3145007622e-06 1.2 1.31453252033e-06 1.2 1.31456427846e-06 1.2 1.31459603659e-06 1.2 1.31462779472e-06 1.2 1.31465955285e-06 1.2 1.31469131098e-06 1.2 1.31472306911e-06 1.2 1.31475482724e-06 1.2 1.31478658537e-06 1.2 1.3148183435e-06 1.2 1.31485010163e-06 1.2 1.31488185976e-06 1.2 1.31491361789e-06 1.2 1.31494537602e-06 1.2 1.31497713415e-06 1.2 1.31500889228e-06 1.2 1.31504065041e-06 1.2 1.31507240854e-06 1.2 1.31510416667e-06 1.2 1.3151359248e-06 1.2 1.31516768293e-06 1.2 1.31519944106e-06 1.2 1.31523119919e-06 1.2 1.31526295732e-06 1.2 1.31529471545e-06 1.2 1.31532647358e-06 1.2 1.31535823171e-06 1.2 1.31538998984e-06 1.2 1.31542174797e-06 1.2 1.3154535061e-06 1.2 1.31548526423e-06 1.2 1.31551702236e-06 1.2 1.31554878049e-06 1.2 1.31558053862e-06 1.2 1.31561229675e-06 1.2 1.31564405488e-06 1.2 1.31567581301e-06 1.2 1.31570757114e-06 1.2 1.31573932927e-06 1.2 1.3157710874e-06 1.2 1.31580284553e-06 1.2 1.31583460366e-06 1.2 1.31586636179e-06 1.2 1.31589811992e-06 1.2 1.31592987805e-06 1.2 1.31596163618e-06 1.2 1.31599339431e-06 1.2 1.31602515244e-06 1.2 1.31605691057e-06 1.2 1.3160886687e-06 1.2 1.31612042683e-06 1.2 1.31615218496e-06 1.2 1.31618394309e-06 1.2 1.31621570122e-06 1.2 1.31624745935e-06 1.2 1.31627921748e-06 1.2 1.31631097561e-06 1.2 1.31634273374e-06 1.2 1.31637449187e-06 1.2 1.31640625e-06 1.2 1.31643800813e-06 1.2 1.31646976626e-06 1.2 1.31650152439e-06 1.2 1.31653328252e-06 1.2 1.31656504065e-06 1.2 1.31659679878e-06 1.2 1.31662855691e-06 1.2 1.31666031504e-06 1.2 1.31669207317e-06 1.2 1.3167238313e-06 1.2 1.31675558943e-06 1.2 1.31678734756e-06 1.2 1.31681910569e-06 1.2 1.31685086382e-06 1.2 1.31688262195e-06 1.2 1.31691438008e-06 1.2 1.31694613821e-06 1.2 1.31697789634e-06 1.2 1.31700965447e-06 1.2 1.3170414126e-06 1.2 1.31707317073e-06 1.2 1.31710492886e-06 1.2 1.31713668699e-06 1.2 1.31716844512e-06 1.2 1.31720020325e-06 1.2 1.31723196138e-06 1.2 1.31726371951e-06 1.2 1.31729547764e-06 1.2 1.31732723577e-06 1.2 1.3173589939e-06 1.2 1.31739075203e-06 1.2 1.31742251016e-06 1.2 1.31745426829e-06 1.2 1.31748602642e-06 1.2 1.31751778455e-06 1.2 1.31754954268e-06 1.2 1.31758130081e-06 1.2 1.31761305894e-06 1.2 1.31764481707e-06 1.2 1.3176765752e-06 1.2 1.31770833333e-06 1.2 1.31774009146e-06 1.2 1.31777184959e-06 1.2 1.31780360772e-06 1.2 1.31783536585e-06 1.2 1.31786712398e-06 1.2 1.31789888211e-06 1.2 1.31793064024e-06 1.2 1.31796239837e-06 1.2 1.3179941565e-06 1.2 1.31802591463e-06 1.2 1.31805767276e-06 1.2 1.31808943089e-06 1.2 1.31812118902e-06 1.2 1.31815294715e-06 1.2 1.31818470528e-06 1.2 1.31821646341e-06 1.2 1.31824822154e-06 1.2 1.31827997967e-06 1.2 1.3183117378e-06 1.2 1.31834349593e-06 1.2 1.31837525407e-06 1.2 1.3184070122e-06 1.2 1.31843877033e-06 1.2 1.31847052846e-06 1.2 1.31850228659e-06 1.2 1.31853404472e-06 1.2 1.31856580285e-06 1.2 1.31859756098e-06 1.2 1.31862931911e-06 1.2 1.31866107724e-06 1.2 1.31869283537e-06 1.2 1.3187245935e-06 1.2 1.31875635163e-06 1.2 1.31878810976e-06 1.2 1.31881986789e-06 1.2 1.31885162602e-06 1.2 1.31888338415e-06 1.2 1.31891514228e-06 1.2 1.31894690041e-06 1.2 1.31897865854e-06 1.2 1.31901041667e-06 1.2 1.3190421748e-06 1.2 1.31907393293e-06 1.2 1.31910569106e-06 1.2 1.31913744919e-06 1.2 1.31916920732e-06 1.2 1.31920096545e-06 1.2 1.31923272358e-06 1.2 1.31926448171e-06 1.2 1.31929623984e-06 1.2 1.31932799797e-06 1.2 1.3193597561e-06 1.2 1.31939151423e-06 1.2 1.31942327236e-06 1.2 1.31945503049e-06 1.2 1.31948678862e-06 1.2 1.31951854675e-06 1.2 1.31955030488e-06 1.2 1.31958206301e-06 1.2 1.31961382114e-06 1.2 1.31964557927e-06 1.2 1.3196773374e-06 1.2 1.31970909553e-06 1.2 1.31974085366e-06 1.2 1.31977261179e-06 1.2 1.31980436992e-06 1.2 1.31983612805e-06 1.2 1.31986788618e-06 1.2 1.31989964431e-06 1.2 1.31993140244e-06 1.2 1.31996316057e-06 1.2 1.3199949187e-06 1.2 1.32002667683e-06 1.2 1.32005843496e-06 1.2 1.32009019309e-06 1.2 1.32012195122e-06 1.2 1.32015370935e-06 1.2 1.32018546748e-06 1.2 1.32021722561e-06 1.2 1.32024898374e-06 1.2 1.32028074187e-06 1.2 1.3203125e-06 1.2 1.32034425813e-06 1.2 1.32037601626e-06 1.2 1.32040777439e-06 1.2 1.32043953252e-06 1.2 1.32047129065e-06 1.2 1.32050304878e-06 1.2 1.32053480691e-06 1.2 1.32056656504e-06 1.2 1.32059832317e-06 1.2 1.3206300813e-06 1.2 1.32066183943e-06 1.2 1.32069359756e-06 1.2 1.32072535569e-06 1.2 1.32075711382e-06 1.2 1.32078887195e-06 1.2 1.32082063008e-06 1.2 1.32085238821e-06 1.2 1.32088414634e-06 1.2 1.32091590447e-06 1.2 1.3209476626e-06 1.2 1.32097942073e-06 1.2 1.32101117886e-06 1.2 1.32104293699e-06 1.2 1.32107469512e-06 1.2 1.32110645325e-06 1.2 1.32113821138e-06 1.2 1.32116996951e-06 1.2 1.32120172764e-06 1.2 1.32123348577e-06 1.2 1.3212652439e-06 1.2 1.32129700203e-06 1.2 1.32132876016e-06 1.2 1.32136051829e-06 1.2 1.32139227642e-06 1.2 1.32142403455e-06 1.2 1.32145579268e-06 1.2 1.32148755081e-06 1.2 1.32151930894e-06 1.2 1.32155106707e-06 1.2 1.3215828252e-06 1.2 1.32161458333e-06 1.2 1.32164634146e-06 1.2 1.32167809959e-06 1.2 1.32170985772e-06 1.2 1.32174161585e-06 1.2 1.32177337398e-06 1.2 1.32180513211e-06 1.2 1.32183689024e-06 1.2 1.32186864837e-06 1.2 1.3219004065e-06 1.2 1.32193216463e-06 1.2 1.32196392276e-06 1.2 1.32199568089e-06 1.2 1.32202743902e-06 1.2 1.32205919715e-06 1.2 1.32209095528e-06 1.2 1.32212271341e-06 1.2 1.32215447154e-06 1.2 1.32218622967e-06 1.2 1.3222179878e-06 1.2 1.32224974593e-06 1.2 1.32228150407e-06 1.2 1.3223132622e-06 1.2 1.32234502033e-06 1.2 1.32237677846e-06 1.2 1.32240853659e-06 1.2 1.32244029472e-06 1.2 1.32247205285e-06 1.2 1.32250381098e-06 1.2 1.32253556911e-06 1.2 1.32256732724e-06 1.2 1.32259908537e-06 1.2 1.3226308435e-06 1.2 1.32266260163e-06 1.2 1.32269435976e-06 1.2 1.32272611789e-06 1.2 1.32275787602e-06 1.2 1.32278963415e-06 1.2 1.32282139228e-06 1.2 1.32285315041e-06 1.2 1.32288490854e-06 1.2 1.32291666667e-06 1.2 1.3229484248e-06 1.2 1.32298018293e-06 1.2 1.32301194106e-06 1.2 1.32304369919e-06 1.2 1.32307545732e-06 1.2 1.32310721545e-06 1.2 1.32313897358e-06 1.2 1.32317073171e-06 1.2 1.32320248984e-06 1.2 1.32323424797e-06 1.2 1.3232660061e-06 1.2 1.32329776423e-06 1.2 1.32332952236e-06 1.2 1.32336128049e-06 1.2 1.32339303862e-06 1.2 1.32342479675e-06 1.2 1.32345655488e-06 1.2 1.32348831301e-06 1.2 1.32352007114e-06 1.2 1.32355182927e-06 1.2 1.3235835874e-06 1.2 1.32361534553e-06 1.2 1.32364710366e-06 1.2 1.32367886179e-06 1.2 1.32371061992e-06 1.2 1.32374237805e-06 1.2 1.32377413618e-06 1.2 1.32380589431e-06 1.2 1.32383765244e-06 1.2 1.32386941057e-06 1.2 1.3239011687e-06 1.2 1.32393292683e-06 1.2 1.32396468496e-06 1.2 1.32399644309e-06 1.2 1.32402820122e-06 1.2 1.32405995935e-06 1.2 1.32409171748e-06 1.2 1.32412347561e-06 1.2 1.32415523374e-06 1.2 1.32418699187e-06 1.2 1.32421875e-06 1.2 1.32425050813e-06 1.2 1.32428226626e-06 1.2 1.32431402439e-06 1.2 1.32434578252e-06 1.2 1.32437754065e-06 1.2 1.32440929878e-06 1.2 1.32444105691e-06 1.2 1.32447281504e-06 1.2 1.32450457317e-06 1.2 1.3245363313e-06 1.2 1.32456808943e-06 1.2 1.32459984756e-06 1.2 1.32463160569e-06 1.2 1.32466336382e-06 1.2 1.32469512195e-06 1.2 1.32472688008e-06 1.2 1.32475863821e-06 1.2 1.32479039634e-06 1.2 1.32482215447e-06 1.2 1.3248539126e-06 1.2 1.32488567073e-06 1.2 1.32491742886e-06 1.2 1.32494918699e-06 1.2 1.32498094512e-06 1.2 1.32501270325e-06 1.2 1.32504446138e-06 1.2 1.32507621951e-06 1.2 1.32510797764e-06 1.2 1.32513973577e-06 1.2 1.3251714939e-06 1.2 1.32520325203e-06 1.2 1.32523501016e-06 1.2 1.32526676829e-06 1.2 1.32529852642e-06 1.2 1.32533028455e-06 1.2 1.32536204268e-06 1.2 1.32539380081e-06 1.2 1.32542555894e-06 1.2 1.32545731707e-06 1.2 1.3254890752e-06 1.2 1.32552083333e-06 1.2 1.32555259146e-06 1.2 1.32558434959e-06 1.2 1.32561610772e-06 1.2 1.32564786585e-06 1.2 1.32567962398e-06 1.2 1.32571138211e-06 1.2 1.32574314024e-06 1.2 1.32577489837e-06 1.2 1.3258066565e-06 1.2 1.32583841463e-06 1.2 1.32587017276e-06 1.2 1.32590193089e-06 1.2 1.32593368902e-06 1.2 1.32596544715e-06 1.2 1.32599720528e-06 1.2 1.32602896341e-06 1.2 1.32606072154e-06 1.2 1.32609247967e-06 1.2 1.3261242378e-06 1.2 1.32615599593e-06 1.2 1.32618775407e-06 1.2 1.3262195122e-06 1.2 1.32625127033e-06 1.2 1.32628302846e-06 1.2 1.32631478659e-06 1.2 1.32634654472e-06 1.2 1.32637830285e-06 1.2 1.32641006098e-06 1.2 1.32644181911e-06 1.2 1.32647357724e-06 1.2 1.32650533537e-06 1.2 1.3265370935e-06 1.2 1.32656885163e-06 1.2 1.32660060976e-06 1.2 1.32663236789e-06 1.2 1.32666412602e-06 1.2 1.32669588415e-06 1.2 1.32672764228e-06 1.2 1.32675940041e-06 1.2 1.32679115854e-06 1.2 1.32682291667e-06 1.2 1.3268546748e-06 1.2 1.32688643293e-06 1.2 1.32691819106e-06 1.2 1.32694994919e-06 1.2 1.32698170732e-06 1.2 1.32701346545e-06 1.2 1.32704522358e-06 1.2 1.32707698171e-06 1.2 1.32710873984e-06 1.2 1.32714049797e-06 1.2 1.3271722561e-06 1.2 1.32720401423e-06 1.2 1.32723577236e-06 1.2 1.32726753049e-06 1.2 1.32729928862e-06 1.2 1.32733104675e-06 1.2 1.32736280488e-06 1.2 1.32739456301e-06 1.2 1.32742632114e-06 1.2 1.32745807927e-06 1.2 1.3274898374e-06 1.2 1.32752159553e-06 1.2 1.32755335366e-06 1.2 1.32758511179e-06 1.2 1.32761686992e-06 1.2 1.32764862805e-06 1.2 1.32768038618e-06 1.2 1.32771214431e-06 1.2 1.32774390244e-06 1.2 1.32777566057e-06 1.2 1.3278074187e-06 1.2 1.32783917683e-06 1.2 1.32787093496e-06 1.2 1.32790269309e-06 1.2 1.32793445122e-06 1.2 1.32796620935e-06 1.2 1.32799796748e-06 1.2 1.32802972561e-06 1.2 1.32806148374e-06 1.2 1.32809324187e-06 1.2 1.328125e-06 1.2 1.32815675813e-06 1.2 1.32818851626e-06 1.2 1.32822027439e-06 1.2 1.32825203252e-06 1.2 1.32828379065e-06 1.2 1.32831554878e-06 1.2 1.32834730691e-06 1.2 1.32837906504e-06 1.2 1.32841082317e-06 1.2 1.3284425813e-06 1.2 1.32847433943e-06 1.2 1.32850609756e-06 1.2 1.32853785569e-06 1.2 1.32856961382e-06 1.2 1.32860137195e-06 1.2 1.32863313008e-06 1.2 1.32866488821e-06 1.2 1.32869664634e-06 1.2 1.32872840447e-06 1.2 1.3287601626e-06 1.2 1.32879192073e-06 1.2 1.32882367886e-06 1.2 1.32885543699e-06 1.2 1.32888719512e-06 1.2 1.32891895325e-06 1.2 1.32895071138e-06 1.2 1.32898246951e-06 1.2 1.32901422764e-06 1.2 1.32904598577e-06 1.2 1.3290777439e-06 1.2 1.32910950203e-06 1.2 1.32914126016e-06 1.2 1.32917301829e-06 1.2 1.32920477642e-06 1.2 1.32923653455e-06 1.2 1.32926829268e-06 1.2 1.32930005081e-06 1.2 1.32933180894e-06 1.2 1.32936356707e-06 1.2 1.3293953252e-06 1.2 1.32942708333e-06 1.2 1.32945884146e-06 1.2 1.32949059959e-06 1.2 1.32952235772e-06 1.2 1.32955411585e-06 1.2 1.32958587398e-06 1.2 1.32961763211e-06 1.2 1.32964939024e-06 1.2 1.32968114837e-06 1.2 1.3297129065e-06 1.2 1.32974466463e-06 1.2 1.32977642276e-06 1.2 1.32980818089e-06 1.2 1.32983993902e-06 1.2 1.32987169715e-06 1.2 1.32990345528e-06 1.2 1.32993521341e-06 1.2 1.32996697154e-06 1.2 1.32999872967e-06 1.2 1.3300304878e-06 1.2 1.33006224593e-06 1.2 1.33009400407e-06 1.2 1.3301257622e-06 1.2 1.33015752033e-06 1.2 1.33018927846e-06 1.2 1.33022103659e-06 1.2 1.33025279472e-06 1.2 1.33028455285e-06 1.2 1.33031631098e-06 1.2 1.33034806911e-06 1.2 1.33037982724e-06 1.2 1.33041158537e-06 1.2 1.3304433435e-06 1.2 1.33047510163e-06 1.2 1.33050685976e-06 1.2 1.33053861789e-06 1.2 1.33057037602e-06 1.2 1.33060213415e-06 1.2 1.33063389228e-06 1.2 1.33066565041e-06 1.2 1.33069740854e-06 1.2 1.33072916667e-06 1.2 1.3307609248e-06 1.2 1.33079268293e-06 1.2 1.33082444106e-06 1.2 1.33085619919e-06 1.2 1.33088795732e-06 1.2 1.33091971545e-06 1.2 1.33095147358e-06 1.2 1.33098323171e-06 1.2 1.33101498984e-06 1.2 1.33104674797e-06 1.2 1.3310785061e-06 1.2 1.33111026423e-06 1.2 1.33114202236e-06 1.2 1.33117378049e-06 1.2 1.33120553862e-06 1.2 1.33123729675e-06 1.2 1.33126905488e-06 1.2 1.33130081301e-06 1.2 1.33133257114e-06 1.2 1.33136432927e-06 1.2 1.3313960874e-06 1.2 1.33142784553e-06 1.2 1.33145960366e-06 1.2 1.33149136179e-06 1.2 1.33152311992e-06 1.2 1.33155487805e-06 1.2 1.33158663618e-06 1.2 1.33161839431e-06 1.2 1.33165015244e-06 1.2 1.33168191057e-06 1.2 1.3317136687e-06 1.2 1.33174542683e-06 1.2 1.33177718496e-06 1.2 1.33180894309e-06 1.2 1.33184070122e-06 1.2 1.33187245935e-06 1.2 1.33190421748e-06 1.2 1.33193597561e-06 1.2 1.33196773374e-06 1.2 1.33199949187e-06 1.2 1.33203125e-06 1.2 1.33206300813e-06 1.2 1.33209476626e-06 1.2 1.33212652439e-06 1.2 1.33215828252e-06 1.2 1.33219004065e-06 1.2 1.33222179878e-06 1.2 1.33225355691e-06 1.2 1.33228531504e-06 1.2 1.33231707317e-06 1.2 1.3323488313e-06 1.2 1.33238058943e-06 1.2 1.33241234756e-06 1.2 1.33244410569e-06 1.2 1.33247586382e-06 1.2 1.33250762195e-06 1.2 1.33253938008e-06 1.2 1.33257113821e-06 1.2 1.33260289634e-06 1.2 1.33263465447e-06 1.2 1.3326664126e-06 1.2 1.33269817073e-06 1.2 1.33272992886e-06 1.2 1.33276168699e-06 1.2 1.33279344512e-06 1.2 1.33282520325e-06 1.2 1.33285696138e-06 1.2 1.33288871951e-06 1.2 1.33292047764e-06 1.2 1.33295223577e-06 1.2 1.3329839939e-06 1.2 1.33301575203e-06 1.2 1.33304751016e-06 1.2 1.33307926829e-06 1.2 1.33311102642e-06 1.2 1.33314278455e-06 1.2 1.33317454268e-06 1.2 1.33320630081e-06 1.2 1.33323805894e-06 1.2 1.33326981707e-06 1.2 1.3333015752e-06 1.2 1.33333333333e-06 1.2 1.33336509146e-06 1.2 1.33339684959e-06 1.2 1.33342860772e-06 1.2 1.33346036585e-06 1.2 1.33349212398e-06 1.2 1.33352388211e-06 1.2 1.33355564024e-06 1.2 1.33358739837e-06 1.2 1.3336191565e-06 1.2 1.33365091463e-06 1.2 1.33368267276e-06 1.2 1.33371443089e-06 1.2 1.33374618902e-06 1.2 1.33377794715e-06 1.2 1.33380970528e-06 1.2 1.33384146341e-06 1.2 1.33387322154e-06 1.2 1.33390497967e-06 1.2 1.3339367378e-06 1.2 1.33396849593e-06 1.2 1.33400025407e-06 1.2 1.3340320122e-06 1.2 1.33406377033e-06 1.2 1.33409552846e-06 1.2 1.33412728659e-06 1.2 1.33415904472e-06 1.2 1.33419080285e-06 1.2 1.33422256098e-06 1.2 1.33425431911e-06 1.2 1.33428607724e-06 1.2 1.33431783537e-06 1.2 1.3343495935e-06 1.2 1.33438135163e-06 1.2 1.33441310976e-06 1.2 1.33444486789e-06 1.2 1.33447662602e-06 1.2 1.33450838415e-06 1.2 1.33454014228e-06 1.2 1.33457190041e-06 1.2 1.33460365854e-06 1.2 1.33463541667e-06 1.2 1.3346671748e-06 1.2 1.33469893293e-06 1.2 1.33473069106e-06 1.2 1.33476244919e-06 1.2 1.33479420732e-06 1.2 1.33482596545e-06 1.2 1.33485772358e-06 1.2 1.33488948171e-06 1.2 1.33492123984e-06 1.2 1.33495299797e-06 1.2 1.3349847561e-06 1.2 1.33501651423e-06 1.2 1.33504827236e-06 1.2 1.33508003049e-06 1.2 1.33511178862e-06 1.2 1.33514354675e-06 1.2 1.33517530488e-06 1.2 1.33520706301e-06 1.2 1.33523882114e-06 1.2 1.33527057927e-06 1.2 1.3353023374e-06 1.2 1.33533409553e-06 1.2 1.33536585366e-06 1.2 1.33539761179e-06 1.2 1.33542936992e-06 1.2 1.33546112805e-06 1.2 1.33549288618e-06 1.2 1.33552464431e-06 1.2 1.33555640244e-06 1.2 1.33558816057e-06 1.2 1.3356199187e-06 1.2 1.33565167683e-06 1.2 1.33568343496e-06 1.2 1.33571519309e-06 1.2 1.33574695122e-06 1.2 1.33577870935e-06 1.2 1.33581046748e-06 1.2 1.33584222561e-06 1.2 1.33587398374e-06 1.2 1.33590574187e-06 1.2 1.3359375e-06 1.2 1.33596925813e-06 1.2 1.33600101626e-06 1.2 1.33603277439e-06 1.2 1.33606453252e-06 1.2 1.33609629065e-06 1.2 1.33612804878e-06 1.2 1.33615980691e-06 1.2 1.33619156504e-06 1.2 1.33622332317e-06 1.2 1.3362550813e-06 1.2 1.33628683943e-06 1.2 1.33631859756e-06 1.2 1.33635035569e-06 1.2 1.33638211382e-06 1.2 1.33641387195e-06 1.2 1.33644563008e-06 1.2 1.33647738821e-06 1.2 1.33650914634e-06 1.2 1.33654090447e-06 1.2 1.3365726626e-06 1.2 1.33660442073e-06 1.2 1.33663617886e-06 1.2 1.33666793699e-06 1.2 1.33669969512e-06 1.2 1.33673145325e-06 1.2 1.33676321138e-06 1.2 1.33679496951e-06 1.2 1.33682672764e-06 1.2 1.33685848577e-06 1.2 1.3368902439e-06 1.2 1.33692200203e-06 1.2 1.33695376016e-06 1.2 1.33698551829e-06 1.2 1.33701727642e-06 1.2 1.33704903455e-06 1.2 1.33708079268e-06 1.2 1.33711255081e-06 1.2 1.33714430894e-06 1.2 1.33717606707e-06 1.2 1.3372078252e-06 1.2 1.33723958333e-06 1.2 1.33727134146e-06 1.2 1.33730309959e-06 1.2 1.33733485772e-06 1.2 1.33736661585e-06 1.2 1.33739837398e-06 1.2 1.33743013211e-06 1.2 1.33746189024e-06 1.2 1.33749364837e-06 1.2 1.3375254065e-06 1.2 1.33755716463e-06 1.2 1.33758892276e-06 1.2 1.33762068089e-06 1.2 1.33765243902e-06 1.2 1.33768419715e-06 1.2 1.33771595528e-06 1.2 1.33774771341e-06 1.2 1.33777947154e-06 1.2 1.33781122967e-06 1.2 1.3378429878e-06 1.2 1.33787474593e-06 1.2 1.33790650407e-06 1.2 1.3379382622e-06 1.2 1.33797002033e-06 1.2 1.33800177846e-06 1.2 1.33803353659e-06 1.2 1.33806529472e-06 1.2 1.33809705285e-06 1.2 1.33812881098e-06 1.2 1.33816056911e-06 1.2 1.33819232724e-06 1.2 1.33822408537e-06 1.2 1.3382558435e-06 1.2 1.33828760163e-06 1.2 1.33831935976e-06 1.2 1.33835111789e-06 1.2 1.33838287602e-06 1.2 1.33841463415e-06 1.2 1.33844639228e-06 1.2 1.33847815041e-06 1.2 1.33850990854e-06 1.2 1.33854166667e-06 1.2 1.3385734248e-06 1.2 1.33860518293e-06 1.2 1.33863694106e-06 1.2 1.33866869919e-06 1.2 1.33870045732e-06 1.2 1.33873221545e-06 1.2 1.33876397358e-06 1.2 1.33879573171e-06 1.2 1.33882748984e-06 1.2 1.33885924797e-06 1.2 1.3388910061e-06 1.2 1.33892276423e-06 1.2 1.33895452236e-06 1.2 1.33898628049e-06 1.2 1.33901803862e-06 1.2 1.33904979675e-06 1.2 1.33908155488e-06 1.2 1.33911331301e-06 1.2 1.33914507114e-06 1.2 1.33917682927e-06 1.2 1.3392085874e-06 1.2 1.33924034553e-06 1.2 1.33927210366e-06 1.2 1.33930386179e-06 1.2 1.33933561992e-06 1.2 1.33936737805e-06 1.2 1.33939913618e-06 1.2 1.33943089431e-06 1.2 1.33946265244e-06 1.2 1.33949441057e-06 1.2 1.3395261687e-06 1.2 1.33955792683e-06 1.2 1.33958968496e-06 1.2 1.33962144309e-06 1.2 1.33965320122e-06 1.2 1.33968495935e-06 1.2 1.33971671748e-06 1.2 1.33974847561e-06 1.2 1.33978023374e-06 1.2 1.33981199187e-06 1.2 1.33984375e-06 1.2 1.33987550813e-06 1.2 1.33990726626e-06 1.2 1.33993902439e-06 1.2 1.33997078252e-06 1.2 1.34000254065e-06 1.2 1.34003429878e-06 1.2 1.34006605691e-06 1.2 1.34009781504e-06 1.2 1.34012957317e-06 1.2 1.3401613313e-06 1.2 1.34019308943e-06 1.2 1.34022484756e-06 1.2 1.34025660569e-06 1.2 1.34028836382e-06 1.2 1.34032012195e-06 1.2 1.34035188008e-06 1.2 1.34038363821e-06 1.2 1.34041539634e-06 1.2 1.34044715447e-06 1.2 1.3404789126e-06 1.2 1.34051067073e-06 1.2 1.34054242886e-06 1.2 1.34057418699e-06 1.2 1.34060594512e-06 1.2 1.34063770325e-06 1.2 1.34066946138e-06 1.2 1.34070121951e-06 1.2 1.34073297764e-06 1.2 1.34076473577e-06 1.2 1.3407964939e-06 1.2 1.34082825203e-06 1.2 1.34086001016e-06 1.2 1.34089176829e-06 1.2 1.34092352642e-06 1.2 1.34095528455e-06 1.2 1.34098704268e-06 1.2 1.34101880081e-06 1.2 1.34105055894e-06 1.2 1.34108231707e-06 1.2 1.3411140752e-06 1.2 1.34114583333e-06 1.2 1.34117759146e-06 1.2 1.34120934959e-06 1.2 1.34124110772e-06 1.2 1.34127286585e-06 1.2 1.34130462398e-06 1.2 1.34133638211e-06 1.2 1.34136814024e-06 1.2 1.34139989837e-06 1.2 1.3414316565e-06 1.2 1.34146341463e-06 1.2 1.34149517276e-06 1.2 1.34152693089e-06 1.2 1.34155868902e-06 1.2 1.34159044715e-06 1.2 1.34162220528e-06 1.2 1.34165396341e-06 1.2 1.34168572154e-06 1.2 1.34171747967e-06 1.2 1.3417492378e-06 1.2 1.34178099593e-06 1.2 1.34181275407e-06 1.2 1.3418445122e-06 1.2 1.34187627033e-06 1.2 1.34190802846e-06 1.2 1.34193978659e-06 1.2 1.34197154472e-06 1.2 1.34200330285e-06 1.2 1.34203506098e-06 1.2 1.34206681911e-06 1.2 1.34209857724e-06 1.2 1.34213033537e-06 1.2 1.3421620935e-06 1.2 1.34219385163e-06 1.2 1.34222560976e-06 1.2 1.34225736789e-06 1.2 1.34228912602e-06 1.2 1.34232088415e-06 1.2 1.34235264228e-06 1.2 1.34238440041e-06 1.2 1.34241615854e-06 1.2 1.34244791667e-06 1.2 1.3424796748e-06 1.2 1.34251143293e-06 1.2 1.34254319106e-06 1.2 1.34257494919e-06 1.2 1.34260670732e-06 1.2 1.34263846545e-06 1.2 1.34267022358e-06 1.2 1.34270198171e-06 1.2 1.34273373984e-06 1.2 1.34276549797e-06 1.2 1.3427972561e-06 1.2 1.34282901423e-06 1.2 1.34286077236e-06 1.2 1.34289253049e-06 1.2 1.34292428862e-06 1.2 1.34295604675e-06 1.2 1.34298780488e-06 1.2 1.34301956301e-06 1.2 1.34305132114e-06 1.2 1.34308307927e-06 1.2 1.3431148374e-06 1.2 1.34314659553e-06 1.2 1.34317835366e-06 1.2 1.34321011179e-06 1.2 1.34324186992e-06 1.2 1.34327362805e-06 1.2 1.34330538618e-06 1.2 1.34333714431e-06 1.2 1.34336890244e-06 1.2 1.34340066057e-06 1.2 1.3434324187e-06 1.2 1.34346417683e-06 1.2 1.34349593496e-06 1.2 1.34352769309e-06 1.2 1.34355945122e-06 1.2 1.34359120935e-06 1.2 1.34362296748e-06 1.2 1.34365472561e-06 1.2 1.34368648374e-06 1.2 1.34371824187e-06 1.2 1.34375e-06 1.2 1.34378175813e-06 1.2 1.34381351626e-06 1.2 1.34384527439e-06 1.2 1.34387703252e-06 1.2 1.34390879065e-06 1.2 1.34394054878e-06 1.2 1.34397230691e-06 1.2 1.34400406504e-06 1.2 1.34403582317e-06 1.2 1.3440675813e-06 1.2 1.34409933943e-06 1.2 1.34413109756e-06 1.2 1.34416285569e-06 1.2 1.34419461382e-06 1.2 1.34422637195e-06 1.2 1.34425813008e-06 1.2 1.34428988821e-06 1.2 1.34432164634e-06 1.2 1.34435340447e-06 1.2 1.3443851626e-06 1.2 1.34441692073e-06 1.2 1.34444867886e-06 1.2 1.34448043699e-06 1.2 1.34451219512e-06 1.2 1.34454395325e-06 1.2 1.34457571138e-06 1.2 1.34460746951e-06 1.2 1.34463922764e-06 1.2 1.34467098577e-06 1.2 1.3447027439e-06 1.2 1.34473450203e-06 1.2 1.34476626016e-06 1.2 1.34479801829e-06 1.2 1.34482977642e-06 1.2 1.34486153455e-06 1.2 1.34489329268e-06 1.2 1.34492505081e-06 1.2 1.34495680894e-06 1.2 1.34498856707e-06 1.2 1.3450203252e-06 1.2 1.34505208333e-06 1.2 1.34508384146e-06 1.2 1.34511559959e-06 1.2 1.34514735772e-06 1.2 1.34517911585e-06 1.2 1.34521087398e-06 1.2 1.34524263211e-06 1.2 1.34527439024e-06 1.2 1.34530614837e-06 1.2 1.3453379065e-06 1.2 1.34536966463e-06 1.2 1.34540142276e-06 1.2 1.34543318089e-06 1.2 1.34546493902e-06 1.2 1.34549669715e-06 1.2 1.34552845528e-06 1.2 1.34556021341e-06 1.2 1.34559197154e-06 1.2 1.34562372967e-06 1.2 1.3456554878e-06 1.2 1.34568724593e-06 1.2 1.34571900407e-06 1.2 1.3457507622e-06 1.2 1.34578252033e-06 1.2 1.34581427846e-06 1.2 1.34584603659e-06 1.2 1.34587779472e-06 1.2 1.34590955285e-06 1.2 1.34594131098e-06 1.2 1.34597306911e-06 1.2 1.34600482724e-06 1.2 1.34603658537e-06 1.2 1.3460683435e-06 1.2 1.34610010163e-06 1.2 1.34613185976e-06 1.2 1.34616361789e-06 1.2 1.34619537602e-06 1.2 1.34622713415e-06 1.2 1.34625889228e-06 1.2 1.34629065041e-06 1.2 1.34632240854e-06 1.2 1.34635416667e-06 1.2 1.3463859248e-06 1.2 1.34641768293e-06 1.2 1.34644944106e-06 1.2 1.34648119919e-06 1.2 1.34651295732e-06 1.2 1.34654471545e-06 1.2 1.34657647358e-06 1.2 1.34660823171e-06 1.2 1.34663998984e-06 1.2 1.34667174797e-06 1.2 1.3467035061e-06 1.2 1.34673526423e-06 1.2 1.34676702236e-06 1.2 1.34679878049e-06 1.2 1.34683053862e-06 1.2 1.34686229675e-06 1.2 1.34689405488e-06 1.2 1.34692581301e-06 1.2 1.34695757114e-06 1.2 1.34698932927e-06 1.2 1.3470210874e-06 1.2 1.34705284553e-06 1.2 1.34708460366e-06 1.2 1.34711636179e-06 1.2 1.34714811992e-06 1.2 1.34717987805e-06 1.2 1.34721163618e-06 1.2 1.34724339431e-06 1.2 1.34727515244e-06 1.2 1.34730691057e-06 1.2 1.3473386687e-06 1.2 1.34737042683e-06 1.2 1.34740218496e-06 1.2 1.34743394309e-06 1.2 1.34746570122e-06 1.2 1.34749745935e-06 1.2 1.34752921748e-06 1.2 1.34756097561e-06 1.2 1.34759273374e-06 1.2 1.34762449187e-06 1.2 1.34765625e-06 1.2 1.34768800813e-06 1.2 1.34771976626e-06 1.2 1.34775152439e-06 1.2 1.34778328252e-06 1.2 1.34781504065e-06 1.2 1.34784679878e-06 1.2 1.34787855691e-06 1.2 1.34791031504e-06 1.2 1.34794207317e-06 1.2 1.3479738313e-06 1.2 1.34800558943e-06 1.2 1.34803734756e-06 1.2 1.34806910569e-06 1.2 1.34810086382e-06 1.2 1.34813262195e-06 1.2 1.34816438008e-06 1.2 1.34819613821e-06 1.2 1.34822789634e-06 1.2 1.34825965447e-06 1.2 1.3482914126e-06 1.2 1.34832317073e-06 1.2 1.34835492886e-06 1.2 1.34838668699e-06 1.2 1.34841844512e-06 1.2 1.34845020325e-06 1.2 1.34848196138e-06 1.2 1.34851371951e-06 1.2 1.34854547764e-06 1.2 1.34857723577e-06 1.2 1.3486089939e-06 1.2 1.34864075203e-06 1.2 1.34867251016e-06 1.2 1.34870426829e-06 1.2 1.34873602642e-06 1.2 1.34876778455e-06 1.2 1.34879954268e-06 1.2 1.34883130081e-06 1.2 1.34886305894e-06 1.2 1.34889481707e-06 1.2 1.3489265752e-06 1.2 1.34895833333e-06 1.2 1.34899009146e-06 1.2 1.34902184959e-06 1.2 1.34905360772e-06 1.2 1.34908536585e-06 1.2 1.34911712398e-06 1.2 1.34914888211e-06 1.2 1.34918064024e-06 1.2 1.34921239837e-06 1.2 1.3492441565e-06 1.2 1.34927591463e-06 1.2 1.34930767276e-06 1.2 1.34933943089e-06 1.2 1.34937118902e-06 1.2 1.34940294715e-06 1.2 1.34943470528e-06 1.2 1.34946646341e-06 1.2 1.34949822154e-06 1.2 1.34952997967e-06 1.2 1.3495617378e-06 1.2 1.34959349593e-06 1.2 1.34962525407e-06 1.2 1.3496570122e-06 1.2 1.34968877033e-06 1.2 1.34972052846e-06 1.2 1.34975228659e-06 1.2 1.34978404472e-06 1.2 1.34981580285e-06 1.2 1.34984756098e-06 1.2 1.34987931911e-06 1.2 1.34991107724e-06 1.2 1.34994283537e-06 1.2 1.3499745935e-06 1.2 1.35000635163e-06 1.2 1.35003810976e-06 1.2 1.35006986789e-06 1.2 1.35010162602e-06 1.2 1.35013338415e-06 1.2 1.35016514228e-06 1.2 1.35019690041e-06 1.2 1.35022865854e-06 1.2 1.35026041667e-06 1.2 1.3502921748e-06 1.2 1.35032393293e-06 1.2 1.35035569106e-06 1.2 1.35038744919e-06 1.2 1.35041920732e-06 1.2 1.35045096545e-06 1.2 1.35048272358e-06 1.2 1.35051448171e-06 1.2 1.35054623984e-06 1.2 1.35057799797e-06 1.2 1.3506097561e-06 1.2 1.35064151423e-06 1.2 1.35067327236e-06 1.2 1.35070503049e-06 1.2 1.35073678862e-06 1.2 1.35076854675e-06 1.2 1.35080030488e-06 1.2 1.35083206301e-06 1.2 1.35086382114e-06 1.2 1.35089557927e-06 1.2 1.3509273374e-06 1.2 1.35095909553e-06 1.2 1.35099085366e-06 1.2 1.35102261179e-06 1.2 1.35105436992e-06 1.2 1.35108612805e-06 1.2 1.35111788618e-06 1.2 1.35114964431e-06 1.2 1.35118140244e-06 1.2 1.35121316057e-06 1.2 1.3512449187e-06 1.2 1.35127667683e-06 1.2 1.35130843496e-06 1.2 1.35134019309e-06 1.2 1.35137195122e-06 1.2 1.35140370935e-06 1.2 1.35143546748e-06 1.2 1.35146722561e-06 1.2 1.35149898374e-06 1.2 1.35153074187e-06 1.2 1.3515625e-06 1.2 1.35159425813e-06 1.2 1.35162601626e-06 1.2 1.35165777439e-06 1.2 1.35168953252e-06 1.2 1.35172129065e-06 1.2 1.35175304878e-06 1.2 1.35178480691e-06 1.2 1.35181656504e-06 1.2 1.35184832317e-06 1.2 1.3518800813e-06 1.2 1.35191183943e-06 1.2 1.35194359756e-06 1.2 1.35197535569e-06 1.2 1.35200711382e-06 1.2 1.35203887195e-06 1.2 1.35207063008e-06 1.2 1.35210238821e-06 1.2 1.35213414634e-06 1.2 1.35216590447e-06 1.2 1.3521976626e-06 1.2 1.35222942073e-06 1.2 1.35226117886e-06 1.2 1.35229293699e-06 1.2 1.35232469512e-06 1.2 1.35235645325e-06 1.2 1.35238821138e-06 1.2 1.35241996951e-06 1.2 1.35245172764e-06 1.2 1.35248348577e-06 1.2 1.3525152439e-06 1.2 1.35254700203e-06 1.2 1.35257876016e-06 1.2 1.35261051829e-06 1.2 1.35264227642e-06 1.2 1.35267403455e-06 1.2 1.35270579268e-06 1.2 1.35273755081e-06 1.2 1.35276930894e-06 1.2 1.35280106707e-06 1.2 1.3528328252e-06 1.2 1.35286458333e-06 1.2 1.35289634146e-06 1.2 1.35292809959e-06 1.2 1.35295985772e-06 1.2 1.35299161585e-06 1.2 1.35302337398e-06 1.2 1.35305513211e-06 1.2 1.35308689024e-06 1.2 1.35311864837e-06 1.2 1.3531504065e-06 1.2 1.35318216463e-06 1.2 1.35321392276e-06 1.2 1.35324568089e-06 1.2 1.35327743902e-06 1.2 1.35330919715e-06 1.2 1.35334095528e-06 1.2 1.35337271341e-06 1.2 1.35340447154e-06 1.2 1.35343622967e-06 1.2 1.3534679878e-06 1.2 1.35349974593e-06 1.2 1.35353150407e-06 1.2 1.3535632622e-06 1.2 1.35359502033e-06 1.2 1.35362677846e-06 1.2 1.35365853659e-06 1.2 1.35369029472e-06 1.2 1.35372205285e-06 1.2 1.35375381098e-06 1.2 1.35378556911e-06 1.2 1.35381732724e-06 1.2 1.35384908537e-06 1.2 1.3538808435e-06 1.2 1.35391260163e-06 1.2 1.35394435976e-06 1.2 1.35397611789e-06 1.2 1.35400787602e-06 1.2 1.35403963415e-06 1.2 1.35407139228e-06 1.2 1.35410315041e-06 1.2 1.35413490854e-06 1.2 1.35416666667e-06 1.2 1.3541984248e-06 1.2 1.35423018293e-06 1.2 1.35426194106e-06 1.2 1.35429369919e-06 1.2 1.35432545732e-06 1.2 1.35435721545e-06 1.2 1.35438897358e-06 1.2 1.35442073171e-06 1.2 1.35445248984e-06 1.2 1.35448424797e-06 1.2 1.3545160061e-06 1.2 1.35454776423e-06 1.2 1.35457952236e-06 1.2 1.35461128049e-06 1.2 1.35464303862e-06 1.2 1.35467479675e-06 1.2 1.35470655488e-06 1.2 1.35473831301e-06 1.2 1.35477007114e-06 1.2 1.35480182927e-06 1.2 1.3548335874e-06 1.2 1.35486534553e-06 1.2 1.35489710366e-06 1.2 1.35492886179e-06 1.2 1.35496061992e-06 1.2 1.35499237805e-06 1.2 1.35502413618e-06 1.2 1.35505589431e-06 1.2 1.35508765244e-06 1.2 1.35511941057e-06 1.2 1.3551511687e-06 1.2 1.35518292683e-06 1.2 1.35521468496e-06 1.2 1.35524644309e-06 1.2 1.35527820122e-06 1.2 1.35530995935e-06 1.2 1.35534171748e-06 1.2 1.35537347561e-06 1.2 1.35540523374e-06 1.2 1.35543699187e-06 1.2 1.35546875e-06 1.2 1.35550050813e-06 1.2 1.35553226626e-06 1.2 1.35556402439e-06 1.2 1.35559578252e-06 1.2 1.35562754065e-06 1.2 1.35565929878e-06 1.2 1.35569105691e-06 1.2 1.35572281504e-06 1.2 1.35575457317e-06 1.2 1.3557863313e-06 1.2 1.35581808943e-06 1.2 1.35584984756e-06 1.2 1.35588160569e-06 1.2 1.35591336382e-06 1.2 1.35594512195e-06 1.2 1.35597688008e-06 1.2 1.35600863821e-06 1.2 1.35604039634e-06 1.2 1.35607215447e-06 1.2 1.3561039126e-06 1.2 1.35613567073e-06 1.2 1.35616742886e-06 1.2 1.35619918699e-06 1.2 1.35623094512e-06 1.2 1.35626270325e-06 1.2 1.35629446138e-06 1.2 1.35632621951e-06 1.2 1.35635797764e-06 1.2 1.35638973577e-06 1.2 1.3564214939e-06 1.2 1.35645325203e-06 1.2 1.35648501016e-06 1.2 1.35651676829e-06 1.2 1.35654852642e-06 1.2 1.35658028455e-06 1.2 1.35661204268e-06 1.2 1.35664380081e-06 1.2 1.35667555894e-06 1.2 1.35670731707e-06 1.2 1.3567390752e-06 1.2 1.35677083333e-06 1.2 1.35680259146e-06 1.2 1.35683434959e-06 1.2 1.35686610772e-06 1.2 1.35689786585e-06 1.2 1.35692962398e-06 1.2 1.35696138211e-06 1.2 1.35699314024e-06 1.2 1.35702489837e-06 1.2 1.3570566565e-06 1.2 1.35708841463e-06 1.2 1.35712017276e-06 1.2 1.35715193089e-06 1.2 1.35718368902e-06 1.2 1.35721544715e-06 1.2 1.35724720528e-06 1.2 1.35727896341e-06 1.2 1.35731072154e-06 1.2 1.35734247967e-06 1.2 1.3573742378e-06 1.2 1.35740599593e-06 1.2 1.35743775407e-06 1.2 1.3574695122e-06 1.2 1.35750127033e-06 1.2 1.35753302846e-06 1.2 1.35756478659e-06 1.2 1.35759654472e-06 1.2 1.35762830285e-06 1.2 1.35766006098e-06 1.2 1.35769181911e-06 1.2 1.35772357724e-06 1.2 1.35775533537e-06 1.2 1.3577870935e-06 1.2 1.35781885163e-06 1.2 1.35785060976e-06 1.2 1.35788236789e-06 1.2 1.35791412602e-06 1.2 1.35794588415e-06 1.2 1.35797764228e-06 1.2 1.35800940041e-06 1.2 1.35804115854e-06 1.2 1.35807291667e-06 1.2 1.3581046748e-06 1.2 1.35813643293e-06 1.2 1.35816819106e-06 1.2 1.35819994919e-06 1.2 1.35823170732e-06 1.2 1.35826346545e-06 1.2 1.35829522358e-06 1.2 1.35832698171e-06 1.2 1.35835873984e-06 1.2 1.35839049797e-06 1.2 1.3584222561e-06 1.2 1.35845401423e-06 1.2 1.35848577236e-06 1.2 1.35851753049e-06 1.2 1.35854928862e-06 1.2 1.35858104675e-06 1.2 1.35861280488e-06 1.2 1.35864456301e-06 1.2 1.35867632114e-06 1.2 1.35870807927e-06 1.2 1.3587398374e-06 1.2 1.35877159553e-06 1.2 1.35880335366e-06 1.2 1.35883511179e-06 1.2 1.35886686992e-06 1.2 1.35889862805e-06 1.2 1.35893038618e-06 1.2 1.35896214431e-06 1.2 1.35899390244e-06 1.2 1.35902566057e-06 1.2 1.3590574187e-06 1.2 1.35908917683e-06 1.2 1.35912093496e-06 1.2 1.35915269309e-06 1.2 1.35918445122e-06 1.2 1.35921620935e-06 1.2 1.35924796748e-06 1.2 1.35927972561e-06 1.2 1.35931148374e-06 1.2 1.35934324187e-06 1.2 1.359375e-06 1.2 1.35940675813e-06 1.2 1.35943851626e-06 1.2 1.35947027439e-06 1.2 1.35950203252e-06 1.2 1.35953379065e-06 1.2 1.35956554878e-06 1.2 1.35959730691e-06 1.2 1.35962906504e-06 1.2 1.35966082317e-06 1.2 1.3596925813e-06 1.2 1.35972433943e-06 1.2 1.35975609756e-06 1.2 1.35978785569e-06 1.2 1.35981961382e-06 1.2 1.35985137195e-06 1.2 1.35988313008e-06 1.2 1.35991488821e-06 1.2 1.35994664634e-06 1.2 1.35997840447e-06 1.2 1.3600101626e-06 1.2 1.36004192073e-06 1.2 1.36007367886e-06 1.2 1.36010543699e-06 1.2 1.36013719512e-06 1.2 1.36016895325e-06 1.2 1.36020071138e-06 1.2 1.36023246951e-06 1.2 1.36026422764e-06 1.2 1.36029598577e-06 1.2 1.3603277439e-06 1.2 1.36035950203e-06 1.2 1.36039126016e-06 1.2 1.36042301829e-06 1.2 1.36045477642e-06 1.2 1.36048653455e-06 1.2 1.36051829268e-06 1.2 1.36055005081e-06 1.2 1.36058180894e-06 1.2 1.36061356707e-06 1.2 1.3606453252e-06 1.2 1.36067708333e-06 1.2 1.36070884146e-06 1.2 1.36074059959e-06 1.2 1.36077235772e-06 1.2 1.36080411585e-06 1.2 1.36083587398e-06 1.2 1.36086763211e-06 1.2 1.36089939024e-06 1.2 1.36093114837e-06 1.2 1.3609629065e-06 1.2 1.36099466463e-06 1.2 1.36102642276e-06 1.2 1.36105818089e-06 1.2 1.36108993902e-06 1.2 1.36112169715e-06 1.2 1.36115345528e-06 1.2 1.36118521341e-06 1.2 1.36121697154e-06 1.2 1.36124872967e-06 1.2 1.3612804878e-06 1.2 1.36131224593e-06 1.2 1.36134400407e-06 1.2 1.3613757622e-06 1.2 1.36140752033e-06 1.2 1.36143927846e-06 1.2 1.36147103659e-06 1.2 1.36150279472e-06 1.2 1.36153455285e-06 1.2 1.36156631098e-06 1.2 1.36159806911e-06 1.2 1.36162982724e-06 1.2 1.36166158537e-06 1.2 1.3616933435e-06 1.2 1.36172510163e-06 1.2 1.36175685976e-06 1.2 1.36178861789e-06 1.2 1.36182037602e-06 1.2 1.36185213415e-06 1.2 1.36188389228e-06 1.2 1.36191565041e-06 1.2 1.36194740854e-06 1.2 1.36197916667e-06 1.2 1.3620109248e-06 1.2 1.36204268293e-06 1.2 1.36207444106e-06 1.2 1.36210619919e-06 1.2 1.36213795732e-06 1.2 1.36216971545e-06 1.2 1.36220147358e-06 1.2 1.36223323171e-06 1.2 1.36226498984e-06 1.2 1.36229674797e-06 1.2 1.3623285061e-06 1.2 1.36236026423e-06 1.2 1.36239202236e-06 1.2 1.36242378049e-06 1.2 1.36245553862e-06 1.2 1.36248729675e-06 1.2 1.36251905488e-06 1.2 1.36255081301e-06 1.2 1.36258257114e-06 1.2 1.36261432927e-06 1.2 1.3626460874e-06 1.2 1.36267784553e-06 1.2 1.36270960366e-06 1.2 1.36274136179e-06 1.2 1.36277311992e-06 1.2 1.36280487805e-06 1.2 1.36283663618e-06 1.2 1.36286839431e-06 1.2 1.36290015244e-06 1.2 1.36293191057e-06 1.2 1.3629636687e-06 1.2 1.36299542683e-06 1.2 1.36302718496e-06 1.2 1.36305894309e-06 1.2 1.36309070122e-06 1.2 1.36312245935e-06 1.2 1.36315421748e-06 1.2 1.36318597561e-06 1.2 1.36321773374e-06 1.2 1.36324949187e-06 1.2 1.36328125e-06 1.2 1.36331300813e-06 1.2 1.36334476626e-06 1.2 1.36337652439e-06 1.2 1.36340828252e-06 1.2 1.36344004065e-06 1.2 1.36347179878e-06 1.2 1.36350355691e-06 1.2 1.36353531504e-06 1.2 1.36356707317e-06 1.2 1.3635988313e-06 1.2 1.36363058943e-06 1.2 1.36366234756e-06 1.2 1.36369410569e-06 1.2 1.36372586382e-06 1.2 1.36375762195e-06 1.2 1.36378938008e-06 1.2 1.36382113821e-06 1.2 1.36385289634e-06 1.2 1.36388465447e-06 1.2 1.3639164126e-06 1.2 1.36394817073e-06 1.2 1.36397992886e-06 1.2 1.36401168699e-06 1.2 1.36404344512e-06 1.2 1.36407520325e-06 1.2 1.36410696138e-06 1.2 1.36413871951e-06 1.2 1.36417047764e-06 1.2 1.36420223577e-06 1.2 1.3642339939e-06 1.2 1.36426575203e-06 1.2 1.36429751016e-06 1.2 1.36432926829e-06 1.2 1.36436102642e-06 1.2 1.36439278455e-06 1.2 1.36442454268e-06 1.2 1.36445630081e-06 1.2 1.36448805894e-06 1.2 1.36451981707e-06 1.2 1.3645515752e-06 1.2 1.36458333333e-06 1.2 1.36461509146e-06 1.2 1.36464684959e-06 1.2 1.36467860772e-06 1.2 1.36471036585e-06 1.2 1.36474212398e-06 1.2 1.36477388211e-06 1.2 1.36480564024e-06 1.2 1.36483739837e-06 1.2 1.3648691565e-06 1.2 1.36490091463e-06 1.2 1.36493267276e-06 1.2 1.36496443089e-06 1.2 1.36499618902e-06 1.2 1.36502794715e-06 1.2 1.36505970528e-06 1.2 1.36509146341e-06 1.2 1.36512322154e-06 1.2 1.36515497967e-06 1.2 1.3651867378e-06 1.2 1.36521849593e-06 1.2 1.36525025407e-06 1.2 1.3652820122e-06 1.2 1.36531377033e-06 1.2 1.36534552846e-06 1.2 1.36537728659e-06 1.2 1.36540904472e-06 1.2 1.36544080285e-06 1.2 1.36547256098e-06 1.2 1.36550431911e-06 1.2 1.36553607724e-06 1.2 1.36556783537e-06 1.2 1.3655995935e-06 1.2 1.36563135163e-06 1.2 1.36566310976e-06 1.2 1.36569486789e-06 1.2 1.36572662602e-06 1.2 1.36575838415e-06 1.2 1.36579014228e-06 1.2 1.36582190041e-06 1.2 1.36585365854e-06 1.2 1.36588541667e-06 1.2 1.3659171748e-06 1.2 1.36594893293e-06 1.2 1.36598069106e-06 1.2 1.36601244919e-06 1.2 1.36604420732e-06 1.2 1.36607596545e-06 1.2 1.36610772358e-06 1.2 1.36613948171e-06 1.2 1.36617123984e-06 1.2 1.36620299797e-06 1.2 1.3662347561e-06 1.2 1.36626651423e-06 1.2 1.36629827236e-06 1.2 1.36633003049e-06 1.2 1.36636178862e-06 1.2 1.36639354675e-06 1.2 1.36642530488e-06 1.2 1.36645706301e-06 1.2 1.36648882114e-06 1.2 1.36652057927e-06 1.2 1.3665523374e-06 1.2 1.36658409553e-06 1.2 1.36661585366e-06 1.2 1.36664761179e-06 1.2 1.36667936992e-06 1.2 1.36671112805e-06 1.2 1.36674288618e-06 1.2 1.36677464431e-06 1.2 1.36680640244e-06 1.2 1.36683816057e-06 1.2 1.3668699187e-06 1.2 1.36690167683e-06 1.2 1.36693343496e-06 1.2 1.36696519309e-06 1.2 1.36699695122e-06 1.2 1.36702870935e-06 1.2 1.36706046748e-06 1.2 1.36709222561e-06 1.2 1.36712398374e-06 1.2 1.36715574187e-06 1.2 1.3671875e-06 1.2 1.36721925813e-06 1.2 1.36725101626e-06 1.2 1.36728277439e-06 1.2 1.36731453252e-06 1.2 1.36734629065e-06 1.2 1.36737804878e-06 1.2 1.36740980691e-06 1.2 1.36744156504e-06 1.2 1.36747332317e-06 1.2 1.3675050813e-06 1.2 1.36753683943e-06 1.2 1.36756859756e-06 1.2 1.36760035569e-06 1.2 1.36763211382e-06 1.2 1.36766387195e-06 1.2 1.36769563008e-06 1.2 1.36772738821e-06 1.2 1.36775914634e-06 1.2 1.36779090447e-06 1.2 1.3678226626e-06 1.2 1.36785442073e-06 1.2 1.36788617886e-06 1.2 1.36791793699e-06 1.2 1.36794969512e-06 1.2 1.36798145325e-06 1.2 1.36801321138e-06 1.2 1.36804496951e-06 1.2 1.36807672764e-06 1.2 1.36810848577e-06 1.2 1.3681402439e-06 1.2 1.36817200203e-06 1.2 1.36820376016e-06 1.2 1.36823551829e-06 1.2 1.36826727642e-06 1.2 1.36829903455e-06 1.2 1.36833079268e-06 1.2 1.36836255081e-06 1.2 1.36839430894e-06 1.2 1.36842606707e-06 1.2 1.3684578252e-06 1.2 1.36848958333e-06 1.2 1.36852134146e-06 1.2 1.36855309959e-06 1.2 1.36858485772e-06 1.2 1.36861661585e-06 1.2 1.36864837398e-06 1.2 1.36868013211e-06 1.2 1.36871189024e-06 1.2 1.36874364837e-06 1.2 1.3687754065e-06 1.2 1.36880716463e-06 1.2 1.36883892276e-06 1.2 1.36887068089e-06 1.2 1.36890243902e-06 1.2 1.36893419715e-06 1.2 1.36896595528e-06 1.2 1.36899771341e-06 1.2 1.36902947154e-06 1.2 1.36906122967e-06 1.2 1.3690929878e-06 1.2 1.36912474593e-06 1.2 1.36915650407e-06 1.2 1.3691882622e-06 1.2 1.36922002033e-06 1.2 1.36925177846e-06 1.2 1.36928353659e-06 1.2 1.36931529472e-06 1.2 1.36934705285e-06 1.2 1.36937881098e-06 1.2 1.36941056911e-06 1.2 1.36944232724e-06 1.2 1.36947408537e-06 1.2 1.3695058435e-06 1.2 1.36953760163e-06 1.2 1.36956935976e-06 1.2 1.36960111789e-06 1.2 1.36963287602e-06 1.2 1.36966463415e-06 1.2 1.36969639228e-06 1.2 1.36972815041e-06 1.2 1.36975990854e-06 1.2 1.36979166667e-06 1.2 1.3698234248e-06 1.2 1.36985518293e-06 1.2 1.36988694106e-06 1.2 1.36991869919e-06 1.2 1.36995045732e-06 1.2 1.36998221545e-06 1.2 1.37001397358e-06 1.2 1.37004573171e-06 1.2 1.37007748984e-06 1.2 1.37010924797e-06 1.2 1.3701410061e-06 1.2 1.37017276423e-06 1.2 1.37020452236e-06 1.2 1.37023628049e-06 1.2 1.37026803862e-06 1.2 1.37029979675e-06 1.2 1.37033155488e-06 1.2 1.37036331301e-06 1.2 1.37039507114e-06 1.2 1.37042682927e-06 1.2 1.3704585874e-06 1.2 1.37049034553e-06 1.2 1.37052210366e-06 1.2 1.37055386179e-06 1.2 1.37058561992e-06 1.2 1.37061737805e-06 1.2 1.37064913618e-06 1.2 1.37068089431e-06 1.2 1.37071265244e-06 1.2 1.37074441057e-06 1.2 1.3707761687e-06 1.2 1.37080792683e-06 1.2 1.37083968496e-06 1.2 1.37087144309e-06 1.2 1.37090320122e-06 1.2 1.37093495935e-06 1.2 1.37096671748e-06 1.2 1.37099847561e-06 1.2 1.37103023374e-06 1.2 1.37106199187e-06 1.2 1.37109375e-06 1.2 1.37112550813e-06 1.2 1.37115726626e-06 1.2 1.37118902439e-06 1.2 1.37122078252e-06 1.2 1.37125254065e-06 1.2 1.37128429878e-06 1.2 1.37131605691e-06 1.2 1.37134781504e-06 1.2 1.37137957317e-06 1.2 1.3714113313e-06 1.2 1.37144308943e-06 1.2 1.37147484756e-06 1.2 1.37150660569e-06 1.2 1.37153836382e-06 1.2 1.37157012195e-06 1.2 1.37160188008e-06 1.2 1.37163363821e-06 1.2 1.37166539634e-06 1.2 1.37169715447e-06 1.2 1.3717289126e-06 1.2 1.37176067073e-06 1.2 1.37179242886e-06 1.2 1.37182418699e-06 1.2 1.37185594512e-06 1.2 1.37188770325e-06 1.2 1.37191946138e-06 1.2 1.37195121951e-06 1.2 1.37198297764e-06 1.2 1.37201473577e-06 1.2 1.3720464939e-06 1.2 1.37207825203e-06 1.2 1.37211001016e-06 1.2 1.37214176829e-06 1.2 1.37217352642e-06 1.2 1.37220528455e-06 1.2 1.37223704268e-06 1.2 1.37226880081e-06 1.2 1.37230055894e-06 1.2 1.37233231707e-06 1.2 1.3723640752e-06 1.2 1.37239583333e-06 1.2 1.37242759146e-06 1.2 1.37245934959e-06 1.2 1.37249110772e-06 1.2 1.37252286585e-06 1.2 1.37255462398e-06 1.2 1.37258638211e-06 1.2 1.37261814024e-06 1.2 1.37264989837e-06 1.2 1.3726816565e-06 1.2 1.37271341463e-06 1.2 1.37274517276e-06 1.2 1.37277693089e-06 1.2 1.37280868902e-06 1.2 1.37284044715e-06 1.2 1.37287220528e-06 1.2 1.37290396341e-06 1.2 1.37293572154e-06 1.2 1.37296747967e-06 1.2 1.3729992378e-06 1.2 1.37303099593e-06 1.2 1.37306275407e-06 1.2 1.3730945122e-06 1.2 1.37312627033e-06 1.2 1.37315802846e-06 1.2 1.37318978659e-06 1.2 1.37322154472e-06 1.2 1.37325330285e-06 1.2 1.37328506098e-06 1.2 1.37331681911e-06 1.2 1.37334857724e-06 1.2 1.37338033537e-06 1.2 1.3734120935e-06 1.2 1.37344385163e-06 1.2 1.37347560976e-06 1.2 1.37350736789e-06 1.2 1.37353912602e-06 1.2 1.37357088415e-06 1.2 1.37360264228e-06 1.2 1.37363440041e-06 1.2 1.37366615854e-06 1.2 1.37369791667e-06 1.2 1.3737296748e-06 1.2 1.37376143293e-06 1.2 1.37379319106e-06 1.2 1.37382494919e-06 1.2 1.37385670732e-06 1.2 1.37388846545e-06 1.2 1.37392022358e-06 1.2 1.37395198171e-06 1.2 1.37398373984e-06 1.2 1.37401549797e-06 1.2 1.3740472561e-06 1.2 1.37407901423e-06 1.2 1.37411077236e-06 1.2 1.37414253049e-06 1.2 1.37417428862e-06 1.2 1.37420604675e-06 1.2 1.37423780488e-06 1.2 1.37426956301e-06 1.2 1.37430132114e-06 1.2 1.37433307927e-06 1.2 1.3743648374e-06 1.2 1.37439659553e-06 1.2 1.37442835366e-06 1.2 1.37446011179e-06 1.2 1.37449186992e-06 1.2 1.37452362805e-06 1.2 1.37455538618e-06 1.2 1.37458714431e-06 1.2 1.37461890244e-06 1.2 1.37465066057e-06 1.2 1.3746824187e-06 1.2 1.37471417683e-06 1.2 1.37474593496e-06 1.2 1.37477769309e-06 1.2 1.37480945122e-06 1.2 1.37484120935e-06 1.2 1.37487296748e-06 1.2 1.37490472561e-06 1.2 1.37493648374e-06 1.2 1.37496824187e-06 1.2 1.375e-06 1.2 1.37503175813e-06 1.2 1.37506351626e-06 1.2 1.37509527439e-06 1.2 1.37512703252e-06 1.2 1.37515879065e-06 1.2 1.37519054878e-06 1.2 1.37522230691e-06 1.2 1.37525406504e-06 1.2 1.37528582317e-06 1.2 1.3753175813e-06 1.2 1.37534933943e-06 1.2 1.37538109756e-06 1.2 1.37541285569e-06 1.2 1.37544461382e-06 1.2 1.37547637195e-06 1.2 1.37550813008e-06 1.2 1.37553988821e-06 1.2 1.37557164634e-06 1.2 1.37560340447e-06 1.2 1.3756351626e-06 1.2 1.37566692073e-06 1.2 1.37569867886e-06 1.2 1.37573043699e-06 1.2 1.37576219512e-06 1.2 1.37579395325e-06 1.2 1.37582571138e-06 1.2 1.37585746951e-06 1.2 1.37588922764e-06 1.2 1.37592098577e-06 1.2 1.3759527439e-06 1.2 1.37598450203e-06 1.2 1.37601626016e-06 1.2 1.37604801829e-06 1.2 1.37607977642e-06 1.2 1.37611153455e-06 1.2 1.37614329268e-06 1.2 1.37617505081e-06 1.2 1.37620680894e-06 1.2 1.37623856707e-06 1.2 1.3762703252e-06 1.2 1.37630208333e-06 1.2 1.37633384146e-06 1.2 1.37636559959e-06 1.2 1.37639735772e-06 1.2 1.37642911585e-06 1.2 1.37646087398e-06 1.2 1.37649263211e-06 1.2 1.37652439024e-06 1.2 1.37655614837e-06 1.2 1.3765879065e-06 1.2 1.37661966463e-06 1.2 1.37665142276e-06 1.2 1.37668318089e-06 1.2 1.37671493902e-06 1.2 1.37674669715e-06 1.2 1.37677845528e-06 1.2 1.37681021341e-06 1.2 1.37684197154e-06 1.2 1.37687372967e-06 1.2 1.3769054878e-06 1.2 1.37693724593e-06 1.2 1.37696900407e-06 1.2 1.3770007622e-06 1.2 1.37703252033e-06 1.2 1.37706427846e-06 1.2 1.37709603659e-06 1.2 1.37712779472e-06 1.2 1.37715955285e-06 1.2 1.37719131098e-06 1.2 1.37722306911e-06 1.2 1.37725482724e-06 1.2 1.37728658537e-06 1.2 1.3773183435e-06 1.2 1.37735010163e-06 1.2 1.37738185976e-06 1.2 1.37741361789e-06 1.2 1.37744537602e-06 1.2 1.37747713415e-06 1.2 1.37750889228e-06 1.2 1.37754065041e-06 1.2 1.37757240854e-06 1.2 1.37760416667e-06 1.2 1.3776359248e-06 1.2 1.37766768293e-06 1.2 1.37769944106e-06 1.2 1.37773119919e-06 1.2 1.37776295732e-06 1.2 1.37779471545e-06 1.2 1.37782647358e-06 1.2 1.37785823171e-06 1.2 1.37788998984e-06 1.2 1.37792174797e-06 1.2 1.3779535061e-06 1.2 1.37798526423e-06 1.2 1.37801702236e-06 1.2 1.37804878049e-06 1.2 1.37808053862e-06 1.2 1.37811229675e-06 1.2 1.37814405488e-06 1.2 1.37817581301e-06 1.2 1.37820757114e-06 1.2 1.37823932927e-06 1.2 1.3782710874e-06 1.2 1.37830284553e-06 1.2 1.37833460366e-06 1.2 1.37836636179e-06 1.2 1.37839811992e-06 1.2 1.37842987805e-06 1.2 1.37846163618e-06 1.2 1.37849339431e-06 1.2 1.37852515244e-06 1.2 1.37855691057e-06 1.2 1.3785886687e-06 1.2 1.37862042683e-06 1.2 1.37865218496e-06 1.2 1.37868394309e-06 1.2 1.37871570122e-06 1.2 1.37874745935e-06 1.2 1.37877921748e-06 1.2 1.37881097561e-06 1.2 1.37884273374e-06 1.2 1.37887449187e-06 1.2 1.37890625e-06 1.2 1.37893800813e-06 1.2 1.37896976626e-06 1.2 1.37900152439e-06 1.2 1.37903328252e-06 1.2 1.37906504065e-06 1.2 1.37909679878e-06 1.2 1.37912855691e-06 1.2 1.37916031504e-06 1.2 1.37919207317e-06 1.2 1.3792238313e-06 1.2 1.37925558943e-06 1.2 1.37928734756e-06 1.2 1.37931910569e-06 1.2 1.37935086382e-06 1.2 1.37938262195e-06 1.2 1.37941438008e-06 1.2 1.37944613821e-06 1.2 1.37947789634e-06 1.2 1.37950965447e-06 1.2 1.3795414126e-06 1.2 1.37957317073e-06 1.2 1.37960492886e-06 1.2 1.37963668699e-06 1.2 1.37966844512e-06 1.2 1.37970020325e-06 1.2 1.37973196138e-06 1.2 1.37976371951e-06 1.2 1.37979547764e-06 1.2 1.37982723577e-06 1.2 1.3798589939e-06 1.2 1.37989075203e-06 1.2 1.37992251016e-06 1.2 1.37995426829e-06 1.2 1.37998602642e-06 1.2 1.38001778455e-06 1.2 1.38004954268e-06 1.2 1.38008130081e-06 1.2 1.38011305894e-06 1.2 1.38014481707e-06 1.2 1.3801765752e-06 1.2 1.38020833333e-06 1.2 1.38024009146e-06 1.2 1.38027184959e-06 1.2 1.38030360772e-06 1.2 1.38033536585e-06 1.2 1.38036712398e-06 1.2 1.38039888211e-06 1.2 1.38043064024e-06 1.2 1.38046239837e-06 1.2 1.3804941565e-06 1.2 1.38052591463e-06 1.2 1.38055767276e-06 1.2 1.38058943089e-06 1.2 1.38062118902e-06 1.2 1.38065294715e-06 1.2 1.38068470528e-06 1.2 1.38071646341e-06 1.2 1.38074822154e-06 1.2 1.38077997967e-06 1.2 1.3808117378e-06 1.2 1.38084349593e-06 1.2 1.38087525407e-06 1.2 1.3809070122e-06 1.2 1.38093877033e-06 1.2 1.38097052846e-06 1.2 1.38100228659e-06 1.2 1.38103404472e-06 1.2 1.38106580285e-06 1.2 1.38109756098e-06 1.2 1.38112931911e-06 1.2 1.38116107724e-06 1.2 1.38119283537e-06 1.2 1.3812245935e-06 1.2 1.38125635163e-06 1.2 1.38128810976e-06 1.2 1.38131986789e-06 1.2 1.38135162602e-06 1.2 1.38138338415e-06 1.2 1.38141514228e-06 1.2 1.38144690041e-06 1.2 1.38147865854e-06 1.2 1.38151041667e-06 1.2 1.3815421748e-06 1.2 1.38157393293e-06 1.2 1.38160569106e-06 1.2 1.38163744919e-06 1.2 1.38166920732e-06 1.2 1.38170096545e-06 1.2 1.38173272358e-06 1.2 1.38176448171e-06 1.2 1.38179623984e-06 1.2 1.38182799797e-06 1.2 1.3818597561e-06 1.2 1.38189151423e-06 1.2 1.38192327236e-06 1.2 1.38195503049e-06 1.2 1.38198678862e-06 1.2 1.38201854675e-06 1.2 1.38205030488e-06 1.2 1.38208206301e-06 1.2 1.38211382114e-06 1.2 1.38214557927e-06 1.2 1.3821773374e-06 1.2 1.38220909553e-06 1.2 1.38224085366e-06 1.2 1.38227261179e-06 1.2 1.38230436992e-06 1.2 1.38233612805e-06 1.2 1.38236788618e-06 1.2 1.38239964431e-06 1.2 1.38243140244e-06 1.2 1.38246316057e-06 1.2 1.3824949187e-06 1.2 1.38252667683e-06 1.2 1.38255843496e-06 1.2 1.38259019309e-06 1.2 1.38262195122e-06 1.2 1.38265370935e-06 1.2 1.38268546748e-06 1.2 1.38271722561e-06 1.2 1.38274898374e-06 1.2 1.38278074187e-06 1.2 1.3828125e-06 1.2 1.38284425813e-06 1.2 1.38287601626e-06 1.2 1.38290777439e-06 1.2 1.38293953252e-06 1.2 1.38297129065e-06 1.2 1.38300304878e-06 1.2 1.38303480691e-06 1.2 1.38306656504e-06 1.2 1.38309832317e-06 1.2 1.3831300813e-06 1.2 1.38316183943e-06 1.2 1.38319359756e-06 1.2 1.38322535569e-06 1.2 1.38325711382e-06 1.2 1.38328887195e-06 1.2 1.38332063008e-06 1.2 1.38335238821e-06 1.2 1.38338414634e-06 1.2 1.38341590447e-06 1.2 1.3834476626e-06 1.2 1.38347942073e-06 1.2 1.38351117886e-06 1.2 1.38354293699e-06 1.2 1.38357469512e-06 1.2 1.38360645325e-06 1.2 1.38363821138e-06 1.2 1.38366996951e-06 1.2 1.38370172764e-06 1.2 1.38373348577e-06 1.2 1.3837652439e-06 1.2 1.38379700203e-06 1.2 1.38382876016e-06 1.2 1.38386051829e-06 1.2 1.38389227642e-06 1.2 1.38392403455e-06 1.2 1.38395579268e-06 1.2 1.38398755081e-06 1.2 1.38401930894e-06 1.2 1.38405106707e-06 1.2 1.3840828252e-06 1.2 1.38411458333e-06 1.2 1.38414634146e-06 1.2 1.38417809959e-06 1.2 1.38420985772e-06 1.2 1.38424161585e-06 1.2 1.38427337398e-06 1.2 1.38430513211e-06 1.2 1.38433689024e-06 1.2 1.38436864837e-06 1.2 1.3844004065e-06 1.2 1.38443216463e-06 1.2 1.38446392276e-06 1.2 1.38449568089e-06 1.2 1.38452743902e-06 1.2 1.38455919715e-06 1.2 1.38459095528e-06 1.2 1.38462271341e-06 1.2 1.38465447154e-06 1.2 1.38468622967e-06 1.2 1.3847179878e-06 1.2 1.38474974593e-06 1.2 1.38478150407e-06 1.2 1.3848132622e-06 1.2 1.38484502033e-06 1.2 1.38487677846e-06 1.2 1.38490853659e-06 1.2 1.38494029472e-06 1.2 1.38497205285e-06 1.2 1.38500381098e-06 1.2 1.38503556911e-06 1.2 1.38506732724e-06 1.2 1.38509908537e-06 1.2 1.3851308435e-06 1.2 1.38516260163e-06 1.2 1.38519435976e-06 1.2 1.38522611789e-06 1.2 1.38525787602e-06 1.2 1.38528963415e-06 1.2 1.38532139228e-06 1.2 1.38535315041e-06 1.2 1.38538490854e-06 1.2 1.38541666667e-06 1.2 1.3854484248e-06 1.2 1.38548018293e-06 1.2 1.38551194106e-06 1.2 1.38554369919e-06 1.2 1.38557545732e-06 1.2 1.38560721545e-06 1.2 1.38563897358e-06 1.2 1.38567073171e-06 1.2 1.38570248984e-06 1.2 1.38573424797e-06 1.2 1.3857660061e-06 1.2 1.38579776423e-06 1.2 1.38582952236e-06 1.2 1.38586128049e-06 1.2 1.38589303862e-06 1.2 1.38592479675e-06 1.2 1.38595655488e-06 1.2 1.38598831301e-06 1.2 1.38602007114e-06 1.2 1.38605182927e-06 1.2 1.3860835874e-06 1.2 1.38611534553e-06 1.2 1.38614710366e-06 1.2 1.38617886179e-06 1.2 1.38621061992e-06 1.2 1.38624237805e-06 1.2 1.38627413618e-06 1.2 1.38630589431e-06 1.2 1.38633765244e-06 1.2 1.38636941057e-06 1.2 1.3864011687e-06 1.2 1.38643292683e-06 1.2 1.38646468496e-06 1.2 1.38649644309e-06 1.2 1.38652820122e-06 1.2 1.38655995935e-06 1.2 1.38659171748e-06 1.2 1.38662347561e-06 1.2 1.38665523374e-06 1.2 1.38668699187e-06 1.2 1.38671875e-06 1.2 1.38675050813e-06 1.2 1.38678226626e-06 1.2 1.38681402439e-06 1.2 1.38684578252e-06 1.2 1.38687754065e-06 1.2 1.38690929878e-06 1.2 1.38694105691e-06 1.2 1.38697281504e-06 1.2 1.38700457317e-06 1.2 1.3870363313e-06 1.2 1.38706808943e-06 1.2 1.38709984756e-06 1.2 1.38713160569e-06 1.2 1.38716336382e-06 1.2 1.38719512195e-06 1.2 1.38722688008e-06 1.2 1.38725863821e-06 1.2 1.38729039634e-06 1.2 1.38732215447e-06 1.2 1.3873539126e-06 1.2 1.38738567073e-06 1.2 1.38741742886e-06 1.2 1.38744918699e-06 1.2 1.38748094512e-06 1.2 1.38751270325e-06 1.2 1.38754446138e-06 1.2 1.38757621951e-06 1.2 1.38760797764e-06 1.2 1.38763973577e-06 1.2 1.3876714939e-06 1.2 1.38770325203e-06 1.2 1.38773501016e-06 1.2 1.38776676829e-06 1.2 1.38779852642e-06 1.2 1.38783028455e-06 1.2 1.38786204268e-06 1.2 1.38789380081e-06 1.2 1.38792555894e-06 1.2 1.38795731707e-06 1.2 1.3879890752e-06 1.2 1.38802083333e-06 1.2 1.38805259146e-06 1.2 1.38808434959e-06 1.2 1.38811610772e-06 1.2 1.38814786585e-06 1.2 1.38817962398e-06 1.2 1.38821138211e-06 1.2 1.38824314024e-06 1.2 1.38827489837e-06 1.2 1.3883066565e-06 1.2 1.38833841463e-06 1.2 1.38837017276e-06 1.2 1.38840193089e-06 1.2 1.38843368902e-06 1.2 1.38846544715e-06 1.2 1.38849720528e-06 1.2 1.38852896341e-06 1.2 1.38856072154e-06 1.2 1.38859247967e-06 1.2 1.3886242378e-06 1.2 1.38865599593e-06 1.2 1.38868775407e-06 1.2 1.3887195122e-06 1.2 1.38875127033e-06 1.2 1.38878302846e-06 1.2 1.38881478659e-06 1.2 1.38884654472e-06 1.2 1.38887830285e-06 1.2 1.38891006098e-06 1.2 1.38894181911e-06 1.2 1.38897357724e-06 1.2 1.38900533537e-06 1.2 1.3890370935e-06 1.2 1.38906885163e-06 1.2 1.38910060976e-06 1.2 1.38913236789e-06 1.2 1.38916412602e-06 1.2 1.38919588415e-06 1.2 1.38922764228e-06 1.2 1.38925940041e-06 1.2 1.38929115854e-06 1.2 1.38932291667e-06 1.2 1.3893546748e-06 1.2 1.38938643293e-06 1.2 1.38941819106e-06 1.2 1.38944994919e-06 1.2 1.38948170732e-06 1.2 1.38951346545e-06 1.2 1.38954522358e-06 1.2 1.38957698171e-06 1.2 1.38960873984e-06 1.2 1.38964049797e-06 1.2 1.3896722561e-06 1.2 1.38970401423e-06 1.2 1.38973577236e-06 1.2 1.38976753049e-06 1.2 1.38979928862e-06 1.2 1.38983104675e-06 1.2 1.38986280488e-06 1.2 1.38989456301e-06 1.2 1.38992632114e-06 1.2 1.38995807927e-06 1.2 1.3899898374e-06 1.2 1.39002159553e-06 1.2 1.39005335366e-06 1.2 1.39008511179e-06 1.2 1.39011686992e-06 1.2 1.39014862805e-06 1.2 1.39018038618e-06 1.2 1.39021214431e-06 1.2 1.39024390244e-06 1.2 1.39027566057e-06 1.2 1.3903074187e-06 1.2 1.39033917683e-06 1.2 1.39037093496e-06 1.2 1.39040269309e-06 1.2 1.39043445122e-06 1.2 1.39046620935e-06 1.2 1.39049796748e-06 1.2 1.39052972561e-06 1.2 1.39056148374e-06 1.2 1.39059324187e-06 1.2 1.390625e-06 1.2 1.39065675813e-06 1.2 1.39068851626e-06 1.2 1.39072027439e-06 1.2 1.39075203252e-06 1.2 1.39078379065e-06 1.2 1.39081554878e-06 1.2 1.39084730691e-06 1.2 1.39087906504e-06 1.2 1.39091082317e-06 1.2 1.3909425813e-06 1.2 1.39097433943e-06 1.2 1.39100609756e-06 1.2 1.39103785569e-06 1.2 1.39106961382e-06 1.2 1.39110137195e-06 1.2 1.39113313008e-06 1.2 1.39116488821e-06 1.2 1.39119664634e-06 1.2 1.39122840447e-06 1.2 1.3912601626e-06 1.2 1.39129192073e-06 1.2 1.39132367886e-06 1.2 1.39135543699e-06 1.2 1.39138719512e-06 1.2 1.39141895325e-06 1.2 1.39145071138e-06 1.2 1.39148246951e-06 1.2 1.39151422764e-06 1.2 1.39154598577e-06 1.2 1.3915777439e-06 1.2 1.39160950203e-06 1.2 1.39164126016e-06 1.2 1.39167301829e-06 1.2 1.39170477642e-06 1.2 1.39173653455e-06 1.2 1.39176829268e-06 1.2 1.39180005081e-06 1.2 1.39183180894e-06 1.2 1.39186356707e-06 1.2 1.3918953252e-06 1.2 1.39192708333e-06 1.2 1.39195884146e-06 1.2 1.39199059959e-06 1.2 1.39202235772e-06 1.2 1.39205411585e-06 1.2 1.39208587398e-06 1.2 1.39211763211e-06 1.2 1.39214939024e-06 1.2 1.39218114837e-06 1.2 1.3922129065e-06 1.2 1.39224466463e-06 1.2 1.39227642276e-06 1.2 1.39230818089e-06 1.2 1.39233993902e-06 1.2 1.39237169715e-06 1.2 1.39240345528e-06 1.2 1.39243521341e-06 1.2 1.39246697154e-06 1.2 1.39249872967e-06 1.2 1.3925304878e-06 1.2 1.39256224593e-06 1.2 1.39259400407e-06 1.2 1.3926257622e-06 1.2 1.39265752033e-06 1.2 1.39268927846e-06 1.2 1.39272103659e-06 1.2 1.39275279472e-06 1.2 1.39278455285e-06 1.2 1.39281631098e-06 1.2 1.39284806911e-06 1.2 1.39287982724e-06 1.2 1.39291158537e-06 1.2 1.3929433435e-06 1.2 1.39297510163e-06 1.2 1.39300685976e-06 1.2 1.39303861789e-06 1.2 1.39307037602e-06 1.2 1.39310213415e-06 1.2 1.39313389228e-06 1.2 1.39316565041e-06 1.2 1.39319740854e-06 1.2 1.39322916667e-06 1.2 1.3932609248e-06 1.2 1.39329268293e-06 1.2 1.39332444106e-06 1.2 1.39335619919e-06 1.2 1.39338795732e-06 1.2 1.39341971545e-06 1.2 1.39345147358e-06 1.2 1.39348323171e-06 1.2 1.39351498984e-06 1.2 1.39354674797e-06 1.2 1.3935785061e-06 1.2 1.39361026423e-06 1.2 1.39364202236e-06 1.2 1.39367378049e-06 1.2 1.39370553862e-06 1.2 1.39373729675e-06 1.2 1.39376905488e-06 1.2 1.39380081301e-06 1.2 1.39383257114e-06 1.2 1.39386432927e-06 1.2 1.3938960874e-06 1.2 1.39392784553e-06 1.2 1.39395960366e-06 1.2 1.39399136179e-06 1.2 1.39402311992e-06 1.2 1.39405487805e-06 1.2 1.39408663618e-06 1.2 1.39411839431e-06 1.2 1.39415015244e-06 1.2 1.39418191057e-06 1.2 1.3942136687e-06 1.2 1.39424542683e-06 1.2 1.39427718496e-06 1.2 1.39430894309e-06 1.2 1.39434070122e-06 1.2 1.39437245935e-06 1.2 1.39440421748e-06 1.2 1.39443597561e-06 1.2 1.39446773374e-06 1.2 1.39449949187e-06 1.2 1.39453125e-06 1.2 1.39456300813e-06 1.2 1.39459476626e-06 1.2 1.39462652439e-06 1.2 1.39465828252e-06 1.2 1.39469004065e-06 1.2 1.39472179878e-06 1.2 1.39475355691e-06 1.2 1.39478531504e-06 1.2 1.39481707317e-06 1.2 1.3948488313e-06 1.2 1.39488058943e-06 1.2 1.39491234756e-06 1.2 1.39494410569e-06 1.2 1.39497586382e-06 1.2 1.39500762195e-06 1.2 1.39503938008e-06 1.2 1.39507113821e-06 1.2 1.39510289634e-06 1.2 1.39513465447e-06 1.2 1.3951664126e-06 1.2 1.39519817073e-06 1.2 1.39522992886e-06 1.2 1.39526168699e-06 1.2 1.39529344512e-06 1.2 1.39532520325e-06 1.2 1.39535696138e-06 1.2 1.39538871951e-06 1.2 1.39542047764e-06 1.2 1.39545223577e-06 1.2 1.3954839939e-06 1.2 1.39551575203e-06 1.2 1.39554751016e-06 1.2 1.39557926829e-06 1.2 1.39561102642e-06 1.2 1.39564278455e-06 1.2 1.39567454268e-06 1.2 1.39570630081e-06 1.2 1.39573805894e-06 1.2 1.39576981707e-06 1.2 1.3958015752e-06 1.2 1.39583333333e-06 1.2 1.39586509146e-06 1.2 1.39589684959e-06 1.2 1.39592860772e-06 1.2 1.39596036585e-06 1.2 1.39599212398e-06 1.2 1.39602388211e-06 1.2 1.39605564024e-06 1.2 1.39608739837e-06 1.2 1.3961191565e-06 1.2 1.39615091463e-06 1.2 1.39618267276e-06 1.2 1.39621443089e-06 1.2 1.39624618902e-06 1.2 1.39627794715e-06 1.2 1.39630970528e-06 1.2 1.39634146341e-06 1.2 1.39637322154e-06 1.2 1.39640497967e-06 1.2 1.3964367378e-06 1.2 1.39646849593e-06 1.2 1.39650025407e-06 1.2 1.3965320122e-06 1.2 1.39656377033e-06 1.2 1.39659552846e-06 1.2 1.39662728659e-06 1.2 1.39665904472e-06 1.2 1.39669080285e-06 1.2 1.39672256098e-06 1.2 1.39675431911e-06 1.2 1.39678607724e-06 1.2 1.39681783537e-06 1.2 1.3968495935e-06 1.2 1.39688135163e-06 1.2 1.39691310976e-06 1.2 1.39694486789e-06 1.2 1.39697662602e-06 1.2 1.39700838415e-06 1.2 1.39704014228e-06 1.2 1.39707190041e-06 1.2 1.39710365854e-06 1.2 1.39713541667e-06 1.2 1.3971671748e-06 1.2 1.39719893293e-06 1.2 1.39723069106e-06 1.2 1.39726244919e-06 1.2 1.39729420732e-06 1.2 1.39732596545e-06 1.2 1.39735772358e-06 1.2 1.39738948171e-06 1.2 1.39742123984e-06 1.2 1.39745299797e-06 1.2 1.3974847561e-06 1.2 1.39751651423e-06 1.2 1.39754827236e-06 1.2 1.39758003049e-06 1.2 1.39761178862e-06 1.2 1.39764354675e-06 1.2 1.39767530488e-06 1.2 1.39770706301e-06 1.2 1.39773882114e-06 1.2 1.39777057927e-06 1.2 1.3978023374e-06 1.2 1.39783409553e-06 1.2 1.39786585366e-06 1.2 1.39789761179e-06 1.2 1.39792936992e-06 1.2 1.39796112805e-06 1.2 1.39799288618e-06 1.2 1.39802464431e-06 1.2 1.39805640244e-06 1.2 1.39808816057e-06 1.2 1.3981199187e-06 1.2 1.39815167683e-06 1.2 1.39818343496e-06 1.2 1.39821519309e-06 1.2 1.39824695122e-06 1.2 1.39827870935e-06 1.2 1.39831046748e-06 1.2 1.39834222561e-06 1.2 1.39837398374e-06 1.2 1.39840574187e-06 1.2 1.3984375e-06 1.2 1.39846925813e-06 1.2 1.39850101626e-06 1.2 1.39853277439e-06 1.2 1.39856453252e-06 1.2 1.39859629065e-06 1.2 1.39862804878e-06 1.2 1.39865980691e-06 1.2 1.39869156504e-06 1.2 1.39872332317e-06 1.2 1.3987550813e-06 1.2 1.39878683943e-06 1.2 1.39881859756e-06 1.2 1.39885035569e-06 1.2 1.39888211382e-06 1.2 1.39891387195e-06 1.2 1.39894563008e-06 1.2 1.39897738821e-06 1.2 1.39900914634e-06 1.2 1.39904090447e-06 1.2 1.3990726626e-06 1.2 1.39910442073e-06 1.2 1.39913617886e-06 1.2 1.39916793699e-06 1.2 1.39919969512e-06 1.2 1.39923145325e-06 1.2 1.39926321138e-06 1.2 1.39929496951e-06 1.2 1.39932672764e-06 1.2 1.39935848577e-06 1.2 1.3993902439e-06 1.2 1.39942200203e-06 1.2 1.39945376016e-06 1.2 1.39948551829e-06 1.2 1.39951727642e-06 1.2 1.39954903455e-06 1.2 1.39958079268e-06 1.2 1.39961255081e-06 1.2 1.39964430894e-06 1.2 1.39967606707e-06 1.2 1.3997078252e-06 1.2 1.39973958333e-06 1.2 1.39977134146e-06 1.2 1.39980309959e-06 1.2 1.39983485772e-06 1.2 1.39986661585e-06 1.2 1.39989837398e-06 1.2 1.39993013211e-06 1.2 1.39996189024e-06 1.2 1.39999364837e-06 1.2 1.4000254065e-06 1.2 1.40005716463e-06 1.2 1.40008892276e-06 1.2 1.40012068089e-06 1.2 1.40015243902e-06 1.2 1.40018419715e-06 1.2 1.40021595528e-06 1.2 1.40024771341e-06 1.2 1.40027947154e-06 1.2 1.40031122967e-06 1.2 1.4003429878e-06 1.2 1.40037474593e-06 1.2 1.40040650407e-06 1.2 1.4004382622e-06 1.2 1.40047002033e-06 1.2 1.40050177846e-06 1.2 1.40053353659e-06 1.2 1.40056529472e-06 1.2 1.40059705285e-06 1.2 1.40062881098e-06 1.2 1.40066056911e-06 1.2 1.40069232724e-06 1.2 1.40072408537e-06 1.2 1.4007558435e-06 1.2 1.40078760163e-06 1.2 1.40081935976e-06 1.2 1.40085111789e-06 1.2 1.40088287602e-06 1.2 1.40091463415e-06 1.2 1.40094639228e-06 1.2 1.40097815041e-06 1.2 1.40100990854e-06 1.2 1.40104166667e-06 1.2 1.4010734248e-06 1.2 1.40110518293e-06 1.2 1.40113694106e-06 1.2 1.40116869919e-06 1.2 1.40120045732e-06 1.2 1.40123221545e-06 1.2 1.40126397358e-06 1.2 1.40129573171e-06 1.2 1.40132748984e-06 1.2 1.40135924797e-06 1.2 1.4013910061e-06 1.2 1.40142276423e-06 1.2 1.40145452236e-06 1.2 1.40148628049e-06 1.2 1.40151803862e-06 1.2 1.40154979675e-06 1.2 1.40158155488e-06 1.2 1.40161331301e-06 1.2 1.40164507114e-06 1.2 1.40167682927e-06 1.2 1.4017085874e-06 1.2 1.40174034553e-06 1.2 1.40177210366e-06 1.2 1.40180386179e-06 1.2 1.40183561992e-06 1.2 1.40186737805e-06 1.2 1.40189913618e-06 1.2 1.40193089431e-06 1.2 1.40196265244e-06 1.2 1.40199441057e-06 1.2 1.4020261687e-06 1.2 1.40205792683e-06 1.2 1.40208968496e-06 1.2 1.40212144309e-06 1.2 1.40215320122e-06 1.2 1.40218495935e-06 1.2 1.40221671748e-06 1.2 1.40224847561e-06 1.2 1.40228023374e-06 1.2 1.40231199187e-06 1.2 1.40234375e-06 1.2 1.40237550813e-06 1.2 1.40240726626e-06 1.2 1.40243902439e-06 1.2 1.40247078252e-06 1.2 1.40250254065e-06 1.2 1.40253429878e-06 1.2 1.40256605691e-06 1.2 1.40259781504e-06 1.2 1.40262957317e-06 1.2 1.4026613313e-06 1.2 1.40269308943e-06 1.2 1.40272484756e-06 1.2 1.40275660569e-06 1.2 1.40278836382e-06 1.2 1.40282012195e-06 1.2 1.40285188008e-06 1.2 1.40288363821e-06 1.2 1.40291539634e-06 1.2 1.40294715447e-06 1.2 1.4029789126e-06 1.2 1.40301067073e-06 1.2 1.40304242886e-06 1.2 1.40307418699e-06 1.2 1.40310594512e-06 1.2 1.40313770325e-06 1.2 1.40316946138e-06 1.2 1.40320121951e-06 1.2 1.40323297764e-06 1.2 1.40326473577e-06 1.2 1.4032964939e-06 1.2 1.40332825203e-06 1.2 1.40336001016e-06 1.2 1.40339176829e-06 1.2 1.40342352642e-06 1.2 1.40345528455e-06 1.2 1.40348704268e-06 1.2 1.40351880081e-06 1.2 1.40355055894e-06 1.2 1.40358231707e-06 1.2 1.4036140752e-06 1.2 1.40364583333e-06 1.2 1.40367759146e-06 1.2 1.40370934959e-06 1.2 1.40374110772e-06 1.2 1.40377286585e-06 1.2 1.40380462398e-06 1.2 1.40383638211e-06 1.2 1.40386814024e-06 1.2 1.40389989837e-06 1.2 1.4039316565e-06 1.2 1.40396341463e-06 1.2 1.40399517276e-06 1.2 1.40402693089e-06 1.2 1.40405868902e-06 1.2 1.40409044715e-06 1.2 1.40412220528e-06 1.2 1.40415396341e-06 1.2 1.40418572154e-06 1.2 1.40421747967e-06 1.2 1.4042492378e-06 1.2 1.40428099593e-06 1.2 1.40431275407e-06 1.2 1.4043445122e-06 1.2 1.40437627033e-06 1.2 1.40440802846e-06 1.2 1.40443978659e-06 1.2 1.40447154472e-06 1.2 1.40450330285e-06 1.2 1.40453506098e-06 1.2 1.40456681911e-06 1.2 1.40459857724e-06 1.2 1.40463033537e-06 1.2 1.4046620935e-06 1.2 1.40469385163e-06 1.2 1.40472560976e-06 1.2 1.40475736789e-06 1.2 1.40478912602e-06 1.2 1.40482088415e-06 1.2 1.40485264228e-06 1.2 1.40488440041e-06 1.2 1.40491615854e-06 1.2 1.40494791667e-06 1.2 1.4049796748e-06 1.2 1.40501143293e-06 1.2 1.40504319106e-06 1.2 1.40507494919e-06 1.2 1.40510670732e-06 1.2 1.40513846545e-06 1.2 1.40517022358e-06 1.2 1.40520198171e-06 1.2 1.40523373984e-06 1.2 1.40526549797e-06 1.2 1.4052972561e-06 1.2 1.40532901423e-06 1.2 1.40536077236e-06 1.2 1.40539253049e-06 1.2 1.40542428862e-06 1.2 1.40545604675e-06 1.2 1.40548780488e-06 1.2 1.40551956301e-06 1.2 1.40555132114e-06 1.2 1.40558307927e-06 1.2 1.4056148374e-06 1.2 1.40564659553e-06 1.2 1.40567835366e-06 1.2 1.40571011179e-06 1.2 1.40574186992e-06 1.2 1.40577362805e-06 1.2 1.40580538618e-06 1.2 1.40583714431e-06 1.2 1.40586890244e-06 1.2 1.40590066057e-06 1.2 1.4059324187e-06 1.2 1.40596417683e-06 1.2 1.40599593496e-06 1.2 1.40602769309e-06 1.2 1.40605945122e-06 1.2 1.40609120935e-06 1.2 1.40612296748e-06 1.2 1.40615472561e-06 1.2 1.40618648374e-06 1.2 1.40621824187e-06 1.2 1.40625e-06 1.2 1.40628175813e-06 1.2 1.40631351626e-06 1.2 1.40634527439e-06 1.2 1.40637703252e-06 1.2 1.40640879065e-06 1.2 1.40644054878e-06 1.2 1.40647230691e-06 1.2 1.40650406504e-06 1.2 1.40653582317e-06 1.2 1.4065675813e-06 1.2 1.40659933943e-06 1.2 1.40663109756e-06 1.2 1.40666285569e-06 1.2 1.40669461382e-06 1.2 1.40672637195e-06 1.2 1.40675813008e-06 1.2 1.40678988821e-06 1.2 1.40682164634e-06 1.2 1.40685340447e-06 1.2 1.4068851626e-06 1.2 1.40691692073e-06 1.2 1.40694867886e-06 1.2 1.40698043699e-06 1.2 1.40701219512e-06 1.2 1.40704395325e-06 1.2 1.40707571138e-06 1.2 1.40710746951e-06 1.2 1.40713922764e-06 1.2 1.40717098577e-06 1.2 1.4072027439e-06 1.2 1.40723450203e-06 1.2 1.40726626016e-06 1.2 1.40729801829e-06 1.2 1.40732977642e-06 1.2 1.40736153455e-06 1.2 1.40739329268e-06 1.2 1.40742505081e-06 1.2 1.40745680894e-06 1.2 1.40748856707e-06 1.2 1.4075203252e-06 1.2 1.40755208333e-06 1.2 1.40758384146e-06 1.2 1.40761559959e-06 1.2 1.40764735772e-06 1.2 1.40767911585e-06 1.2 1.40771087398e-06 1.2 1.40774263211e-06 1.2 1.40777439024e-06 1.2 1.40780614837e-06 1.2 1.4078379065e-06 1.2 1.40786966463e-06 1.2 1.40790142276e-06 1.2 1.40793318089e-06 1.2 1.40796493902e-06 1.2 1.40799669715e-06 1.2 1.40802845528e-06 1.2 1.40806021341e-06 1.2 1.40809197154e-06 1.2 1.40812372967e-06 1.2 1.4081554878e-06 1.2 1.40818724593e-06 1.2 1.40821900407e-06 1.2 1.4082507622e-06 1.2 1.40828252033e-06 1.2 1.40831427846e-06 1.2 1.40834603659e-06 1.2 1.40837779472e-06 1.2 1.40840955285e-06 1.2 1.40844131098e-06 1.2 1.40847306911e-06 1.2 1.40850482724e-06 1.2 1.40853658537e-06 1.2 1.4085683435e-06 1.2 1.40860010163e-06 1.2 1.40863185976e-06 1.2 1.40866361789e-06 1.2 1.40869537602e-06 1.2 1.40872713415e-06 1.2 1.40875889228e-06 1.2 1.40879065041e-06 1.2 1.40882240854e-06 1.2 1.40885416667e-06 1.2 1.4088859248e-06 1.2 1.40891768293e-06 1.2 1.40894944106e-06 1.2 1.40898119919e-06 1.2 1.40901295732e-06 1.2 1.40904471545e-06 1.2 1.40907647358e-06 1.2 1.40910823171e-06 1.2 1.40913998984e-06 1.2 1.40917174797e-06 1.2 1.4092035061e-06 1.2 1.40923526423e-06 1.2 1.40926702236e-06 1.2 1.40929878049e-06 1.2 1.40933053862e-06 1.2 1.40936229675e-06 1.2 1.40939405488e-06 1.2 1.40942581301e-06 1.2 1.40945757114e-06 1.2 1.40948932927e-06 1.2 1.4095210874e-06 1.2 1.40955284553e-06 1.2 1.40958460366e-06 1.2 1.40961636179e-06 1.2 1.40964811992e-06 1.2 1.40967987805e-06 1.2 1.40971163618e-06 1.2 1.40974339431e-06 1.2 1.40977515244e-06 1.2 1.40980691057e-06 1.2 1.4098386687e-06 1.2 1.40987042683e-06 1.2 1.40990218496e-06 1.2 1.40993394309e-06 1.2 1.40996570122e-06 1.2 1.40999745935e-06 1.2 1.41002921748e-06 1.2 1.41006097561e-06 1.2 1.41009273374e-06 1.2 1.41012449187e-06 1.2 1.41015625e-06 1.2 1.41018800813e-06 1.2 1.41021976626e-06 1.2 1.41025152439e-06 1.2 1.41028328252e-06 1.2 1.41031504065e-06 1.2 1.41034679878e-06 1.2 1.41037855691e-06 1.2 1.41041031504e-06 1.2 1.41044207317e-06 1.2 1.4104738313e-06 1.2 1.41050558943e-06 1.2 1.41053734756e-06 1.2 1.41056910569e-06 1.2 1.41060086382e-06 1.2 1.41063262195e-06 1.2 1.41066438008e-06 1.2 1.41069613821e-06 1.2 1.41072789634e-06 1.2 1.41075965447e-06 1.2 1.4107914126e-06 1.2 1.41082317073e-06 1.2 1.41085492886e-06 1.2 1.41088668699e-06 1.2 1.41091844512e-06 1.2 1.41095020325e-06 1.2 1.41098196138e-06 1.2 1.41101371951e-06 1.2 1.41104547764e-06 1.2 1.41107723577e-06 1.2 1.4111089939e-06 1.2 1.41114075203e-06 1.2 1.41117251016e-06 1.2 1.41120426829e-06 1.2 1.41123602642e-06 1.2 1.41126778455e-06 1.2 1.41129954268e-06 1.2 1.41133130081e-06 1.2 1.41136305894e-06 1.2 1.41139481707e-06 1.2 1.4114265752e-06 1.2 1.41145833333e-06 1.2 1.41149009146e-06 1.2 1.41152184959e-06 1.2 1.41155360772e-06 1.2 1.41158536585e-06 1.2 1.41161712398e-06 1.2 1.41164888211e-06 1.2 1.41168064024e-06 1.2 1.41171239837e-06 1.2 1.4117441565e-06 1.2 1.41177591463e-06 1.2 1.41180767276e-06 1.2 1.41183943089e-06 1.2 1.41187118902e-06 1.2 1.41190294715e-06 1.2 1.41193470528e-06 1.2 1.41196646341e-06 1.2 1.41199822154e-06 1.2 1.41202997967e-06 1.2 1.4120617378e-06 1.2 1.41209349593e-06 1.2 1.41212525407e-06 1.2 1.4121570122e-06 1.2 1.41218877033e-06 1.2 1.41222052846e-06 1.2 1.41225228659e-06 1.2 1.41228404472e-06 1.2 1.41231580285e-06 1.2 1.41234756098e-06 1.2 1.41237931911e-06 1.2 1.41241107724e-06 1.2 1.41244283537e-06 1.2 1.4124745935e-06 1.2 1.41250635163e-06 1.2 1.41253810976e-06 1.2 1.41256986789e-06 1.2 1.41260162602e-06 1.2 1.41263338415e-06 1.2 1.41266514228e-06 1.2 1.41269690041e-06 1.2 1.41272865854e-06 1.2 1.41276041667e-06 1.2 1.4127921748e-06 1.2 1.41282393293e-06 1.2 1.41285569106e-06 1.2 1.41288744919e-06 1.2 1.41291920732e-06 1.2 1.41295096545e-06 1.2 1.41298272358e-06 1.2 1.41301448171e-06 1.2 1.41304623984e-06 1.2 1.41307799797e-06 1.2 1.4131097561e-06 1.2 1.41314151423e-06 1.2 1.41317327236e-06 1.2 1.41320503049e-06 1.2 1.41323678862e-06 1.2 1.41326854675e-06 1.2 1.41330030488e-06 1.2 1.41333206301e-06 1.2 1.41336382114e-06 1.2 1.41339557927e-06 1.2 1.4134273374e-06 1.2 1.41345909553e-06 1.2 1.41349085366e-06 1.2 1.41352261179e-06 1.2 1.41355436992e-06 1.2 1.41358612805e-06 1.2 1.41361788618e-06 1.2 1.41364964431e-06 1.2 1.41368140244e-06 1.2 1.41371316057e-06 1.2 1.4137449187e-06 1.2 1.41377667683e-06 1.2 1.41380843496e-06 1.2 1.41384019309e-06 1.2 1.41387195122e-06 1.2 1.41390370935e-06 1.2 1.41393546748e-06 1.2 1.41396722561e-06 1.2 1.41399898374e-06 1.2 1.41403074187e-06 1.2 1.4140625e-06 1.2 1.41409425813e-06 1.2 1.41412601626e-06 1.2 1.41415777439e-06 1.2 1.41418953252e-06 1.2 1.41422129065e-06 1.2 1.41425304878e-06 1.2 1.41428480691e-06 1.2 1.41431656504e-06 1.2 1.41434832317e-06 1.2 1.4143800813e-06 1.2 1.41441183943e-06 1.2 1.41444359756e-06 1.2 1.41447535569e-06 1.2 1.41450711382e-06 1.2 1.41453887195e-06 1.2 1.41457063008e-06 1.2 1.41460238821e-06 1.2 1.41463414634e-06 1.2 1.41466590447e-06 1.2 1.4146976626e-06 1.2 1.41472942073e-06 1.2 1.41476117886e-06 1.2 1.41479293699e-06 1.2 1.41482469512e-06 1.2 1.41485645325e-06 1.2 1.41488821138e-06 1.2 1.41491996951e-06 1.2 1.41495172764e-06 1.2 1.41498348577e-06 1.2 1.4150152439e-06 1.2 1.41504700203e-06 1.2 1.41507876016e-06 1.2 1.41511051829e-06 1.2 1.41514227642e-06 1.2 1.41517403455e-06 1.2 1.41520579268e-06 1.2 1.41523755081e-06 1.2 1.41526930894e-06 1.2 1.41530106707e-06 1.2 1.4153328252e-06 1.2 1.41536458333e-06 1.2 1.41539634146e-06 1.2 1.41542809959e-06 1.2 1.41545985772e-06 1.2 1.41549161585e-06 1.2 1.41552337398e-06 1.2 1.41555513211e-06 1.2 1.41558689024e-06 1.2 1.41561864837e-06 1.2 1.4156504065e-06 1.2 1.41568216463e-06 1.2 1.41571392276e-06 1.2 1.41574568089e-06 1.2 1.41577743902e-06 1.2 1.41580919715e-06 1.2 1.41584095528e-06 1.2 1.41587271341e-06 1.2 1.41590447154e-06 1.2 1.41593622967e-06 1.2 1.4159679878e-06 1.2 1.41599974593e-06 1.2 1.41603150407e-06 1.2 1.4160632622e-06 1.2 1.41609502033e-06 1.2 1.41612677846e-06 1.2 1.41615853659e-06 1.2 1.41619029472e-06 1.2 1.41622205285e-06 1.2 1.41625381098e-06 1.2 1.41628556911e-06 1.2 1.41631732724e-06 1.2 1.41634908537e-06 1.2 1.4163808435e-06 1.2 1.41641260163e-06 1.2 1.41644435976e-06 1.2 1.41647611789e-06 1.2 1.41650787602e-06 1.2 1.41653963415e-06 1.2 1.41657139228e-06 1.2 1.41660315041e-06 1.2 1.41663490854e-06 1.2 1.41666666667e-06 1.2 1.4166984248e-06 1.2 1.41673018293e-06 1.2 1.41676194106e-06 1.2 1.41679369919e-06 1.2 1.41682545732e-06 1.2 1.41685721545e-06 1.2 1.41688897358e-06 1.2 1.41692073171e-06 1.2 1.41695248984e-06 1.2 1.41698424797e-06 1.2 1.4170160061e-06 1.2 1.41704776423e-06 1.2 1.41707952236e-06 1.2 1.41711128049e-06 1.2 1.41714303862e-06 1.2 1.41717479675e-06 1.2 1.41720655488e-06 1.2 1.41723831301e-06 1.2 1.41727007114e-06 1.2 1.41730182927e-06 1.2 1.4173335874e-06 1.2 1.41736534553e-06 1.2 1.41739710366e-06 1.2 1.41742886179e-06 1.2 1.41746061992e-06 1.2 1.41749237805e-06 1.2 1.41752413618e-06 1.2 1.41755589431e-06 1.2 1.41758765244e-06 1.2 1.41761941057e-06 1.2 1.4176511687e-06 1.2 1.41768292683e-06 1.2 1.41771468496e-06 1.2 1.41774644309e-06 1.2 1.41777820122e-06 1.2 1.41780995935e-06 1.2 1.41784171748e-06 1.2 1.41787347561e-06 1.2 1.41790523374e-06 1.2 1.41793699187e-06 1.2 1.41796875e-06 1.2 1.41800050813e-06 1.2 1.41803226626e-06 1.2 1.41806402439e-06 1.2 1.41809578252e-06 1.2 1.41812754065e-06 1.2 1.41815929878e-06 1.2 1.41819105691e-06 1.2 1.41822281504e-06 1.2 1.41825457317e-06 1.2 1.4182863313e-06 1.2 1.41831808943e-06 1.2 1.41834984756e-06 1.2 1.41838160569e-06 1.2 1.41841336382e-06 1.2 1.41844512195e-06 1.2 1.41847688008e-06 1.2 1.41850863821e-06 1.2 1.41854039634e-06 1.2 1.41857215447e-06 1.2 1.4186039126e-06 1.2 1.41863567073e-06 1.2 1.41866742886e-06 1.2 1.41869918699e-06 1.2 1.41873094512e-06 1.2 1.41876270325e-06 1.2 1.41879446138e-06 1.2 1.41882621951e-06 1.2 1.41885797764e-06 1.2 1.41888973577e-06 1.2 1.4189214939e-06 1.2 1.41895325203e-06 1.2 1.41898501016e-06 1.2 1.41901676829e-06 1.2 1.41904852642e-06 1.2 1.41908028455e-06 1.2 1.41911204268e-06 1.2 1.41914380081e-06 1.2 1.41917555894e-06 1.2 1.41920731707e-06 1.2 1.4192390752e-06 1.2 1.41927083333e-06 1.2 1.41930259146e-06 1.2 1.41933434959e-06 1.2 1.41936610772e-06 1.2 1.41939786585e-06 1.2 1.41942962398e-06 1.2 1.41946138211e-06 1.2 1.41949314024e-06 1.2 1.41952489837e-06 1.2 1.4195566565e-06 1.2 1.41958841463e-06 1.2 1.41962017276e-06 1.2 1.41965193089e-06 1.2 1.41968368902e-06 1.2 1.41971544715e-06 1.2 1.41974720528e-06 1.2 1.41977896341e-06 1.2 1.41981072154e-06 1.2 1.41984247967e-06 1.2 1.4198742378e-06 1.2 1.41990599593e-06 1.2 1.41993775407e-06 1.2 1.4199695122e-06 1.2 1.42000127033e-06 1.2 1.42003302846e-06 1.2 1.42006478659e-06 1.2 1.42009654472e-06 1.2 1.42012830285e-06 1.2 1.42016006098e-06 1.2 1.42019181911e-06 1.2 1.42022357724e-06 1.2 1.42025533537e-06 1.2 1.4202870935e-06 1.2 1.42031885163e-06 1.2 1.42035060976e-06 1.2 1.42038236789e-06 1.2 1.42041412602e-06 1.2 1.42044588415e-06 1.2 1.42047764228e-06 1.2 1.42050940041e-06 1.2 1.42054115854e-06 1.2 1.42057291667e-06 1.2 1.4206046748e-06 1.2 1.42063643293e-06 1.2 1.42066819106e-06 1.2 1.42069994919e-06 1.2 1.42073170732e-06 1.2 1.42076346545e-06 1.2 1.42079522358e-06 1.2 1.42082698171e-06 1.2 1.42085873984e-06 1.2 1.42089049797e-06 1.2 1.4209222561e-06 1.2 1.42095401423e-06 1.2 1.42098577236e-06 1.2 1.42101753049e-06 1.2 1.42104928862e-06 1.2 1.42108104675e-06 1.2 1.42111280488e-06 1.2 1.42114456301e-06 1.2 1.42117632114e-06 1.2 1.42120807927e-06 1.2 1.4212398374e-06 1.2 1.42127159553e-06 1.2 1.42130335366e-06 1.2 1.42133511179e-06 1.2 1.42136686992e-06 1.2 1.42139862805e-06 1.2 1.42143038618e-06 1.2 1.42146214431e-06 1.2 1.42149390244e-06 1.2 1.42152566057e-06 1.2 1.4215574187e-06 1.2 1.42158917683e-06 1.2 1.42162093496e-06 1.2 1.42165269309e-06 1.2 1.42168445122e-06 1.2 1.42171620935e-06 1.2 1.42174796748e-06 1.2 1.42177972561e-06 1.2 1.42181148374e-06 1.2 1.42184324187e-06 1.2 1.421875e-06 1.2 1.42190675813e-06 1.2 1.42193851626e-06 1.2 1.42197027439e-06 1.2 1.42200203252e-06 1.2 1.42203379065e-06 1.2 1.42206554878e-06 1.2 1.42209730691e-06 1.2 1.42212906504e-06 1.2 1.42216082317e-06 1.2 1.4221925813e-06 1.2 1.42222433943e-06 1.2 1.42225609756e-06 1.2 1.42228785569e-06 1.2 1.42231961382e-06 1.2 1.42235137195e-06 1.2 1.42238313008e-06 1.2 1.42241488821e-06 1.2 1.42244664634e-06 1.2 1.42247840447e-06 1.2 1.4225101626e-06 1.2 1.42254192073e-06 1.2 1.42257367886e-06 1.2 1.42260543699e-06 1.2 1.42263719512e-06 1.2 1.42266895325e-06 1.2 1.42270071138e-06 1.2 1.42273246951e-06 1.2 1.42276422764e-06 1.2 1.42279598577e-06 1.2 1.4228277439e-06 1.2 1.42285950203e-06 1.2 1.42289126016e-06 1.2 1.42292301829e-06 1.2 1.42295477642e-06 1.2 1.42298653455e-06 1.2 1.42301829268e-06 1.2 1.42305005081e-06 1.2 1.42308180894e-06 1.2 1.42311356707e-06 1.2 1.4231453252e-06 1.2 1.42317708333e-06 1.2 1.42320884146e-06 1.2 1.42324059959e-06 1.2 1.42327235772e-06 1.2 1.42330411585e-06 1.2 1.42333587398e-06 1.2 1.42336763211e-06 1.2 1.42339939024e-06 1.2 1.42343114837e-06 1.2 1.4234629065e-06 1.2 1.42349466463e-06 1.2 1.42352642276e-06 1.2 1.42355818089e-06 1.2 1.42358993902e-06 1.2 1.42362169715e-06 1.2 1.42365345528e-06 1.2 1.42368521341e-06 1.2 1.42371697154e-06 1.2 1.42374872967e-06 1.2 1.4237804878e-06 1.2 1.42381224593e-06 1.2 1.42384400407e-06 1.2 1.4238757622e-06 1.2 1.42390752033e-06 1.2 1.42393927846e-06 1.2 1.42397103659e-06 1.2 1.42400279472e-06 1.2 1.42403455285e-06 1.2 1.42406631098e-06 1.2 1.42409806911e-06 1.2 1.42412982724e-06 1.2 1.42416158537e-06 1.2 1.4241933435e-06 1.2 1.42422510163e-06 1.2 1.42425685976e-06 1.2 1.42428861789e-06 1.2 1.42432037602e-06 1.2 1.42435213415e-06 1.2 1.42438389228e-06 1.2 1.42441565041e-06 1.2 1.42444740854e-06 1.2 1.42447916667e-06 1.2 1.4245109248e-06 1.2 1.42454268293e-06 1.2 1.42457444106e-06 1.2 1.42460619919e-06 1.2 1.42463795732e-06 1.2 1.42466971545e-06 1.2 1.42470147358e-06 1.2 1.42473323171e-06 1.2 1.42476498984e-06 1.2 1.42479674797e-06 1.2 1.4248285061e-06 1.2 1.42486026423e-06 1.2 1.42489202236e-06 1.2 1.42492378049e-06 1.2 1.42495553862e-06 1.2 1.42498729675e-06 1.2 1.42501905488e-06 1.2 1.42505081301e-06 1.2 1.42508257114e-06 1.2 1.42511432927e-06 1.2 1.4251460874e-06 1.2 1.42517784553e-06 1.2 1.42520960366e-06 1.2 1.42524136179e-06 1.2 1.42527311992e-06 1.2 1.42530487805e-06 1.2 1.42533663618e-06 1.2 1.42536839431e-06 1.2 1.42540015244e-06 1.2 1.42543191057e-06 1.2 1.4254636687e-06 1.2 1.42549542683e-06 1.2 1.42552718496e-06 1.2 1.42555894309e-06 1.2 1.42559070122e-06 1.2 1.42562245935e-06 1.2 1.42565421748e-06 1.2 1.42568597561e-06 1.2 1.42571773374e-06 1.2 1.42574949187e-06 1.2 1.42578125e-06 1.2 1.42581300813e-06 1.2 1.42584476626e-06 1.2 1.42587652439e-06 1.2 1.42590828252e-06 1.2 1.42594004065e-06 1.2 1.42597179878e-06 1.2 1.42600355691e-06 1.2 1.42603531504e-06 1.2 1.42606707317e-06 1.2 1.4260988313e-06 1.2 1.42613058943e-06 1.2 1.42616234756e-06 1.2 1.42619410569e-06 1.2 1.42622586382e-06 1.2 1.42625762195e-06 1.2 1.42628938008e-06 1.2 1.42632113821e-06 1.2 1.42635289634e-06 1.2 1.42638465447e-06 1.2 1.4264164126e-06 1.2 1.42644817073e-06 1.2 1.42647992886e-06 1.2 1.42651168699e-06 1.2 1.42654344512e-06 1.2 1.42657520325e-06 1.2 1.42660696138e-06 1.2 1.42663871951e-06 1.2 1.42667047764e-06 1.2 1.42670223577e-06 1.2 1.4267339939e-06 1.2 1.42676575203e-06 1.2 1.42679751016e-06 1.2 1.42682926829e-06 1.2 1.42686102642e-06 1.2 1.42689278455e-06 1.2 1.42692454268e-06 1.2 1.42695630081e-06 1.2 1.42698805894e-06 1.2 1.42701981707e-06 1.2 1.4270515752e-06 1.2 1.42708333333e-06 1.2 1.42711509146e-06 1.2 1.42714684959e-06 1.2 1.42717860772e-06 1.2 1.42721036585e-06 1.2 1.42724212398e-06 1.2 1.42727388211e-06 1.2 1.42730564024e-06 1.2 1.42733739837e-06 1.2 1.4273691565e-06 1.2 1.42740091463e-06 1.2 1.42743267276e-06 1.2 1.42746443089e-06 1.2 1.42749618902e-06 1.2 1.42752794715e-06 1.2 1.42755970528e-06 1.2 1.42759146341e-06 1.2 1.42762322154e-06 1.2 1.42765497967e-06 1.2 1.4276867378e-06 1.2 1.42771849593e-06 1.2 1.42775025407e-06 1.2 1.4277820122e-06 1.2 1.42781377033e-06 1.2 1.42784552846e-06 1.2 1.42787728659e-06 1.2 1.42790904472e-06 1.2 1.42794080285e-06 1.2 1.42797256098e-06 1.2 1.42800431911e-06 1.2 1.42803607724e-06 1.2 1.42806783537e-06 1.2 1.4280995935e-06 1.2 1.42813135163e-06 1.2 1.42816310976e-06 1.2 1.42819486789e-06 1.2 1.42822662602e-06 1.2 1.42825838415e-06 1.2 1.42829014228e-06 1.2 1.42832190041e-06 1.2 1.42835365854e-06 1.2 1.42838541667e-06 1.2 1.4284171748e-06 1.2 1.42844893293e-06 1.2 1.42848069106e-06 1.2 1.42851244919e-06 1.2 1.42854420732e-06 1.2 1.42857596545e-06 1.2 1.42860772358e-06 1.2 1.42863948171e-06 1.2 1.42867123984e-06 1.2 1.42870299797e-06 1.2 1.4287347561e-06 1.2 1.42876651423e-06 1.2 1.42879827236e-06 1.2 1.42883003049e-06 1.2 1.42886178862e-06 1.2 1.42889354675e-06 1.2 1.42892530488e-06 1.2 1.42895706301e-06 1.2 1.42898882114e-06 1.2 1.42902057927e-06 1.2 1.4290523374e-06 1.2 1.42908409553e-06 1.2 1.42911585366e-06 1.2 1.42914761179e-06 1.2 1.42917936992e-06 1.2 1.42921112805e-06 1.2 1.42924288618e-06 1.2 1.42927464431e-06 1.2 1.42930640244e-06 1.2 1.42933816057e-06 1.2 1.4293699187e-06 1.2 1.42940167683e-06 1.2 1.42943343496e-06 1.2 1.42946519309e-06 1.2 1.42949695122e-06 1.2 1.42952870935e-06 1.2 1.42956046748e-06 1.2 1.42959222561e-06 1.2 1.42962398374e-06 1.2 1.42965574187e-06 1.2 1.4296875e-06 1.2 1.42971925813e-06 1.2 1.42975101626e-06 1.2 1.42978277439e-06 1.2 1.42981453252e-06 1.2 1.42984629065e-06 1.2 1.42987804878e-06 1.2 1.42990980691e-06 1.2 1.42994156504e-06 1.2 1.42997332317e-06 1.2 1.4300050813e-06 1.2 1.43003683943e-06 1.2 1.43006859756e-06 1.2 1.43010035569e-06 1.2 1.43013211382e-06 1.2 1.43016387195e-06 1.2 1.43019563008e-06 1.2 1.43022738821e-06 1.2 1.43025914634e-06 1.2 1.43029090447e-06 1.2 1.4303226626e-06 1.2 1.43035442073e-06 1.2 1.43038617886e-06 1.2 1.43041793699e-06 1.2 1.43044969512e-06 1.2 1.43048145325e-06 1.2 1.43051321138e-06 1.2 1.43054496951e-06 1.2 1.43057672764e-06 1.2 1.43060848577e-06 1.2 1.4306402439e-06 1.2 1.43067200203e-06 1.2 1.43070376016e-06 1.2 1.43073551829e-06 1.2 1.43076727642e-06 1.2 1.43079903455e-06 1.2 1.43083079268e-06 1.2 1.43086255081e-06 1.2 1.43089430894e-06 1.2 1.43092606707e-06 1.2 1.4309578252e-06 1.2 1.43098958333e-06 1.2 1.43102134146e-06 1.2 1.43105309959e-06 1.2 1.43108485772e-06 1.2 1.43111661585e-06 1.2 1.43114837398e-06 1.2 1.43118013211e-06 1.2 1.43121189024e-06 1.2 1.43124364837e-06 1.2 1.4312754065e-06 1.2 1.43130716463e-06 1.2 1.43133892276e-06 1.2 1.43137068089e-06 1.2 1.43140243902e-06 1.2 1.43143419715e-06 1.2 1.43146595528e-06 1.2 1.43149771341e-06 1.2 1.43152947154e-06 1.2 1.43156122967e-06 1.2 1.4315929878e-06 1.2 1.43162474593e-06 1.2 1.43165650407e-06 1.2 1.4316882622e-06 1.2 1.43172002033e-06 1.2 1.43175177846e-06 1.2 1.43178353659e-06 1.2 1.43181529472e-06 1.2 1.43184705285e-06 1.2 1.43187881098e-06 1.2 1.43191056911e-06 1.2 1.43194232724e-06 1.2 1.43197408537e-06 1.2 1.4320058435e-06 1.2 1.43203760163e-06 1.2 1.43206935976e-06 1.2 1.43210111789e-06 1.2 1.43213287602e-06 1.2 1.43216463415e-06 1.2 1.43219639228e-06 1.2 1.43222815041e-06 1.2 1.43225990854e-06 1.2 1.43229166667e-06 1.2 1.4323234248e-06 1.2 1.43235518293e-06 1.2 1.43238694106e-06 1.2 1.43241869919e-06 1.2 1.43245045732e-06 1.2 1.43248221545e-06 1.2 1.43251397358e-06 1.2 1.43254573171e-06 1.2 1.43257748984e-06 1.2 1.43260924797e-06 1.2 1.4326410061e-06 1.2 1.43267276423e-06 1.2 1.43270452236e-06 1.2 1.43273628049e-06 1.2 1.43276803862e-06 1.2 1.43279979675e-06 1.2 1.43283155488e-06 1.2 1.43286331301e-06 1.2 1.43289507114e-06 1.2 1.43292682927e-06 1.2 1.4329585874e-06 1.2 1.43299034553e-06 1.2 1.43302210366e-06 1.2 1.43305386179e-06 1.2 1.43308561992e-06 1.2 1.43311737805e-06 1.2 1.43314913618e-06 1.2 1.43318089431e-06 1.2 1.43321265244e-06 1.2 1.43324441057e-06 1.2 1.4332761687e-06 1.2 1.43330792683e-06 1.2 1.43333968496e-06 1.2 1.43337144309e-06 1.2 1.43340320122e-06 1.2 1.43343495935e-06 1.2 1.43346671748e-06 1.2 1.43349847561e-06 1.2 1.43353023374e-06 1.2 1.43356199187e-06 1.2 1.43359375e-06 1.2 1.43362550813e-06 1.2 1.43365726626e-06 1.2 1.43368902439e-06 1.2 1.43372078252e-06 1.2 1.43375254065e-06 1.2 1.43378429878e-06 1.2 1.43381605691e-06 1.2 1.43384781504e-06 1.2 1.43387957317e-06 1.2 1.4339113313e-06 1.2 1.43394308943e-06 1.2 1.43397484756e-06 1.2 1.43400660569e-06 1.2 1.43403836382e-06 1.2 1.43407012195e-06 1.2 1.43410188008e-06 1.2 1.43413363821e-06 1.2 1.43416539634e-06 1.2 1.43419715447e-06 1.2 1.4342289126e-06 1.2 1.43426067073e-06 1.2 1.43429242886e-06 1.2 1.43432418699e-06 1.2 1.43435594512e-06 1.2 1.43438770325e-06 1.2 1.43441946138e-06 1.2 1.43445121951e-06 1.2 1.43448297764e-06 1.2 1.43451473577e-06 1.2 1.4345464939e-06 1.2 1.43457825203e-06 1.2 1.43461001016e-06 1.2 1.43464176829e-06 1.2 1.43467352642e-06 1.2 1.43470528455e-06 1.2 1.43473704268e-06 1.2 1.43476880081e-06 1.2 1.43480055894e-06 1.2 1.43483231707e-06 1.2 1.4348640752e-06 1.2 1.43489583333e-06 1.2 1.43492759146e-06 1.2 1.43495934959e-06 1.2 1.43499110772e-06 1.2 1.43502286585e-06 1.2 1.43505462398e-06 1.2 1.43508638211e-06 1.2 1.43511814024e-06 1.2 1.43514989837e-06 1.2 1.4351816565e-06 1.2 1.43521341463e-06 1.2 1.43524517276e-06 1.2 1.43527693089e-06 1.2 1.43530868902e-06 1.2 1.43534044715e-06 1.2 1.43537220528e-06 1.2 1.43540396341e-06 1.2 1.43543572154e-06 1.2 1.43546747967e-06 1.2 1.4354992378e-06 1.2 1.43553099593e-06 1.2 1.43556275407e-06 1.2 1.4355945122e-06 1.2 1.43562627033e-06 1.2 1.43565802846e-06 1.2 1.43568978659e-06 1.2 1.43572154472e-06 1.2 1.43575330285e-06 1.2 1.43578506098e-06 1.2 1.43581681911e-06 1.2 1.43584857724e-06 1.2 1.43588033537e-06 1.2 1.4359120935e-06 1.2 1.43594385163e-06 1.2 1.43597560976e-06 1.2 1.43600736789e-06 1.2 1.43603912602e-06 1.2 1.43607088415e-06 1.2 1.43610264228e-06 1.2 1.43613440041e-06 1.2 1.43616615854e-06 1.2 1.43619791667e-06 1.2 1.4362296748e-06 1.2 1.43626143293e-06 1.2 1.43629319106e-06 1.2 1.43632494919e-06 1.2 1.43635670732e-06 1.2 1.43638846545e-06 1.2 1.43642022358e-06 1.2 1.43645198171e-06 1.2 1.43648373984e-06 1.2 1.43651549797e-06 1.2 1.4365472561e-06 1.2 1.43657901423e-06 1.2 1.43661077236e-06 1.2 1.43664253049e-06 1.2 1.43667428862e-06 1.2 1.43670604675e-06 1.2 1.43673780488e-06 1.2 1.43676956301e-06 1.2 1.43680132114e-06 1.2 1.43683307927e-06 1.2 1.4368648374e-06 1.2 1.43689659553e-06 1.2 1.43692835366e-06 1.2 1.43696011179e-06 1.2 1.43699186992e-06 1.2 1.43702362805e-06 1.2 1.43705538618e-06 1.2 1.43708714431e-06 1.2 1.43711890244e-06 1.2 1.43715066057e-06 1.2 1.4371824187e-06 1.2 1.43721417683e-06 1.2 1.43724593496e-06 1.2 1.43727769309e-06 1.2 1.43730945122e-06 1.2 1.43734120935e-06 1.2 1.43737296748e-06 1.2 1.43740472561e-06 1.2 1.43743648374e-06 1.2 1.43746824187e-06 1.2 1.4375e-06 1.2 1.43753175813e-06 1.2 1.43756351626e-06 1.2 1.43759527439e-06 1.2 1.43762703252e-06 1.2 1.43765879065e-06 1.2 1.43769054878e-06 1.2 1.43772230691e-06 1.2 1.43775406504e-06 1.2 1.43778582317e-06 1.2 1.4378175813e-06 1.2 1.43784933943e-06 1.2 1.43788109756e-06 1.2 1.43791285569e-06 1.2 1.43794461382e-06 1.2 1.43797637195e-06 1.2 1.43800813008e-06 1.2 1.43803988821e-06 1.2 1.43807164634e-06 1.2 1.43810340447e-06 1.2 1.4381351626e-06 1.2 1.43816692073e-06 1.2 1.43819867886e-06 1.2 1.43823043699e-06 1.2 1.43826219512e-06 1.2 1.43829395325e-06 1.2 1.43832571138e-06 1.2 1.43835746951e-06 1.2 1.43838922764e-06 1.2 1.43842098577e-06 1.2 1.4384527439e-06 1.2 1.43848450203e-06 1.2 1.43851626016e-06 1.2 1.43854801829e-06 1.2 1.43857977642e-06 1.2 1.43861153455e-06 1.2 1.43864329268e-06 1.2 1.43867505081e-06 1.2 1.43870680894e-06 1.2 1.43873856707e-06 1.2 1.4387703252e-06 1.2 1.43880208333e-06 1.2 1.43883384146e-06 1.2 1.43886559959e-06 1.2 1.43889735772e-06 1.2 1.43892911585e-06 1.2 1.43896087398e-06 1.2 1.43899263211e-06 1.2 1.43902439024e-06 1.2 1.43905614837e-06 1.2 1.4390879065e-06 1.2 1.43911966463e-06 1.2 1.43915142276e-06 1.2 1.43918318089e-06 1.2 1.43921493902e-06 1.2 1.43924669715e-06 1.2 1.43927845528e-06 1.2 1.43931021341e-06 1.2 1.43934197154e-06 1.2 1.43937372967e-06 1.2 1.4394054878e-06 1.2 1.43943724593e-06 1.2 1.43946900407e-06 1.2 1.4395007622e-06 1.2 1.43953252033e-06 1.2 1.43956427846e-06 1.2 1.43959603659e-06 1.2 1.43962779472e-06 1.2 1.43965955285e-06 1.2 1.43969131098e-06 1.2 1.43972306911e-06 1.2 1.43975482724e-06 1.2 1.43978658537e-06 1.2 1.4398183435e-06 1.2 1.43985010163e-06 1.2 1.43988185976e-06 1.2 1.43991361789e-06 1.2 1.43994537602e-06 1.2 1.43997713415e-06 1.2 1.44000889228e-06 1.2 1.44004065041e-06 1.2 1.44007240854e-06 1.2 1.44010416667e-06 1.2 1.4401359248e-06 1.2 1.44016768293e-06 1.2 1.44019944106e-06 1.2 1.44023119919e-06 1.2 1.44026295732e-06 1.2 1.44029471545e-06 1.2 1.44032647358e-06 1.2 1.44035823171e-06 1.2 1.44038998984e-06 1.2 1.44042174797e-06 1.2 1.4404535061e-06 1.2 1.44048526423e-06 1.2 1.44051702236e-06 1.2 1.44054878049e-06 1.2 1.44058053862e-06 1.2 1.44061229675e-06 1.2 1.44064405488e-06 1.2 1.44067581301e-06 1.2 1.44070757114e-06 1.2 1.44073932927e-06 1.2 1.4407710874e-06 1.2 1.44080284553e-06 1.2 1.44083460366e-06 1.2 1.44086636179e-06 1.2 1.44089811992e-06 1.2 1.44092987805e-06 1.2 1.44096163618e-06 1.2 1.44099339431e-06 1.2 1.44102515244e-06 1.2 1.44105691057e-06 1.2 1.4410886687e-06 1.2 1.44112042683e-06 1.2 1.44115218496e-06 1.2 1.44118394309e-06 1.2 1.44121570122e-06 1.2 1.44124745935e-06 1.2 1.44127921748e-06 1.2 1.44131097561e-06 1.2 1.44134273374e-06 1.2 1.44137449187e-06 1.2 1.44140625e-06 1.2 1.44143800813e-06 1.2 1.44146976626e-06 1.2 1.44150152439e-06 1.2 1.44153328252e-06 1.2 1.44156504065e-06 1.2 1.44159679878e-06 1.2 1.44162855691e-06 1.2 1.44166031504e-06 1.2 1.44169207317e-06 1.2 1.4417238313e-06 1.2 1.44175558943e-06 1.2 1.44178734756e-06 1.2 1.44181910569e-06 1.2 1.44185086382e-06 1.2 1.44188262195e-06 1.2 1.44191438008e-06 1.2 1.44194613821e-06 1.2 1.44197789634e-06 1.2 1.44200965447e-06 1.2 1.4420414126e-06 1.2 1.44207317073e-06 1.2 1.44210492886e-06 1.2 1.44213668699e-06 1.2 1.44216844512e-06 1.2 1.44220020325e-06 1.2 1.44223196138e-06 1.2 1.44226371951e-06 1.2 1.44229547764e-06 1.2 1.44232723577e-06 1.2 1.4423589939e-06 1.2 1.44239075203e-06 1.2 1.44242251016e-06 1.2 1.44245426829e-06 1.2 1.44248602642e-06 1.2 1.44251778455e-06 1.2 1.44254954268e-06 1.2 1.44258130081e-06 1.2 1.44261305894e-06 1.2 1.44264481707e-06 1.2 1.4426765752e-06 1.2 1.44270833333e-06 1.2 1.44274009146e-06 1.2 1.44277184959e-06 1.2 1.44280360772e-06 1.2 1.44283536585e-06 1.2 1.44286712398e-06 1.2 1.44289888211e-06 1.2 1.44293064024e-06 1.2 1.44296239837e-06 1.2 1.4429941565e-06 1.2 1.44302591463e-06 1.2 1.44305767276e-06 1.2 1.44308943089e-06 1.2 1.44312118902e-06 1.2 1.44315294715e-06 1.2 1.44318470528e-06 1.2 1.44321646341e-06 1.2 1.44324822154e-06 1.2 1.44327997967e-06 1.2 1.4433117378e-06 1.2 1.44334349593e-06 1.2 1.44337525407e-06 1.2 1.4434070122e-06 1.2 1.44343877033e-06 1.2 1.44347052846e-06 1.2 1.44350228659e-06 1.2 1.44353404472e-06 1.2 1.44356580285e-06 1.2 1.44359756098e-06 1.2 1.44362931911e-06 1.2 1.44366107724e-06 1.2 1.44369283537e-06 1.2 1.4437245935e-06 1.2 1.44375635163e-06 1.2 1.44378810976e-06 1.2 1.44381986789e-06 1.2 1.44385162602e-06 1.2 1.44388338415e-06 1.2 1.44391514228e-06 1.2 1.44394690041e-06 1.2 1.44397865854e-06 1.2 1.44401041667e-06 1.2 1.4440421748e-06 1.2 1.44407393293e-06 1.2 1.44410569106e-06 1.2 1.44413744919e-06 1.2 1.44416920732e-06 1.2 1.44420096545e-06 1.2 1.44423272358e-06 1.2 1.44426448171e-06 1.2 1.44429623984e-06 1.2 1.44432799797e-06 1.2 1.4443597561e-06 1.2 1.44439151423e-06 1.2 1.44442327236e-06 1.2 1.44445503049e-06 1.2 1.44448678862e-06 1.2 1.44451854675e-06 1.2 1.44455030488e-06 1.2 1.44458206301e-06 1.2 1.44461382114e-06 1.2 1.44464557927e-06 1.2 1.4446773374e-06 1.2 1.44470909553e-06 1.2 1.44474085366e-06 1.2 1.44477261179e-06 1.2 1.44480436992e-06 1.2 1.44483612805e-06 1.2 1.44486788618e-06 1.2 1.44489964431e-06 1.2 1.44493140244e-06 1.2 1.44496316057e-06 1.2 1.4449949187e-06 1.2 1.44502667683e-06 1.2 1.44505843496e-06 1.2 1.44509019309e-06 1.2 1.44512195122e-06 1.2 1.44515370935e-06 1.2 1.44518546748e-06 1.2 1.44521722561e-06 1.2 1.44524898374e-06 1.2 1.44528074187e-06 1.2 1.4453125e-06 1.2 1.44534425813e-06 1.2 1.44537601626e-06 1.2 1.44540777439e-06 1.2 1.44543953252e-06 1.2 1.44547129065e-06 1.2 1.44550304878e-06 1.2 1.44553480691e-06 1.2 1.44556656504e-06 1.2 1.44559832317e-06 1.2 1.4456300813e-06 1.2 1.44566183943e-06 1.2 1.44569359756e-06 1.2 1.44572535569e-06 1.2 1.44575711382e-06 1.2 1.44578887195e-06 1.2 1.44582063008e-06 1.2 1.44585238821e-06 1.2 1.44588414634e-06 1.2 1.44591590447e-06 1.2 1.4459476626e-06 1.2 1.44597942073e-06 1.2 1.44601117886e-06 1.2 1.44604293699e-06 1.2 1.44607469512e-06 1.2 1.44610645325e-06 1.2 1.44613821138e-06 1.2 1.44616996951e-06 1.2 1.44620172764e-06 1.2 1.44623348577e-06 1.2 1.4462652439e-06 1.2 1.44629700203e-06 1.2 1.44632876016e-06 1.2 1.44636051829e-06 1.2 1.44639227642e-06 1.2 1.44642403455e-06 1.2 1.44645579268e-06 1.2 1.44648755081e-06 1.2 1.44651930894e-06 1.2 1.44655106707e-06 1.2 1.4465828252e-06 1.2 1.44661458333e-06 1.2 1.44664634146e-06 1.2 1.44667809959e-06 1.2 1.44670985772e-06 1.2 1.44674161585e-06 1.2 1.44677337398e-06 1.2 1.44680513211e-06 1.2 1.44683689024e-06 1.2 1.44686864837e-06 1.2 1.4469004065e-06 1.2 1.44693216463e-06 1.2 1.44696392276e-06 1.2 1.44699568089e-06 1.2 1.44702743902e-06 1.2 1.44705919715e-06 1.2 1.44709095528e-06 1.2 1.44712271341e-06 1.2 1.44715447154e-06 1.2 1.44718622967e-06 1.2 1.4472179878e-06 1.2 1.44724974593e-06 1.2 1.44728150407e-06 1.2 1.4473132622e-06 1.2 1.44734502033e-06 1.2 1.44737677846e-06 1.2 1.44740853659e-06 1.2 1.44744029472e-06 1.2 1.44747205285e-06 1.2 1.44750381098e-06 1.2 1.44753556911e-06 1.2 1.44756732724e-06 1.2 1.44759908537e-06 1.2 1.4476308435e-06 1.2 1.44766260163e-06 1.2 1.44769435976e-06 1.2 1.44772611789e-06 1.2 1.44775787602e-06 1.2 1.44778963415e-06 1.2 1.44782139228e-06 1.2 1.44785315041e-06 1.2 1.44788490854e-06 1.2 1.44791666667e-06 1.2 1.4479484248e-06 1.2 1.44798018293e-06 1.2 1.44801194106e-06 1.2 1.44804369919e-06 1.2 1.44807545732e-06 1.2 1.44810721545e-06 1.2 1.44813897358e-06 1.2 1.44817073171e-06 1.2 1.44820248984e-06 1.2 1.44823424797e-06 1.2 1.4482660061e-06 1.2 1.44829776423e-06 1.2 1.44832952236e-06 1.2 1.44836128049e-06 1.2 1.44839303862e-06 1.2 1.44842479675e-06 1.2 1.44845655488e-06 1.2 1.44848831301e-06 1.2 1.44852007114e-06 1.2 1.44855182927e-06 1.2 1.4485835874e-06 1.2 1.44861534553e-06 1.2 1.44864710366e-06 1.2 1.44867886179e-06 1.2 1.44871061992e-06 1.2 1.44874237805e-06 1.2 1.44877413618e-06 1.2 1.44880589431e-06 1.2 1.44883765244e-06 1.2 1.44886941057e-06 1.2 1.4489011687e-06 1.2 1.44893292683e-06 1.2 1.44896468496e-06 1.2 1.44899644309e-06 1.2 1.44902820122e-06 1.2 1.44905995935e-06 1.2 1.44909171748e-06 1.2 1.44912347561e-06 1.2 1.44915523374e-06 1.2 1.44918699187e-06 1.2 1.44921875e-06 1.2 1.44925050813e-06 1.2 1.44928226626e-06 1.2 1.44931402439e-06 1.2 1.44934578252e-06 1.2 1.44937754065e-06 1.2 1.44940929878e-06 1.2 1.44944105691e-06 1.2 1.44947281504e-06 1.2 1.44950457317e-06 1.2 1.4495363313e-06 1.2 1.44956808943e-06 1.2 1.44959984756e-06 1.2 1.44963160569e-06 1.2 1.44966336382e-06 1.2 1.44969512195e-06 1.2 1.44972688008e-06 1.2 1.44975863821e-06 1.2 1.44979039634e-06 1.2 1.44982215447e-06 1.2 1.4498539126e-06 1.2 1.44988567073e-06 1.2 1.44991742886e-06 1.2 1.44994918699e-06 1.2 1.44998094512e-06 1.2 1.45001270325e-06 1.2 1.45004446138e-06 1.2 1.45007621951e-06 1.2 1.45010797764e-06 1.2 1.45013973577e-06 1.2 1.4501714939e-06 1.2 1.45020325203e-06 1.2 1.45023501016e-06 1.2 1.45026676829e-06 1.2 1.45029852642e-06 1.2 1.45033028455e-06 1.2 1.45036204268e-06 1.2 1.45039380081e-06 1.2 1.45042555894e-06 1.2 1.45045731707e-06 1.2 1.4504890752e-06 1.2 1.45052083333e-06 1.2 1.45055259146e-06 1.2 1.45058434959e-06 1.2 1.45061610772e-06 1.2 1.45064786585e-06 1.2 1.45067962398e-06 1.2 1.45071138211e-06 1.2 1.45074314024e-06 1.2 1.45077489837e-06 1.2 1.4508066565e-06 1.2 1.45083841463e-06 1.2 1.45087017276e-06 1.2 1.45090193089e-06 1.2 1.45093368902e-06 1.2 1.45096544715e-06 1.2 1.45099720528e-06 1.2 1.45102896341e-06 1.2 1.45106072154e-06 1.2 1.45109247967e-06 1.2 1.4511242378e-06 1.2 1.45115599593e-06 1.2 1.45118775407e-06 1.2 1.4512195122e-06 1.2 1.45125127033e-06 1.2 1.45128302846e-06 1.2 1.45131478659e-06 1.2 1.45134654472e-06 1.2 1.45137830285e-06 1.2 1.45141006098e-06 1.2 1.45144181911e-06 1.2 1.45147357724e-06 1.2 1.45150533537e-06 1.2 1.4515370935e-06 1.2 1.45156885163e-06 1.2 1.45160060976e-06 1.2 1.45163236789e-06 1.2 1.45166412602e-06 1.2 1.45169588415e-06 1.2 1.45172764228e-06 1.2 1.45175940041e-06 1.2 1.45179115854e-06 1.2 1.45182291667e-06 1.2 1.4518546748e-06 1.2 1.45188643293e-06 1.2 1.45191819106e-06 1.2 1.45194994919e-06 1.2 1.45198170732e-06 1.2 1.45201346545e-06 1.2 1.45204522358e-06 1.2 1.45207698171e-06 1.2 1.45210873984e-06 1.2 1.45214049797e-06 1.2 1.4521722561e-06 1.2 1.45220401423e-06 1.2 1.45223577236e-06 1.2 1.45226753049e-06 1.2 1.45229928862e-06 1.2 1.45233104675e-06 1.2 1.45236280488e-06 1.2 1.45239456301e-06 1.2 1.45242632114e-06 1.2 1.45245807927e-06 1.2 1.4524898374e-06 1.2 1.45252159553e-06 1.2 1.45255335366e-06 1.2 1.45258511179e-06 1.2 1.45261686992e-06 1.2 1.45264862805e-06 1.2 1.45268038618e-06 1.2 1.45271214431e-06 1.2 1.45274390244e-06 1.2 1.45277566057e-06 1.2 1.4528074187e-06 1.2 1.45283917683e-06 1.2 1.45287093496e-06 1.2 1.45290269309e-06 1.2 1.45293445122e-06 1.2 1.45296620935e-06 1.2 1.45299796748e-06 1.2 1.45302972561e-06 1.2 1.45306148374e-06 1.2 1.45309324187e-06 1.2 1.453125e-06 1.2 1.45315675813e-06 1.2 1.45318851626e-06 1.2 1.45322027439e-06 1.2 1.45325203252e-06 1.2 1.45328379065e-06 1.2 1.45331554878e-06 1.2 1.45334730691e-06 1.2 1.45337906504e-06 1.2 1.45341082317e-06 1.2 1.4534425813e-06 1.2 1.45347433943e-06 1.2 1.45350609756e-06 1.2 1.45353785569e-06 1.2 1.45356961382e-06 1.2 1.45360137195e-06 1.2 1.45363313008e-06 1.2 1.45366488821e-06 1.2 1.45369664634e-06 1.2 1.45372840447e-06 1.2 1.4537601626e-06 1.2 1.45379192073e-06 1.2 1.45382367886e-06 1.2 1.45385543699e-06 1.2 1.45388719512e-06 1.2 1.45391895325e-06 1.2 1.45395071138e-06 1.2 1.45398246951e-06 1.2 1.45401422764e-06 1.2 1.45404598577e-06 1.2 1.4540777439e-06 1.2 1.45410950203e-06 1.2 1.45414126016e-06 1.2 1.45417301829e-06 1.2 1.45420477642e-06 1.2 1.45423653455e-06 1.2 1.45426829268e-06 1.2 1.45430005081e-06 1.2 1.45433180894e-06 1.2 1.45436356707e-06 1.2 1.4543953252e-06 1.2 1.45442708333e-06 1.2 1.45445884146e-06 1.2 1.45449059959e-06 1.2 1.45452235772e-06 1.2 1.45455411585e-06 1.2 1.45458587398e-06 1.2 1.45461763211e-06 1.2 1.45464939024e-06 1.2 1.45468114837e-06 1.2 1.4547129065e-06 1.2 1.45474466463e-06 1.2 1.45477642276e-06 1.2 1.45480818089e-06 1.2 1.45483993902e-06 1.2 1.45487169715e-06 1.2 1.45490345528e-06 1.2 1.45493521341e-06 1.2 1.45496697154e-06 1.2 1.45499872967e-06 1.2 1.4550304878e-06 1.2 1.45506224593e-06 1.2 1.45509400407e-06 1.2 1.4551257622e-06 1.2 1.45515752033e-06 1.2 1.45518927846e-06 1.2 1.45522103659e-06 1.2 1.45525279472e-06 1.2 1.45528455285e-06 1.2 1.45531631098e-06 1.2 1.45534806911e-06 1.2 1.45537982724e-06 1.2 1.45541158537e-06 1.2 1.4554433435e-06 1.2 1.45547510163e-06 1.2 1.45550685976e-06 1.2 1.45553861789e-06 1.2 1.45557037602e-06 1.2 1.45560213415e-06 1.2 1.45563389228e-06 1.2 1.45566565041e-06 1.2 1.45569740854e-06 1.2 1.45572916667e-06 1.2 1.4557609248e-06 1.2 1.45579268293e-06 1.2 1.45582444106e-06 1.2 1.45585619919e-06 1.2 1.45588795732e-06 1.2 1.45591971545e-06 1.2 1.45595147358e-06 1.2 1.45598323171e-06 1.2 1.45601498984e-06 1.2 1.45604674797e-06 1.2 1.4560785061e-06 1.2 1.45611026423e-06 1.2 1.45614202236e-06 1.2 1.45617378049e-06 1.2 1.45620553862e-06 1.2 1.45623729675e-06 1.2 1.45626905488e-06 1.2 1.45630081301e-06 1.2 1.45633257114e-06 1.2 1.45636432927e-06 1.2 1.4563960874e-06 1.2 1.45642784553e-06 1.2 1.45645960366e-06 1.2 1.45649136179e-06 1.2 1.45652311992e-06 1.2 1.45655487805e-06 1.2 1.45658663618e-06 1.2 1.45661839431e-06 1.2 1.45665015244e-06 1.2 1.45668191057e-06 1.2 1.4567136687e-06 1.2 1.45674542683e-06 1.2 1.45677718496e-06 1.2 1.45680894309e-06 1.2 1.45684070122e-06 1.2 1.45687245935e-06 1.2 1.45690421748e-06 1.2 1.45693597561e-06 1.2 1.45696773374e-06 1.2 1.45699949187e-06 1.2 1.45703125e-06 1.2 1.45706300813e-06 1.2 1.45709476626e-06 1.2 1.45712652439e-06 1.2 1.45715828252e-06 1.2 1.45719004065e-06 1.2 1.45722179878e-06 1.2 1.45725355691e-06 1.2 1.45728531504e-06 1.2 1.45731707317e-06 1.2 1.4573488313e-06 1.2 1.45738058943e-06 1.2 1.45741234756e-06 1.2 1.45744410569e-06 1.2 1.45747586382e-06 1.2 1.45750762195e-06 1.2 1.45753938008e-06 1.2 1.45757113821e-06 1.2 1.45760289634e-06 1.2 1.45763465447e-06 1.2 1.4576664126e-06 1.2 1.45769817073e-06 1.2 1.45772992886e-06 1.2 1.45776168699e-06 1.2 1.45779344512e-06 1.2 1.45782520325e-06 1.2 1.45785696138e-06 1.2 1.45788871951e-06 1.2 1.45792047764e-06 1.2 1.45795223577e-06 1.2 1.4579839939e-06 1.2 1.45801575203e-06 1.2 1.45804751016e-06 1.2 1.45807926829e-06 1.2 1.45811102642e-06 1.2 1.45814278455e-06 1.2 1.45817454268e-06 1.2 1.45820630081e-06 1.2 1.45823805894e-06 1.2 1.45826981707e-06 1.2 1.4583015752e-06 1.2 1.45833333333e-06 1.2 1.45836509146e-06 1.2 1.45839684959e-06 1.2 1.45842860772e-06 1.2 1.45846036585e-06 1.2 1.45849212398e-06 1.2 1.45852388211e-06 1.2 1.45855564024e-06 1.2 1.45858739837e-06 1.2 1.4586191565e-06 1.2 1.45865091463e-06 1.2 1.45868267276e-06 1.2 1.45871443089e-06 1.2 1.45874618902e-06 1.2 1.45877794715e-06 1.2 1.45880970528e-06 1.2 1.45884146341e-06 1.2 1.45887322154e-06 1.2 1.45890497967e-06 1.2 1.4589367378e-06 1.2 1.45896849593e-06 1.2 1.45900025407e-06 1.2 1.4590320122e-06 1.2 1.45906377033e-06 1.2 1.45909552846e-06 1.2 1.45912728659e-06 1.2 1.45915904472e-06 1.2 1.45919080285e-06 1.2 1.45922256098e-06 1.2 1.45925431911e-06 1.2 1.45928607724e-06 1.2 1.45931783537e-06 1.2 1.4593495935e-06 1.2 1.45938135163e-06 1.2 1.45941310976e-06 1.2 1.45944486789e-06 1.2 1.45947662602e-06 1.2 1.45950838415e-06 1.2 1.45954014228e-06 1.2 1.45957190041e-06 1.2 1.45960365854e-06 1.2 1.45963541667e-06 1.2 1.4596671748e-06 1.2 1.45969893293e-06 1.2 1.45973069106e-06 1.2 1.45976244919e-06 1.2 1.45979420732e-06 1.2 1.45982596545e-06 1.2 1.45985772358e-06 1.2 1.45988948171e-06 1.2 1.45992123984e-06 1.2 1.45995299797e-06 1.2 1.4599847561e-06 1.2 1.46001651423e-06 1.2 1.46004827236e-06 1.2 1.46008003049e-06 1.2 1.46011178862e-06 1.2 1.46014354675e-06 1.2 1.46017530488e-06 1.2 1.46020706301e-06 1.2 1.46023882114e-06 1.2 1.46027057927e-06 1.2 1.4603023374e-06 1.2 1.46033409553e-06 1.2 1.46036585366e-06 1.2 1.46039761179e-06 1.2 1.46042936992e-06 1.2 1.46046112805e-06 1.2 1.46049288618e-06 1.2 1.46052464431e-06 1.2 1.46055640244e-06 1.2 1.46058816057e-06 1.2 1.4606199187e-06 1.2 1.46065167683e-06 1.2 1.46068343496e-06 1.2 1.46071519309e-06 1.2 1.46074695122e-06 1.2 1.46077870935e-06 1.2 1.46081046748e-06 1.2 1.46084222561e-06 1.2 1.46087398374e-06 1.2 1.46090574187e-06 1.2 1.4609375e-06 1.2 1.46096925813e-06 1.2 1.46100101626e-06 1.2 1.46103277439e-06 1.2 1.46106453252e-06 1.2 1.46109629065e-06 1.2 1.46112804878e-06 1.2 1.46115980691e-06 1.2 1.46119156504e-06 1.2 1.46122332317e-06 1.2 1.4612550813e-06 1.2 1.46128683943e-06 1.2 1.46131859756e-06 1.2 1.46135035569e-06 1.2 1.46138211382e-06 1.2 1.46141387195e-06 1.2 1.46144563008e-06 1.2 1.46147738821e-06 1.2 1.46150914634e-06 1.2 1.46154090447e-06 1.2 1.4615726626e-06 1.2 1.46160442073e-06 1.2 1.46163617886e-06 1.2 1.46166793699e-06 1.2 1.46169969512e-06 1.2 1.46173145325e-06 1.2 1.46176321138e-06 1.2 1.46179496951e-06 1.2 1.46182672764e-06 1.2 1.46185848577e-06 1.2 1.4618902439e-06 1.2 1.46192200203e-06 1.2 1.46195376016e-06 1.2 1.46198551829e-06 1.2 1.46201727642e-06 1.2 1.46204903455e-06 1.2 1.46208079268e-06 1.2 1.46211255081e-06 1.2 1.46214430894e-06 1.2 1.46217606707e-06 1.2 1.4622078252e-06 1.2 1.46223958333e-06 1.2 1.46227134146e-06 1.2 1.46230309959e-06 1.2 1.46233485772e-06 1.2 1.46236661585e-06 1.2 1.46239837398e-06 1.2 1.46243013211e-06 1.2 1.46246189024e-06 1.2 1.46249364837e-06 1.2 1.4625254065e-06 1.2 1.46255716463e-06 1.2 1.46258892276e-06 1.2 1.46262068089e-06 1.2 1.46265243902e-06 1.2 1.46268419715e-06 1.2 1.46271595528e-06 1.2 1.46274771341e-06 1.2 1.46277947154e-06 1.2 1.46281122967e-06 1.2 1.4628429878e-06 1.2 1.46287474593e-06 1.2 1.46290650407e-06 1.2 1.4629382622e-06 1.2 1.46297002033e-06 1.2 1.46300177846e-06 1.2 1.46303353659e-06 1.2 1.46306529472e-06 1.2 1.46309705285e-06 1.2 1.46312881098e-06 1.2 1.46316056911e-06 1.2 1.46319232724e-06 1.2 1.46322408537e-06 1.2 1.4632558435e-06 1.2 1.46328760163e-06 1.2 1.46331935976e-06 1.2 1.46335111789e-06 1.2 1.46338287602e-06 1.2 1.46341463415e-06 1.2 1.46344639228e-06 1.2 1.46347815041e-06 1.2 1.46350990854e-06 1.2 1.46354166667e-06 1.2 1.4635734248e-06 1.2 1.46360518293e-06 1.2 1.46363694106e-06 1.2 1.46366869919e-06 1.2 1.46370045732e-06 1.2 1.46373221545e-06 1.2 1.46376397358e-06 1.2 1.46379573171e-06 1.2 1.46382748984e-06 1.2 1.46385924797e-06 1.2 1.4638910061e-06 1.2 1.46392276423e-06 1.2 1.46395452236e-06 1.2 1.46398628049e-06 1.2 1.46401803862e-06 1.2 1.46404979675e-06 1.2 1.46408155488e-06 1.2 1.46411331301e-06 1.2 1.46414507114e-06 1.2 1.46417682927e-06 1.2 1.4642085874e-06 1.2 1.46424034553e-06 1.2 1.46427210366e-06 1.2 1.46430386179e-06 1.2 1.46433561992e-06 1.2 1.46436737805e-06 1.2 1.46439913618e-06 1.2 1.46443089431e-06 1.2 1.46446265244e-06 1.2 1.46449441057e-06 1.2 1.4645261687e-06 1.2 1.46455792683e-06 1.2 1.46458968496e-06 1.2 1.46462144309e-06 1.2 1.46465320122e-06 1.2 1.46468495935e-06 1.2 1.46471671748e-06 1.2 1.46474847561e-06 1.2 1.46478023374e-06 1.2 1.46481199187e-06 1.2 1.46484375e-06 1.2 1.46487550813e-06 1.2 1.46490726626e-06 1.2 1.46493902439e-06 1.2 1.46497078252e-06 1.2 1.46500254065e-06 1.2 1.46503429878e-06 1.2 1.46506605691e-06 1.2 1.46509781504e-06 1.2 1.46512957317e-06 1.2 1.4651613313e-06 1.2 1.46519308943e-06 1.2 1.46522484756e-06 1.2 1.46525660569e-06 1.2 1.46528836382e-06 1.2 1.46532012195e-06 1.2 1.46535188008e-06 1.2 1.46538363821e-06 1.2 1.46541539634e-06 1.2 1.46544715447e-06 1.2 1.4654789126e-06 1.2 1.46551067073e-06 1.2 1.46554242886e-06 1.2 1.46557418699e-06 1.2 1.46560594512e-06 1.2 1.46563770325e-06 1.2 1.46566946138e-06 1.2 1.46570121951e-06 1.2 1.46573297764e-06 1.2 1.46576473577e-06 1.2 1.4657964939e-06 1.2 1.46582825203e-06 1.2 1.46586001016e-06 1.2 1.46589176829e-06 1.2 1.46592352642e-06 1.2 1.46595528455e-06 1.2 1.46598704268e-06 1.2 1.46601880081e-06 1.2 1.46605055894e-06 1.2 1.46608231707e-06 1.2 1.4661140752e-06 1.2 1.46614583333e-06 1.2 1.46617759146e-06 1.2 1.46620934959e-06 1.2 1.46624110772e-06 1.2 1.46627286585e-06 1.2 1.46630462398e-06 1.2 1.46633638211e-06 1.2 1.46636814024e-06 1.2 1.46639989837e-06 1.2 1.4664316565e-06 1.2 1.46646341463e-06 1.2 1.46649517276e-06 1.2 1.46652693089e-06 1.2 1.46655868902e-06 1.2 1.46659044715e-06 1.2 1.46662220528e-06 1.2 1.46665396341e-06 1.2 1.46668572154e-06 1.2 1.46671747967e-06 1.2 1.4667492378e-06 1.2 1.46678099593e-06 1.2 1.46681275407e-06 1.2 1.4668445122e-06 1.2 1.46687627033e-06 1.2 1.46690802846e-06 1.2 1.46693978659e-06 1.2 1.46697154472e-06 1.2 1.46700330285e-06 1.2 1.46703506098e-06 1.2 1.46706681911e-06 1.2 1.46709857724e-06 1.2 1.46713033537e-06 1.2 1.4671620935e-06 1.2 1.46719385163e-06 1.2 1.46722560976e-06 1.2 1.46725736789e-06 1.2 1.46728912602e-06 1.2 1.46732088415e-06 1.2 1.46735264228e-06 1.2 1.46738440041e-06 1.2 1.46741615854e-06 1.2 1.46744791667e-06 1.2 1.4674796748e-06 1.2 1.46751143293e-06 1.2 1.46754319106e-06 1.2 1.46757494919e-06 1.2 1.46760670732e-06 1.2 1.46763846545e-06 1.2 1.46767022358e-06 1.2 1.46770198171e-06 1.2 1.46773373984e-06 1.2 1.46776549797e-06 1.2 1.4677972561e-06 1.2 1.46782901423e-06 1.2 1.46786077236e-06 1.2 1.46789253049e-06 1.2 1.46792428862e-06 1.2 1.46795604675e-06 1.2 1.46798780488e-06 1.2 1.46801956301e-06 1.2 1.46805132114e-06 1.2 1.46808307927e-06 1.2 1.4681148374e-06 1.2 1.46814659553e-06 1.2 1.46817835366e-06 1.2 1.46821011179e-06 1.2 1.46824186992e-06 1.2 1.46827362805e-06 1.2 1.46830538618e-06 1.2 1.46833714431e-06 1.2 1.46836890244e-06 1.2 1.46840066057e-06 1.2 1.4684324187e-06 1.2 1.46846417683e-06 1.2 1.46849593496e-06 1.2 1.46852769309e-06 1.2 1.46855945122e-06 1.2 1.46859120935e-06 1.2 1.46862296748e-06 1.2 1.46865472561e-06 1.2 1.46868648374e-06 1.2 1.46871824187e-06 1.2 1.46875e-06 1.2 1.46878175813e-06 1.2 1.46881351626e-06 1.2 1.46884527439e-06 1.2 1.46887703252e-06 1.2 1.46890879065e-06 1.2 1.46894054878e-06 1.2 1.46897230691e-06 1.2 1.46900406504e-06 1.2 1.46903582317e-06 1.2 1.4690675813e-06 1.2 1.46909933943e-06 1.2 1.46913109756e-06 1.2 1.46916285569e-06 1.2 1.46919461382e-06 1.2 1.46922637195e-06 1.2 1.46925813008e-06 1.2 1.46928988821e-06 1.2 1.46932164634e-06 1.2 1.46935340447e-06 1.2 1.4693851626e-06 1.2 1.46941692073e-06 1.2 1.46944867886e-06 1.2 1.46948043699e-06 1.2 1.46951219512e-06 1.2 1.46954395325e-06 1.2 1.46957571138e-06 1.2 1.46960746951e-06 1.2 1.46963922764e-06 1.2 1.46967098577e-06 1.2 1.4697027439e-06 1.2 1.46973450203e-06 1.2 1.46976626016e-06 1.2 1.46979801829e-06 1.2 1.46982977642e-06 1.2 1.46986153455e-06 1.2 1.46989329268e-06 1.2 1.46992505081e-06 1.2 1.46995680894e-06 1.2 1.46998856707e-06 1.2 1.4700203252e-06 1.2 1.47005208333e-06 1.2 1.47008384146e-06 1.2 1.47011559959e-06 1.2 1.47014735772e-06 1.2 1.47017911585e-06 1.2 1.47021087398e-06 1.2 1.47024263211e-06 1.2 1.47027439024e-06 1.2 1.47030614837e-06 1.2 1.4703379065e-06 1.2 1.47036966463e-06 1.2 1.47040142276e-06 1.2 1.47043318089e-06 1.2 1.47046493902e-06 1.2 1.47049669715e-06 1.2 1.47052845528e-06 1.2 1.47056021341e-06 1.2 1.47059197154e-06 1.2 1.47062372967e-06 1.2 1.4706554878e-06 1.2 1.47068724593e-06 1.2 1.47071900407e-06 1.2 1.4707507622e-06 1.2 1.47078252033e-06 1.2 1.47081427846e-06 1.2 1.47084603659e-06 1.2 1.47087779472e-06 1.2 1.47090955285e-06 1.2 1.47094131098e-06 1.2 1.47097306911e-06 1.2 1.47100482724e-06 1.2 1.47103658537e-06 1.2 1.4710683435e-06 1.2 1.47110010163e-06 1.2 1.47113185976e-06 1.2 1.47116361789e-06 1.2 1.47119537602e-06 1.2 1.47122713415e-06 1.2 1.47125889228e-06 1.2 1.47129065041e-06 1.2 1.47132240854e-06 1.2 1.47135416667e-06 1.2 1.4713859248e-06 1.2 1.47141768293e-06 1.2 1.47144944106e-06 1.2 1.47148119919e-06 1.2 1.47151295732e-06 1.2 1.47154471545e-06 1.2 1.47157647358e-06 1.2 1.47160823171e-06 1.2 1.47163998984e-06 1.2 1.47167174797e-06 1.2 1.4717035061e-06 1.2 1.47173526423e-06 1.2 1.47176702236e-06 1.2 1.47179878049e-06 1.2 1.47183053862e-06 1.2 1.47186229675e-06 1.2 1.47189405488e-06 1.2 1.47192581301e-06 1.2 1.47195757114e-06 1.2 1.47198932927e-06 1.2 1.4720210874e-06 1.2 1.47205284553e-06 1.2 1.47208460366e-06 1.2 1.47211636179e-06 1.2 1.47214811992e-06 1.2 1.47217987805e-06 1.2 1.47221163618e-06 1.2 1.47224339431e-06 1.2 1.47227515244e-06 1.2 1.47230691057e-06 1.2 1.4723386687e-06 1.2 1.47237042683e-06 1.2 1.47240218496e-06 1.2 1.47243394309e-06 1.2 1.47246570122e-06 1.2 1.47249745935e-06 1.2 1.47252921748e-06 1.2 1.47256097561e-06 1.2 1.47259273374e-06 1.2 1.47262449187e-06 1.2 1.47265625e-06 1.2 1.47268800813e-06 1.2 1.47271976626e-06 1.2 1.47275152439e-06 1.2 1.47278328252e-06 1.2 1.47281504065e-06 1.2 1.47284679878e-06 1.2 1.47287855691e-06 1.2 1.47291031504e-06 1.2 1.47294207317e-06 1.2 1.4729738313e-06 1.2 1.47300558943e-06 1.2 1.47303734756e-06 1.2 1.47306910569e-06 1.2 1.47310086382e-06 1.2 1.47313262195e-06 1.2 1.47316438008e-06 1.2 1.47319613821e-06 1.2 1.47322789634e-06 1.2 1.47325965447e-06 1.2 1.4732914126e-06 1.2 1.47332317073e-06 1.2 1.47335492886e-06 1.2 1.47338668699e-06 1.2 1.47341844512e-06 1.2 1.47345020325e-06 1.2 1.47348196138e-06 1.2 1.47351371951e-06 1.2 1.47354547764e-06 1.2 1.47357723577e-06 1.2 1.4736089939e-06 1.2 1.47364075203e-06 1.2 1.47367251016e-06 1.2 1.47370426829e-06 1.2 1.47373602642e-06 1.2 1.47376778455e-06 1.2 1.47379954268e-06 1.2 1.47383130081e-06 1.2 1.47386305894e-06 1.2 1.47389481707e-06 1.2 1.4739265752e-06 1.2 1.47395833333e-06 1.2 1.47399009146e-06 1.2 1.47402184959e-06 1.2 1.47405360772e-06 1.2 1.47408536585e-06 1.2 1.47411712398e-06 1.2 1.47414888211e-06 1.2 1.47418064024e-06 1.2 1.47421239837e-06 1.2 1.4742441565e-06 1.2 1.47427591463e-06 1.2 1.47430767276e-06 1.2 1.47433943089e-06 1.2 1.47437118902e-06 1.2 1.47440294715e-06 1.2 1.47443470528e-06 1.2 1.47446646341e-06 1.2 1.47449822154e-06 1.2 1.47452997967e-06 1.2 1.4745617378e-06 1.2 1.47459349593e-06 1.2 1.47462525407e-06 1.2 1.4746570122e-06 1.2 1.47468877033e-06 1.2 1.47472052846e-06 1.2 1.47475228659e-06 1.2 1.47478404472e-06 1.2 1.47481580285e-06 1.2 1.47484756098e-06 1.2 1.47487931911e-06 1.2 1.47491107724e-06 1.2 1.47494283537e-06 1.2 1.4749745935e-06 1.2 1.47500635163e-06 1.2 1.47503810976e-06 1.2 1.47506986789e-06 1.2 1.47510162602e-06 1.2 1.47513338415e-06 1.2 1.47516514228e-06 1.2 1.47519690041e-06 1.2 1.47522865854e-06 1.2 1.47526041667e-06 1.2 1.4752921748e-06 1.2 1.47532393293e-06 1.2 1.47535569106e-06 1.2 1.47538744919e-06 1.2 1.47541920732e-06 1.2 1.47545096545e-06 1.2 1.47548272358e-06 1.2 1.47551448171e-06 1.2 1.47554623984e-06 1.2 1.47557799797e-06 1.2 1.4756097561e-06 1.2 1.47564151423e-06 1.2 1.47567327236e-06 1.2 1.47570503049e-06 1.2 1.47573678862e-06 1.2 1.47576854675e-06 1.2 1.47580030488e-06 1.2 1.47583206301e-06 1.2 1.47586382114e-06 1.2 1.47589557927e-06 1.2 1.4759273374e-06 1.2 1.47595909553e-06 1.2 1.47599085366e-06 1.2 1.47602261179e-06 1.2 1.47605436992e-06 1.2 1.47608612805e-06 1.2 1.47611788618e-06 1.2 1.47614964431e-06 1.2 1.47618140244e-06 1.2 1.47621316057e-06 1.2 1.4762449187e-06 1.2 1.47627667683e-06 1.2 1.47630843496e-06 1.2 1.47634019309e-06 1.2 1.47637195122e-06 1.2 1.47640370935e-06 1.2 1.47643546748e-06 1.2 1.47646722561e-06 1.2 1.47649898374e-06 1.2 1.47653074187e-06 1.2 1.4765625e-06 1.2 1.47659425813e-06 1.2 1.47662601626e-06 1.2 1.47665777439e-06 1.2 1.47668953252e-06 1.2 1.47672129065e-06 1.2 1.47675304878e-06 1.2 1.47678480691e-06 1.2 1.47681656504e-06 1.2 1.47684832317e-06 1.2 1.4768800813e-06 1.2 1.47691183943e-06 1.2 1.47694359756e-06 1.2 1.47697535569e-06 1.2 1.47700711382e-06 1.2 1.47703887195e-06 1.2 1.47707063008e-06 1.2 1.47710238821e-06 1.2 1.47713414634e-06 1.2 1.47716590447e-06 1.2 1.4771976626e-06 1.2 1.47722942073e-06 1.2 1.47726117886e-06 1.2 1.47729293699e-06 1.2 1.47732469512e-06 1.2 1.47735645325e-06 1.2 1.47738821138e-06 1.2 1.47741996951e-06 1.2 1.47745172764e-06 1.2 1.47748348577e-06 1.2 1.4775152439e-06 1.2 1.47754700203e-06 1.2 1.47757876016e-06 1.2 1.47761051829e-06 1.2 1.47764227642e-06 1.2 1.47767403455e-06 1.2 1.47770579268e-06 1.2 1.47773755081e-06 1.2 1.47776930894e-06 1.2 1.47780106707e-06 1.2 1.4778328252e-06 1.2 1.47786458333e-06 1.2 1.47789634146e-06 1.2 1.47792809959e-06 1.2 1.47795985772e-06 1.2 1.47799161585e-06 1.2 1.47802337398e-06 1.2 1.47805513211e-06 1.2 1.47808689024e-06 1.2 1.47811864837e-06 1.2 1.4781504065e-06 1.2 1.47818216463e-06 1.2 1.47821392276e-06 1.2 1.47824568089e-06 1.2 1.47827743902e-06 1.2 1.47830919715e-06 1.2 1.47834095528e-06 1.2 1.47837271341e-06 1.2 1.47840447154e-06 1.2 1.47843622967e-06 1.2 1.4784679878e-06 1.2 1.47849974593e-06 1.2 1.47853150407e-06 1.2 1.4785632622e-06 1.2 1.47859502033e-06 1.2 1.47862677846e-06 1.2 1.47865853659e-06 1.2 1.47869029472e-06 1.2 1.47872205285e-06 1.2 1.47875381098e-06 1.2 1.47878556911e-06 1.2 1.47881732724e-06 1.2 1.47884908537e-06 1.2 1.4788808435e-06 1.2 1.47891260163e-06 1.2 1.47894435976e-06 1.2 1.47897611789e-06 1.2 1.47900787602e-06 1.2 1.47903963415e-06 1.2 1.47907139228e-06 1.2 1.47910315041e-06 1.2 1.47913490854e-06 1.2 1.47916666667e-06 1.2 1.4791984248e-06 1.2 1.47923018293e-06 1.2 1.47926194106e-06 1.2 1.47929369919e-06 1.2 1.47932545732e-06 1.2 1.47935721545e-06 1.2 1.47938897358e-06 1.2 1.47942073171e-06 1.2 1.47945248984e-06 1.2 1.47948424797e-06 1.2 1.4795160061e-06 1.2 1.47954776423e-06 1.2 1.47957952236e-06 1.2 1.47961128049e-06 1.2 1.47964303862e-06 1.2 1.47967479675e-06 1.2 1.47970655488e-06 1.2 1.47973831301e-06 1.2 1.47977007114e-06 1.2 1.47980182927e-06 1.2 1.4798335874e-06 1.2 1.47986534553e-06 1.2 1.47989710366e-06 1.2 1.47992886179e-06 1.2 1.47996061992e-06 1.2 1.47999237805e-06 1.2 1.48002413618e-06 1.2 1.48005589431e-06 1.2 1.48008765244e-06 1.2 1.48011941057e-06 1.2 1.4801511687e-06 1.2 1.48018292683e-06 1.2 1.48021468496e-06 1.2 1.48024644309e-06 1.2 1.48027820122e-06 1.2 1.48030995935e-06 1.2 1.48034171748e-06 1.2 1.48037347561e-06 1.2 1.48040523374e-06 1.2 1.48043699187e-06 1.2 1.48046875e-06 1.2 1.48050050813e-06 1.2 1.48053226626e-06 1.2 1.48056402439e-06 1.2 1.48059578252e-06 1.2 1.48062754065e-06 1.2 1.48065929878e-06 1.2 1.48069105691e-06 1.2 1.48072281504e-06 1.2 1.48075457317e-06 1.2 1.4807863313e-06 1.2 1.48081808943e-06 1.2 1.48084984756e-06 1.2 1.48088160569e-06 1.2 1.48091336382e-06 1.2 1.48094512195e-06 1.2 1.48097688008e-06 1.2 1.48100863821e-06 1.2 1.48104039634e-06 1.2 1.48107215447e-06 1.2 1.4811039126e-06 1.2 1.48113567073e-06 1.2 1.48116742886e-06 1.2 1.48119918699e-06 1.2 1.48123094512e-06 1.2 1.48126270325e-06 1.2 1.48129446138e-06 1.2 1.48132621951e-06 1.2 1.48135797764e-06 1.2 1.48138973577e-06 1.2 1.4814214939e-06 1.2 1.48145325203e-06 1.2 1.48148501016e-06 1.2 1.48151676829e-06 1.2 1.48154852642e-06 1.2 1.48158028455e-06 1.2 1.48161204268e-06 1.2 1.48164380081e-06 1.2 1.48167555894e-06 1.2 1.48170731707e-06 1.2 1.4817390752e-06 1.2 1.48177083333e-06 1.2 1.48180259146e-06 1.2 1.48183434959e-06 1.2 1.48186610772e-06 1.2 1.48189786585e-06 1.2 1.48192962398e-06 1.2 1.48196138211e-06 1.2 1.48199314024e-06 1.2 1.48202489837e-06 1.2 1.4820566565e-06 1.2 1.48208841463e-06 1.2 1.48212017276e-06 1.2 1.48215193089e-06 1.2 1.48218368902e-06 1.2 1.48221544715e-06 1.2 1.48224720528e-06 1.2 1.48227896341e-06 1.2 1.48231072154e-06 1.2 1.48234247967e-06 1.2 1.4823742378e-06 1.2 1.48240599593e-06 1.2 1.48243775407e-06 1.2 1.4824695122e-06 1.2 1.48250127033e-06 1.2 1.48253302846e-06 1.2 1.48256478659e-06 1.2 1.48259654472e-06 1.2 1.48262830285e-06 1.2 1.48266006098e-06 1.2 1.48269181911e-06 1.2 1.48272357724e-06 1.2 1.48275533537e-06 1.2 1.4827870935e-06 1.2 1.48281885163e-06 1.2 1.48285060976e-06 1.2 1.48288236789e-06 1.2 1.48291412602e-06 1.2 1.48294588415e-06 1.2 1.48297764228e-06 1.2 1.48300940041e-06 1.2 1.48304115854e-06 1.2 1.48307291667e-06 1.2 1.4831046748e-06 1.2 1.48313643293e-06 1.2 1.48316819106e-06 1.2 1.48319994919e-06 1.2 1.48323170732e-06 1.2 1.48326346545e-06 1.2 1.48329522358e-06 1.2 1.48332698171e-06 1.2 1.48335873984e-06 1.2 1.48339049797e-06 1.2 1.4834222561e-06 1.2 1.48345401423e-06 1.2 1.48348577236e-06 1.2 1.48351753049e-06 1.2 1.48354928862e-06 1.2 1.48358104675e-06 1.2 1.48361280488e-06 1.2 1.48364456301e-06 1.2 1.48367632114e-06 1.2 1.48370807927e-06 1.2 1.4837398374e-06 1.2 1.48377159553e-06 1.2 1.48380335366e-06 1.2 1.48383511179e-06 1.2 1.48386686992e-06 1.2 1.48389862805e-06 1.2 1.48393038618e-06 1.2 1.48396214431e-06 1.2 1.48399390244e-06 1.2 1.48402566057e-06 1.2 1.4840574187e-06 1.2 1.48408917683e-06 1.2 1.48412093496e-06 1.2 1.48415269309e-06 1.2 1.48418445122e-06 1.2 1.48421620935e-06 1.2 1.48424796748e-06 1.2 1.48427972561e-06 1.2 1.48431148374e-06 1.2 1.48434324187e-06 1.2 1.484375e-06 1.2 1.48440675813e-06 1.2 1.48443851626e-06 1.2 1.48447027439e-06 1.2 1.48450203252e-06 1.2 1.48453379065e-06 1.2 1.48456554878e-06 1.2 1.48459730691e-06 1.2 1.48462906504e-06 1.2 1.48466082317e-06 1.2 1.4846925813e-06 1.2 1.48472433943e-06 1.2 1.48475609756e-06 1.2 1.48478785569e-06 1.2 1.48481961382e-06 1.2 1.48485137195e-06 1.2 1.48488313008e-06 1.2 1.48491488821e-06 1.2 1.48494664634e-06 1.2 1.48497840447e-06 1.2 1.4850101626e-06 1.2 1.48504192073e-06 1.2 1.48507367886e-06 1.2 1.48510543699e-06 1.2 1.48513719512e-06 1.2 1.48516895325e-06 1.2 1.48520071138e-06 1.2 1.48523246951e-06 1.2 1.48526422764e-06 1.2 1.48529598577e-06 1.2 1.4853277439e-06 1.2 1.48535950203e-06 1.2 1.48539126016e-06 1.2 1.48542301829e-06 1.2 1.48545477642e-06 1.2 1.48548653455e-06 1.2 1.48551829268e-06 1.2 1.48555005081e-06 1.2 1.48558180894e-06 1.2 1.48561356707e-06 1.2 1.4856453252e-06 1.2 1.48567708333e-06 1.2 1.48570884146e-06 1.2 1.48574059959e-06 1.2 1.48577235772e-06 1.2 1.48580411585e-06 1.2 1.48583587398e-06 1.2 1.48586763211e-06 1.2 1.48589939024e-06 1.2 1.48593114837e-06 1.2 1.4859629065e-06 1.2 1.48599466463e-06 1.2 1.48602642276e-06 1.2 1.48605818089e-06 1.2 1.48608993902e-06 1.2 1.48612169715e-06 1.2 1.48615345528e-06 1.2 1.48618521341e-06 1.2 1.48621697154e-06 1.2 1.48624872967e-06 1.2 1.4862804878e-06 1.2 1.48631224593e-06 1.2 1.48634400407e-06 1.2 1.4863757622e-06 1.2 1.48640752033e-06 1.2 1.48643927846e-06 1.2 1.48647103659e-06 1.2 1.48650279472e-06 1.2 1.48653455285e-06 1.2 1.48656631098e-06 1.2 1.48659806911e-06 1.2 1.48662982724e-06 1.2 1.48666158537e-06 1.2 1.4866933435e-06 1.2 1.48672510163e-06 1.2 1.48675685976e-06 1.2 1.48678861789e-06 1.2 1.48682037602e-06 1.2 1.48685213415e-06 1.2 1.48688389228e-06 1.2 1.48691565041e-06 1.2 1.48694740854e-06 1.2 1.48697916667e-06 1.2 1.4870109248e-06 1.2 1.48704268293e-06 1.2 1.48707444106e-06 1.2 1.48710619919e-06 1.2 1.48713795732e-06 1.2 1.48716971545e-06 1.2 1.48720147358e-06 1.2 1.48723323171e-06 1.2 1.48726498984e-06 1.2 1.48729674797e-06 1.2 1.4873285061e-06 1.2 1.48736026423e-06 1.2 1.48739202236e-06 1.2 1.48742378049e-06 1.2 1.48745553862e-06 1.2 1.48748729675e-06 1.2 1.48751905488e-06 1.2 1.48755081301e-06 1.2 1.48758257114e-06 1.2 1.48761432927e-06 1.2 1.4876460874e-06 1.2 1.48767784553e-06 1.2 1.48770960366e-06 1.2 1.48774136179e-06 1.2 1.48777311992e-06 1.2 1.48780487805e-06 1.2 1.48783663618e-06 1.2 1.48786839431e-06 1.2 1.48790015244e-06 1.2 1.48793191057e-06 1.2 1.4879636687e-06 1.2 1.48799542683e-06 1.2 1.48802718496e-06 1.2 1.48805894309e-06 1.2 1.48809070122e-06 1.2 1.48812245935e-06 1.2 1.48815421748e-06 1.2 1.48818597561e-06 1.2 1.48821773374e-06 1.2 1.48824949187e-06 1.2 1.48828125e-06 1.2 1.48831300813e-06 1.2 1.48834476626e-06 1.2 1.48837652439e-06 1.2 1.48840828252e-06 1.2 1.48844004065e-06 1.2 1.48847179878e-06 1.2 1.48850355691e-06 1.2 1.48853531504e-06 1.2 1.48856707317e-06 1.2 1.4885988313e-06 1.2 1.48863058943e-06 1.2 1.48866234756e-06 1.2 1.48869410569e-06 1.2 1.48872586382e-06 1.2 1.48875762195e-06 1.2 1.48878938008e-06 1.2 1.48882113821e-06 1.2 1.48885289634e-06 1.2 1.48888465447e-06 1.2 1.4889164126e-06 1.2 1.48894817073e-06 1.2 1.48897992886e-06 1.2 1.48901168699e-06 1.2 1.48904344512e-06 1.2 1.48907520325e-06 1.2 1.48910696138e-06 1.2 1.48913871951e-06 1.2 1.48917047764e-06 1.2 1.48920223577e-06 1.2 1.4892339939e-06 1.2 1.48926575203e-06 1.2 1.48929751016e-06 1.2 1.48932926829e-06 1.2 1.48936102642e-06 1.2 1.48939278455e-06 1.2 1.48942454268e-06 1.2 1.48945630081e-06 1.2 1.48948805894e-06 1.2 1.48951981707e-06 1.2 1.4895515752e-06 1.2 1.48958333333e-06 1.2 1.48961509146e-06 1.2 1.48964684959e-06 1.2 1.48967860772e-06 1.2 1.48971036585e-06 1.2 1.48974212398e-06 1.2 1.48977388211e-06 1.2 1.48980564024e-06 1.2 1.48983739837e-06 1.2 1.4898691565e-06 1.2 1.48990091463e-06 1.2 1.48993267276e-06 1.2 1.48996443089e-06 1.2 1.48999618902e-06 1.2 1.49002794715e-06 1.2 1.49005970528e-06 1.2 1.49009146341e-06 1.2 1.49012322154e-06 1.2 1.49015497967e-06 1.2 1.4901867378e-06 1.2 1.49021849593e-06 1.2 1.49025025407e-06 1.2 1.4902820122e-06 1.2 1.49031377033e-06 1.2 1.49034552846e-06 1.2 1.49037728659e-06 1.2 1.49040904472e-06 1.2 1.49044080285e-06 1.2 1.49047256098e-06 1.2 1.49050431911e-06 1.2 1.49053607724e-06 1.2 1.49056783537e-06 1.2 1.4905995935e-06 1.2 1.49063135163e-06 1.2 1.49066310976e-06 1.2 1.49069486789e-06 1.2 1.49072662602e-06 1.2 1.49075838415e-06 1.2 1.49079014228e-06 1.2 1.49082190041e-06 1.2 1.49085365854e-06 1.2 1.49088541667e-06 1.2 1.4909171748e-06 1.2 1.49094893293e-06 1.2 1.49098069106e-06 1.2 1.49101244919e-06 1.2 1.49104420732e-06 1.2 1.49107596545e-06 1.2 1.49110772358e-06 1.2 1.49113948171e-06 1.2 1.49117123984e-06 1.2 1.49120299797e-06 1.2 1.4912347561e-06 1.2 1.49126651423e-06 1.2 1.49129827236e-06 1.2 1.49133003049e-06 1.2 1.49136178862e-06 1.2 1.49139354675e-06 1.2 1.49142530488e-06 1.2 1.49145706301e-06 1.2 1.49148882114e-06 1.2 1.49152057927e-06 1.2 1.4915523374e-06 1.2 1.49158409553e-06 1.2 1.49161585366e-06 1.2 1.49164761179e-06 1.2 1.49167936992e-06 1.2 1.49171112805e-06 1.2 1.49174288618e-06 1.2 1.49177464431e-06 1.2 1.49180640244e-06 1.2 1.49183816057e-06 1.2 1.4918699187e-06 1.2 1.49190167683e-06 1.2 1.49193343496e-06 1.2 1.49196519309e-06 1.2 1.49199695122e-06 1.2 1.49202870935e-06 1.2 1.49206046748e-06 1.2 1.49209222561e-06 1.2 1.49212398374e-06 1.2 1.49215574187e-06 1.2 1.4921875e-06 1.2 1.49221925813e-06 1.2 1.49225101626e-06 1.2 1.49228277439e-06 1.2 1.49231453252e-06 1.2 1.49234629065e-06 1.2 1.49237804878e-06 1.2 1.49240980691e-06 1.2 1.49244156504e-06 1.2 1.49247332317e-06 1.2 1.4925050813e-06 1.2 1.49253683943e-06 1.2 1.49256859756e-06 1.2 1.49260035569e-06 1.2 1.49263211382e-06 1.2 1.49266387195e-06 1.2 1.49269563008e-06 1.2 1.49272738821e-06 1.2 1.49275914634e-06 1.2 1.49279090447e-06 1.2 1.4928226626e-06 1.2 1.49285442073e-06 1.2 1.49288617886e-06 1.2 1.49291793699e-06 1.2 1.49294969512e-06 1.2 1.49298145325e-06 1.2 1.49301321138e-06 1.2 1.49304496951e-06 1.2 1.49307672764e-06 1.2 1.49310848577e-06 1.2 1.4931402439e-06 1.2 1.49317200203e-06 1.2 1.49320376016e-06 1.2 1.49323551829e-06 1.2 1.49326727642e-06 1.2 1.49329903455e-06 1.2 1.49333079268e-06 1.2 1.49336255081e-06 1.2 1.49339430894e-06 1.2 1.49342606707e-06 1.2 1.4934578252e-06 1.2 1.49348958333e-06 1.2 1.49352134146e-06 1.2 1.49355309959e-06 1.2 1.49358485772e-06 1.2 1.49361661585e-06 1.2 1.49364837398e-06 1.2 1.49368013211e-06 1.2 1.49371189024e-06 1.2 1.49374364837e-06 1.2 1.4937754065e-06 1.2 1.49380716463e-06 1.2 1.49383892276e-06 1.2 1.49387068089e-06 1.2 1.49390243902e-06 1.2 1.49393419715e-06 1.2 1.49396595528e-06 1.2 1.49399771341e-06 1.2 1.49402947154e-06 1.2 1.49406122967e-06 1.2 1.4940929878e-06 1.2 1.49412474593e-06 1.2 1.49415650407e-06 1.2 1.4941882622e-06 1.2 1.49422002033e-06 1.2 1.49425177846e-06 1.2 1.49428353659e-06 1.2 1.49431529472e-06 1.2 1.49434705285e-06 1.2 1.49437881098e-06 1.2 1.49441056911e-06 1.2 1.49444232724e-06 1.2 1.49447408537e-06 1.2 1.4945058435e-06 1.2 1.49453760163e-06 1.2 1.49456935976e-06 1.2 1.49460111789e-06 1.2 1.49463287602e-06 1.2 1.49466463415e-06 1.2 1.49469639228e-06 1.2 1.49472815041e-06 1.2 1.49475990854e-06 1.2 1.49479166667e-06 1.2 1.4948234248e-06 1.2 1.49485518293e-06 1.2 1.49488694106e-06 1.2 1.49491869919e-06 1.2 1.49495045732e-06 1.2 1.49498221545e-06 1.2 1.49501397358e-06 1.2 1.49504573171e-06 1.2 1.49507748984e-06 1.2 1.49510924797e-06 1.2 1.4951410061e-06 1.2 1.49517276423e-06 1.2 1.49520452236e-06 1.2 1.49523628049e-06 1.2 1.49526803862e-06 1.2 1.49529979675e-06 1.2 1.49533155488e-06 1.2 1.49536331301e-06 1.2 1.49539507114e-06 1.2 1.49542682927e-06 1.2 1.4954585874e-06 1.2 1.49549034553e-06 1.2 1.49552210366e-06 1.2 1.49555386179e-06 1.2 1.49558561992e-06 1.2 1.49561737805e-06 1.2 1.49564913618e-06 1.2 1.49568089431e-06 1.2 1.49571265244e-06 1.2 1.49574441057e-06 1.2 1.4957761687e-06 1.2 1.49580792683e-06 1.2 1.49583968496e-06 1.2 1.49587144309e-06 1.2 1.49590320122e-06 1.2 1.49593495935e-06 1.2 1.49596671748e-06 1.2 1.49599847561e-06 1.2 1.49603023374e-06 1.2 1.49606199187e-06 1.2 1.49609375e-06 1.2 1.49612550813e-06 1.2 1.49615726626e-06 1.2 1.49618902439e-06 1.2 1.49622078252e-06 1.2 1.49625254065e-06 1.2 1.49628429878e-06 1.2 1.49631605691e-06 1.2 1.49634781504e-06 1.2 1.49637957317e-06 1.2 1.4964113313e-06 1.2 1.49644308943e-06 1.2 1.49647484756e-06 1.2 1.49650660569e-06 1.2 1.49653836382e-06 1.2 1.49657012195e-06 1.2 1.49660188008e-06 1.2 1.49663363821e-06 1.2 1.49666539634e-06 1.2 1.49669715447e-06 1.2 1.4967289126e-06 1.2 1.49676067073e-06 1.2 1.49679242886e-06 1.2 1.49682418699e-06 1.2 1.49685594512e-06 1.2 1.49688770325e-06 1.2 1.49691946138e-06 1.2 1.49695121951e-06 1.2 1.49698297764e-06 1.2 1.49701473577e-06 1.2 1.4970464939e-06 1.2 1.49707825203e-06 1.2 1.49711001016e-06 1.2 1.49714176829e-06 1.2 1.49717352642e-06 1.2 1.49720528455e-06 1.2 1.49723704268e-06 1.2 1.49726880081e-06 1.2 1.49730055894e-06 1.2 1.49733231707e-06 1.2 1.4973640752e-06 1.2 1.49739583333e-06 1.2 1.49742759146e-06 1.2 1.49745934959e-06 1.2 1.49749110772e-06 1.2 1.49752286585e-06 1.2 1.49755462398e-06 1.2 1.49758638211e-06 1.2 1.49761814024e-06 1.2 1.49764989837e-06 1.2 1.4976816565e-06 1.2 1.49771341463e-06 1.2 1.49774517276e-06 1.2 1.49777693089e-06 1.2 1.49780868902e-06 1.2 1.49784044715e-06 1.2 1.49787220528e-06 1.2 1.49790396341e-06 1.2 1.49793572154e-06 1.2 1.49796747967e-06 1.2 1.4979992378e-06 1.2 1.49803099593e-06 1.2 1.49806275407e-06 1.2 1.4980945122e-06 1.2 1.49812627033e-06 1.2 1.49815802846e-06 1.2 1.49818978659e-06 1.2 1.49822154472e-06 1.2 1.49825330285e-06 1.2 1.49828506098e-06 1.2 1.49831681911e-06 1.2 1.49834857724e-06 1.2 1.49838033537e-06 1.2 1.4984120935e-06 1.2 1.49844385163e-06 1.2 1.49847560976e-06 1.2 1.49850736789e-06 1.2 1.49853912602e-06 1.2 1.49857088415e-06 1.2 1.49860264228e-06 1.2 1.49863440041e-06 1.2 1.49866615854e-06 1.2 1.49869791667e-06 1.2 1.4987296748e-06 1.2 1.49876143293e-06 1.2 1.49879319106e-06 1.2 1.49882494919e-06 1.2 1.49885670732e-06 1.2 1.49888846545e-06 1.2 1.49892022358e-06 1.2 1.49895198171e-06 1.2 1.49898373984e-06 1.2 1.49901549797e-06 1.2 1.4990472561e-06 1.2 1.49907901423e-06 1.2 1.49911077236e-06 1.2 1.49914253049e-06 1.2 1.49917428862e-06 1.2 1.49920604675e-06 1.2 1.49923780488e-06 1.2 1.49926956301e-06 1.2 1.49930132114e-06 1.2 1.49933307927e-06 1.2 1.4993648374e-06 1.2 1.49939659553e-06 1.2 1.49942835366e-06 1.2 1.49946011179e-06 1.2 1.49949186992e-06 1.2 1.49952362805e-06 1.2 1.49955538618e-06 1.2 1.49958714431e-06 1.2 1.49961890244e-06 1.2 1.49965066057e-06 1.2 1.4996824187e-06 1.2 1.49971417683e-06 1.2 1.49974593496e-06 1.2 1.49977769309e-06 1.2 1.49980945122e-06 1.2 1.49984120935e-06 1.2 1.49987296748e-06 1.2 1.49990472561e-06 1.2 1.49993648374e-06 1.2 1.49996824187e-06 1.2 1.5e-06 1.2 1.50003175813e-06 1.2 1.50006351626e-06 1.2 1.50009527439e-06 1.2 1.50012703252e-06 1.2 1.50015879065e-06 1.2 1.50019054878e-06 1.2 1.50022230691e-06 1.2 1.50025406504e-06 1.2 1.50028582317e-06 1.2 1.5003175813e-06 1.2 1.50034933943e-06 1.2 1.50038109756e-06 1.2 1.50041285569e-06 1.2 1.50044461382e-06 1.2 1.50047637195e-06 1.2 1.50050813008e-06 1.2 1.50053988821e-06 1.2 1.50057164634e-06 1.2 1.50060340447e-06 1.2 1.5006351626e-06 1.2 1.50066692073e-06 1.2 1.50069867886e-06 1.2 1.50073043699e-06 1.2 1.50076219512e-06 1.2 1.50079395325e-06 1.2 1.50082571138e-06 1.2 1.50085746951e-06 1.2 1.50088922764e-06 1.2 1.50092098577e-06 1.2 1.5009527439e-06 1.2 1.50098450203e-06 1.2 1.50101626016e-06 1.2 1.50104801829e-06 1.2 1.50107977642e-06 1.2 1.50111153455e-06 1.2 1.50114329268e-06 1.2 1.50117505081e-06 1.2 1.50120680894e-06 1.2 1.50123856707e-06 1.2 1.5012703252e-06 1.2 1.50130208333e-06 1.2 1.50133384146e-06 1.2 1.50136559959e-06 1.2 1.50139735772e-06 1.2 1.50142911585e-06 1.2 1.50146087398e-06 1.2 1.50149263211e-06 1.2 1.50152439024e-06 1.2 1.50155614837e-06 1.2 1.5015879065e-06 1.2 1.50161966463e-06 1.2 1.50165142276e-06 1.2 1.50168318089e-06 1.2 1.50171493902e-06 1.2 1.50174669715e-06 1.2 1.50177845528e-06 1.2 1.50181021341e-06 1.2 1.50184197154e-06 1.2 1.50187372967e-06 1.2 1.5019054878e-06 1.2 1.50193724593e-06 1.2 1.50196900407e-06 1.2 1.5020007622e-06 1.2 1.50203252033e-06 1.2 1.50206427846e-06 1.2 1.50209603659e-06 1.2 1.50212779472e-06 1.2 1.50215955285e-06 1.2 1.50219131098e-06 1.2 1.50222306911e-06 1.2 1.50225482724e-06 1.2 1.50228658537e-06 1.2 1.5023183435e-06 1.2 1.50235010163e-06 1.2 1.50238185976e-06 1.2 1.50241361789e-06 1.2 1.50244537602e-06 1.2 1.50247713415e-06 1.2 1.50250889228e-06 1.2 1.50254065041e-06 1.2 1.50257240854e-06 1.2 1.50260416667e-06 1.2 1.5026359248e-06 1.2 1.50266768293e-06 1.2 1.50269944106e-06 1.2 1.50273119919e-06 1.2 1.50276295732e-06 1.2 1.50279471545e-06 1.2 1.50282647358e-06 1.2 1.50285823171e-06 1.2 1.50288998984e-06 1.2 1.50292174797e-06 1.2 1.5029535061e-06 1.2 1.50298526423e-06 1.2 1.50301702236e-06 1.2 1.50304878049e-06 1.2 1.50308053862e-06 1.2 1.50311229675e-06 1.2 1.50314405488e-06 1.2 1.50317581301e-06 1.2 1.50320757114e-06 1.2 1.50323932927e-06 1.2 1.5032710874e-06 1.2 1.50330284553e-06 1.2 1.50333460366e-06 1.2 1.50336636179e-06 1.2 1.50339811992e-06 1.2 1.50342987805e-06 1.2 1.50346163618e-06 1.2 1.50349339431e-06 1.2 1.50352515244e-06 1.2 1.50355691057e-06 1.2 1.5035886687e-06 1.2 1.50362042683e-06 1.2 1.50365218496e-06 1.2 1.50368394309e-06 1.2 1.50371570122e-06 1.2 1.50374745935e-06 1.2 1.50377921748e-06 1.2 1.50381097561e-06 1.2 1.50384273374e-06 1.2 1.50387449187e-06 1.2 1.50390625e-06 1.2 1.50393800813e-06 1.2 1.50396976626e-06 1.2 1.50400152439e-06 1.2 1.50403328252e-06 1.2 1.50406504065e-06 1.2 1.50409679878e-06 1.2 1.50412855691e-06 1.2 1.50416031504e-06 1.2 1.50419207317e-06 1.2 1.5042238313e-06 1.2 1.50425558943e-06 1.2 1.50428734756e-06 1.2 1.50431910569e-06 1.2 1.50435086382e-06 1.2 1.50438262195e-06 1.2 1.50441438008e-06 1.2 1.50444613821e-06 1.2 1.50447789634e-06 1.2 1.50450965447e-06 1.2 1.5045414126e-06 1.2 1.50457317073e-06 1.2 1.50460492886e-06 1.2 1.50463668699e-06 1.2 1.50466844512e-06 1.2 1.50470020325e-06 1.2 1.50473196138e-06 1.2 1.50476371951e-06 1.2 1.50479547764e-06 1.2 1.50482723577e-06 1.2 1.5048589939e-06 1.2 1.50489075203e-06 1.2 1.50492251016e-06 1.2 1.50495426829e-06 1.2 1.50498602642e-06 1.2 1.50501778455e-06 1.2 1.50504954268e-06 1.2 1.50508130081e-06 1.2 1.50511305894e-06 1.2 1.50514481707e-06 1.2 1.5051765752e-06 1.2 1.50520833333e-06 1.2 1.50524009146e-06 1.2 1.50527184959e-06 1.2 1.50530360772e-06 1.2 1.50533536585e-06 1.2 1.50536712398e-06 1.2 1.50539888211e-06 1.2 1.50543064024e-06 1.2 1.50546239837e-06 1.2 1.5054941565e-06 1.2 1.50552591463e-06 1.2 1.50555767276e-06 1.2 1.50558943089e-06 1.2 1.50562118902e-06 1.2 1.50565294715e-06 1.2 1.50568470528e-06 1.2 1.50571646341e-06 1.2 1.50574822154e-06 1.2 1.50577997967e-06 1.2 1.5058117378e-06 1.2 1.50584349593e-06 1.2 1.50587525407e-06 1.2 1.5059070122e-06 1.2 1.50593877033e-06 1.2 1.50597052846e-06 1.2 1.50600228659e-06 1.2 1.50603404472e-06 1.2 1.50606580285e-06 1.2 1.50609756098e-06 1.2 1.50612931911e-06 1.2 1.50616107724e-06 1.2 1.50619283537e-06 1.2 1.5062245935e-06 1.2 1.50625635163e-06 1.2 1.50628810976e-06 1.2 1.50631986789e-06 1.2 1.50635162602e-06 1.2 1.50638338415e-06 1.2 1.50641514228e-06 1.2 1.50644690041e-06 1.2 1.50647865854e-06 1.2 1.50651041667e-06 1.2 1.5065421748e-06 1.2 1.50657393293e-06 1.2 1.50660569106e-06 1.2 1.50663744919e-06 1.2 1.50666920732e-06 1.2 1.50670096545e-06 1.2 1.50673272358e-06 1.2 1.50676448171e-06 1.2 1.50679623984e-06 1.2 1.50682799797e-06 1.2 1.5068597561e-06 1.2 1.50689151423e-06 1.2 1.50692327236e-06 1.2 1.50695503049e-06 1.2 1.50698678862e-06 1.2 1.50701854675e-06 1.2 1.50705030488e-06 1.2 1.50708206301e-06 1.2 1.50711382114e-06 1.2 1.50714557927e-06 1.2 1.5071773374e-06 1.2 1.50720909553e-06 1.2 1.50724085366e-06 1.2 1.50727261179e-06 1.2 1.50730436992e-06 1.2 1.50733612805e-06 1.2 1.50736788618e-06 1.2 1.50739964431e-06 1.2 1.50743140244e-06 1.2 1.50746316057e-06 1.2 1.5074949187e-06 1.2 1.50752667683e-06 1.2 1.50755843496e-06 1.2 1.50759019309e-06 1.2 1.50762195122e-06 1.2 1.50765370935e-06 1.2 1.50768546748e-06 1.2 1.50771722561e-06 1.2 1.50774898374e-06 1.2 1.50778074187e-06 1.2 1.5078125e-06 1.2 1.50784425813e-06 1.2 1.50787601626e-06 1.2 1.50790777439e-06 1.2 1.50793953252e-06 1.2 1.50797129065e-06 1.2 1.50800304878e-06 1.2 1.50803480691e-06 1.2 1.50806656504e-06 1.2 1.50809832317e-06 1.2 1.5081300813e-06 1.2 1.50816183943e-06 1.2 1.50819359756e-06 1.2 1.50822535569e-06 1.2 1.50825711382e-06 1.2 1.50828887195e-06 1.2 1.50832063008e-06 1.2 1.50835238821e-06 1.2 1.50838414634e-06 1.2 1.50841590447e-06 1.2 1.5084476626e-06 1.2 1.50847942073e-06 1.2 1.50851117886e-06 1.2 1.50854293699e-06 1.2 1.50857469512e-06 1.2 1.50860645325e-06 1.2 1.50863821138e-06 1.2 1.50866996951e-06 1.2 1.50870172764e-06 1.2 1.50873348577e-06 1.2 1.5087652439e-06 1.2 1.50879700203e-06 1.2 1.50882876016e-06 1.2 1.50886051829e-06 1.2 1.50889227642e-06 1.2 1.50892403455e-06 1.2 1.50895579268e-06 1.2 1.50898755081e-06 1.2 1.50901930894e-06 1.2 1.50905106707e-06 1.2 1.5090828252e-06 1.2 1.50911458333e-06 1.2 1.50914634146e-06 1.2 1.50917809959e-06 1.2 1.50920985772e-06 1.2 1.50924161585e-06 1.2 1.50927337398e-06 1.2 1.50930513211e-06 1.2 1.50933689024e-06 1.2 1.50936864837e-06 1.2 1.5094004065e-06 1.2 1.50943216463e-06 1.2 1.50946392276e-06 1.2 1.50949568089e-06 1.2 1.50952743902e-06 1.2 1.50955919715e-06 1.2 1.50959095528e-06 1.2 1.50962271341e-06 1.2 1.50965447154e-06 1.2 1.50968622967e-06 1.2 1.5097179878e-06 1.2 1.50974974593e-06 1.2 1.50978150407e-06 1.2 1.5098132622e-06 1.2 1.50984502033e-06 1.2 1.50987677846e-06 1.2 1.50990853659e-06 1.2 1.50994029472e-06 1.2 1.50997205285e-06 1.2 1.51000381098e-06 1.2 1.51003556911e-06 1.2 1.51006732724e-06 1.2 1.51009908537e-06 1.2 1.5101308435e-06 1.2 1.51016260163e-06 1.2 1.51019435976e-06 1.2 1.51022611789e-06 1.2 1.51025787602e-06 1.2 1.51028963415e-06 1.2 1.51032139228e-06 1.2 1.51035315041e-06 1.2 1.51038490854e-06 1.2 1.51041666667e-06 1.2 1.5104484248e-06 1.2 1.51048018293e-06 1.2 1.51051194106e-06 1.2 1.51054369919e-06 1.2 1.51057545732e-06 1.2 1.51060721545e-06 1.2 1.51063897358e-06 1.2 1.51067073171e-06 1.2 1.51070248984e-06 1.2 1.51073424797e-06 1.2 1.5107660061e-06 1.2 1.51079776423e-06 1.2 1.51082952236e-06 1.2 1.51086128049e-06 1.2 1.51089303862e-06 1.2 1.51092479675e-06 1.2 1.51095655488e-06 1.2 1.51098831301e-06 1.2 1.51102007114e-06 1.2 1.51105182927e-06 1.2 1.5110835874e-06 1.2 1.51111534553e-06 1.2 1.51114710366e-06 1.2 1.51117886179e-06 1.2 1.51121061992e-06 1.2 1.51124237805e-06 1.2 1.51127413618e-06 1.2 1.51130589431e-06 1.2 1.51133765244e-06 1.2 1.51136941057e-06 1.2 1.5114011687e-06 1.2 1.51143292683e-06 1.2 1.51146468496e-06 1.2 1.51149644309e-06 1.2 1.51152820122e-06 1.2 1.51155995935e-06 1.2 1.51159171748e-06 1.2 1.51162347561e-06 1.2 1.51165523374e-06 1.2 1.51168699187e-06 1.2 1.51171875e-06 1.2 1.51175050813e-06 1.2 1.51178226626e-06 1.2 1.51181402439e-06 1.2 1.51184578252e-06 1.2 1.51187754065e-06 1.2 1.51190929878e-06 1.2 1.51194105691e-06 1.2 1.51197281504e-06 1.2 1.51200457317e-06 1.2 1.5120363313e-06 1.2 1.51206808943e-06 1.2 1.51209984756e-06 1.2 1.51213160569e-06 1.2 1.51216336382e-06 1.2 1.51219512195e-06 1.2 1.51222688008e-06 1.2 1.51225863821e-06 1.2 1.51229039634e-06 1.2 1.51232215447e-06 1.2 1.5123539126e-06 1.2 1.51238567073e-06 1.2 1.51241742886e-06 1.2 1.51244918699e-06 1.2 1.51248094512e-06 1.2 1.51251270325e-06 1.2 1.51254446138e-06 1.2 1.51257621951e-06 1.2 1.51260797764e-06 1.2 1.51263973577e-06 1.2 1.5126714939e-06 1.2 1.51270325203e-06 1.2 1.51273501016e-06 1.2 1.51276676829e-06 1.2 1.51279852642e-06 1.2 1.51283028455e-06 1.2 1.51286204268e-06 1.2 1.51289380081e-06 1.2 1.51292555894e-06 1.2 1.51295731707e-06 1.2 1.5129890752e-06 1.2 1.51302083333e-06 1.2 1.51305259146e-06 1.2 1.51308434959e-06 1.2 1.51311610772e-06 1.2 1.51314786585e-06 1.2 1.51317962398e-06 1.2 1.51321138211e-06 1.2 1.51324314024e-06 1.2 1.51327489837e-06 1.2 1.5133066565e-06 1.2 1.51333841463e-06 1.2 1.51337017276e-06 1.2 1.51340193089e-06 1.2 1.51343368902e-06 1.2 1.51346544715e-06 1.2 1.51349720528e-06 1.2 1.51352896341e-06 1.2 1.51356072154e-06 1.2 1.51359247967e-06 1.2 1.5136242378e-06 1.2 1.51365599593e-06 1.2 1.51368775407e-06 1.2 1.5137195122e-06 1.2 1.51375127033e-06 1.2 1.51378302846e-06 1.2 1.51381478659e-06 1.2 1.51384654472e-06 1.2 1.51387830285e-06 1.2 1.51391006098e-06 1.2 1.51394181911e-06 1.2 1.51397357724e-06 1.2 1.51400533537e-06 1.2 1.5140370935e-06 1.2 1.51406885163e-06 1.2 1.51410060976e-06 1.2 1.51413236789e-06 1.2 1.51416412602e-06 1.2 1.51419588415e-06 1.2 1.51422764228e-06 1.2 1.51425940041e-06 1.2 1.51429115854e-06 1.2 1.51432291667e-06 1.2 1.5143546748e-06 1.2 1.51438643293e-06 1.2 1.51441819106e-06 1.2 1.51444994919e-06 1.2 1.51448170732e-06 1.2 1.51451346545e-06 1.2 1.51454522358e-06 1.2 1.51457698171e-06 1.2 1.51460873984e-06 1.2 1.51464049797e-06 1.2 1.5146722561e-06 1.2 1.51470401423e-06 1.2 1.51473577236e-06 1.2 1.51476753049e-06 1.2 1.51479928862e-06 1.2 1.51483104675e-06 1.2 1.51486280488e-06 1.2 1.51489456301e-06 1.2 1.51492632114e-06 1.2 1.51495807927e-06 1.2 1.5149898374e-06 1.2 1.51502159553e-06 1.2 1.51505335366e-06 1.2 1.51508511179e-06 1.2 1.51511686992e-06 1.2 1.51514862805e-06 1.2 1.51518038618e-06 1.2 1.51521214431e-06 1.2 1.51524390244e-06 1.2 1.51527566057e-06 1.2 1.5153074187e-06 1.2 1.51533917683e-06 1.2 1.51537093496e-06 1.2 1.51540269309e-06 1.2 1.51543445122e-06 1.2 1.51546620935e-06 1.2 1.51549796748e-06 1.2 1.51552972561e-06 1.2 1.51556148374e-06 1.2 1.51559324187e-06 1.2 1.515625e-06 1.2 1.51565675813e-06 1.2 1.51568851626e-06 1.2 1.51572027439e-06 1.2 1.51575203252e-06 1.2 1.51578379065e-06 1.2 1.51581554878e-06 1.2 1.51584730691e-06 1.2 1.51587906504e-06 1.2 1.51591082317e-06 1.2 1.5159425813e-06 1.2 1.51597433943e-06 1.2 1.51600609756e-06 1.2 1.51603785569e-06 1.2 1.51606961382e-06 1.2 1.51610137195e-06 1.2 1.51613313008e-06 1.2 1.51616488821e-06 1.2 1.51619664634e-06 1.2 1.51622840447e-06 1.2 1.5162601626e-06 1.2 1.51629192073e-06 1.2 1.51632367886e-06 1.2 1.51635543699e-06 1.2 1.51638719512e-06 1.2 1.51641895325e-06 1.2 1.51645071138e-06 1.2 1.51648246951e-06 1.2 1.51651422764e-06 1.2 1.51654598577e-06 1.2 1.5165777439e-06 1.2 1.51660950203e-06 1.2 1.51664126016e-06 1.2 1.51667301829e-06 1.2 1.51670477642e-06 1.2 1.51673653455e-06 1.2 1.51676829268e-06 1.2 1.51680005081e-06 1.2 1.51683180894e-06 1.2 1.51686356707e-06 1.2 1.5168953252e-06 1.2 1.51692708333e-06 1.2 1.51695884146e-06 1.2 1.51699059959e-06 1.2 1.51702235772e-06 1.2 1.51705411585e-06 1.2 1.51708587398e-06 1.2 1.51711763211e-06 1.2 1.51714939024e-06 1.2 1.51718114837e-06 1.2 1.5172129065e-06 1.2 1.51724466463e-06 1.2 1.51727642276e-06 1.2 1.51730818089e-06 1.2 1.51733993902e-06 1.2 1.51737169715e-06 1.2 1.51740345528e-06 1.2 1.51743521341e-06 1.2 1.51746697154e-06 1.2 1.51749872967e-06 1.2 1.5175304878e-06 1.2 1.51756224593e-06 1.2 1.51759400407e-06 1.2 1.5176257622e-06 1.2 1.51765752033e-06 1.2 1.51768927846e-06 1.2 1.51772103659e-06 1.2 1.51775279472e-06 1.2 1.51778455285e-06 1.2 1.51781631098e-06 1.2 1.51784806911e-06 1.2 1.51787982724e-06 1.2 1.51791158537e-06 1.2 1.5179433435e-06 1.2 1.51797510163e-06 1.2 1.51800685976e-06 1.2 1.51803861789e-06 1.2 1.51807037602e-06 1.2 1.51810213415e-06 1.2 1.51813389228e-06 1.2 1.51816565041e-06 1.2 1.51819740854e-06 1.2 1.51822916667e-06 1.2 1.5182609248e-06 1.2 1.51829268293e-06 1.2 1.51832444106e-06 1.2 1.51835619919e-06 1.2 1.51838795732e-06 1.2 1.51841971545e-06 1.2 1.51845147358e-06 1.2 1.51848323171e-06 1.2 1.51851498984e-06 1.2 1.51854674797e-06 1.2 1.5185785061e-06 1.2 1.51861026423e-06 1.2 1.51864202236e-06 1.2 1.51867378049e-06 1.2 1.51870553862e-06 1.2 1.51873729675e-06 1.2 1.51876905488e-06 1.2 1.51880081301e-06 1.2 1.51883257114e-06 1.2 1.51886432927e-06 1.2 1.5188960874e-06 1.2 1.51892784553e-06 1.2 1.51895960366e-06 1.2 1.51899136179e-06 1.2 1.51902311992e-06 1.2 1.51905487805e-06 1.2 1.51908663618e-06 1.2 1.51911839431e-06 1.2 1.51915015244e-06 1.2 1.51918191057e-06 1.2 1.5192136687e-06 1.2 1.51924542683e-06 1.2 1.51927718496e-06 1.2 1.51930894309e-06 1.2 1.51934070122e-06 1.2 1.51937245935e-06 1.2 1.51940421748e-06 1.2 1.51943597561e-06 1.2 1.51946773374e-06 1.2 1.51949949187e-06 1.2 1.51953125e-06 1.2 1.51956300813e-06 1.2 1.51959476626e-06 1.2 1.51962652439e-06 1.2 1.51965828252e-06 1.2 1.51969004065e-06 1.2 1.51972179878e-06 1.2 1.51975355691e-06 1.2 1.51978531504e-06 1.2 1.51981707317e-06 1.2 1.5198488313e-06 1.2 1.51988058943e-06 1.2 1.51991234756e-06 1.2 1.51994410569e-06 1.2 1.51997586382e-06 1.2 1.52000762195e-06 1.2 1.52003938008e-06 1.2 1.52007113821e-06 1.2 1.52010289634e-06 1.2 1.52013465447e-06 1.2 1.5201664126e-06 1.2 1.52019817073e-06 1.2 1.52022992886e-06 1.2 1.52026168699e-06 1.2 1.52029344512e-06 1.2 1.52032520325e-06 1.2 1.52035696138e-06 1.2 1.52038871951e-06 1.2 1.52042047764e-06 1.2 1.52045223577e-06 1.2 1.5204839939e-06 1.2 1.52051575203e-06 1.2 1.52054751016e-06 1.2 1.52057926829e-06 1.2 1.52061102642e-06 1.2 1.52064278455e-06 1.2 1.52067454268e-06 1.2 1.52070630081e-06 1.2 1.52073805894e-06 1.2 1.52076981707e-06 1.2 1.5208015752e-06 1.2 1.52083333333e-06 1.2 1.52086509146e-06 1.2 1.52089684959e-06 1.2 1.52092860772e-06 1.2 1.52096036585e-06 1.2 1.52099212398e-06 1.2 1.52102388211e-06 1.2 1.52105564024e-06 1.2 1.52108739837e-06 1.2 1.5211191565e-06 1.2 1.52115091463e-06 1.2 1.52118267276e-06 1.2 1.52121443089e-06 1.2 1.52124618902e-06 1.2 1.52127794715e-06 1.2 1.52130970528e-06 1.2 1.52134146341e-06 1.2 1.52137322154e-06 1.2 1.52140497967e-06 1.2 1.5214367378e-06 1.2 1.52146849593e-06 1.2 1.52150025407e-06 1.2 1.5215320122e-06 1.2 1.52156377033e-06 1.2 1.52159552846e-06 1.2 1.52162728659e-06 1.2 1.52165904472e-06 1.2 1.52169080285e-06 1.2 1.52172256098e-06 1.2 1.52175431911e-06 1.2 1.52178607724e-06 1.2 1.52181783537e-06 1.2 1.5218495935e-06 1.2 1.52188135163e-06 1.2 1.52191310976e-06 1.2 1.52194486789e-06 1.2 1.52197662602e-06 1.2 1.52200838415e-06 1.2 1.52204014228e-06 1.2 1.52207190041e-06 1.2 1.52210365854e-06 1.2 1.52213541667e-06 1.2 1.5221671748e-06 1.2 1.52219893293e-06 1.2 1.52223069106e-06 1.2 1.52226244919e-06 1.2 1.52229420732e-06 1.2 1.52232596545e-06 1.2 1.52235772358e-06 1.2 1.52238948171e-06 1.2 1.52242123984e-06 1.2 1.52245299797e-06 1.2 1.5224847561e-06 1.2 1.52251651423e-06 1.2 1.52254827236e-06 1.2 1.52258003049e-06 1.2 1.52261178862e-06 1.2 1.52264354675e-06 1.2 1.52267530488e-06 1.2 1.52270706301e-06 1.2 1.52273882114e-06 1.2 1.52277057927e-06 1.2 1.5228023374e-06 1.2 1.52283409553e-06 1.2 1.52286585366e-06 1.2 1.52289761179e-06 1.2 1.52292936992e-06 1.2 1.52296112805e-06 1.2 1.52299288618e-06 1.2 1.52302464431e-06 1.2 1.52305640244e-06 1.2 1.52308816057e-06 1.2 1.5231199187e-06 1.2 1.52315167683e-06 1.2 1.52318343496e-06 1.2 1.52321519309e-06 1.2 1.52324695122e-06 1.2 1.52327870935e-06 1.2 1.52331046748e-06 1.2 1.52334222561e-06 1.2 1.52337398374e-06 1.2 1.52340574187e-06 1.2 1.5234375e-06 1.2 1.52346925813e-06 1.2 1.52350101626e-06 1.2 1.52353277439e-06 1.2 1.52356453252e-06 1.2 1.52359629065e-06 1.2 1.52362804878e-06 1.2 1.52365980691e-06 1.2 1.52369156504e-06 1.2 1.52372332317e-06 1.2 1.5237550813e-06 1.2 1.52378683943e-06 1.2 1.52381859756e-06 1.2 1.52385035569e-06 1.2 1.52388211382e-06 1.2 1.52391387195e-06 1.2 1.52394563008e-06 1.2 1.52397738821e-06 1.2 1.52400914634e-06 1.2 1.52404090447e-06 1.2 1.5240726626e-06 1.2 1.52410442073e-06 1.2 1.52413617886e-06 1.2 1.52416793699e-06 1.2 1.52419969512e-06 1.2 1.52423145325e-06 1.2 1.52426321138e-06 1.2 1.52429496951e-06 1.2 1.52432672764e-06 1.2 1.52435848577e-06 1.2 1.5243902439e-06 1.2 1.52442200203e-06 1.2 1.52445376016e-06 1.2 1.52448551829e-06 1.2 1.52451727642e-06 1.2 1.52454903455e-06 1.2 1.52458079268e-06 1.2 1.52461255081e-06 1.2 1.52464430894e-06 1.2 1.52467606707e-06 1.2 1.5247078252e-06 1.2 1.52473958333e-06 1.2 1.52477134146e-06 1.2 1.52480309959e-06 1.2 1.52483485772e-06 1.2 1.52486661585e-06 1.2 1.52489837398e-06 1.2 1.52493013211e-06 1.2 1.52496189024e-06 1.2 1.52499364837e-06 1.2 1.5250254065e-06 1.2 1.52505716463e-06 1.2 1.52508892276e-06 1.2 1.52512068089e-06 1.2 1.52515243902e-06 1.2 1.52518419715e-06 1.2 1.52521595528e-06 1.2 1.52524771341e-06 1.2 1.52527947154e-06 1.2 1.52531122967e-06 1.2 1.5253429878e-06 1.2 1.52537474593e-06 1.2 1.52540650407e-06 1.2 1.5254382622e-06 1.2 1.52547002033e-06 1.2 1.52550177846e-06 1.2 1.52553353659e-06 1.2 1.52556529472e-06 1.2 1.52559705285e-06 1.2 1.52562881098e-06 1.2 1.52566056911e-06 1.2 1.52569232724e-06 1.2 1.52572408537e-06 1.2 1.5257558435e-06 1.2 1.52578760163e-06 1.2 1.52581935976e-06 1.2 1.52585111789e-06 1.2 1.52588287602e-06 1.2 1.52591463415e-06 1.2 1.52594639228e-06 1.2 1.52597815041e-06 1.2 1.52600990854e-06 1.2 1.52604166667e-06 1.2 1.5260734248e-06 1.2 1.52610518293e-06 1.2 1.52613694106e-06 1.2 1.52616869919e-06 1.2 1.52620045732e-06 1.2 1.52623221545e-06 1.2 1.52626397358e-06 1.2 1.52629573171e-06 1.2 1.52632748984e-06 1.2 1.52635924797e-06 1.2 1.5263910061e-06 1.2 1.52642276423e-06 1.2 1.52645452236e-06 1.2 1.52648628049e-06 1.2 1.52651803862e-06 1.2 1.52654979675e-06 1.2 1.52658155488e-06 1.2 1.52661331301e-06 1.2 1.52664507114e-06 1.2 1.52667682927e-06 1.2 1.5267085874e-06 1.2 1.52674034553e-06 1.2 1.52677210366e-06 1.2 1.52680386179e-06 1.2 1.52683561992e-06 1.2 1.52686737805e-06 1.2 1.52689913618e-06 1.2 1.52693089431e-06 1.2 1.52696265244e-06 1.2 1.52699441057e-06 1.2 1.5270261687e-06 1.2 1.52705792683e-06 1.2 1.52708968496e-06 1.2 1.52712144309e-06 1.2 1.52715320122e-06 1.2 1.52718495935e-06 1.2 1.52721671748e-06 1.2 1.52724847561e-06 1.2 1.52728023374e-06 1.2 1.52731199187e-06 1.2 1.52734375e-06 1.2 1.52737550813e-06 1.2 1.52740726626e-06 1.2 1.52743902439e-06 1.2 1.52747078252e-06 1.2 1.52750254065e-06 1.2 1.52753429878e-06 1.2 1.52756605691e-06 1.2 1.52759781504e-06 1.2 1.52762957317e-06 1.2 1.5276613313e-06 1.2 1.52769308943e-06 1.2 1.52772484756e-06 1.2 1.52775660569e-06 1.2 1.52778836382e-06 1.2 1.52782012195e-06 1.2 1.52785188008e-06 1.2 1.52788363821e-06 1.2 1.52791539634e-06 1.2 1.52794715447e-06 1.2 1.5279789126e-06 1.2 1.52801067073e-06 1.2 1.52804242886e-06 1.2 1.52807418699e-06 1.2 1.52810594512e-06 1.2 1.52813770325e-06 1.2 1.52816946138e-06 1.2 1.52820121951e-06 1.2 1.52823297764e-06 1.2 1.52826473577e-06 1.2 1.5282964939e-06 1.2 1.52832825203e-06 1.2 1.52836001016e-06 1.2 1.52839176829e-06 1.2 1.52842352642e-06 1.2 1.52845528455e-06 1.2 1.52848704268e-06 1.2 1.52851880081e-06 1.2 1.52855055894e-06 1.2 1.52858231707e-06 1.2 1.5286140752e-06 1.2 1.52864583333e-06 1.2 1.52867759146e-06 1.2 1.52870934959e-06 1.2 1.52874110772e-06 1.2 1.52877286585e-06 1.2 1.52880462398e-06 1.2 1.52883638211e-06 1.2 1.52886814024e-06 1.2 1.52889989837e-06 1.2 1.5289316565e-06 1.2 1.52896341463e-06 1.2 1.52899517276e-06 1.2 1.52902693089e-06 1.2 1.52905868902e-06 1.2 1.52909044715e-06 1.2 1.52912220528e-06 1.2 1.52915396341e-06 1.2 1.52918572154e-06 1.2 1.52921747967e-06 1.2 1.5292492378e-06 1.2 1.52928099593e-06 1.2 1.52931275407e-06 1.2 1.5293445122e-06 1.2 1.52937627033e-06 1.2 1.52940802846e-06 1.2 1.52943978659e-06 1.2 1.52947154472e-06 1.2 1.52950330285e-06 1.2 1.52953506098e-06 1.2 1.52956681911e-06 1.2 1.52959857724e-06 1.2 1.52963033537e-06 1.2 1.5296620935e-06 1.2 1.52969385163e-06 1.2 1.52972560976e-06 1.2 1.52975736789e-06 1.2 1.52978912602e-06 1.2 1.52982088415e-06 1.2 1.52985264228e-06 1.2 1.52988440041e-06 1.2 1.52991615854e-06 1.2 1.52994791667e-06 1.2 1.5299796748e-06 1.2 1.53001143293e-06 1.2 1.53004319106e-06 1.2 1.53007494919e-06 1.2 1.53010670732e-06 1.2 1.53013846545e-06 1.2 1.53017022358e-06 1.2 1.53020198171e-06 1.2 1.53023373984e-06 1.2 1.53026549797e-06 1.2 1.5302972561e-06 1.2 1.53032901423e-06 1.2 1.53036077236e-06 1.2 1.53039253049e-06 1.2 1.53042428862e-06 1.2 1.53045604675e-06 1.2 1.53048780488e-06 1.2 1.53051956301e-06 1.2 1.53055132114e-06 1.2 1.53058307927e-06 1.2 1.5306148374e-06 1.2 1.53064659553e-06 1.2 1.53067835366e-06 1.2 1.53071011179e-06 1.2 1.53074186992e-06 1.2 1.53077362805e-06 1.2 1.53080538618e-06 1.2 1.53083714431e-06 1.2 1.53086890244e-06 1.2 1.53090066057e-06 1.2 1.5309324187e-06 1.2 1.53096417683e-06 1.2 1.53099593496e-06 1.2 1.53102769309e-06 1.2 1.53105945122e-06 1.2 1.53109120935e-06 1.2 1.53112296748e-06 1.2 1.53115472561e-06 1.2 1.53118648374e-06 1.2 1.53121824187e-06 1.2 1.53125e-06 1.2 1.53128175813e-06 1.2 1.53131351626e-06 1.2 1.53134527439e-06 1.2 1.53137703252e-06 1.2 1.53140879065e-06 1.2 1.53144054878e-06 1.2 1.53147230691e-06 1.2 1.53150406504e-06 1.2 1.53153582317e-06 1.2 1.5315675813e-06 1.2 1.53159933943e-06 1.2 1.53163109756e-06 1.2 1.53166285569e-06 1.2 1.53169461382e-06 1.2 1.53172637195e-06 1.2 1.53175813008e-06 1.2 1.53178988821e-06 1.2 1.53182164634e-06 1.2 1.53185340447e-06 1.2 1.5318851626e-06 1.2 1.53191692073e-06 1.2 1.53194867886e-06 1.2 1.53198043699e-06 1.2 1.53201219512e-06 1.2 1.53204395325e-06 1.2 1.53207571138e-06 1.2 1.53210746951e-06 1.2 1.53213922764e-06 1.2 1.53217098577e-06 1.2 1.5322027439e-06 1.2 1.53223450203e-06 1.2 1.53226626016e-06 1.2 1.53229801829e-06 1.2 1.53232977642e-06 1.2 1.53236153455e-06 1.2 1.53239329268e-06 1.2 1.53242505081e-06 1.2 1.53245680894e-06 1.2 1.53248856707e-06 1.2 1.5325203252e-06 1.2 1.53255208333e-06 1.2 1.53258384146e-06 1.2 1.53261559959e-06 1.2 1.53264735772e-06 1.2 1.53267911585e-06 1.2 1.53271087398e-06 1.2 1.53274263211e-06 1.2 1.53277439024e-06 1.2 1.53280614837e-06 1.2 1.5328379065e-06 1.2 1.53286966463e-06 1.2 1.53290142276e-06 1.2 1.53293318089e-06 1.2 1.53296493902e-06 1.2 1.53299669715e-06 1.2 1.53302845528e-06 1.2 1.53306021341e-06 1.2 1.53309197154e-06 1.2 1.53312372967e-06 1.2 1.5331554878e-06 1.2 1.53318724593e-06 1.2 1.53321900407e-06 1.2 1.5332507622e-06 1.2 1.53328252033e-06 1.2 1.53331427846e-06 1.2 1.53334603659e-06 1.2 1.53337779472e-06 1.2 1.53340955285e-06 1.2 1.53344131098e-06 1.2 1.53347306911e-06 1.2 1.53350482724e-06 1.2 1.53353658537e-06 1.2 1.5335683435e-06 1.2 1.53360010163e-06 1.2 1.53363185976e-06 1.2 1.53366361789e-06 1.2 1.53369537602e-06 1.2 1.53372713415e-06 1.2 1.53375889228e-06 1.2 1.53379065041e-06 1.2 1.53382240854e-06 1.2 1.53385416667e-06 1.2 1.5338859248e-06 1.2 1.53391768293e-06 1.2 1.53394944106e-06 1.2 1.53398119919e-06 1.2 1.53401295732e-06 1.2 1.53404471545e-06 1.2 1.53407647358e-06 1.2 1.53410823171e-06 1.2 1.53413998984e-06 1.2 1.53417174797e-06 1.2 1.5342035061e-06 1.2 1.53423526423e-06 1.2 1.53426702236e-06 1.2 1.53429878049e-06 1.2 1.53433053862e-06 1.2 1.53436229675e-06 1.2 1.53439405488e-06 1.2 1.53442581301e-06 1.2 1.53445757114e-06 1.2 1.53448932927e-06 1.2 1.5345210874e-06 1.2 1.53455284553e-06 1.2 1.53458460366e-06 1.2 1.53461636179e-06 1.2 1.53464811992e-06 1.2 1.53467987805e-06 1.2 1.53471163618e-06 1.2 1.53474339431e-06 1.2 1.53477515244e-06 1.2 1.53480691057e-06 1.2 1.5348386687e-06 1.2 1.53487042683e-06 1.2 1.53490218496e-06 1.2 1.53493394309e-06 1.2 1.53496570122e-06 1.2 1.53499745935e-06 1.2 1.53502921748e-06 1.2 1.53506097561e-06 1.2 1.53509273374e-06 1.2 1.53512449187e-06 1.2 1.53515625e-06 1.2 1.53518800813e-06 1.2 1.53521976626e-06 1.2 1.53525152439e-06 1.2 1.53528328252e-06 1.2 1.53531504065e-06 1.2 1.53534679878e-06 1.2 1.53537855691e-06 1.2 1.53541031504e-06 1.2 1.53544207317e-06 1.2 1.5354738313e-06 1.2 1.53550558943e-06 1.2 1.53553734756e-06 1.2 1.53556910569e-06 1.2 1.53560086382e-06 1.2 1.53563262195e-06 1.2 1.53566438008e-06 1.2 1.53569613821e-06 1.2 1.53572789634e-06 1.2 1.53575965447e-06 1.2 1.5357914126e-06 1.2 1.53582317073e-06 1.2 1.53585492886e-06 1.2 1.53588668699e-06 1.2 1.53591844512e-06 1.2 1.53595020325e-06 1.2 1.53598196138e-06 1.2 1.53601371951e-06 1.2 1.53604547764e-06 1.2 1.53607723577e-06 1.2 1.5361089939e-06 1.2 1.53614075203e-06 1.2 1.53617251016e-06 1.2 1.53620426829e-06 1.2 1.53623602642e-06 1.2 1.53626778455e-06 1.2 1.53629954268e-06 1.2 1.53633130081e-06 1.2 1.53636305894e-06 1.2 1.53639481707e-06 1.2 1.5364265752e-06 1.2 1.53645833333e-06 1.2 1.53649009146e-06 1.2 1.53652184959e-06 1.2 1.53655360772e-06 1.2 1.53658536585e-06 1.2 1.53661712398e-06 1.2 1.53664888211e-06 1.2 1.53668064024e-06 1.2 1.53671239837e-06 1.2 1.5367441565e-06 1.2 1.53677591463e-06 1.2 1.53680767276e-06 1.2 1.53683943089e-06 1.2 1.53687118902e-06 1.2 1.53690294715e-06 1.2 1.53693470528e-06 1.2 1.53696646341e-06 1.2 1.53699822154e-06 1.2 1.53702997967e-06 1.2 1.5370617378e-06 1.2 1.53709349593e-06 1.2 1.53712525407e-06 1.2 1.5371570122e-06 1.2 1.53718877033e-06 1.2 1.53722052846e-06 1.2 1.53725228659e-06 1.2 1.53728404472e-06 1.2 1.53731580285e-06 1.2 1.53734756098e-06 1.2 1.53737931911e-06 1.2 1.53741107724e-06 1.2 1.53744283537e-06 1.2 1.5374745935e-06 1.2 1.53750635163e-06 1.2 1.53753810976e-06 1.2 1.53756986789e-06 1.2 1.53760162602e-06 1.2 1.53763338415e-06 1.2 1.53766514228e-06 1.2 1.53769690041e-06 1.2 1.53772865854e-06 1.2 1.53776041667e-06 1.2 1.5377921748e-06 1.2 1.53782393293e-06 1.2 1.53785569106e-06 1.2 1.53788744919e-06 1.2 1.53791920732e-06 1.2 1.53795096545e-06 1.2 1.53798272358e-06 1.2 1.53801448171e-06 1.2 1.53804623984e-06 1.2 1.53807799797e-06 1.2 1.5381097561e-06 1.2 1.53814151423e-06 1.2 1.53817327236e-06 1.2 1.53820503049e-06 1.2 1.53823678862e-06 1.2 1.53826854675e-06 1.2 1.53830030488e-06 1.2 1.53833206301e-06 1.2 1.53836382114e-06 1.2 1.53839557927e-06 1.2 1.5384273374e-06 1.2 1.53845909553e-06 1.2 1.53849085366e-06 1.2 1.53852261179e-06 1.2 1.53855436992e-06 1.2 1.53858612805e-06 1.2 1.53861788618e-06 1.2 1.53864964431e-06 1.2 1.53868140244e-06 1.2 1.53871316057e-06 1.2 1.5387449187e-06 1.2 1.53877667683e-06 1.2 1.53880843496e-06 1.2 1.53884019309e-06 1.2 1.53887195122e-06 1.2 1.53890370935e-06 1.2 1.53893546748e-06 1.2 1.53896722561e-06 1.2 1.53899898374e-06 1.2 1.53903074187e-06 1.2 1.5390625e-06 1.2 1.53909425813e-06 1.2 1.53912601626e-06 1.2 1.53915777439e-06 1.2 1.53918953252e-06 1.2 1.53922129065e-06 1.2 1.53925304878e-06 1.2 1.53928480691e-06 1.2 1.53931656504e-06 1.2 1.53934832317e-06 1.2 1.5393800813e-06 1.2 1.53941183943e-06 1.2 1.53944359756e-06 1.2 1.53947535569e-06 1.2 1.53950711382e-06 1.2 1.53953887195e-06 1.2 1.53957063008e-06 1.2 1.53960238821e-06 1.2 1.53963414634e-06 1.2 1.53966590447e-06 1.2 1.5396976626e-06 1.2 1.53972942073e-06 1.2 1.53976117886e-06 1.2 1.53979293699e-06 1.2 1.53982469512e-06 1.2 1.53985645325e-06 1.2 1.53988821138e-06 1.2 1.53991996951e-06 1.2 1.53995172764e-06 1.2 1.53998348577e-06 1.2 1.5400152439e-06 1.2 1.54004700203e-06 1.2 1.54007876016e-06 1.2 1.54011051829e-06 1.2 1.54014227642e-06 1.2 1.54017403455e-06 1.2 1.54020579268e-06 1.2 1.54023755081e-06 1.2 1.54026930894e-06 1.2 1.54030106707e-06 1.2 1.5403328252e-06 1.2 1.54036458333e-06 1.2 1.54039634146e-06 1.2 1.54042809959e-06 1.2 1.54045985772e-06 1.2 1.54049161585e-06 1.2 1.54052337398e-06 1.2 1.54055513211e-06 1.2 1.54058689024e-06 1.2 1.54061864837e-06 1.2 1.5406504065e-06 1.2 1.54068216463e-06 1.2 1.54071392276e-06 1.2 1.54074568089e-06 1.2 1.54077743902e-06 1.2 1.54080919715e-06 1.2 1.54084095528e-06 1.2 1.54087271341e-06 1.2 1.54090447154e-06 1.2 1.54093622967e-06 1.2 1.5409679878e-06 1.2 1.54099974593e-06 1.2 1.54103150407e-06 1.2 1.5410632622e-06 1.2 1.54109502033e-06 1.2 1.54112677846e-06 1.2 1.54115853659e-06 1.2 1.54119029472e-06 1.2 1.54122205285e-06 1.2 1.54125381098e-06 1.2 1.54128556911e-06 1.2 1.54131732724e-06 1.2 1.54134908537e-06 1.2 1.5413808435e-06 1.2 1.54141260163e-06 1.2 1.54144435976e-06 1.2 1.54147611789e-06 1.2 1.54150787602e-06 1.2 1.54153963415e-06 1.2 1.54157139228e-06 1.2 1.54160315041e-06 1.2 1.54163490854e-06 1.2 1.54166666667e-06 1.2 1.5416984248e-06 1.2 1.54173018293e-06 1.2 1.54176194106e-06 1.2 1.54179369919e-06 1.2 1.54182545732e-06 1.2 1.54185721545e-06 1.2 1.54188897358e-06 1.2 1.54192073171e-06 1.2 1.54195248984e-06 1.2 1.54198424797e-06 1.2 1.5420160061e-06 1.2 1.54204776423e-06 1.2 1.54207952236e-06 1.2 1.54211128049e-06 1.2 1.54214303862e-06 1.2 1.54217479675e-06 1.2 1.54220655488e-06 1.2 1.54223831301e-06 1.2 1.54227007114e-06 1.2 1.54230182927e-06 1.2 1.5423335874e-06 1.2 1.54236534553e-06 1.2 1.54239710366e-06 1.2 1.54242886179e-06 1.2 1.54246061992e-06 1.2 1.54249237805e-06 1.2 1.54252413618e-06 1.2 1.54255589431e-06 1.2 1.54258765244e-06 1.2 1.54261941057e-06 1.2 1.5426511687e-06 1.2 1.54268292683e-06 1.2 1.54271468496e-06 1.2 1.54274644309e-06 1.2 1.54277820122e-06 1.2 1.54280995935e-06 1.2 1.54284171748e-06 1.2 1.54287347561e-06 1.2 1.54290523374e-06 1.2 1.54293699187e-06 1.2 1.54296875e-06 1.2 1.54300050813e-06 1.2 1.54303226626e-06 1.2 1.54306402439e-06 1.2 1.54309578252e-06 1.2 1.54312754065e-06 1.2 1.54315929878e-06 1.2 1.54319105691e-06 1.2 1.54322281504e-06 1.2 1.54325457317e-06 1.2 1.5432863313e-06 1.2 1.54331808943e-06 1.2 1.54334984756e-06 1.2 1.54338160569e-06 1.2 1.54341336382e-06 1.2 1.54344512195e-06 1.2 1.54347688008e-06 1.2 1.54350863821e-06 1.2 1.54354039634e-06 1.2 1.54357215447e-06 1.2 1.5436039126e-06 1.2 1.54363567073e-06 1.2 1.54366742886e-06 1.2 1.54369918699e-06 1.2 1.54373094512e-06 1.2 1.54376270325e-06 1.2 1.54379446138e-06 1.2 1.54382621951e-06 1.2 1.54385797764e-06 1.2 1.54388973577e-06 1.2 1.5439214939e-06 1.2 1.54395325203e-06 1.2 1.54398501016e-06 1.2 1.54401676829e-06 1.2 1.54404852642e-06 1.2 1.54408028455e-06 1.2 1.54411204268e-06 1.2 1.54414380081e-06 1.2 1.54417555894e-06 1.2 1.54420731707e-06 1.2 1.5442390752e-06 1.2 1.54427083333e-06 1.2 1.54430259146e-06 1.2 1.54433434959e-06 1.2 1.54436610772e-06 1.2 1.54439786585e-06 1.2 1.54442962398e-06 1.2 1.54446138211e-06 1.2 1.54449314024e-06 1.2 1.54452489837e-06 1.2 1.5445566565e-06 1.2 1.54458841463e-06 1.2 1.54462017276e-06 1.2 1.54465193089e-06 1.2 1.54468368902e-06 1.2 1.54471544715e-06 1.2 1.54474720528e-06 1.2 1.54477896341e-06 1.2 1.54481072154e-06 1.2 1.54484247967e-06 1.2 1.5448742378e-06 1.2 1.54490599593e-06 1.2 1.54493775407e-06 1.2 1.5449695122e-06 1.2 1.54500127033e-06 1.2 1.54503302846e-06 1.2 1.54506478659e-06 1.2 1.54509654472e-06 1.2 1.54512830285e-06 1.2 1.54516006098e-06 1.2 1.54519181911e-06 1.2 1.54522357724e-06 1.2 1.54525533537e-06 1.2 1.5452870935e-06 1.2 1.54531885163e-06 1.2 1.54535060976e-06 1.2 1.54538236789e-06 1.2 1.54541412602e-06 1.2 1.54544588415e-06 1.2 1.54547764228e-06 1.2 1.54550940041e-06 1.2 1.54554115854e-06 1.2 1.54557291667e-06 1.2 1.5456046748e-06 1.2 1.54563643293e-06 1.2 1.54566819106e-06 1.2 1.54569994919e-06 1.2 1.54573170732e-06 1.2 1.54576346545e-06 1.2 1.54579522358e-06 1.2 1.54582698171e-06 1.2 1.54585873984e-06 1.2 1.54589049797e-06 1.2 1.5459222561e-06 1.2 1.54595401423e-06 1.2 1.54598577236e-06 1.2 1.54601753049e-06 1.2 1.54604928862e-06 1.2 1.54608104675e-06 1.2 1.54611280488e-06 1.2 1.54614456301e-06 1.2 1.54617632114e-06 1.2 1.54620807927e-06 1.2 1.5462398374e-06 1.2 1.54627159553e-06 1.2 1.54630335366e-06 1.2 1.54633511179e-06 1.2 1.54636686992e-06 1.2 1.54639862805e-06 1.2 1.54643038618e-06 1.2 1.54646214431e-06 1.2 1.54649390244e-06 1.2 1.54652566057e-06 1.2 1.5465574187e-06 1.2 1.54658917683e-06 1.2 1.54662093496e-06 1.2 1.54665269309e-06 1.2 1.54668445122e-06 1.2 1.54671620935e-06 1.2 1.54674796748e-06 1.2 1.54677972561e-06 1.2 1.54681148374e-06 1.2 1.54684324187e-06 1.2 1.546875e-06 1.2 1.54690675813e-06 1.2 1.54693851626e-06 1.2 1.54697027439e-06 1.2 1.54700203252e-06 1.2 1.54703379065e-06 1.2 1.54706554878e-06 1.2 1.54709730691e-06 1.2 1.54712906504e-06 1.2 1.54716082317e-06 1.2 1.5471925813e-06 1.2 1.54722433943e-06 1.2 1.54725609756e-06 1.2 1.54728785569e-06 1.2 1.54731961382e-06 1.2 1.54735137195e-06 1.2 1.54738313008e-06 1.2 1.54741488821e-06 1.2 1.54744664634e-06 1.2 1.54747840447e-06 1.2 1.5475101626e-06 1.2 1.54754192073e-06 1.2 1.54757367886e-06 1.2 1.54760543699e-06 1.2 1.54763719512e-06 1.2 1.54766895325e-06 1.2 1.54770071138e-06 1.2 1.54773246951e-06 1.2 1.54776422764e-06 1.2 1.54779598577e-06 1.2 1.5478277439e-06 1.2 1.54785950203e-06 1.2 1.54789126016e-06 1.2 1.54792301829e-06 1.2 1.54795477642e-06 1.2 1.54798653455e-06 1.2 1.54801829268e-06 1.2 1.54805005081e-06 1.2 1.54808180894e-06 1.2 1.54811356707e-06 1.2 1.5481453252e-06 1.2 1.54817708333e-06 1.2 1.54820884146e-06 1.2 1.54824059959e-06 1.2 1.54827235772e-06 1.2 1.54830411585e-06 1.2 1.54833587398e-06 1.2 1.54836763211e-06 1.2 1.54839939024e-06 1.2 1.54843114837e-06 1.2 1.5484629065e-06 1.2 1.54849466463e-06 1.2 1.54852642276e-06 1.2 1.54855818089e-06 1.2 1.54858993902e-06 1.2 1.54862169715e-06 1.2 1.54865345528e-06 1.2 1.54868521341e-06 1.2 1.54871697154e-06 1.2 1.54874872967e-06 1.2 1.5487804878e-06 1.2 1.54881224593e-06 1.2 1.54884400407e-06 1.2 1.5488757622e-06 1.2 1.54890752033e-06 1.2 1.54893927846e-06 1.2 1.54897103659e-06 1.2 1.54900279472e-06 1.2 1.54903455285e-06 1.2 1.54906631098e-06 1.2 1.54909806911e-06 1.2 1.54912982724e-06 1.2 1.54916158537e-06 1.2 1.5491933435e-06 1.2 1.54922510163e-06 1.2 1.54925685976e-06 1.2 1.54928861789e-06 1.2 1.54932037602e-06 1.2 1.54935213415e-06 1.2 1.54938389228e-06 1.2 1.54941565041e-06 1.2 1.54944740854e-06 1.2 1.54947916667e-06 1.2 1.5495109248e-06 1.2 1.54954268293e-06 1.2 1.54957444106e-06 1.2 1.54960619919e-06 1.2 1.54963795732e-06 1.2 1.54966971545e-06 1.2 1.54970147358e-06 1.2 1.54973323171e-06 1.2 1.54976498984e-06 1.2 1.54979674797e-06 1.2 1.5498285061e-06 1.2 1.54986026423e-06 1.2 1.54989202236e-06 1.2 1.54992378049e-06 1.2 1.54995553862e-06 1.2 1.54998729675e-06 1.2 1.55001905488e-06 1.2 1.55005081301e-06 1.2 1.55008257114e-06 1.2 1.55011432927e-06 1.2 1.5501460874e-06 1.2 1.55017784553e-06 1.2 1.55020960366e-06 1.2 1.55024136179e-06 1.2 1.55027311992e-06 1.2 1.55030487805e-06 1.2 1.55033663618e-06 1.2 1.55036839431e-06 1.2 1.55040015244e-06 1.2 1.55043191057e-06 1.2 1.5504636687e-06 1.2 1.55049542683e-06 1.2 1.55052718496e-06 1.2 1.55055894309e-06 1.2 1.55059070122e-06 1.2 1.55062245935e-06 1.2 1.55065421748e-06 1.2 1.55068597561e-06 1.2 1.55071773374e-06 1.2 1.55074949187e-06 1.2 1.55078125e-06 1.2 1.55081300813e-06 1.2 1.55084476626e-06 1.2 1.55087652439e-06 1.2 1.55090828252e-06 1.2 1.55094004065e-06 1.2 1.55097179878e-06 1.2 1.55100355691e-06 1.2 1.55103531504e-06 1.2 1.55106707317e-06 1.2 1.5510988313e-06 1.2 1.55113058943e-06 1.2 1.55116234756e-06 1.2 1.55119410569e-06 1.2 1.55122586382e-06 1.2 1.55125762195e-06 1.2 1.55128938008e-06 1.2 1.55132113821e-06 1.2 1.55135289634e-06 1.2 1.55138465447e-06 1.2 1.5514164126e-06 1.2 1.55144817073e-06 1.2 1.55147992886e-06 1.2 1.55151168699e-06 1.2 1.55154344512e-06 1.2 1.55157520325e-06 1.2 1.55160696138e-06 1.2 1.55163871951e-06 1.2 1.55167047764e-06 1.2 1.55170223577e-06 1.2 1.5517339939e-06 1.2 1.55176575203e-06 1.2 1.55179751016e-06 1.2 1.55182926829e-06 1.2 1.55186102642e-06 1.2 1.55189278455e-06 1.2 1.55192454268e-06 1.2 1.55195630081e-06 1.2 1.55198805894e-06 1.2 1.55201981707e-06 1.2 1.5520515752e-06 1.2 1.55208333333e-06 1.2 1.55211509146e-06 1.2 1.55214684959e-06 1.2 1.55217860772e-06 1.2 1.55221036585e-06 1.2 1.55224212398e-06 1.2 1.55227388211e-06 1.2 1.55230564024e-06 1.2 1.55233739837e-06 1.2 1.5523691565e-06 1.2 1.55240091463e-06 1.2 1.55243267276e-06 1.2 1.55246443089e-06 1.2 1.55249618902e-06 1.2 1.55252794715e-06 1.2 1.55255970528e-06 1.2 1.55259146341e-06 1.2 1.55262322154e-06 1.2 1.55265497967e-06 1.2 1.5526867378e-06 1.2 1.55271849593e-06 1.2 1.55275025407e-06 1.2 1.5527820122e-06 1.2 1.55281377033e-06 1.2 1.55284552846e-06 1.2 1.55287728659e-06 1.2 1.55290904472e-06 1.2 1.55294080285e-06 1.2 1.55297256098e-06 1.2 1.55300431911e-06 1.2 1.55303607724e-06 1.2 1.55306783537e-06 1.2 1.5530995935e-06 1.2 1.55313135163e-06 1.2 1.55316310976e-06 1.2 1.55319486789e-06 1.2 1.55322662602e-06 1.2 1.55325838415e-06 1.2 1.55329014228e-06 1.2 1.55332190041e-06 1.2 1.55335365854e-06 1.2 1.55338541667e-06 1.2 1.5534171748e-06 1.2 1.55344893293e-06 1.2 1.55348069106e-06 1.2 1.55351244919e-06 1.2 1.55354420732e-06 1.2 1.55357596545e-06 1.2 1.55360772358e-06 1.2 1.55363948171e-06 1.2 1.55367123984e-06 1.2 1.55370299797e-06 1.2 1.5537347561e-06 1.2 1.55376651423e-06 1.2 1.55379827236e-06 1.2 1.55383003049e-06 1.2 1.55386178862e-06 1.2 1.55389354675e-06 1.2 1.55392530488e-06 1.2 1.55395706301e-06 1.2 1.55398882114e-06 1.2 1.55402057927e-06 1.2 1.5540523374e-06 1.2 1.55408409553e-06 1.2 1.55411585366e-06 1.2 1.55414761179e-06 1.2 1.55417936992e-06 1.2 1.55421112805e-06 1.2 1.55424288618e-06 1.2 1.55427464431e-06 1.2 1.55430640244e-06 1.2 1.55433816057e-06 1.2 1.5543699187e-06 1.2 1.55440167683e-06 1.2 1.55443343496e-06 1.2 1.55446519309e-06 1.2 1.55449695122e-06 1.2 1.55452870935e-06 1.2 1.55456046748e-06 1.2 1.55459222561e-06 1.2 1.55462398374e-06 1.2 1.55465574187e-06 1.2 1.5546875e-06 1.2 1.55471925813e-06 1.2 1.55475101626e-06 1.2 1.55478277439e-06 1.2 1.55481453252e-06 1.2 1.55484629065e-06 1.2 1.55487804878e-06 1.2 1.55490980691e-06 1.2 1.55494156504e-06 1.2 1.55497332317e-06 1.2 1.5550050813e-06 1.2 1.55503683943e-06 1.2 1.55506859756e-06 1.2 1.55510035569e-06 1.2 1.55513211382e-06 1.2 1.55516387195e-06 1.2 1.55519563008e-06 1.2 1.55522738821e-06 1.2 1.55525914634e-06 1.2 1.55529090447e-06 1.2 1.5553226626e-06 1.2 1.55535442073e-06 1.2 1.55538617886e-06 1.2 1.55541793699e-06 1.2 1.55544969512e-06 1.2 1.55548145325e-06 1.2 1.55551321138e-06 1.2 1.55554496951e-06 1.2 1.55557672764e-06 1.2 1.55560848577e-06 1.2 1.5556402439e-06 1.2 1.55567200203e-06 1.2 1.55570376016e-06 1.2 1.55573551829e-06 1.2 1.55576727642e-06 1.2 1.55579903455e-06 1.2 1.55583079268e-06 1.2 1.55586255081e-06 1.2 1.55589430894e-06 1.2 1.55592606707e-06 1.2 1.5559578252e-06 1.2 1.55598958333e-06 1.2 1.55602134146e-06 1.2 1.55605309959e-06 1.2 1.55608485772e-06 1.2 1.55611661585e-06 1.2 1.55614837398e-06 1.2 1.55618013211e-06 1.2 1.55621189024e-06 1.2 1.55624364837e-06 1.2 1.5562754065e-06 1.2 1.55630716463e-06 1.2 1.55633892276e-06 1.2 1.55637068089e-06 1.2 1.55640243902e-06 1.2 1.55643419715e-06 1.2 1.55646595528e-06 1.2 1.55649771341e-06 1.2 1.55652947154e-06 1.2 1.55656122967e-06 1.2 1.5565929878e-06 1.2 1.55662474593e-06 1.2 1.55665650407e-06 1.2 1.5566882622e-06 1.2 1.55672002033e-06 1.2 1.55675177846e-06 1.2 1.55678353659e-06 1.2 1.55681529472e-06 1.2 1.55684705285e-06 1.2 1.55687881098e-06 1.2 1.55691056911e-06 1.2 1.55694232724e-06 1.2 1.55697408537e-06 1.2 1.5570058435e-06 1.2 1.55703760163e-06 1.2 1.55706935976e-06 1.2 1.55710111789e-06 1.2 1.55713287602e-06 1.2 1.55716463415e-06 1.2 1.55719639228e-06 1.2 1.55722815041e-06 1.2 1.55725990854e-06 1.2 1.55729166667e-06 1.2 1.5573234248e-06 1.2 1.55735518293e-06 1.2 1.55738694106e-06 1.2 1.55741869919e-06 1.2 1.55745045732e-06 1.2 1.55748221545e-06 1.2 1.55751397358e-06 1.2 1.55754573171e-06 1.2 1.55757748984e-06 1.2 1.55760924797e-06 1.2 1.5576410061e-06 1.2 1.55767276423e-06 1.2 1.55770452236e-06 1.2 1.55773628049e-06 1.2 1.55776803862e-06 1.2 1.55779979675e-06 1.2 1.55783155488e-06 1.2 1.55786331301e-06 1.2 1.55789507114e-06 1.2 1.55792682927e-06 1.2 1.5579585874e-06 1.2 1.55799034553e-06 1.2 1.55802210366e-06 1.2 1.55805386179e-06 1.2 1.55808561992e-06 1.2 1.55811737805e-06 1.2 1.55814913618e-06 1.2 1.55818089431e-06 1.2 1.55821265244e-06 1.2 1.55824441057e-06 1.2 1.5582761687e-06 1.2 1.55830792683e-06 1.2 1.55833968496e-06 1.2 1.55837144309e-06 1.2 1.55840320122e-06 1.2 1.55843495935e-06 1.2 1.55846671748e-06 1.2 1.55849847561e-06 1.2 1.55853023374e-06 1.2 1.55856199187e-06 1.2 1.55859375e-06 1.2 1.55862550813e-06 1.2 1.55865726626e-06 1.2 1.55868902439e-06 1.2 1.55872078252e-06 1.2 1.55875254065e-06 1.2 1.55878429878e-06 1.2 1.55881605691e-06 1.2 1.55884781504e-06 1.2 1.55887957317e-06 1.2 1.5589113313e-06 1.2 1.55894308943e-06 1.2 1.55897484756e-06 1.2 1.55900660569e-06 1.2 1.55903836382e-06 1.2 1.55907012195e-06 1.2 1.55910188008e-06 1.2 1.55913363821e-06 1.2 1.55916539634e-06 1.2 1.55919715447e-06 1.2 1.5592289126e-06 1.2 1.55926067073e-06 1.2 1.55929242886e-06 1.2 1.55932418699e-06 1.2 1.55935594512e-06 1.2 1.55938770325e-06 1.2 1.55941946138e-06 1.2 1.55945121951e-06 1.2 1.55948297764e-06 1.2 1.55951473577e-06 1.2 1.5595464939e-06 1.2 1.55957825203e-06 1.2 1.55961001016e-06 1.2 1.55964176829e-06 1.2 1.55967352642e-06 1.2 1.55970528455e-06 1.2 1.55973704268e-06 1.2 1.55976880081e-06 1.2 1.55980055894e-06 1.2 1.55983231707e-06 1.2 1.5598640752e-06 1.2 1.55989583333e-06 1.2 1.55992759146e-06 1.2 1.55995934959e-06 1.2 1.55999110772e-06 1.2 1.56002286585e-06 1.2 1.56005462398e-06 1.2 1.56008638211e-06 1.2 1.56011814024e-06 1.2 1.56014989837e-06 1.2 1.5601816565e-06 1.2 1.56021341463e-06 1.2 1.56024517276e-06 1.2 1.56027693089e-06 1.2 1.56030868902e-06 1.2 1.56034044715e-06 1.2 1.56037220528e-06 1.2 1.56040396341e-06 1.2 1.56043572154e-06 1.2 1.56046747967e-06 1.2 1.5604992378e-06 1.2 1.56053099593e-06 1.2 1.56056275407e-06 1.2 1.5605945122e-06 1.2 1.56062627033e-06 1.2 1.56065802846e-06 1.2 1.56068978659e-06 1.2 1.56072154472e-06 1.2 1.56075330285e-06 1.2 1.56078506098e-06 1.2 1.56081681911e-06 1.2 1.56084857724e-06 1.2 1.56088033537e-06 1.2 1.5609120935e-06 1.2 1.56094385163e-06 1.2 1.56097560976e-06 1.2 1.56100736789e-06 1.2 1.56103912602e-06 1.2 1.56107088415e-06 1.2 1.56110264228e-06 1.2 1.56113440041e-06 1.2 1.56116615854e-06 1.2 1.56119791667e-06 1.2 1.5612296748e-06 1.2 1.56126143293e-06 1.2 1.56129319106e-06 1.2 1.56132494919e-06 1.2 1.56135670732e-06 1.2 1.56138846545e-06 1.2 1.56142022358e-06 1.2 1.56145198171e-06 1.2 1.56148373984e-06 1.2 1.56151549797e-06 1.2 1.5615472561e-06 1.2 1.56157901423e-06 1.2 1.56161077236e-06 1.2 1.56164253049e-06 1.2 1.56167428862e-06 1.2 1.56170604675e-06 1.2 1.56173780488e-06 1.2 1.56176956301e-06 1.2 1.56180132114e-06 1.2 1.56183307927e-06 1.2 1.5618648374e-06 1.2 1.56189659553e-06 1.2 1.56192835366e-06 1.2 1.56196011179e-06 1.2 1.56199186992e-06 1.2 1.56202362805e-06 1.2 1.56205538618e-06 1.2 1.56208714431e-06 1.2 1.56211890244e-06 1.2 1.56215066057e-06 1.2 1.5621824187e-06 1.2 1.56221417683e-06 1.2 1.56224593496e-06 1.2 1.56227769309e-06 1.2 1.56230945122e-06 1.2 1.56234120935e-06 1.2 1.56237296748e-06 1.2 1.56240472561e-06 1.2 1.56243648374e-06 1.2 1.56246824187e-06 1.2 1.5625e-06 1.2 1.56253175813e-06 1.2 1.56256351626e-06 1.2 1.56259527439e-06 1.2 1.56262703252e-06 1.2 1.56265879065e-06 1.2 1.56269054878e-06 1.2 1.56272230691e-06 1.2 1.56275406504e-06 1.2 1.56278582317e-06 1.2 1.5628175813e-06 1.2 1.56284933943e-06 1.2 1.56288109756e-06 1.2 1.56291285569e-06 1.2 1.56294461382e-06 1.2 1.56297637195e-06 1.2 1.56300813008e-06 1.2 1.56303988821e-06 1.2 1.56307164634e-06 1.2 1.56310340447e-06 1.2 1.5631351626e-06 1.2 1.56316692073e-06 1.2 1.56319867886e-06 1.2 1.56323043699e-06 1.2 1.56326219512e-06 1.2 1.56329395325e-06 1.2 1.56332571138e-06 1.2 1.56335746951e-06 1.2 1.56338922764e-06 1.2 1.56342098577e-06 1.2 1.5634527439e-06 1.2 1.56348450203e-06 1.2 1.56351626016e-06 1.2 1.56354801829e-06 1.2 1.56357977642e-06 1.2 1.56361153455e-06 1.2 1.56364329268e-06 1.2 1.56367505081e-06 1.2 1.56370680894e-06 1.2 1.56373856707e-06 1.2 1.5637703252e-06 1.2 1.56380208333e-06 1.2 1.56383384146e-06 1.2 1.56386559959e-06 1.2 1.56389735772e-06 1.2 1.56392911585e-06 1.2 1.56396087398e-06 1.2 1.56399263211e-06 1.2 1.56402439024e-06 1.2 1.56405614837e-06 1.2 1.5640879065e-06 1.2 1.56411966463e-06 1.2 1.56415142276e-06 1.2 1.56418318089e-06 1.2 1.56421493902e-06 1.2 1.56424669715e-06 1.2 1.56427845528e-06 1.2 1.56431021341e-06 1.2 1.56434197154e-06 1.2 1.56437372967e-06 1.2 1.5644054878e-06 1.2 1.56443724593e-06 1.2 1.56446900407e-06 1.2 1.5645007622e-06 1.2 1.56453252033e-06 1.2 1.56456427846e-06 1.2 1.56459603659e-06 1.2 1.56462779472e-06 1.2 1.56465955285e-06 1.2 1.56469131098e-06 1.2 1.56472306911e-06 1.2 1.56475482724e-06 1.2 1.56478658537e-06 1.2 1.5648183435e-06 1.2 1.56485010163e-06 1.2 1.56488185976e-06 1.2 1.56491361789e-06 1.2 1.56494537602e-06 1.2 1.56497713415e-06 1.2 1.56500889228e-06 1.2 1.56504065041e-06 1.2 1.56507240854e-06 1.2 1.56510416667e-06 1.2 1.5651359248e-06 1.2 1.56516768293e-06 1.2 1.56519944106e-06 1.2 1.56523119919e-06 1.2 1.56526295732e-06 1.2 1.56529471545e-06 1.2 1.56532647358e-06 1.2 1.56535823171e-06 1.2 1.56538998984e-06 1.2 1.56542174797e-06 1.2 1.5654535061e-06 1.2 1.56548526423e-06 1.2 1.56551702236e-06 1.2 1.56554878049e-06 1.2 1.56558053862e-06 1.2 1.56561229675e-06 1.2 1.56564405488e-06 1.2 1.56567581301e-06 1.2 1.56570757114e-06 1.2 1.56573932927e-06 1.2 1.5657710874e-06 1.2 1.56580284553e-06 1.2 1.56583460366e-06 1.2 1.56586636179e-06 1.2 1.56589811992e-06 1.2 1.56592987805e-06 1.2 1.56596163618e-06 1.2 1.56599339431e-06 1.2 1.56602515244e-06 1.2 1.56605691057e-06 1.2 1.5660886687e-06 1.2 1.56612042683e-06 1.2 1.56615218496e-06 1.2 1.56618394309e-06 1.2 1.56621570122e-06 1.2 1.56624745935e-06 1.2 1.56627921748e-06 1.2 1.56631097561e-06 1.2 1.56634273374e-06 1.2 1.56637449187e-06 1.2 1.56640625e-06 1.2 1.56643800813e-06 1.2 1.56646976626e-06 1.2 1.56650152439e-06 1.2 1.56653328252e-06 1.2 1.56656504065e-06 1.2 1.56659679878e-06 1.2 1.56662855691e-06 1.2 1.56666031504e-06 1.2 1.56669207317e-06 1.2 1.5667238313e-06 1.2 1.56675558943e-06 1.2 1.56678734756e-06 1.2 1.56681910569e-06 1.2 1.56685086382e-06 1.2 1.56688262195e-06 1.2 1.56691438008e-06 1.2 1.56694613821e-06 1.2 1.56697789634e-06 1.2 1.56700965447e-06 1.2 1.5670414126e-06 1.2 1.56707317073e-06 1.2 1.56710492886e-06 1.2 1.56713668699e-06 1.2 1.56716844512e-06 1.2 1.56720020325e-06 1.2 1.56723196138e-06 1.2 1.56726371951e-06 1.2 1.56729547764e-06 1.2 1.56732723577e-06 1.2 1.5673589939e-06 1.2 1.56739075203e-06 1.2 1.56742251016e-06 1.2 1.56745426829e-06 1.2 1.56748602642e-06 1.2 1.56751778455e-06 1.2 1.56754954268e-06 1.2 1.56758130081e-06 1.2 1.56761305894e-06 1.2 1.56764481707e-06 1.2 1.5676765752e-06 1.2 1.56770833333e-06 1.2 1.56774009146e-06 1.2 1.56777184959e-06 1.2 1.56780360772e-06 1.2 1.56783536585e-06 1.2 1.56786712398e-06 1.2 1.56789888211e-06 1.2 1.56793064024e-06 1.2 1.56796239837e-06 1.2 1.5679941565e-06 1.2 1.56802591463e-06 1.2 1.56805767276e-06 1.2 1.56808943089e-06 1.2 1.56812118902e-06 1.2 1.56815294715e-06 1.2 1.56818470528e-06 1.2 1.56821646341e-06 1.2 1.56824822154e-06 1.2 1.56827997967e-06 1.2 1.5683117378e-06 1.2 1.56834349593e-06 1.2 1.56837525407e-06 1.2 1.5684070122e-06 1.2 1.56843877033e-06 1.2 1.56847052846e-06 1.2 1.56850228659e-06 1.2 1.56853404472e-06 1.2 1.56856580285e-06 1.2 1.56859756098e-06 1.2 1.56862931911e-06 1.2 1.56866107724e-06 1.2 1.56869283537e-06 1.2 1.5687245935e-06 1.2 1.56875635163e-06 1.2 1.56878810976e-06 1.2 1.56881986789e-06 1.2 1.56885162602e-06 1.2 1.56888338415e-06 1.2 1.56891514228e-06 1.2 1.56894690041e-06 1.2 1.56897865854e-06 1.2 1.56901041667e-06 1.2 1.5690421748e-06 1.2 1.56907393293e-06 1.2 1.56910569106e-06 1.2 1.56913744919e-06 1.2 1.56916920732e-06 1.2 1.56920096545e-06 1.2 1.56923272358e-06 1.2 1.56926448171e-06 1.2 1.56929623984e-06 1.2 1.56932799797e-06 1.2 1.5693597561e-06 1.2 1.56939151423e-06 1.2 1.56942327236e-06 1.2 1.56945503049e-06 1.2 1.56948678862e-06 1.2 1.56951854675e-06 1.2 1.56955030488e-06 1.2 1.56958206301e-06 1.2 1.56961382114e-06 1.2 1.56964557927e-06 1.2 1.5696773374e-06 1.2 1.56970909553e-06 1.2 1.56974085366e-06 1.2 1.56977261179e-06 1.2 1.56980436992e-06 1.2 1.56983612805e-06 1.2 1.56986788618e-06 1.2 1.56989964431e-06 1.2 1.56993140244e-06 1.2 1.56996316057e-06 1.2 1.5699949187e-06 1.2 1.57002667683e-06 1.2 1.57005843496e-06 1.2 1.57009019309e-06 1.2 1.57012195122e-06 1.2 1.57015370935e-06 1.2 1.57018546748e-06 1.2 1.57021722561e-06 1.2 1.57024898374e-06 1.2 1.57028074187e-06 1.2 1.5703125e-06 1.2 1.57034425813e-06 1.2 1.57037601626e-06 1.2 1.57040777439e-06 1.2 1.57043953252e-06 1.2 1.57047129065e-06 1.2 1.57050304878e-06 1.2 1.57053480691e-06 1.2 1.57056656504e-06 1.2 1.57059832317e-06 1.2 1.5706300813e-06 1.2 1.57066183943e-06 1.2 1.57069359756e-06 1.2 1.57072535569e-06 1.2 1.57075711382e-06 1.2 1.57078887195e-06 1.2 1.57082063008e-06 1.2 1.57085238821e-06 1.2 1.57088414634e-06 1.2 1.57091590447e-06 1.2 1.5709476626e-06 1.2 1.57097942073e-06 1.2 1.57101117886e-06 1.2 1.57104293699e-06 1.2 1.57107469512e-06 1.2 1.57110645325e-06 1.2 1.57113821138e-06 1.2 1.57116996951e-06 1.2 1.57120172764e-06 1.2 1.57123348577e-06 1.2 1.5712652439e-06 1.2 1.57129700203e-06 1.2 1.57132876016e-06 1.2 1.57136051829e-06 1.2 1.57139227642e-06 1.2 1.57142403455e-06 1.2 1.57145579268e-06 1.2 1.57148755081e-06 1.2 1.57151930894e-06 1.2 1.57155106707e-06 1.2 1.5715828252e-06 1.2 1.57161458333e-06 1.2 1.57164634146e-06 1.2 1.57167809959e-06 1.2 1.57170985772e-06 1.2 1.57174161585e-06 1.2 1.57177337398e-06 1.2 1.57180513211e-06 1.2 1.57183689024e-06 1.2 1.57186864837e-06 1.2 1.5719004065e-06 1.2 1.57193216463e-06 1.2 1.57196392276e-06 1.2 1.57199568089e-06 1.2 1.57202743902e-06 1.2 1.57205919715e-06 1.2 1.57209095528e-06 1.2 1.57212271341e-06 1.2 1.57215447154e-06 1.2 1.57218622967e-06 1.2 1.5722179878e-06 1.2 1.57224974593e-06 1.2 1.57228150407e-06 1.2 1.5723132622e-06 1.2 1.57234502033e-06 1.2 1.57237677846e-06 1.2 1.57240853659e-06 1.2 1.57244029472e-06 1.2 1.57247205285e-06 1.2 1.57250381098e-06 1.2 1.57253556911e-06 1.2 1.57256732724e-06 1.2 1.57259908537e-06 1.2 1.5726308435e-06 1.2 1.57266260163e-06 1.2 1.57269435976e-06 1.2 1.57272611789e-06 1.2 1.57275787602e-06 1.2 1.57278963415e-06 1.2 1.57282139228e-06 1.2 1.57285315041e-06 1.2 1.57288490854e-06 1.2 1.57291666667e-06 1.2 1.5729484248e-06 1.2 1.57298018293e-06 1.2 1.57301194106e-06 1.2 1.57304369919e-06 1.2 1.57307545732e-06 1.2 1.57310721545e-06 1.2 1.57313897358e-06 1.2 1.57317073171e-06 1.2 1.57320248984e-06 1.2 1.57323424797e-06 1.2 1.5732660061e-06 1.2 1.57329776423e-06 1.2 1.57332952236e-06 1.2 1.57336128049e-06 1.2 1.57339303862e-06 1.2 1.57342479675e-06 1.2 1.57345655488e-06 1.2 1.57348831301e-06 1.2 1.57352007114e-06 1.2 1.57355182927e-06 1.2 1.5735835874e-06 1.2 1.57361534553e-06 1.2 1.57364710366e-06 1.2 1.57367886179e-06 1.2 1.57371061992e-06 1.2 1.57374237805e-06 1.2 1.57377413618e-06 1.2 1.57380589431e-06 1.2 1.57383765244e-06 1.2 1.57386941057e-06 1.2 1.5739011687e-06 1.2 1.57393292683e-06 1.2 1.57396468496e-06 1.2 1.57399644309e-06 1.2 1.57402820122e-06 1.2 1.57405995935e-06 1.2 1.57409171748e-06 1.2 1.57412347561e-06 1.2 1.57415523374e-06 1.2 1.57418699187e-06 1.2 1.57421875e-06 1.2 1.57425050813e-06 1.2 1.57428226626e-06 1.2 1.57431402439e-06 1.2 1.57434578252e-06 1.2 1.57437754065e-06 1.2 1.57440929878e-06 1.2 1.57444105691e-06 1.2 1.57447281504e-06 1.2 1.57450457317e-06 1.2 1.5745363313e-06 1.2 1.57456808943e-06 1.2 1.57459984756e-06 1.2 1.57463160569e-06 1.2 1.57466336382e-06 1.2 1.57469512195e-06 1.2 1.57472688008e-06 1.2 1.57475863821e-06 1.2 1.57479039634e-06 1.2 1.57482215447e-06 1.2 1.5748539126e-06 1.2 1.57488567073e-06 1.2 1.57491742886e-06 1.2 1.57494918699e-06 1.2 1.57498094512e-06 1.2 1.57501270325e-06 1.2 1.57504446138e-06 1.2 1.57507621951e-06 1.2 1.57510797764e-06 1.2 1.57513973577e-06 1.2 1.5751714939e-06 1.2 1.57520325203e-06 1.2 1.57523501016e-06 1.2 1.57526676829e-06 1.2 1.57529852642e-06 1.2 1.57533028455e-06 1.2 1.57536204268e-06 1.2 1.57539380081e-06 1.2 1.57542555894e-06 1.2 1.57545731707e-06 1.2 1.5754890752e-06 1.2 1.57552083333e-06 1.2 1.57555259146e-06 1.2 1.57558434959e-06 1.2 1.57561610772e-06 1.2 1.57564786585e-06 1.2 1.57567962398e-06 1.2 1.57571138211e-06 1.2 1.57574314024e-06 1.2 1.57577489837e-06 1.2 1.5758066565e-06 1.2 1.57583841463e-06 1.2 1.57587017276e-06 1.2 1.57590193089e-06 1.2 1.57593368902e-06 1.2 1.57596544715e-06 1.2 1.57599720528e-06 1.2 1.57602896341e-06 1.2 1.57606072154e-06 1.2 1.57609247967e-06 1.2 1.5761242378e-06 1.2 1.57615599593e-06 1.2 1.57618775407e-06 1.2 1.5762195122e-06 1.2 1.57625127033e-06 1.2 1.57628302846e-06 1.2 1.57631478659e-06 1.2 1.57634654472e-06 1.2 1.57637830285e-06 1.2 1.57641006098e-06 1.2 1.57644181911e-06 1.2 1.57647357724e-06 1.2 1.57650533537e-06 1.2 1.5765370935e-06 1.2 1.57656885163e-06 1.2 1.57660060976e-06 1.2 1.57663236789e-06 1.2 1.57666412602e-06 1.2 1.57669588415e-06 1.2 1.57672764228e-06 1.2 1.57675940041e-06 1.2 1.57679115854e-06 1.2 1.57682291667e-06 1.2 1.5768546748e-06 1.2 1.57688643293e-06 1.2 1.57691819106e-06 1.2 1.57694994919e-06 1.2 1.57698170732e-06 1.2 1.57701346545e-06 1.2 1.57704522358e-06 1.2 1.57707698171e-06 1.2 1.57710873984e-06 1.2 1.57714049797e-06 1.2 1.5771722561e-06 1.2 1.57720401423e-06 1.2 1.57723577236e-06 1.2 1.57726753049e-06 1.2 1.57729928862e-06 1.2 1.57733104675e-06 1.2 1.57736280488e-06 1.2 1.57739456301e-06 1.2 1.57742632114e-06 1.2 1.57745807927e-06 1.2 1.5774898374e-06 1.2 1.57752159553e-06 1.2 1.57755335366e-06 1.2 1.57758511179e-06 1.2 1.57761686992e-06 1.2 1.57764862805e-06 1.2 1.57768038618e-06 1.2 1.57771214431e-06 1.2 1.57774390244e-06 1.2 1.57777566057e-06 1.2 1.5778074187e-06 1.2 1.57783917683e-06 1.2 1.57787093496e-06 1.2 1.57790269309e-06 1.2 1.57793445122e-06 1.2 1.57796620935e-06 1.2 1.57799796748e-06 1.2 1.57802972561e-06 1.2 1.57806148374e-06 1.2 1.57809324187e-06 1.2 1.578125e-06 1.2 1.57815675813e-06 1.2 1.57818851626e-06 1.2 1.57822027439e-06 1.2 1.57825203252e-06 1.2 1.57828379065e-06 1.2 1.57831554878e-06 1.2 1.57834730691e-06 1.2 1.57837906504e-06 1.2 1.57841082317e-06 1.2 1.5784425813e-06 1.2 1.57847433943e-06 1.2 1.57850609756e-06 1.2 1.57853785569e-06 1.2 1.57856961382e-06 1.2 1.57860137195e-06 1.2 1.57863313008e-06 1.2 1.57866488821e-06 1.2 1.57869664634e-06 1.2 1.57872840447e-06 1.2 1.5787601626e-06 1.2 1.57879192073e-06 1.2 1.57882367886e-06 1.2 1.57885543699e-06 1.2 1.57888719512e-06 1.2 1.57891895325e-06 1.2 1.57895071138e-06 1.2 1.57898246951e-06 1.2 1.57901422764e-06 1.2 1.57904598577e-06 1.2 1.5790777439e-06 1.2 1.57910950203e-06 1.2 1.57914126016e-06 1.2 1.57917301829e-06 1.2 1.57920477642e-06 1.2 1.57923653455e-06 1.2 1.57926829268e-06 1.2 1.57930005081e-06 1.2 1.57933180894e-06 1.2 1.57936356707e-06 1.2 1.5793953252e-06 1.2 1.57942708333e-06 1.2 1.57945884146e-06 1.2 1.57949059959e-06 1.2 1.57952235772e-06 1.2 1.57955411585e-06 1.2 1.57958587398e-06 1.2 1.57961763211e-06 1.2 1.57964939024e-06 1.2 1.57968114837e-06 1.2 1.5797129065e-06 1.2 1.57974466463e-06 1.2 1.57977642276e-06 1.2 1.57980818089e-06 1.2 1.57983993902e-06 1.2 1.57987169715e-06 1.2 1.57990345528e-06 1.2 1.57993521341e-06 1.2 1.57996697154e-06 1.2 1.57999872967e-06 1.2 1.5800304878e-06 1.2 1.58006224593e-06 1.2 1.58009400407e-06 1.2 1.5801257622e-06 1.2 1.58015752033e-06 1.2 1.58018927846e-06 1.2 1.58022103659e-06 1.2 1.58025279472e-06 1.2 1.58028455285e-06 1.2 1.58031631098e-06 1.2 1.58034806911e-06 1.2 1.58037982724e-06 1.2 1.58041158537e-06 1.2 1.5804433435e-06 1.2 1.58047510163e-06 1.2 1.58050685976e-06 1.2 1.58053861789e-06 1.2 1.58057037602e-06 1.2 1.58060213415e-06 1.2 1.58063389228e-06 1.2 1.58066565041e-06 1.2 1.58069740854e-06 1.2 1.58072916667e-06 1.2 1.5807609248e-06 1.2 1.58079268293e-06 1.2 1.58082444106e-06 1.2 1.58085619919e-06 1.2 1.58088795732e-06 1.2 1.58091971545e-06 1.2 1.58095147358e-06 1.2 1.58098323171e-06 1.2 1.58101498984e-06 1.2 1.58104674797e-06 1.2 1.5810785061e-06 1.2 1.58111026423e-06 1.2 1.58114202236e-06 1.2 1.58117378049e-06 1.2 1.58120553862e-06 1.2 1.58123729675e-06 1.2 1.58126905488e-06 1.2 1.58130081301e-06 1.2 1.58133257114e-06 1.2 1.58136432927e-06 1.2 1.5813960874e-06 1.2 1.58142784553e-06 1.2 1.58145960366e-06 1.2 1.58149136179e-06 1.2 1.58152311992e-06 1.2 1.58155487805e-06 1.2 1.58158663618e-06 1.2 1.58161839431e-06 1.2 1.58165015244e-06 1.2 1.58168191057e-06 1.2 1.5817136687e-06 1.2 1.58174542683e-06 1.2 1.58177718496e-06 1.2 1.58180894309e-06 1.2 1.58184070122e-06 1.2 1.58187245935e-06 1.2 1.58190421748e-06 1.2 1.58193597561e-06 1.2 1.58196773374e-06 1.2 1.58199949187e-06 1.2 1.58203125e-06 1.2 1.58206300813e-06 1.2 1.58209476626e-06 1.2 1.58212652439e-06 1.2 1.58215828252e-06 1.2 1.58219004065e-06 1.2 1.58222179878e-06 1.2 1.58225355691e-06 1.2 1.58228531504e-06 1.2 1.58231707317e-06 1.2 1.5823488313e-06 1.2 1.58238058943e-06 1.2 1.58241234756e-06 1.2 1.58244410569e-06 1.2 1.58247586382e-06 1.2 1.58250762195e-06 1.2 1.58253938008e-06 1.2 1.58257113821e-06 1.2 1.58260289634e-06 1.2 1.58263465447e-06 1.2 1.5826664126e-06 1.2 1.58269817073e-06 1.2 1.58272992886e-06 1.2 1.58276168699e-06 1.2 1.58279344512e-06 1.2 1.58282520325e-06 1.2 1.58285696138e-06 1.2 1.58288871951e-06 1.2 1.58292047764e-06 1.2 1.58295223577e-06 1.2 1.5829839939e-06 1.2 1.58301575203e-06 1.2 1.58304751016e-06 1.2 1.58307926829e-06 1.2 1.58311102642e-06 1.2 1.58314278455e-06 1.2 1.58317454268e-06 1.2 1.58320630081e-06 1.2 1.58323805894e-06 1.2 1.58326981707e-06 1.2 1.5833015752e-06 1.2 1.58333333333e-06 1.2 1.58336509146e-06 1.2 1.58339684959e-06 1.2 1.58342860772e-06 1.2 1.58346036585e-06 1.2 1.58349212398e-06 1.2 1.58352388211e-06 1.2 1.58355564024e-06 1.2 1.58358739837e-06 1.2 1.5836191565e-06 1.2 1.58365091463e-06 1.2 1.58368267276e-06 1.2 1.58371443089e-06 1.2 1.58374618902e-06 1.2 1.58377794715e-06 1.2 1.58380970528e-06 1.2 1.58384146341e-06 1.2 1.58387322154e-06 1.2 1.58390497967e-06 1.2 1.5839367378e-06 1.2 1.58396849593e-06 1.2 1.58400025407e-06 1.2 1.5840320122e-06 1.2 1.58406377033e-06 1.2 1.58409552846e-06 1.2 1.58412728659e-06 1.2 1.58415904472e-06 1.2 1.58419080285e-06 1.2 1.58422256098e-06 1.2 1.58425431911e-06 1.2 1.58428607724e-06 1.2 1.58431783537e-06 1.2 1.5843495935e-06 1.2 1.58438135163e-06 1.2 1.58441310976e-06 1.2 1.58444486789e-06 1.2 1.58447662602e-06 1.2 1.58450838415e-06 1.2 1.58454014228e-06 1.2 1.58457190041e-06 1.2 1.58460365854e-06 1.2 1.58463541667e-06 1.2 1.5846671748e-06 1.2 1.58469893293e-06 1.2 1.58473069106e-06 1.2 1.58476244919e-06 1.2 1.58479420732e-06 1.2 1.58482596545e-06 1.2 1.58485772358e-06 1.2 1.58488948171e-06 1.2 1.58492123984e-06 1.2 1.58495299797e-06 1.2 1.5849847561e-06 1.2 1.58501651423e-06 1.2 1.58504827236e-06 1.2 1.58508003049e-06 1.2 1.58511178862e-06 1.2 1.58514354675e-06 1.2 1.58517530488e-06 1.2 1.58520706301e-06 1.2 1.58523882114e-06 1.2 1.58527057927e-06 1.2 1.5853023374e-06 1.2 1.58533409553e-06 1.2 1.58536585366e-06 1.2 1.58539761179e-06 1.2 1.58542936992e-06 1.2 1.58546112805e-06 1.2 1.58549288618e-06 1.2 1.58552464431e-06 1.2 1.58555640244e-06 1.2 1.58558816057e-06 1.2 1.5856199187e-06 1.2 1.58565167683e-06 1.2 1.58568343496e-06 1.2 1.58571519309e-06 1.2 1.58574695122e-06 1.2 1.58577870935e-06 1.2 1.58581046748e-06 1.2 1.58584222561e-06 1.2 1.58587398374e-06 1.2 1.58590574187e-06 1.2 1.5859375e-06 1.2 1.58596925813e-06 1.2 1.58600101626e-06 1.2 1.58603277439e-06 1.2 1.58606453252e-06 1.2 1.58609629065e-06 1.2 1.58612804878e-06 1.2 1.58615980691e-06 1.2 1.58619156504e-06 1.2 1.58622332317e-06 1.2 1.5862550813e-06 1.2 1.58628683943e-06 1.2 1.58631859756e-06 1.2 1.58635035569e-06 1.2 1.58638211382e-06 1.2 1.58641387195e-06 1.2 1.58644563008e-06 1.2 1.58647738821e-06 1.2 1.58650914634e-06 1.2 1.58654090447e-06 1.2 1.5865726626e-06 1.2 1.58660442073e-06 1.2 1.58663617886e-06 1.2 1.58666793699e-06 1.2 1.58669969512e-06 1.2 1.58673145325e-06 1.2 1.58676321138e-06 1.2 1.58679496951e-06 1.2 1.58682672764e-06 1.2 1.58685848577e-06 1.2 1.5868902439e-06 1.2 1.58692200203e-06 1.2 1.58695376016e-06 1.2 1.58698551829e-06 1.2 1.58701727642e-06 1.2 1.58704903455e-06 1.2 1.58708079268e-06 1.2 1.58711255081e-06 1.2 1.58714430894e-06 1.2 1.58717606707e-06 1.2 1.5872078252e-06 1.2 1.58723958333e-06 1.2 1.58727134146e-06 1.2 1.58730309959e-06 1.2 1.58733485772e-06 1.2 1.58736661585e-06 1.2 1.58739837398e-06 1.2 1.58743013211e-06 1.2 1.58746189024e-06 1.2 1.58749364837e-06 1.2 1.5875254065e-06 1.2 1.58755716463e-06 1.2 1.58758892276e-06 1.2 1.58762068089e-06 1.2 1.58765243902e-06 1.2 1.58768419715e-06 1.2 1.58771595528e-06 1.2 1.58774771341e-06 1.2 1.58777947154e-06 1.2 1.58781122967e-06 1.2 1.5878429878e-06 1.2 1.58787474593e-06 1.2 1.58790650407e-06 1.2 1.5879382622e-06 1.2 1.58797002033e-06 1.2 1.58800177846e-06 1.2 1.58803353659e-06 1.2 1.58806529472e-06 1.2 1.58809705285e-06 1.2 1.58812881098e-06 1.2 1.58816056911e-06 1.2 1.58819232724e-06 1.2 1.58822408537e-06 1.2 1.5882558435e-06 1.2 1.58828760163e-06 1.2 1.58831935976e-06 1.2 1.58835111789e-06 1.2 1.58838287602e-06 1.2 1.58841463415e-06 1.2 1.58844639228e-06 1.2 1.58847815041e-06 1.2 1.58850990854e-06 1.2 1.58854166667e-06 1.2 1.5885734248e-06 1.2 1.58860518293e-06 1.2 1.58863694106e-06 1.2 1.58866869919e-06 1.2 1.58870045732e-06 1.2 1.58873221545e-06 1.2 1.58876397358e-06 1.2 1.58879573171e-06 1.2 1.58882748984e-06 1.2 1.58885924797e-06 1.2 1.5888910061e-06 1.2 1.58892276423e-06 1.2 1.58895452236e-06 1.2 1.58898628049e-06 1.2 1.58901803862e-06 1.2 1.58904979675e-06 1.2 1.58908155488e-06 1.2 1.58911331301e-06 1.2 1.58914507114e-06 1.2 1.58917682927e-06 1.2 1.5892085874e-06 1.2 1.58924034553e-06 1.2 1.58927210366e-06 1.2 1.58930386179e-06 1.2 1.58933561992e-06 1.2 1.58936737805e-06 1.2 1.58939913618e-06 1.2 1.58943089431e-06 1.2 1.58946265244e-06 1.2 1.58949441057e-06 1.2 1.5895261687e-06 1.2 1.58955792683e-06 1.2 1.58958968496e-06 1.2 1.58962144309e-06 1.2 1.58965320122e-06 1.2 1.58968495935e-06 1.2 1.58971671748e-06 1.2 1.58974847561e-06 1.2 1.58978023374e-06 1.2 1.58981199187e-06 1.2 1.58984375e-06 1.2 1.58987550813e-06 1.2 1.58990726626e-06 1.2 1.58993902439e-06 1.2 1.58997078252e-06 1.2 1.59000254065e-06 1.2 1.59003429878e-06 1.2 1.59006605691e-06 1.2 1.59009781504e-06 1.2 1.59012957317e-06 1.2 1.5901613313e-06 1.2 1.59019308943e-06 1.2 1.59022484756e-06 1.2 1.59025660569e-06 1.2 1.59028836382e-06 1.2 1.59032012195e-06 1.2 1.59035188008e-06 1.2 1.59038363821e-06 1.2 1.59041539634e-06 1.2 1.59044715447e-06 1.2 1.5904789126e-06 1.2 1.59051067073e-06 1.2 1.59054242886e-06 1.2 1.59057418699e-06 1.2 1.59060594512e-06 1.2 1.59063770325e-06 1.2 1.59066946138e-06 1.2 1.59070121951e-06 1.2 1.59073297764e-06 1.2 1.59076473577e-06 1.2 1.5907964939e-06 1.2 1.59082825203e-06 1.2 1.59086001016e-06 1.2 1.59089176829e-06 1.2 1.59092352642e-06 1.2 1.59095528455e-06 1.2 1.59098704268e-06 1.2 1.59101880081e-06 1.2 1.59105055894e-06 1.2 1.59108231707e-06 1.2 1.5911140752e-06 1.2 1.59114583333e-06 1.2 1.59117759146e-06 1.2 1.59120934959e-06 1.2 1.59124110772e-06 1.2 1.59127286585e-06 1.2 1.59130462398e-06 1.2 1.59133638211e-06 1.2 1.59136814024e-06 1.2 1.59139989837e-06 1.2 1.5914316565e-06 1.2 1.59146341463e-06 1.2 1.59149517276e-06 1.2 1.59152693089e-06 1.2 1.59155868902e-06 1.2 1.59159044715e-06 1.2 1.59162220528e-06 1.2 1.59165396341e-06 1.2 1.59168572154e-06 1.2 1.59171747967e-06 1.2 1.5917492378e-06 1.2 1.59178099593e-06 1.2 1.59181275407e-06 1.2 1.5918445122e-06 1.2 1.59187627033e-06 1.2 1.59190802846e-06 1.2 1.59193978659e-06 1.2 1.59197154472e-06 1.2 1.59200330285e-06 1.2 1.59203506098e-06 1.2 1.59206681911e-06 1.2 1.59209857724e-06 1.2 1.59213033537e-06 1.2 1.5921620935e-06 1.2 1.59219385163e-06 1.2 1.59222560976e-06 1.2 1.59225736789e-06 1.2 1.59228912602e-06 1.2 1.59232088415e-06 1.2 1.59235264228e-06 1.2 1.59238440041e-06 1.2 1.59241615854e-06 1.2 1.59244791667e-06 1.2 1.5924796748e-06 1.2 1.59251143293e-06 1.2 1.59254319106e-06 1.2 1.59257494919e-06 1.2 1.59260670732e-06 1.2 1.59263846545e-06 1.2 1.59267022358e-06 1.2 1.59270198171e-06 1.2 1.59273373984e-06 1.2 1.59276549797e-06 1.2 1.5927972561e-06 1.2 1.59282901423e-06 1.2 1.59286077236e-06 1.2 1.59289253049e-06 1.2 1.59292428862e-06 1.2 1.59295604675e-06 1.2 1.59298780488e-06 1.2 1.59301956301e-06 1.2 1.59305132114e-06 1.2 1.59308307927e-06 1.2 1.5931148374e-06 1.2 1.59314659553e-06 1.2 1.59317835366e-06 1.2 1.59321011179e-06 1.2 1.59324186992e-06 1.2 1.59327362805e-06 1.2 1.59330538618e-06 1.2 1.59333714431e-06 1.2 1.59336890244e-06 1.2 1.59340066057e-06 1.2 1.5934324187e-06 1.2 1.59346417683e-06 1.2 1.59349593496e-06 1.2 1.59352769309e-06 1.2 1.59355945122e-06 1.2 1.59359120935e-06 1.2 1.59362296748e-06 1.2 1.59365472561e-06 1.2 1.59368648374e-06 1.2 1.59371824187e-06 1.2 1.59375e-06 1.2 1.59378175813e-06 1.2 1.59381351626e-06 1.2 1.59384527439e-06 1.2 1.59387703252e-06 1.2 1.59390879065e-06 1.2 1.59394054878e-06 1.2 1.59397230691e-06 1.2 1.59400406504e-06 1.2 1.59403582317e-06 1.2 1.5940675813e-06 1.2 1.59409933943e-06 1.2 1.59413109756e-06 1.2 1.59416285569e-06 1.2 1.59419461382e-06 1.2 1.59422637195e-06 1.2 1.59425813008e-06 1.2 1.59428988821e-06 1.2 1.59432164634e-06 1.2 1.59435340447e-06 1.2 1.5943851626e-06 1.2 1.59441692073e-06 1.2 1.59444867886e-06 1.2 1.59448043699e-06 1.2 1.59451219512e-06 1.2 1.59454395325e-06 1.2 1.59457571138e-06 1.2 1.59460746951e-06 1.2 1.59463922764e-06 1.2 1.59467098577e-06 1.2 1.5947027439e-06 1.2 1.59473450203e-06 1.2 1.59476626016e-06 1.2 1.59479801829e-06 1.2 1.59482977642e-06 1.2 1.59486153455e-06 1.2 1.59489329268e-06 1.2 1.59492505081e-06 1.2 1.59495680894e-06 1.2 1.59498856707e-06 1.2 1.5950203252e-06 1.2 1.59505208333e-06 1.2 1.59508384146e-06 1.2 1.59511559959e-06 1.2 1.59514735772e-06 1.2 1.59517911585e-06 1.2 1.59521087398e-06 1.2 1.59524263211e-06 1.2 1.59527439024e-06 1.2 1.59530614837e-06 1.2 1.5953379065e-06 1.2 1.59536966463e-06 1.2 1.59540142276e-06 1.2 1.59543318089e-06 1.2 1.59546493902e-06 1.2 1.59549669715e-06 1.2 1.59552845528e-06 1.2 1.59556021341e-06 1.2 1.59559197154e-06 1.2 1.59562372967e-06 1.2 1.5956554878e-06 1.2 1.59568724593e-06 1.2 1.59571900407e-06 1.2 1.5957507622e-06 1.2 1.59578252033e-06 1.2 1.59581427846e-06 1.2 1.59584603659e-06 1.2 1.59587779472e-06 1.2 1.59590955285e-06 1.2 1.59594131098e-06 1.2 1.59597306911e-06 1.2 1.59600482724e-06 1.2 1.59603658537e-06 1.2 1.5960683435e-06 1.2 1.59610010163e-06 1.2 1.59613185976e-06 1.2 1.59616361789e-06 1.2 1.59619537602e-06 1.2 1.59622713415e-06 1.2 1.59625889228e-06 1.2 1.59629065041e-06 1.2 1.59632240854e-06 1.2 1.59635416667e-06 1.2 1.5963859248e-06 1.2 1.59641768293e-06 1.2 1.59644944106e-06 1.2 1.59648119919e-06 1.2 1.59651295732e-06 1.2 1.59654471545e-06 1.2 1.59657647358e-06 1.2 1.59660823171e-06 1.2 1.59663998984e-06 1.2 1.59667174797e-06 1.2 1.5967035061e-06 1.2 1.59673526423e-06 1.2 1.59676702236e-06 1.2 1.59679878049e-06 1.2 1.59683053862e-06 1.2 1.59686229675e-06 1.2 1.59689405488e-06 1.2 1.59692581301e-06 1.2 1.59695757114e-06 1.2 1.59698932927e-06 1.2 1.5970210874e-06 1.2 1.59705284553e-06 1.2 1.59708460366e-06 1.2 1.59711636179e-06 1.2 1.59714811992e-06 1.2 1.59717987805e-06 1.2 1.59721163618e-06 1.2 1.59724339431e-06 1.2 1.59727515244e-06 1.2 1.59730691057e-06 1.2 1.5973386687e-06 1.2 1.59737042683e-06 1.2 1.59740218496e-06 1.2 1.59743394309e-06 1.2 1.59746570122e-06 1.2 1.59749745935e-06 1.2 1.59752921748e-06 1.2 1.59756097561e-06 1.2 1.59759273374e-06 1.2 1.59762449187e-06 1.2 1.59765625e-06 1.2 1.59768800813e-06 1.2 1.59771976626e-06 1.2 1.59775152439e-06 1.2 1.59778328252e-06 1.2 1.59781504065e-06 1.2 1.59784679878e-06 1.2 1.59787855691e-06 1.2 1.59791031504e-06 1.2 1.59794207317e-06 1.2 1.5979738313e-06 1.2 1.59800558943e-06 1.2 1.59803734756e-06 1.2 1.59806910569e-06 1.2 1.59810086382e-06 1.2 1.59813262195e-06 1.2 1.59816438008e-06 1.2 1.59819613821e-06 1.2 1.59822789634e-06 1.2 1.59825965447e-06 1.2 1.5982914126e-06 1.2 1.59832317073e-06 1.2 1.59835492886e-06 1.2 1.59838668699e-06 1.2 1.59841844512e-06 1.2 1.59845020325e-06 1.2 1.59848196138e-06 1.2 1.59851371951e-06 1.2 1.59854547764e-06 1.2 1.59857723577e-06 1.2 1.5986089939e-06 1.2 1.59864075203e-06 1.2 1.59867251016e-06 1.2 1.59870426829e-06 1.2 1.59873602642e-06 1.2 1.59876778455e-06 1.2 1.59879954268e-06 1.2 1.59883130081e-06 1.2 1.59886305894e-06 1.2 1.59889481707e-06 1.2 1.5989265752e-06 1.2 1.59895833333e-06 1.2 1.59899009146e-06 1.2 1.59902184959e-06 1.2 1.59905360772e-06 1.2 1.59908536585e-06 1.2 1.59911712398e-06 1.2 1.59914888211e-06 1.2 1.59918064024e-06 1.2 1.59921239837e-06 1.2 1.5992441565e-06 1.2 1.59927591463e-06 1.2 1.59930767276e-06 1.2 1.59933943089e-06 1.2 1.59937118902e-06 1.2 1.59940294715e-06 1.2 1.59943470528e-06 1.2 1.59946646341e-06 1.2 1.59949822154e-06 1.2 1.59952997967e-06 1.2 1.5995617378e-06 1.2 1.59959349593e-06 1.2 1.59962525407e-06 1.2 1.5996570122e-06 1.2 1.59968877033e-06 1.2 1.59972052846e-06 1.2 1.59975228659e-06 1.2 1.59978404472e-06 1.2 1.59981580285e-06 1.2 1.59984756098e-06 1.2 1.59987931911e-06 1.2 1.59991107724e-06 1.2 1.59994283537e-06 1.2 1.5999745935e-06 1.2 1.60000635163e-06 1.2 1.60003810976e-06 1.2 1.60006986789e-06 1.2 1.60010162602e-06 1.2 1.60013338415e-06 1.2 1.60016514228e-06 1.2 1.60019690041e-06 1.2 1.60022865854e-06 1.2 1.60026041667e-06 1.2 1.6002921748e-06 1.2 1.60032393293e-06 1.2 1.60035569106e-06 1.2 1.60038744919e-06 1.2 1.60041920732e-06 1.2 1.60045096545e-06 1.2 1.60048272358e-06 1.2 1.60051448171e-06 1.2 1.60054623984e-06 1.2 1.60057799797e-06 1.2 1.6006097561e-06 1.2 1.60064151423e-06 1.2 1.60067327236e-06 1.2 1.60070503049e-06 1.2 1.60073678862e-06 1.2 1.60076854675e-06 1.2 1.60080030488e-06 1.2 1.60083206301e-06 1.2 1.60086382114e-06 1.2 1.60089557927e-06 1.2 1.6009273374e-06 1.2 1.60095909553e-06 1.2 1.60099085366e-06 1.2 1.60102261179e-06 1.2 1.60105436992e-06 1.2 1.60108612805e-06 1.2 1.60111788618e-06 1.2 1.60114964431e-06 1.2 1.60118140244e-06 1.2 1.60121316057e-06 1.2 1.6012449187e-06 1.2 1.60127667683e-06 1.2 1.60130843496e-06 1.2 1.60134019309e-06 1.2 1.60137195122e-06 1.2 1.60140370935e-06 1.2 1.60143546748e-06 1.2 1.60146722561e-06 1.2 1.60149898374e-06 1.2 1.60153074187e-06 1.2 1.6015625e-06 1.2 1.60159425813e-06 1.2 1.60162601626e-06 1.2 1.60165777439e-06 1.2 1.60168953252e-06 1.2 1.60172129065e-06 1.2 1.60175304878e-06 1.2 1.60178480691e-06 1.2 1.60181656504e-06 1.2 1.60184832317e-06 1.2 1.6018800813e-06 1.2 1.60191183943e-06 1.2 1.60194359756e-06 1.2 1.60197535569e-06 1.2 1.60200711382e-06 1.2 1.60203887195e-06 1.2 1.60207063008e-06 1.2 1.60210238821e-06 1.2 1.60213414634e-06 1.2 1.60216590447e-06 1.2 1.6021976626e-06 1.2 1.60222942073e-06 1.2 1.60226117886e-06 1.2 1.60229293699e-06 1.2 1.60232469512e-06 1.2 1.60235645325e-06 1.2 1.60238821138e-06 1.2 1.60241996951e-06 1.2 1.60245172764e-06 1.2 1.60248348577e-06 1.2 1.6025152439e-06 1.2 1.60254700203e-06 1.2 1.60257876016e-06 1.2 1.60261051829e-06 1.2 1.60264227642e-06 1.2 1.60267403455e-06 1.2 1.60270579268e-06 1.2 1.60273755081e-06 1.2 1.60276930894e-06 1.2 1.60280106707e-06 1.2 1.6028328252e-06 1.2 1.60286458333e-06 1.2 1.60289634146e-06 1.2 1.60292809959e-06 1.2 1.60295985772e-06 1.2 1.60299161585e-06 1.2 1.60302337398e-06 1.2 1.60305513211e-06 1.2 1.60308689024e-06 1.2 1.60311864837e-06 1.2 1.6031504065e-06 1.2 1.60318216463e-06 1.2 1.60321392276e-06 1.2 1.60324568089e-06 1.2 1.60327743902e-06 1.2 1.60330919715e-06 1.2 1.60334095528e-06 1.2 1.60337271341e-06 1.2 1.60340447154e-06 1.2 1.60343622967e-06 1.2 1.6034679878e-06 1.2 1.60349974593e-06 1.2 1.60353150407e-06 1.2 1.6035632622e-06 1.2 1.60359502033e-06 1.2 1.60362677846e-06 1.2 1.60365853659e-06 1.2 1.60369029472e-06 1.2 1.60372205285e-06 1.2 1.60375381098e-06 1.2 1.60378556911e-06 1.2 1.60381732724e-06 1.2 1.60384908537e-06 1.2 1.6038808435e-06 1.2 1.60391260163e-06 1.2 1.60394435976e-06 1.2 1.60397611789e-06 1.2 1.60400787602e-06 1.2 1.60403963415e-06 1.2 1.60407139228e-06 1.2 1.60410315041e-06 1.2 1.60413490854e-06 1.2 1.60416666667e-06 1.2 1.6041984248e-06 1.2 1.60423018293e-06 1.2 1.60426194106e-06 1.2 1.60429369919e-06 1.2 1.60432545732e-06 1.2 1.60435721545e-06 1.2 1.60438897358e-06 1.2 1.60442073171e-06 1.2 1.60445248984e-06 1.2 1.60448424797e-06 1.2 1.6045160061e-06 1.2 1.60454776423e-06 1.2 1.60457952236e-06 1.2 1.60461128049e-06 1.2 1.60464303862e-06 1.2 1.60467479675e-06 1.2 1.60470655488e-06 1.2 1.60473831301e-06 1.2 1.60477007114e-06 1.2 1.60480182927e-06 1.2 1.6048335874e-06 1.2 1.60486534553e-06 1.2 1.60489710366e-06 1.2 1.60492886179e-06 1.2 1.60496061992e-06 1.2 1.60499237805e-06 1.2 1.60502413618e-06 1.2 1.60505589431e-06 1.2 1.60508765244e-06 1.2 1.60511941057e-06 1.2 1.6051511687e-06 1.2 1.60518292683e-06 1.2 1.60521468496e-06 1.2 1.60524644309e-06 1.2 1.60527820122e-06 1.2 1.60530995935e-06 1.2 1.60534171748e-06 1.2 1.60537347561e-06 1.2 1.60540523374e-06 1.2 1.60543699187e-06 1.2 1.60546875e-06 1.2 1.60550050813e-06 1.2 1.60553226626e-06 1.2 1.60556402439e-06 1.2 1.60559578252e-06 1.2 1.60562754065e-06 1.2 1.60565929878e-06 1.2 1.60569105691e-06 1.2 1.60572281504e-06 1.2 1.60575457317e-06 1.2 1.6057863313e-06 1.2 1.60581808943e-06 1.2 1.60584984756e-06 1.2 1.60588160569e-06 1.2 1.60591336382e-06 1.2 1.60594512195e-06 1.2 1.60597688008e-06 1.2 1.60600863821e-06 1.2 1.60604039634e-06 1.2 1.60607215447e-06 1.2 1.6061039126e-06 1.2 1.60613567073e-06 1.2 1.60616742886e-06 1.2 1.60619918699e-06 1.2 1.60623094512e-06 1.2 1.60626270325e-06 1.2 1.60629446138e-06 1.2 1.60632621951e-06 1.2 1.60635797764e-06 1.2 1.60638973577e-06 1.2 1.6064214939e-06 1.2 1.60645325203e-06 1.2 1.60648501016e-06 1.2 1.60651676829e-06 1.2 1.60654852642e-06 1.2 1.60658028455e-06 1.2 1.60661204268e-06 1.2 1.60664380081e-06 1.2 1.60667555894e-06 1.2 1.60670731707e-06 1.2 1.6067390752e-06 1.2 1.60677083333e-06 1.2 1.60680259146e-06 1.2 1.60683434959e-06 1.2 1.60686610772e-06 1.2 1.60689786585e-06 1.2 1.60692962398e-06 1.2 1.60696138211e-06 1.2 1.60699314024e-06 1.2 1.60702489837e-06 1.2 1.6070566565e-06 1.2 1.60708841463e-06 1.2 1.60712017276e-06 1.2 1.60715193089e-06 1.2 1.60718368902e-06 1.2 1.60721544715e-06 1.2 1.60724720528e-06 1.2 1.60727896341e-06 1.2 1.60731072154e-06 1.2 1.60734247967e-06 1.2 1.6073742378e-06 1.2 1.60740599593e-06 1.2 1.60743775407e-06 1.2 1.6074695122e-06 1.2 1.60750127033e-06 1.2 1.60753302846e-06 1.2 1.60756478659e-06 1.2 1.60759654472e-06 1.2 1.60762830285e-06 1.2 1.60766006098e-06 1.2 1.60769181911e-06 1.2 1.60772357724e-06 1.2 1.60775533537e-06 1.2 1.6077870935e-06 1.2 1.60781885163e-06 1.2 1.60785060976e-06 1.2 1.60788236789e-06 1.2 1.60791412602e-06 1.2 1.60794588415e-06 1.2 1.60797764228e-06 1.2 1.60800940041e-06 1.2 1.60804115854e-06 1.2 1.60807291667e-06 1.2 1.6081046748e-06 1.2 1.60813643293e-06 1.2 1.60816819106e-06 1.2 1.60819994919e-06 1.2 1.60823170732e-06 1.2 1.60826346545e-06 1.2 1.60829522358e-06 1.2 1.60832698171e-06 1.2 1.60835873984e-06 1.2 1.60839049797e-06 1.2 1.6084222561e-06 1.2 1.60845401423e-06 1.2 1.60848577236e-06 1.2 1.60851753049e-06 1.2 1.60854928862e-06 1.2 1.60858104675e-06 1.2 1.60861280488e-06 1.2 1.60864456301e-06 1.2 1.60867632114e-06 1.2 1.60870807927e-06 1.2 1.6087398374e-06 1.2 1.60877159553e-06 1.2 1.60880335366e-06 1.2 1.60883511179e-06 1.2 1.60886686992e-06 1.2 1.60889862805e-06 1.2 1.60893038618e-06 1.2 1.60896214431e-06 1.2 1.60899390244e-06 1.2 1.60902566057e-06 1.2 1.6090574187e-06 1.2 1.60908917683e-06 1.2 1.60912093496e-06 1.2 1.60915269309e-06 1.2 1.60918445122e-06 1.2 1.60921620935e-06 1.2 1.60924796748e-06 1.2 1.60927972561e-06 1.2 1.60931148374e-06 1.2 1.60934324187e-06 1.2 1.609375e-06 1.2 1.60940675813e-06 1.2 1.60943851626e-06 1.2 1.60947027439e-06 1.2 1.60950203252e-06 1.2 1.60953379065e-06 1.2 1.60956554878e-06 1.2 1.60959730691e-06 1.2 1.60962906504e-06 1.2 1.60966082317e-06 1.2 1.6096925813e-06 1.2 1.60972433943e-06 1.2 1.60975609756e-06 1.2 1.60978785569e-06 1.2 1.60981961382e-06 1.2 1.60985137195e-06 1.2 1.60988313008e-06 1.2 1.60991488821e-06 1.2 1.60994664634e-06 1.2 1.60997840447e-06 1.2 1.6100101626e-06 1.2 1.61004192073e-06 1.2 1.61007367886e-06 1.2 1.61010543699e-06 1.2 1.61013719512e-06 1.2 1.61016895325e-06 1.2 1.61020071138e-06 1.2 1.61023246951e-06 1.2 1.61026422764e-06 1.2 1.61029598577e-06 1.2 1.6103277439e-06 1.2 1.61035950203e-06 1.2 1.61039126016e-06 1.2 1.61042301829e-06 1.2 1.61045477642e-06 1.2 1.61048653455e-06 1.2 1.61051829268e-06 1.2 1.61055005081e-06 1.2 1.61058180894e-06 1.2 1.61061356707e-06 1.2 1.6106453252e-06 1.2 1.61067708333e-06 1.2 1.61070884146e-06 1.2 1.61074059959e-06 1.2 1.61077235772e-06 1.2 1.61080411585e-06 1.2 1.61083587398e-06 1.2 1.61086763211e-06 1.2 1.61089939024e-06 1.2 1.61093114837e-06 1.2 1.6109629065e-06 1.2 1.61099466463e-06 1.2 1.61102642276e-06 1.2 1.61105818089e-06 1.2 1.61108993902e-06 1.2 1.61112169715e-06 1.2 1.61115345528e-06 1.2 1.61118521341e-06 1.2 1.61121697154e-06 1.2 1.61124872967e-06 1.2 1.6112804878e-06 1.2 1.61131224593e-06 1.2 1.61134400407e-06 1.2 1.6113757622e-06 1.2 1.61140752033e-06 1.2 1.61143927846e-06 1.2 1.61147103659e-06 1.2 1.61150279472e-06 1.2 1.61153455285e-06 1.2 1.61156631098e-06 1.2 1.61159806911e-06 1.2 1.61162982724e-06 1.2 1.61166158537e-06 1.2 1.6116933435e-06 1.2 1.61172510163e-06 1.2 1.61175685976e-06 1.2 1.61178861789e-06 1.2 1.61182037602e-06 1.2 1.61185213415e-06 1.2 1.61188389228e-06 1.2 1.61191565041e-06 1.2 1.61194740854e-06 1.2 1.61197916667e-06 1.2 1.6120109248e-06 1.2 1.61204268293e-06 1.2 1.61207444106e-06 1.2 1.61210619919e-06 1.2 1.61213795732e-06 1.2 1.61216971545e-06 1.2 1.61220147358e-06 1.2 1.61223323171e-06 1.2 1.61226498984e-06 1.2 1.61229674797e-06 1.2 1.6123285061e-06 1.2 1.61236026423e-06 1.2 1.61239202236e-06 1.2 1.61242378049e-06 1.2 1.61245553862e-06 1.2 1.61248729675e-06 1.2 1.61251905488e-06 1.2 1.61255081301e-06 1.2 1.61258257114e-06 1.2 1.61261432927e-06 1.2 1.6126460874e-06 1.2 1.61267784553e-06 1.2 1.61270960366e-06 1.2 1.61274136179e-06 1.2 1.61277311992e-06 1.2 1.61280487805e-06 1.2 1.61283663618e-06 1.2 1.61286839431e-06 1.2 1.61290015244e-06 1.2 1.61293191057e-06 1.2 1.6129636687e-06 1.2 1.61299542683e-06 1.2 1.61302718496e-06 1.2 1.61305894309e-06 1.2 1.61309070122e-06 1.2 1.61312245935e-06 1.2 1.61315421748e-06 1.2 1.61318597561e-06 1.2 1.61321773374e-06 1.2 1.61324949187e-06 1.2 1.61328125e-06 1.2 1.61331300813e-06 1.2 1.61334476626e-06 1.2 1.61337652439e-06 1.2 1.61340828252e-06 1.2 1.61344004065e-06 1.2 1.61347179878e-06 1.2 1.61350355691e-06 1.2 1.61353531504e-06 1.2 1.61356707317e-06 1.2 1.6135988313e-06 1.2 1.61363058943e-06 1.2 1.61366234756e-06 1.2 1.61369410569e-06 1.2 1.61372586382e-06 1.2 1.61375762195e-06 1.2 1.61378938008e-06 1.2 1.61382113821e-06 1.2 1.61385289634e-06 1.2 1.61388465447e-06 1.2 1.6139164126e-06 1.2 1.61394817073e-06 1.2 1.61397992886e-06 1.2 1.61401168699e-06 1.2 1.61404344512e-06 1.2 1.61407520325e-06 1.2 1.61410696138e-06 1.2 1.61413871951e-06 1.2 1.61417047764e-06 1.2 1.61420223577e-06 1.2 1.6142339939e-06 1.2 1.61426575203e-06 1.2 1.61429751016e-06 1.2 1.61432926829e-06 1.2 1.61436102642e-06 1.2 1.61439278455e-06 1.2 1.61442454268e-06 1.2 1.61445630081e-06 1.2 1.61448805894e-06 1.2 1.61451981707e-06 1.2 1.6145515752e-06 1.2 1.61458333333e-06 1.2 1.61461509146e-06 1.2 1.61464684959e-06 1.2 1.61467860772e-06 1.2 1.61471036585e-06 1.2 1.61474212398e-06 1.2 1.61477388211e-06 1.2 1.61480564024e-06 1.2 1.61483739837e-06 1.2 1.6148691565e-06 1.2 1.61490091463e-06 1.2 1.61493267276e-06 1.2 1.61496443089e-06 1.2 1.61499618902e-06 1.2 1.61502794715e-06 1.2 1.61505970528e-06 1.2 1.61509146341e-06 1.2 1.61512322154e-06 1.2 1.61515497967e-06 1.2 1.6151867378e-06 1.2 1.61521849593e-06 1.2 1.61525025407e-06 1.2 1.6152820122e-06 1.2 1.61531377033e-06 1.2 1.61534552846e-06 1.2 1.61537728659e-06 1.2 1.61540904472e-06 1.2 1.61544080285e-06 1.2 1.61547256098e-06 1.2 1.61550431911e-06 1.2 1.61553607724e-06 1.2 1.61556783537e-06 1.2 1.6155995935e-06 1.2 1.61563135163e-06 1.2 1.61566310976e-06 1.2 1.61569486789e-06 1.2 1.61572662602e-06 1.2 1.61575838415e-06 1.2 1.61579014228e-06 1.2 1.61582190041e-06 1.2 1.61585365854e-06 1.2 1.61588541667e-06 1.2 1.6159171748e-06 1.2 1.61594893293e-06 1.2 1.61598069106e-06 1.2 1.61601244919e-06 1.2 1.61604420732e-06 1.2 1.61607596545e-06 1.2 1.61610772358e-06 1.2 1.61613948171e-06 1.2 1.61617123984e-06 1.2 1.61620299797e-06 1.2 1.6162347561e-06 1.2 1.61626651423e-06 1.2 1.61629827236e-06 1.2 1.61633003049e-06 1.2 1.61636178862e-06 1.2 1.61639354675e-06 1.2 1.61642530488e-06 1.2 1.61645706301e-06 1.2 1.61648882114e-06 1.2 1.61652057927e-06 1.2 1.6165523374e-06 1.2 1.61658409553e-06 1.2 1.61661585366e-06 1.2 1.61664761179e-06 1.2 1.61667936992e-06 1.2 1.61671112805e-06 1.2 1.61674288618e-06 1.2 1.61677464431e-06 1.2 1.61680640244e-06 1.2 1.61683816057e-06 1.2 1.6168699187e-06 1.2 1.61690167683e-06 1.2 1.61693343496e-06 1.2 1.61696519309e-06 1.2 1.61699695122e-06 1.2 1.61702870935e-06 1.2 1.61706046748e-06 1.2 1.61709222561e-06 1.2 1.61712398374e-06 1.2 1.61715574187e-06 1.2 1.6171875e-06 1.2 1.61721925813e-06 1.2 1.61725101626e-06 1.2 1.61728277439e-06 1.2 1.61731453252e-06 1.2 1.61734629065e-06 1.2 1.61737804878e-06 1.2 1.61740980691e-06 1.2 1.61744156504e-06 1.2 1.61747332317e-06 1.2 1.6175050813e-06 1.2 1.61753683943e-06 1.2 1.61756859756e-06 1.2 1.61760035569e-06 1.2 1.61763211382e-06 1.2 1.61766387195e-06 1.2 1.61769563008e-06 1.2 1.61772738821e-06 1.2 1.61775914634e-06 1.2 1.61779090447e-06 1.2 1.6178226626e-06 1.2 1.61785442073e-06 1.2 1.61788617886e-06 1.2 1.61791793699e-06 1.2 1.61794969512e-06 1.2 1.61798145325e-06 1.2 1.61801321138e-06 1.2 1.61804496951e-06 1.2 1.61807672764e-06 1.2 1.61810848577e-06 1.2 1.6181402439e-06 1.2 1.61817200203e-06 1.2 1.61820376016e-06 1.2 1.61823551829e-06 1.2 1.61826727642e-06 1.2 1.61829903455e-06 1.2 1.61833079268e-06 1.2 1.61836255081e-06 1.2 1.61839430894e-06 1.2 1.61842606707e-06 1.2 1.6184578252e-06 1.2 1.61848958333e-06 1.2 1.61852134146e-06 1.2 1.61855309959e-06 1.2 1.61858485772e-06 1.2 1.61861661585e-06 1.2 1.61864837398e-06 1.2 1.61868013211e-06 1.2 1.61871189024e-06 1.2 1.61874364837e-06 1.2 1.6187754065e-06 1.2 1.61880716463e-06 1.2 1.61883892276e-06 1.2 1.61887068089e-06 1.2 1.61890243902e-06 1.2 1.61893419715e-06 1.2 1.61896595528e-06 1.2 1.61899771341e-06 1.2 1.61902947154e-06 1.2 1.61906122967e-06 1.2 1.6190929878e-06 1.2 1.61912474593e-06 1.2 1.61915650407e-06 1.2 1.6191882622e-06 1.2 1.61922002033e-06 1.2 1.61925177846e-06 1.2 1.61928353659e-06 1.2 1.61931529472e-06 1.2 1.61934705285e-06 1.2 1.61937881098e-06 1.2 1.61941056911e-06 1.2 1.61944232724e-06 1.2 1.61947408537e-06 1.2 1.6195058435e-06 1.2 1.61953760163e-06 1.2 1.61956935976e-06 1.2 1.61960111789e-06 1.2 1.61963287602e-06 1.2 1.61966463415e-06 1.2 1.61969639228e-06 1.2 1.61972815041e-06 1.2 1.61975990854e-06 1.2 1.61979166667e-06 1.2 1.6198234248e-06 1.2 1.61985518293e-06 1.2 1.61988694106e-06 1.2 1.61991869919e-06 1.2 1.61995045732e-06 1.2 1.61998221545e-06 1.2 1.62001397358e-06 1.2 1.62004573171e-06 1.2 1.62007748984e-06 1.2 1.62010924797e-06 1.2 1.6201410061e-06 1.2 1.62017276423e-06 1.2 1.62020452236e-06 1.2 1.62023628049e-06 1.2 1.62026803862e-06 1.2 1.62029979675e-06 1.2 1.62033155488e-06 1.2 1.62036331301e-06 1.2 1.62039507114e-06 1.2 1.62042682927e-06 1.2 1.6204585874e-06 1.2 1.62049034553e-06 1.2 1.62052210366e-06 1.2 1.62055386179e-06 1.2 1.62058561992e-06 1.2 1.62061737805e-06 1.2 1.62064913618e-06 1.2 1.62068089431e-06 1.2 1.62071265244e-06 1.2 1.62074441057e-06 1.2 1.6207761687e-06 1.2 1.62080792683e-06 1.2 1.62083968496e-06 1.2 1.62087144309e-06 1.2 1.62090320122e-06 1.2 1.62093495935e-06 1.2 1.62096671748e-06 1.2 1.62099847561e-06 1.2 1.62103023374e-06 1.2 1.62106199187e-06 1.2 1.62109375e-06 1.2 1.62112550813e-06 1.2 1.62115726626e-06 1.2 1.62118902439e-06 1.2 1.62122078252e-06 1.2 1.62125254065e-06 1.2 1.62128429878e-06 1.2 1.62131605691e-06 1.2 1.62134781504e-06 1.2 1.62137957317e-06 1.2 1.6214113313e-06 1.2 1.62144308943e-06 1.2 1.62147484756e-06 1.2 1.62150660569e-06 1.2 1.62153836382e-06 1.2 1.62157012195e-06 1.2 1.62160188008e-06 1.2 1.62163363821e-06 1.2 1.62166539634e-06 1.2 1.62169715447e-06 1.2 1.6217289126e-06 1.2 1.62176067073e-06 1.2 1.62179242886e-06 1.2 1.62182418699e-06 1.2 1.62185594512e-06 1.2 1.62188770325e-06 1.2 1.62191946138e-06 1.2 1.62195121951e-06 1.2 1.62198297764e-06 1.2 1.62201473577e-06 1.2 1.6220464939e-06 1.2 1.62207825203e-06 1.2 1.62211001016e-06 1.2 1.62214176829e-06 1.2 1.62217352642e-06 1.2 1.62220528455e-06 1.2 1.62223704268e-06 1.2 1.62226880081e-06 1.2 1.62230055894e-06 1.2 1.62233231707e-06 1.2 1.6223640752e-06 1.2 1.62239583333e-06 1.2 1.62242759146e-06 1.2 1.62245934959e-06 1.2 1.62249110772e-06 1.2 1.62252286585e-06 1.2 1.62255462398e-06 1.2 1.62258638211e-06 1.2 1.62261814024e-06 1.2 1.62264989837e-06 1.2 1.6226816565e-06 1.2 1.62271341463e-06 1.2 1.62274517276e-06 1.2 1.62277693089e-06 1.2 1.62280868902e-06 1.2 1.62284044715e-06 1.2 1.62287220528e-06 1.2 1.62290396341e-06 1.2 1.62293572154e-06 1.2 1.62296747967e-06 1.2 1.6229992378e-06 1.2 1.62303099593e-06 1.2 1.62306275407e-06 1.2 1.6230945122e-06 1.2 1.62312627033e-06 1.2 1.62315802846e-06 1.2 1.62318978659e-06 1.2 1.62322154472e-06 1.2 1.62325330285e-06 1.2 1.62328506098e-06 1.2 1.62331681911e-06 1.2 1.62334857724e-06 1.2 1.62338033537e-06 1.2 1.6234120935e-06 1.2 1.62344385163e-06 1.2 1.62347560976e-06 1.2 1.62350736789e-06 1.2 1.62353912602e-06 1.2 1.62357088415e-06 1.2 1.62360264228e-06 1.2 1.62363440041e-06 1.2 1.62366615854e-06 1.2 1.62369791667e-06 1.2 1.6237296748e-06 1.2 1.62376143293e-06 1.2 1.62379319106e-06 1.2 1.62382494919e-06 1.2 1.62385670732e-06 1.2 1.62388846545e-06 1.2 1.62392022358e-06 1.2 1.62395198171e-06 1.2 1.62398373984e-06 1.2 1.62401549797e-06 1.2 1.6240472561e-06 1.2 1.62407901423e-06 1.2 1.62411077236e-06 1.2 1.62414253049e-06 1.2 1.62417428862e-06 1.2 1.62420604675e-06 1.2 1.62423780488e-06 1.2 1.62426956301e-06 1.2 1.62430132114e-06 1.2 1.62433307927e-06 1.2 1.6243648374e-06 1.2 1.62439659553e-06 1.2 1.62442835366e-06 1.2 1.62446011179e-06 1.2 1.62449186992e-06 1.2 1.62452362805e-06 1.2 1.62455538618e-06 1.2 1.62458714431e-06 1.2 1.62461890244e-06 1.2 1.62465066057e-06 1.2 1.6246824187e-06 1.2 1.62471417683e-06 1.2 1.62474593496e-06 1.2 1.62477769309e-06 1.2 1.62480945122e-06 1.2 1.62484120935e-06 1.2 1.62487296748e-06 1.2 1.62490472561e-06 1.2 1.62493648374e-06 1.2 1.62496824187e-06 1.2 1.625e-06 1.2 1.62503175813e-06 1.2 1.62506351626e-06 1.2 1.62509527439e-06 1.2 1.62512703252e-06 1.2 1.62515879065e-06 1.2 1.62519054878e-06 1.2 1.62522230691e-06 1.2 1.62525406504e-06 1.2 1.62528582317e-06 1.2 1.6253175813e-06 1.2 1.62534933943e-06 1.2 1.62538109756e-06 1.2 1.62541285569e-06 1.2 1.62544461382e-06 1.2 1.62547637195e-06 1.2 1.62550813008e-06 1.2 1.62553988821e-06 1.2 1.62557164634e-06 1.2 1.62560340447e-06 1.2 1.6256351626e-06 1.2 1.62566692073e-06 1.2 1.62569867886e-06 1.2 1.62573043699e-06 1.2 1.62576219512e-06 1.2 1.62579395325e-06 1.2 1.62582571138e-06 1.2 1.62585746951e-06 1.2 1.62588922764e-06 1.2 1.62592098577e-06 1.2 1.6259527439e-06 1.2 1.62598450203e-06 1.2 1.62601626016e-06 1.2 1.62604801829e-06 1.2 1.62607977642e-06 1.2 1.62611153455e-06 1.2 1.62614329268e-06 1.2 1.62617505081e-06 1.2 1.62620680894e-06 1.2 1.62623856707e-06 1.2 1.6262703252e-06 1.2 1.62630208333e-06 1.2 1.62633384146e-06 1.2 1.62636559959e-06 1.2 1.62639735772e-06 1.2 1.62642911585e-06 1.2 1.62646087398e-06 1.2 1.62649263211e-06 1.2 1.62652439024e-06 1.2 1.62655614837e-06 1.2 1.6265879065e-06 1.2 1.62661966463e-06 1.2 1.62665142276e-06 1.2 1.62668318089e-06 1.2 1.62671493902e-06 1.2 1.62674669715e-06 1.2 1.62677845528e-06 1.2 1.62681021341e-06 1.2 1.62684197154e-06 1.2 1.62687372967e-06 1.2 1.6269054878e-06 1.2 1.62693724593e-06 1.2 1.62696900407e-06 1.2 1.6270007622e-06 1.2 1.62703252033e-06 1.2 1.62706427846e-06 1.2 1.62709603659e-06 1.2 1.62712779472e-06 1.2 1.62715955285e-06 1.2 1.62719131098e-06 1.2 1.62722306911e-06 1.2 1.62725482724e-06 1.2 1.62728658537e-06 1.2 1.6273183435e-06 1.2 1.62735010163e-06 1.2 1.62738185976e-06 1.2 1.62741361789e-06 1.2 1.62744537602e-06 1.2 1.62747713415e-06 1.2 1.62750889228e-06 1.2 1.62754065041e-06 1.2 1.62757240854e-06 1.2 1.62760416667e-06 1.2 1.6276359248e-06 1.2 1.62766768293e-06 1.2 1.62769944106e-06 1.2 1.62773119919e-06 1.2 1.62776295732e-06 1.2 1.62779471545e-06 1.2 1.62782647358e-06 1.2 1.62785823171e-06 1.2 1.62788998984e-06 1.2 1.62792174797e-06 1.2 1.6279535061e-06 1.2 1.62798526423e-06 1.2 1.62801702236e-06 1.2 1.62804878049e-06 1.2 1.62808053862e-06 1.2 1.62811229675e-06 1.2 1.62814405488e-06 1.2 1.62817581301e-06 1.2 1.62820757114e-06 1.2 1.62823932927e-06 1.2 1.6282710874e-06 1.2 1.62830284553e-06 1.2 1.62833460366e-06 1.2 1.62836636179e-06 1.2 1.62839811992e-06 1.2 1.62842987805e-06 1.2 1.62846163618e-06 1.2 1.62849339431e-06 1.2 1.62852515244e-06 1.2 1.62855691057e-06 1.2 1.6285886687e-06 1.2 1.62862042683e-06 1.2 1.62865218496e-06 1.2 1.62868394309e-06 1.2 1.62871570122e-06 1.2 1.62874745935e-06 1.2 1.62877921748e-06 1.2 1.62881097561e-06 1.2 1.62884273374e-06 1.2 1.62887449187e-06 1.2 1.62890625e-06 1.2 1.62893800813e-06 1.2 1.62896976626e-06 1.2 1.62900152439e-06 1.2 1.62903328252e-06 1.2 1.62906504065e-06 1.2 1.62909679878e-06 1.2 1.62912855691e-06 1.2 1.62916031504e-06 1.2 1.62919207317e-06 1.2 1.6292238313e-06 1.2 1.62925558943e-06 1.2 1.62928734756e-06 1.2 1.62931910569e-06 1.2 1.62935086382e-06 1.2 1.62938262195e-06 1.2 1.62941438008e-06 1.2 1.62944613821e-06 1.2 1.62947789634e-06 1.2 1.62950965447e-06 1.2 1.6295414126e-06 1.2 1.62957317073e-06 1.2 1.62960492886e-06 1.2 1.62963668699e-06 1.2 1.62966844512e-06 1.2 1.62970020325e-06 1.2 1.62973196138e-06 1.2 1.62976371951e-06 1.2 1.62979547764e-06 1.2 1.62982723577e-06 1.2 1.6298589939e-06 1.2 1.62989075203e-06 1.2 1.62992251016e-06 1.2 1.62995426829e-06 1.2 1.62998602642e-06 1.2 1.63001778455e-06 1.2 1.63004954268e-06 1.2 1.63008130081e-06 1.2 1.63011305894e-06 1.2 1.63014481707e-06 1.2 1.6301765752e-06 1.2 1.63020833333e-06 1.2 1.63024009146e-06 1.2 1.63027184959e-06 1.2 1.63030360772e-06 1.2 1.63033536585e-06 1.2 1.63036712398e-06 1.2 1.63039888211e-06 1.2 1.63043064024e-06 1.2 1.63046239837e-06 1.2 1.6304941565e-06 1.2 1.63052591463e-06 1.2 1.63055767276e-06 1.2 1.63058943089e-06 1.2 1.63062118902e-06 1.2 1.63065294715e-06 1.2 1.63068470528e-06 1.2 1.63071646341e-06 1.2 1.63074822154e-06 1.2 1.63077997967e-06 1.2 1.6308117378e-06 1.2 1.63084349593e-06 1.2 1.63087525407e-06 1.2 1.6309070122e-06 1.2 1.63093877033e-06 1.2 1.63097052846e-06 1.2 1.63100228659e-06 1.2 1.63103404472e-06 1.2 1.63106580285e-06 1.2 1.63109756098e-06 1.2 1.63112931911e-06 1.2 1.63116107724e-06 1.2 1.63119283537e-06 1.2 1.6312245935e-06 1.2 1.63125635163e-06 1.2 1.63128810976e-06 1.2 1.63131986789e-06 1.2 1.63135162602e-06 1.2 1.63138338415e-06 1.2 1.63141514228e-06 1.2 1.63144690041e-06 1.2 1.63147865854e-06 1.2 1.63151041667e-06 1.2 1.6315421748e-06 1.2 1.63157393293e-06 1.2 1.63160569106e-06 1.2 1.63163744919e-06 1.2 1.63166920732e-06 1.2 1.63170096545e-06 1.2 1.63173272358e-06 1.2 1.63176448171e-06 1.2 1.63179623984e-06 1.2 1.63182799797e-06 1.2 1.6318597561e-06 1.2 1.63189151423e-06 1.2 1.63192327236e-06 1.2 1.63195503049e-06 1.2 1.63198678862e-06 1.2 1.63201854675e-06 1.2 1.63205030488e-06 1.2 1.63208206301e-06 1.2 1.63211382114e-06 1.2 1.63214557927e-06 1.2 1.6321773374e-06 1.2 1.63220909553e-06 1.2 1.63224085366e-06 1.2 1.63227261179e-06 1.2 1.63230436992e-06 1.2 1.63233612805e-06 1.2 1.63236788618e-06 1.2 1.63239964431e-06 1.2 1.63243140244e-06 1.2 1.63246316057e-06 1.2 1.6324949187e-06 1.2 1.63252667683e-06 1.2 1.63255843496e-06 1.2 1.63259019309e-06 1.2 1.63262195122e-06 1.2 1.63265370935e-06 1.2 1.63268546748e-06 1.2 1.63271722561e-06 1.2 1.63274898374e-06 1.2 1.63278074187e-06 1.2 1.6328125e-06 1.2 1.63284425813e-06 1.2 1.63287601626e-06 1.2 1.63290777439e-06 1.2 1.63293953252e-06 1.2 1.63297129065e-06 1.2 1.63300304878e-06 1.2 1.63303480691e-06 1.2 1.63306656504e-06 1.2 1.63309832317e-06 1.2 1.6331300813e-06 1.2 1.63316183943e-06 1.2 1.63319359756e-06 1.2 1.63322535569e-06 1.2 1.63325711382e-06 1.2 1.63328887195e-06 1.2 1.63332063008e-06 1.2 1.63335238821e-06 1.2 1.63338414634e-06 1.2 1.63341590447e-06 1.2 1.6334476626e-06 1.2 1.63347942073e-06 1.2 1.63351117886e-06 1.2 1.63354293699e-06 1.2 1.63357469512e-06 1.2 1.63360645325e-06 1.2 1.63363821138e-06 1.2 1.63366996951e-06 1.2 1.63370172764e-06 1.2 1.63373348577e-06 1.2 1.6337652439e-06 1.2 1.63379700203e-06 1.2 1.63382876016e-06 1.2 1.63386051829e-06 1.2 1.63389227642e-06 1.2 1.63392403455e-06 1.2 1.63395579268e-06 1.2 1.63398755081e-06 1.2 1.63401930894e-06 1.2 1.63405106707e-06 1.2 1.6340828252e-06 1.2 1.63411458333e-06 1.2 1.63414634146e-06 1.2 1.63417809959e-06 1.2 1.63420985772e-06 1.2 1.63424161585e-06 1.2 1.63427337398e-06 1.2 1.63430513211e-06 1.2 1.63433689024e-06 1.2 1.63436864837e-06 1.2 1.6344004065e-06 1.2 1.63443216463e-06 1.2 1.63446392276e-06 1.2 1.63449568089e-06 1.2 1.63452743902e-06 1.2 1.63455919715e-06 1.2 1.63459095528e-06 1.2 1.63462271341e-06 1.2 1.63465447154e-06 1.2 1.63468622967e-06 1.2 1.6347179878e-06 1.2 1.63474974593e-06 1.2 1.63478150407e-06 1.2 1.6348132622e-06 1.2 1.63484502033e-06 1.2 1.63487677846e-06 1.2 1.63490853659e-06 1.2 1.63494029472e-06 1.2 1.63497205285e-06 1.2 1.63500381098e-06 1.2 1.63503556911e-06 1.2 1.63506732724e-06 1.2 1.63509908537e-06 1.2 1.6351308435e-06 1.2 1.63516260163e-06 1.2 1.63519435976e-06 1.2 1.63522611789e-06 1.2 1.63525787602e-06 1.2 1.63528963415e-06 1.2 1.63532139228e-06 1.2 1.63535315041e-06 1.2 1.63538490854e-06 1.2 1.63541666667e-06 1.2 1.6354484248e-06 1.2 1.63548018293e-06 1.2 1.63551194106e-06 1.2 1.63554369919e-06 1.2 1.63557545732e-06 1.2 1.63560721545e-06 1.2 1.63563897358e-06 1.2 1.63567073171e-06 1.2 1.63570248984e-06 1.2 1.63573424797e-06 1.2 1.6357660061e-06 1.2 1.63579776423e-06 1.2 1.63582952236e-06 1.2 1.63586128049e-06 1.2 1.63589303862e-06 1.2 1.63592479675e-06 1.2 1.63595655488e-06 1.2 1.63598831301e-06 1.2 1.63602007114e-06 1.2 1.63605182927e-06 1.2 1.6360835874e-06 1.2 1.63611534553e-06 1.2 1.63614710366e-06 1.2 1.63617886179e-06 1.2 1.63621061992e-06 1.2 1.63624237805e-06 1.2 1.63627413618e-06 1.2 1.63630589431e-06 1.2 1.63633765244e-06 1.2 1.63636941057e-06 1.2 1.6364011687e-06 1.2 1.63643292683e-06 1.2 1.63646468496e-06 1.2 1.63649644309e-06 1.2 1.63652820122e-06 1.2 1.63655995935e-06 1.2 1.63659171748e-06 1.2 1.63662347561e-06 1.2 1.63665523374e-06 1.2 1.63668699187e-06 1.2 1.63671875e-06 1.2 1.63675050813e-06 1.2 1.63678226626e-06 1.2 1.63681402439e-06 1.2 1.63684578252e-06 1.2 1.63687754065e-06 1.2 1.63690929878e-06 1.2 1.63694105691e-06 1.2 1.63697281504e-06 1.2 1.63700457317e-06 1.2 1.6370363313e-06 1.2 1.63706808943e-06 1.2 1.63709984756e-06 1.2 1.63713160569e-06 1.2 1.63716336382e-06 1.2 1.63719512195e-06 1.2 1.63722688008e-06 1.2 1.63725863821e-06 1.2 1.63729039634e-06 1.2 1.63732215447e-06 1.2 1.6373539126e-06 1.2 1.63738567073e-06 1.2 1.63741742886e-06 1.2 1.63744918699e-06 1.2 1.63748094512e-06 1.2 1.63751270325e-06 1.2 1.63754446138e-06 1.2 1.63757621951e-06 1.2 1.63760797764e-06 1.2 1.63763973577e-06 1.2 1.6376714939e-06 1.2 1.63770325203e-06 1.2 1.63773501016e-06 1.2 1.63776676829e-06 1.2 1.63779852642e-06 1.2 1.63783028455e-06 1.2 1.63786204268e-06 1.2 1.63789380081e-06 1.2 1.63792555894e-06 1.2 1.63795731707e-06 1.2 1.6379890752e-06 1.2 1.63802083333e-06 1.2 1.63805259146e-06 1.2 1.63808434959e-06 1.2 1.63811610772e-06 1.2 1.63814786585e-06 1.2 1.63817962398e-06 1.2 1.63821138211e-06 1.2 1.63824314024e-06 1.2 1.63827489837e-06 1.2 1.6383066565e-06 1.2 1.63833841463e-06 1.2 1.63837017276e-06 1.2 1.63840193089e-06 1.2 1.63843368902e-06 1.2 1.63846544715e-06 1.2 1.63849720528e-06 1.2 1.63852896341e-06 1.2 1.63856072154e-06 1.2 1.63859247967e-06 1.2 1.6386242378e-06 1.2 1.63865599593e-06 1.2 1.63868775407e-06 1.2 1.6387195122e-06 1.2 1.63875127033e-06 1.2 1.63878302846e-06 1.2 1.63881478659e-06 1.2 1.63884654472e-06 1.2 1.63887830285e-06 1.2 1.63891006098e-06 1.2 1.63894181911e-06 1.2 1.63897357724e-06 1.2 1.63900533537e-06 1.2 1.6390370935e-06 1.2 1.63906885163e-06 1.2 1.63910060976e-06 1.2 1.63913236789e-06 1.2 1.63916412602e-06 1.2 1.63919588415e-06 1.2 1.63922764228e-06 1.2 1.63925940041e-06 1.2 1.63929115854e-06 1.2 1.63932291667e-06 1.2 1.6393546748e-06 1.2 1.63938643293e-06 1.2 1.63941819106e-06 1.2 1.63944994919e-06 1.2 1.63948170732e-06 1.2 1.63951346545e-06 1.2 1.63954522358e-06 1.2 1.63957698171e-06 1.2 1.63960873984e-06 1.2 1.63964049797e-06 1.2 1.6396722561e-06 1.2 1.63970401423e-06 1.2 1.63973577236e-06 1.2 1.63976753049e-06 1.2 1.63979928862e-06 1.2 1.63983104675e-06 1.2 1.63986280488e-06 1.2 1.63989456301e-06 1.2 1.63992632114e-06 1.2 1.63995807927e-06 1.2 1.6399898374e-06 1.2 1.64002159553e-06 1.2 1.64005335366e-06 1.2 1.64008511179e-06 1.2 1.64011686992e-06 1.2 1.64014862805e-06 1.2 1.64018038618e-06 1.2 1.64021214431e-06 1.2 1.64024390244e-06 1.2 1.64027566057e-06 1.2 1.6403074187e-06 1.2 1.64033917683e-06 1.2 1.64037093496e-06 1.2 1.64040269309e-06 1.2 1.64043445122e-06 1.2 1.64046620935e-06 1.2 1.64049796748e-06 1.2 1.64052972561e-06 1.2 1.64056148374e-06 1.2 1.64059324187e-06 1.2 1.640625e-06 1.2 1.64065675813e-06 1.2 1.64068851626e-06 1.2 1.64072027439e-06 1.2 1.64075203252e-06 1.2 1.64078379065e-06 1.2 1.64081554878e-06 1.2 1.64084730691e-06 1.2 1.64087906504e-06 1.2 1.64091082317e-06 1.2 1.6409425813e-06 1.2 1.64097433943e-06 1.2 1.64100609756e-06 1.2 1.64103785569e-06 1.2 1.64106961382e-06 1.2 1.64110137195e-06 1.2 1.64113313008e-06 1.2 1.64116488821e-06 1.2 1.64119664634e-06 1.2 1.64122840447e-06 1.2 1.6412601626e-06 1.2 1.64129192073e-06 1.2 1.64132367886e-06 1.2 1.64135543699e-06 1.2 1.64138719512e-06 1.2 1.64141895325e-06 1.2 1.64145071138e-06 1.2 1.64148246951e-06 1.2 1.64151422764e-06 1.2 1.64154598577e-06 1.2 1.6415777439e-06 1.2 1.64160950203e-06 1.2 1.64164126016e-06 1.2 1.64167301829e-06 1.2 1.64170477642e-06 1.2 1.64173653455e-06 1.2 1.64176829268e-06 1.2 1.64180005081e-06 1.2 1.64183180894e-06 1.2 1.64186356707e-06 1.2 1.6418953252e-06 1.2 1.64192708333e-06 1.2 1.64195884146e-06 1.2 1.64199059959e-06 1.2 1.64202235772e-06 1.2 1.64205411585e-06 1.2 1.64208587398e-06 1.2 1.64211763211e-06 1.2 1.64214939024e-06 1.2 1.64218114837e-06 1.2 1.6422129065e-06 1.2 1.64224466463e-06 1.2 1.64227642276e-06 1.2 1.64230818089e-06 1.2 1.64233993902e-06 1.2 1.64237169715e-06 1.2 1.64240345528e-06 1.2 1.64243521341e-06 1.2 1.64246697154e-06 1.2 1.64249872967e-06 1.2 1.6425304878e-06 1.2 1.64256224593e-06 1.2 1.64259400407e-06 1.2 1.6426257622e-06 1.2 1.64265752033e-06 1.2 1.64268927846e-06 1.2 1.64272103659e-06 1.2 1.64275279472e-06 1.2 1.64278455285e-06 1.2 1.64281631098e-06 1.2 1.64284806911e-06 1.2 1.64287982724e-06 1.2 1.64291158537e-06 1.2 1.6429433435e-06 1.2 1.64297510163e-06 1.2 1.64300685976e-06 1.2 1.64303861789e-06 1.2 1.64307037602e-06 1.2 1.64310213415e-06 1.2 1.64313389228e-06 1.2 1.64316565041e-06 1.2 1.64319740854e-06 1.2 1.64322916667e-06 1.2 1.6432609248e-06 1.2 1.64329268293e-06 1.2 1.64332444106e-06 1.2 1.64335619919e-06 1.2 1.64338795732e-06 1.2 1.64341971545e-06 1.2 1.64345147358e-06 1.2 1.64348323171e-06 1.2 1.64351498984e-06 1.2 1.64354674797e-06 1.2 1.6435785061e-06 1.2 1.64361026423e-06 1.2 1.64364202236e-06 1.2 1.64367378049e-06 1.2 1.64370553862e-06 1.2 1.64373729675e-06 1.2 1.64376905488e-06 1.2 1.64380081301e-06 1.2 1.64383257114e-06 1.2 1.64386432927e-06 1.2 1.6438960874e-06 1.2 1.64392784553e-06 1.2 1.64395960366e-06 1.2 1.64399136179e-06 1.2 1.64402311992e-06 1.2 1.64405487805e-06 1.2 1.64408663618e-06 1.2 1.64411839431e-06 1.2 1.64415015244e-06 1.2 1.64418191057e-06 1.2 1.6442136687e-06 1.2 1.64424542683e-06 1.2 1.64427718496e-06 1.2 1.64430894309e-06 1.2 1.64434070122e-06 1.2 1.64437245935e-06 1.2 1.64440421748e-06 1.2 1.64443597561e-06 1.2 1.64446773374e-06 1.2 1.64449949187e-06 1.2 1.64453125e-06 1.2 1.64456300813e-06 1.2 1.64459476626e-06 1.2 1.64462652439e-06 1.2 1.64465828252e-06 1.2 1.64469004065e-06 1.2 1.64472179878e-06 1.2 1.64475355691e-06 1.2 1.64478531504e-06 1.2 1.64481707317e-06 1.2 1.6448488313e-06 1.2 1.64488058943e-06 1.2 1.64491234756e-06 1.2 1.64494410569e-06 1.2 1.64497586382e-06 1.2 1.64500762195e-06 1.2 1.64503938008e-06 1.2 1.64507113821e-06 1.2 1.64510289634e-06 1.2 1.64513465447e-06 1.2 1.6451664126e-06 1.2 1.64519817073e-06 1.2 1.64522992886e-06 1.2 1.64526168699e-06 1.2 1.64529344512e-06 1.2 1.64532520325e-06 1.2 1.64535696138e-06 1.2 1.64538871951e-06 1.2 1.64542047764e-06 1.2 1.64545223577e-06 1.2 1.6454839939e-06 1.2 1.64551575203e-06 1.2 1.64554751016e-06 1.2 1.64557926829e-06 1.2 1.64561102642e-06 1.2 1.64564278455e-06 1.2 1.64567454268e-06 1.2 1.64570630081e-06 1.2 1.64573805894e-06 1.2 1.64576981707e-06 1.2 1.6458015752e-06 1.2 1.64583333333e-06 1.2 1.64586509146e-06 1.2 1.64589684959e-06 1.2 1.64592860772e-06 1.2 1.64596036585e-06 1.2 1.64599212398e-06 1.2 1.64602388211e-06 1.2 1.64605564024e-06 1.2 1.64608739837e-06 1.2 1.6461191565e-06 1.2 1.64615091463e-06 1.2 1.64618267276e-06 1.2 1.64621443089e-06 1.2 1.64624618902e-06 1.2 1.64627794715e-06 1.2 1.64630970528e-06 1.2 1.64634146341e-06 1.2 1.64637322154e-06 1.2 1.64640497967e-06 1.2 1.6464367378e-06 1.2 1.64646849593e-06 1.2 1.64650025407e-06 1.2 1.6465320122e-06 1.2 1.64656377033e-06 1.2 1.64659552846e-06 1.2 1.64662728659e-06 1.2 1.64665904472e-06 1.2 1.64669080285e-06 1.2 1.64672256098e-06 1.2 1.64675431911e-06 1.2 1.64678607724e-06 1.2 1.64681783537e-06 1.2 1.6468495935e-06 1.2 1.64688135163e-06 1.2 1.64691310976e-06 1.2 1.64694486789e-06 1.2 1.64697662602e-06 1.2 1.64700838415e-06 1.2 1.64704014228e-06 1.2 1.64707190041e-06 1.2 1.64710365854e-06 1.2 1.64713541667e-06 1.2 1.6471671748e-06 1.2 1.64719893293e-06 1.2 1.64723069106e-06 1.2 1.64726244919e-06 1.2 1.64729420732e-06 1.2 1.64732596545e-06 1.2 1.64735772358e-06 1.2 1.64738948171e-06 1.2 1.64742123984e-06 1.2 1.64745299797e-06 1.2 1.6474847561e-06 1.2 1.64751651423e-06 1.2 1.64754827236e-06 1.2 1.64758003049e-06 1.2 1.64761178862e-06 1.2 1.64764354675e-06 1.2 1.64767530488e-06 1.2 1.64770706301e-06 1.2 1.64773882114e-06 1.2 1.64777057927e-06 1.2 1.6478023374e-06 1.2 1.64783409553e-06 1.2 1.64786585366e-06 1.2 1.64789761179e-06 1.2 1.64792936992e-06 1.2 1.64796112805e-06 1.2 1.64799288618e-06 1.2 1.64802464431e-06 1.2 1.64805640244e-06 1.2 1.64808816057e-06 1.2 1.6481199187e-06 1.2 1.64815167683e-06 1.2 1.64818343496e-06 1.2 1.64821519309e-06 1.2 1.64824695122e-06 1.2 1.64827870935e-06 1.2 1.64831046748e-06 1.2 1.64834222561e-06 1.2 1.64837398374e-06 1.2 1.64840574187e-06 1.2 1.6484375e-06 1.2 1.64846925813e-06 1.2 1.64850101626e-06 1.2 1.64853277439e-06 1.2 1.64856453252e-06 1.2 1.64859629065e-06 1.2 1.64862804878e-06 1.2 1.64865980691e-06 1.2 1.64869156504e-06 1.2 1.64872332317e-06 1.2 1.6487550813e-06 1.2 1.64878683943e-06 1.2 1.64881859756e-06 1.2 1.64885035569e-06 1.2 1.64888211382e-06 1.2 1.64891387195e-06 1.2 1.64894563008e-06 1.2 1.64897738821e-06 1.2 1.64900914634e-06 1.2 1.64904090447e-06 1.2 1.6490726626e-06 1.2 1.64910442073e-06 1.2 1.64913617886e-06 1.2 1.64916793699e-06 1.2 1.64919969512e-06 1.2 1.64923145325e-06 1.2 1.64926321138e-06 1.2 1.64929496951e-06 1.2 1.64932672764e-06 1.2 1.64935848577e-06 1.2 1.6493902439e-06 1.2 1.64942200203e-06 1.2 1.64945376016e-06 1.2 1.64948551829e-06 1.2 1.64951727642e-06 1.2 1.64954903455e-06 1.2 1.64958079268e-06 1.2 1.64961255081e-06 1.2 1.64964430894e-06 1.2 1.64967606707e-06 1.2 1.6497078252e-06 1.2 1.64973958333e-06 1.2 1.64977134146e-06 1.2 1.64980309959e-06 1.2 1.64983485772e-06 1.2 1.64986661585e-06 1.2 1.64989837398e-06 1.2 1.64993013211e-06 1.2 1.64996189024e-06 1.2 1.64999364837e-06 1.2 1.6500254065e-06 1.2 1.65005716463e-06 1.2 1.65008892276e-06 1.2 1.65012068089e-06 1.2 1.65015243902e-06 1.2 1.65018419715e-06 1.2 1.65021595528e-06 1.2 1.65024771341e-06 1.2 1.65027947154e-06 1.2 1.65031122967e-06 1.2 1.6503429878e-06 1.2 1.65037474593e-06 1.2 1.65040650407e-06 1.2 1.6504382622e-06 1.2 1.65047002033e-06 1.2 1.65050177846e-06 1.2 1.65053353659e-06 1.2 1.65056529472e-06 1.2 1.65059705285e-06 1.2 1.65062881098e-06 1.2 1.65066056911e-06 1.2 1.65069232724e-06 1.2 1.65072408537e-06 1.2 1.6507558435e-06 1.2 1.65078760163e-06 1.2 1.65081935976e-06 1.2 1.65085111789e-06 1.2 1.65088287602e-06 1.2 1.65091463415e-06 1.2 1.65094639228e-06 1.2 1.65097815041e-06 1.2 1.65100990854e-06 1.2 1.65104166667e-06 1.2 1.6510734248e-06 1.2 1.65110518293e-06 1.2 1.65113694106e-06 1.2 1.65116869919e-06 1.2 1.65120045732e-06 1.2 1.65123221545e-06 1.2 1.65126397358e-06 1.2 1.65129573171e-06 1.2 1.65132748984e-06 1.2 1.65135924797e-06 1.2 1.6513910061e-06 1.2 1.65142276423e-06 1.2 1.65145452236e-06 1.2 1.65148628049e-06 1.2 1.65151803862e-06 1.2 1.65154979675e-06 1.2 1.65158155488e-06 1.2 1.65161331301e-06 1.2 1.65164507114e-06 1.2 1.65167682927e-06 1.2 1.6517085874e-06 1.2 1.65174034553e-06 1.2 1.65177210366e-06 1.2 1.65180386179e-06 1.2 1.65183561992e-06 1.2 1.65186737805e-06 1.2 1.65189913618e-06 1.2 1.65193089431e-06 1.2 1.65196265244e-06 1.2 1.65199441057e-06 1.2 1.6520261687e-06 1.2 1.65205792683e-06 1.2 1.65208968496e-06 1.2 1.65212144309e-06 1.2 1.65215320122e-06 1.2 1.65218495935e-06 1.2 1.65221671748e-06 1.2 1.65224847561e-06 1.2 1.65228023374e-06 1.2 1.65231199187e-06 1.2 1.65234375e-06 1.2 1.65237550813e-06 1.2 1.65240726626e-06 1.2 1.65243902439e-06 1.2 1.65247078252e-06 1.2 1.65250254065e-06 1.2 1.65253429878e-06 1.2 1.65256605691e-06 1.2 1.65259781504e-06 1.2 1.65262957317e-06 1.2 1.6526613313e-06 1.2 1.65269308943e-06 1.2 1.65272484756e-06 1.2 1.65275660569e-06 1.2 1.65278836382e-06 1.2 1.65282012195e-06 1.2 1.65285188008e-06 1.2 1.65288363821e-06 1.2 1.65291539634e-06 1.2 1.65294715447e-06 1.2 1.6529789126e-06 1.2 1.65301067073e-06 1.2 1.65304242886e-06 1.2 1.65307418699e-06 1.2 1.65310594512e-06 1.2 1.65313770325e-06 1.2 1.65316946138e-06 1.2 1.65320121951e-06 1.2 1.65323297764e-06 1.2 1.65326473577e-06 1.2 1.6532964939e-06 1.2 1.65332825203e-06 1.2 1.65336001016e-06 1.2 1.65339176829e-06 1.2 1.65342352642e-06 1.2 1.65345528455e-06 1.2 1.65348704268e-06 1.2 1.65351880081e-06 1.2 1.65355055894e-06 1.2 1.65358231707e-06 1.2 1.6536140752e-06 1.2 1.65364583333e-06 1.2 1.65367759146e-06 1.2 1.65370934959e-06 1.2 1.65374110772e-06 1.2 1.65377286585e-06 1.2 1.65380462398e-06 1.2 1.65383638211e-06 1.2 1.65386814024e-06 1.2 1.65389989837e-06 1.2 1.6539316565e-06 1.2 1.65396341463e-06 1.2 1.65399517276e-06 1.2 1.65402693089e-06 1.2 1.65405868902e-06 1.2 1.65409044715e-06 1.2 1.65412220528e-06 1.2 1.65415396341e-06 1.2 1.65418572154e-06 1.2 1.65421747967e-06 1.2 1.6542492378e-06 1.2 1.65428099593e-06 1.2 1.65431275407e-06 1.2 1.6543445122e-06 1.2 1.65437627033e-06 1.2 1.65440802846e-06 1.2 1.65443978659e-06 1.2 1.65447154472e-06 1.2 1.65450330285e-06 1.2 1.65453506098e-06 1.2 1.65456681911e-06 1.2 1.65459857724e-06 1.2 1.65463033537e-06 1.2 1.6546620935e-06 1.2 1.65469385163e-06 1.2 1.65472560976e-06 1.2 1.65475736789e-06 1.2 1.65478912602e-06 1.2 1.65482088415e-06 1.2 1.65485264228e-06 1.2 1.65488440041e-06 1.2 1.65491615854e-06 1.2 1.65494791667e-06 1.2 1.6549796748e-06 1.2 1.65501143293e-06 1.2 1.65504319106e-06 1.2 1.65507494919e-06 1.2 1.65510670732e-06 1.2 1.65513846545e-06 1.2 1.65517022358e-06 1.2 1.65520198171e-06 1.2 1.65523373984e-06 1.2 1.65526549797e-06 1.2 1.6552972561e-06 1.2 1.65532901423e-06 1.2 1.65536077236e-06 1.2 1.65539253049e-06 1.2 1.65542428862e-06 1.2 1.65545604675e-06 1.2 1.65548780488e-06 1.2 1.65551956301e-06 1.2 1.65555132114e-06 1.2 1.65558307927e-06 1.2 1.6556148374e-06 1.2 1.65564659553e-06 1.2 1.65567835366e-06 1.2 1.65571011179e-06 1.2 1.65574186992e-06 1.2 1.65577362805e-06 1.2 1.65580538618e-06 1.2 1.65583714431e-06 1.2 1.65586890244e-06 1.2 1.65590066057e-06 1.2 1.6559324187e-06 1.2 1.65596417683e-06 1.2 1.65599593496e-06 1.2 1.65602769309e-06 1.2 1.65605945122e-06 1.2 1.65609120935e-06 1.2 1.65612296748e-06 1.2 1.65615472561e-06 1.2 1.65618648374e-06 1.2 1.65621824187e-06 1.2 1.65625e-06 1.2 1.65628175813e-06 1.2 1.65631351626e-06 1.2 1.65634527439e-06 1.2 1.65637703252e-06 1.2 1.65640879065e-06 1.2 1.65644054878e-06 1.2 1.65647230691e-06 1.2 1.65650406504e-06 1.2 1.65653582317e-06 1.2 1.6565675813e-06 1.2 1.65659933943e-06 1.2 1.65663109756e-06 1.2 1.65666285569e-06 1.2 1.65669461382e-06 1.2 1.65672637195e-06 1.2 1.65675813008e-06 1.2 1.65678988821e-06 1.2 1.65682164634e-06 1.2 1.65685340447e-06 1.2 1.6568851626e-06 1.2 1.65691692073e-06 1.2 1.65694867886e-06 1.2 1.65698043699e-06 1.2 1.65701219512e-06 1.2 1.65704395325e-06 1.2 1.65707571138e-06 1.2 1.65710746951e-06 1.2 1.65713922764e-06 1.2 1.65717098577e-06 1.2 1.6572027439e-06 1.2 1.65723450203e-06 1.2 1.65726626016e-06 1.2 1.65729801829e-06 1.2 1.65732977642e-06 1.2 1.65736153455e-06 1.2 1.65739329268e-06 1.2 1.65742505081e-06 1.2 1.65745680894e-06 1.2 1.65748856707e-06 1.2 1.6575203252e-06 1.2 1.65755208333e-06 1.2 1.65758384146e-06 1.2 1.65761559959e-06 1.2 1.65764735772e-06 1.2 1.65767911585e-06 1.2 1.65771087398e-06 1.2 1.65774263211e-06 1.2 1.65777439024e-06 1.2 1.65780614837e-06 1.2 1.6578379065e-06 1.2 1.65786966463e-06 1.2 1.65790142276e-06 1.2 1.65793318089e-06 1.2 1.65796493902e-06 1.2 1.65799669715e-06 1.2 1.65802845528e-06 1.2 1.65806021341e-06 1.2 1.65809197154e-06 1.2 1.65812372967e-06 1.2 1.6581554878e-06 1.2 1.65818724593e-06 1.2 1.65821900407e-06 1.2 1.6582507622e-06 1.2 1.65828252033e-06 1.2 1.65831427846e-06 1.2 1.65834603659e-06 1.2 1.65837779472e-06 1.2 1.65840955285e-06 1.2 1.65844131098e-06 1.2 1.65847306911e-06 1.2 1.65850482724e-06 1.2 1.65853658537e-06 1.2 1.6585683435e-06 1.2 1.65860010163e-06 1.2 1.65863185976e-06 1.2 1.65866361789e-06 1.2 1.65869537602e-06 1.2 1.65872713415e-06 1.2 1.65875889228e-06 1.2 1.65879065041e-06 1.2 1.65882240854e-06 1.2 1.65885416667e-06 1.2 1.6588859248e-06 1.2 1.65891768293e-06 1.2 1.65894944106e-06 1.2 1.65898119919e-06 1.2 1.65901295732e-06 1.2 1.65904471545e-06 1.2 1.65907647358e-06 1.2 1.65910823171e-06 1.2 1.65913998984e-06 1.2 1.65917174797e-06 1.2 1.6592035061e-06 1.2 1.65923526423e-06 1.2 1.65926702236e-06 1.2 1.65929878049e-06 1.2 1.65933053862e-06 1.2 1.65936229675e-06 1.2 1.65939405488e-06 1.2 1.65942581301e-06 1.2 1.65945757114e-06 1.2 1.65948932927e-06 1.2 1.6595210874e-06 1.2 1.65955284553e-06 1.2 1.65958460366e-06 1.2 1.65961636179e-06 1.2 1.65964811992e-06 1.2 1.65967987805e-06 1.2 1.65971163618e-06 1.2 1.65974339431e-06 1.2 1.65977515244e-06 1.2 1.65980691057e-06 1.2 1.6598386687e-06 1.2 1.65987042683e-06 1.2 1.65990218496e-06 1.2 1.65993394309e-06 1.2 1.65996570122e-06 1.2 1.65999745935e-06 1.2 1.66002921748e-06 1.2 1.66006097561e-06 1.2 1.66009273374e-06 1.2 1.66012449187e-06 1.2 1.66015625e-06 1.2 1.66018800813e-06 1.2 1.66021976626e-06 1.2 1.66025152439e-06 1.2 1.66028328252e-06 1.2 1.66031504065e-06 1.2 1.66034679878e-06 1.2 1.66037855691e-06 1.2 1.66041031504e-06 1.2 1.66044207317e-06 1.2 1.6604738313e-06 1.2 1.66050558943e-06 1.2 1.66053734756e-06 1.2 1.66056910569e-06 1.2 1.66060086382e-06 1.2 1.66063262195e-06 1.2 1.66066438008e-06 1.2 1.66069613821e-06 1.2 1.66072789634e-06 1.2 1.66075965447e-06 1.2 1.6607914126e-06 1.2 1.66082317073e-06 1.2 1.66085492886e-06 1.2 1.66088668699e-06 1.2 1.66091844512e-06 1.2 1.66095020325e-06 1.2 1.66098196138e-06 1.2 1.66101371951e-06 1.2 1.66104547764e-06 1.2 1.66107723577e-06 1.2 1.6611089939e-06 1.2 1.66114075203e-06 1.2 1.66117251016e-06 1.2 1.66120426829e-06 1.2 1.66123602642e-06 1.2 1.66126778455e-06 1.2 1.66129954268e-06 1.2 1.66133130081e-06 1.2 1.66136305894e-06 1.2 1.66139481707e-06 1.2 1.6614265752e-06 1.2 1.66145833333e-06 1.2 1.66149009146e-06 1.2 1.66152184959e-06 1.2 1.66155360772e-06 1.2 1.66158536585e-06 1.2 1.66161712398e-06 1.2 1.66164888211e-06 1.2 1.66168064024e-06 1.2 1.66171239837e-06 1.2 1.6617441565e-06 1.2 1.66177591463e-06 1.2 1.66180767276e-06 1.2 1.66183943089e-06 1.2 1.66187118902e-06 1.2 1.66190294715e-06 1.2 1.66193470528e-06 1.2 1.66196646341e-06 1.2 1.66199822154e-06 1.2 1.66202997967e-06 1.2 1.6620617378e-06 1.2 1.66209349593e-06 1.2 1.66212525407e-06 1.2 1.6621570122e-06 1.2 1.66218877033e-06 1.2 1.66222052846e-06 1.2 1.66225228659e-06 1.2 1.66228404472e-06 1.2 1.66231580285e-06 1.2 1.66234756098e-06 1.2 1.66237931911e-06 1.2 1.66241107724e-06 1.2 1.66244283537e-06 1.2 1.6624745935e-06 1.2 1.66250635163e-06 1.2 1.66253810976e-06 1.2 1.66256986789e-06 1.2 1.66260162602e-06 1.2 1.66263338415e-06 1.2 1.66266514228e-06 1.2 1.66269690041e-06 1.2 1.66272865854e-06 1.2 1.66276041667e-06 1.2 1.6627921748e-06 1.2 1.66282393293e-06 1.2 1.66285569106e-06 1.2 1.66288744919e-06 1.2 1.66291920732e-06 1.2 1.66295096545e-06 1.2 1.66298272358e-06 1.2 1.66301448171e-06 1.2 1.66304623984e-06 1.2 1.66307799797e-06 1.2 1.6631097561e-06 1.2 1.66314151423e-06 1.2 1.66317327236e-06 1.2 1.66320503049e-06 1.2 1.66323678862e-06 1.2 1.66326854675e-06 1.2 1.66330030488e-06 1.2 1.66333206301e-06 1.2 1.66336382114e-06 1.2 1.66339557927e-06 1.2 1.6634273374e-06 1.2 1.66345909553e-06 1.2 1.66349085366e-06 1.2 1.66352261179e-06 1.2 1.66355436992e-06 1.2 1.66358612805e-06 1.2 1.66361788618e-06 1.2 1.66364964431e-06 1.2 1.66368140244e-06 1.2 1.66371316057e-06 1.2 1.6637449187e-06 1.2 1.66377667683e-06 1.2 1.66380843496e-06 1.2 1.66384019309e-06 1.2 1.66387195122e-06 1.2 1.66390370935e-06 1.2 1.66393546748e-06 1.2 1.66396722561e-06 1.2 1.66399898374e-06 1.2 1.66403074187e-06 1.2 1.6640625e-06 1.2 1.66409425813e-06 1.2 1.66412601626e-06 1.2 1.66415777439e-06 1.2 1.66418953252e-06 1.2 1.66422129065e-06 1.2 1.66425304878e-06 1.2 1.66428480691e-06 1.2 1.66431656504e-06 1.2 1.66434832317e-06 1.2 1.6643800813e-06 1.2 1.66441183943e-06 1.2 1.66444359756e-06 1.2 1.66447535569e-06 1.2 1.66450711382e-06 1.2 1.66453887195e-06 1.2 1.66457063008e-06 1.2 1.66460238821e-06 1.2 1.66463414634e-06 1.2 1.66466590447e-06 1.2 1.6646976626e-06 1.2 1.66472942073e-06 1.2 1.66476117886e-06 1.2 1.66479293699e-06 1.2 1.66482469512e-06 1.2 1.66485645325e-06 1.2 1.66488821138e-06 1.2 1.66491996951e-06 1.2 1.66495172764e-06 1.2 1.66498348577e-06 1.2 1.6650152439e-06 1.2 1.66504700203e-06 1.2 1.66507876016e-06 1.2 1.66511051829e-06 1.2 1.66514227642e-06 1.2 1.66517403455e-06 1.2 1.66520579268e-06 1.2 1.66523755081e-06 1.2 1.66526930894e-06 1.2 1.66530106707e-06 1.2 1.6653328252e-06 1.2 1.66536458333e-06 1.2 1.66539634146e-06 1.2 1.66542809959e-06 1.2 1.66545985772e-06 1.2 1.66549161585e-06 1.2 1.66552337398e-06 1.2 1.66555513211e-06 1.2 1.66558689024e-06 1.2 1.66561864837e-06 1.2 1.6656504065e-06 1.2 1.66568216463e-06 1.2 1.66571392276e-06 1.2 1.66574568089e-06 1.2 1.66577743902e-06 1.2 1.66580919715e-06 1.2 1.66584095528e-06 1.2 1.66587271341e-06 1.2 1.66590447154e-06 1.2 1.66593622967e-06 1.2 1.6659679878e-06 1.2 1.66599974593e-06 1.2 1.66603150407e-06 1.2 1.6660632622e-06 1.2 1.66609502033e-06 1.2 1.66612677846e-06 1.2 1.66615853659e-06 1.2 1.66619029472e-06 1.2 1.66622205285e-06 1.2 1.66625381098e-06 1.2 1.66628556911e-06 1.2 1.66631732724e-06 1.2 1.66634908537e-06 1.2 1.6663808435e-06 1.2 1.66641260163e-06 1.2 1.66644435976e-06 1.2 1.66647611789e-06 1.2 1.66650787602e-06 1.2 1.66653963415e-06 1.2 1.66657139228e-06 1.2 1.66660315041e-06 1.2 1.66663490854e-06 1.2 1.66666666667e-06 1.2 1.6666984248e-06 1.2 1.66673018293e-06 1.2 1.66676194106e-06 1.2 1.66679369919e-06 1.2 1.66682545732e-06 1.2 1.66685721545e-06 1.2 1.66688897358e-06 1.2 1.66692073171e-06 1.2 1.66695248984e-06 1.2 1.66698424797e-06 1.2 1.6670160061e-06 1.2 1.66704776423e-06 1.2 1.66707952236e-06 1.2 1.66711128049e-06 1.2 1.66714303862e-06 1.2 1.66717479675e-06 1.2 1.66720655488e-06 1.2 1.66723831301e-06 1.2 1.66727007114e-06 1.2 1.66730182927e-06 1.2 1.6673335874e-06 1.2 1.66736534553e-06 1.2 1.66739710366e-06 1.2 1.66742886179e-06 1.2 1.66746061992e-06 1.2 1.66749237805e-06 1.2 1.66752413618e-06 1.2 1.66755589431e-06 1.2 1.66758765244e-06 1.2 1.66761941057e-06 1.2 1.6676511687e-06 1.2 1.66768292683e-06 1.2 1.66771468496e-06 1.2 1.66774644309e-06 1.2 1.66777820122e-06 1.2 1.66780995935e-06 1.2 1.66784171748e-06 1.2 1.66787347561e-06 1.2 1.66790523374e-06 1.2 1.66793699187e-06 1.2 1.66796875e-06 1.2 1.66800050813e-06 1.2 1.66803226626e-06 1.2 1.66806402439e-06 1.2 1.66809578252e-06 1.2 1.66812754065e-06 1.2 1.66815929878e-06 1.2 1.66819105691e-06 1.2 1.66822281504e-06 1.2 1.66825457317e-06 1.2 1.6682863313e-06 1.2 1.66831808943e-06 1.2 1.66834984756e-06 1.2 1.66838160569e-06 1.2 1.66841336382e-06 1.2 1.66844512195e-06 1.2 1.66847688008e-06 1.2 1.66850863821e-06 1.2 1.66854039634e-06 1.2 1.66857215447e-06 1.2 1.6686039126e-06 1.2 1.66863567073e-06 1.2 1.66866742886e-06 1.2 1.66869918699e-06 1.2 1.66873094512e-06 1.2 1.66876270325e-06 1.2 1.66879446138e-06 1.2 1.66882621951e-06 1.2 1.66885797764e-06 1.2 1.66888973577e-06 1.2 1.6689214939e-06 1.2 1.66895325203e-06 1.2 1.66898501016e-06 1.2 1.66901676829e-06 1.2 1.66904852642e-06 1.2 1.66908028455e-06 1.2 1.66911204268e-06 1.2 1.66914380081e-06 1.2 1.66917555894e-06 1.2 1.66920731707e-06 1.2 1.6692390752e-06 1.2 1.66927083333e-06 1.2 1.66930259146e-06 1.2 1.66933434959e-06 1.2 1.66936610772e-06 1.2 1.66939786585e-06 1.2 1.66942962398e-06 1.2 1.66946138211e-06 1.2 1.66949314024e-06 1.2 1.66952489837e-06 1.2 1.6695566565e-06 1.2 1.66958841463e-06 1.2 1.66962017276e-06 1.2 1.66965193089e-06 1.2 1.66968368902e-06 1.2 1.66971544715e-06 1.2 1.66974720528e-06 1.2 1.66977896341e-06 1.2 1.66981072154e-06 1.2 1.66984247967e-06 1.2 1.6698742378e-06 1.2 1.66990599593e-06 1.2 1.66993775407e-06 1.2 1.6699695122e-06 1.2 1.67000127033e-06 1.2 1.67003302846e-06 1.2 1.67006478659e-06 1.2 1.67009654472e-06 1.2 1.67012830285e-06 1.2 1.67016006098e-06 1.2 1.67019181911e-06 1.2 1.67022357724e-06 1.2 1.67025533537e-06 1.2 1.6702870935e-06 1.2 1.67031885163e-06 1.2 1.67035060976e-06 1.2 1.67038236789e-06 1.2 1.67041412602e-06 1.2 1.67044588415e-06 1.2 1.67047764228e-06 1.2 1.67050940041e-06 1.2 1.67054115854e-06 1.2 1.67057291667e-06 1.2 1.6706046748e-06 1.2 1.67063643293e-06 1.2 1.67066819106e-06 1.2 1.67069994919e-06 1.2 1.67073170732e-06 1.2 1.67076346545e-06 1.2 1.67079522358e-06 1.2 1.67082698171e-06 1.2 1.67085873984e-06 1.2 1.67089049797e-06 1.2 1.6709222561e-06 1.2 1.67095401423e-06 1.2 1.67098577236e-06 1.2 1.67101753049e-06 1.2 1.67104928862e-06 1.2 1.67108104675e-06 1.2 1.67111280488e-06 1.2 1.67114456301e-06 1.2 1.67117632114e-06 1.2 1.67120807927e-06 1.2 1.6712398374e-06 1.2 1.67127159553e-06 1.2 1.67130335366e-06 1.2 1.67133511179e-06 1.2 1.67136686992e-06 1.2 1.67139862805e-06 1.2 1.67143038618e-06 1.2 1.67146214431e-06 1.2 1.67149390244e-06 1.2 1.67152566057e-06 1.2 1.6715574187e-06 1.2 1.67158917683e-06 1.2 1.67162093496e-06 1.2 1.67165269309e-06 1.2 1.67168445122e-06 1.2 1.67171620935e-06 1.2 1.67174796748e-06 1.2 1.67177972561e-06 1.2 1.67181148374e-06 1.2 1.67184324187e-06 1.2 1.671875e-06 1.2 1.67190675813e-06 1.2 1.67193851626e-06 1.2 1.67197027439e-06 1.2 1.67200203252e-06 1.2 1.67203379065e-06 1.2 1.67206554878e-06 1.2 1.67209730691e-06 1.2 1.67212906504e-06 1.2 1.67216082317e-06 1.2 1.6721925813e-06 1.2 1.67222433943e-06 1.2 1.67225609756e-06 1.2 1.67228785569e-06 1.2 1.67231961382e-06 1.2 1.67235137195e-06 1.2 1.67238313008e-06 1.2 1.67241488821e-06 1.2 1.67244664634e-06 1.2 1.67247840447e-06 1.2 1.6725101626e-06 1.2 1.67254192073e-06 1.2 1.67257367886e-06 1.2 1.67260543699e-06 1.2 1.67263719512e-06 1.2 1.67266895325e-06 1.2 1.67270071138e-06 1.2 1.67273246951e-06 1.2 1.67276422764e-06 1.2 1.67279598577e-06 1.2 1.6728277439e-06 1.2 1.67285950203e-06 1.2 1.67289126016e-06 1.2 1.67292301829e-06 1.2 1.67295477642e-06 1.2 1.67298653455e-06 1.2 1.67301829268e-06 1.2 1.67305005081e-06 1.2 1.67308180894e-06 1.2 1.67311356707e-06 1.2 1.6731453252e-06 1.2 1.67317708333e-06 1.2 1.67320884146e-06 1.2 1.67324059959e-06 1.2 1.67327235772e-06 1.2 1.67330411585e-06 1.2 1.67333587398e-06 1.2 1.67336763211e-06 1.2 1.67339939024e-06 1.2 1.67343114837e-06 1.2 1.6734629065e-06 1.2 1.67349466463e-06 1.2 1.67352642276e-06 1.2 1.67355818089e-06 1.2 1.67358993902e-06 1.2 1.67362169715e-06 1.2 1.67365345528e-06 1.2 1.67368521341e-06 1.2 1.67371697154e-06 1.2 1.67374872967e-06 1.2 1.6737804878e-06 1.2 1.67381224593e-06 1.2 1.67384400407e-06 1.2 1.6738757622e-06 1.2 1.67390752033e-06 1.2 1.67393927846e-06 1.2 1.67397103659e-06 1.2 1.67400279472e-06 1.2 1.67403455285e-06 1.2 1.67406631098e-06 1.2 1.67409806911e-06 1.2 1.67412982724e-06 1.2 1.67416158537e-06 1.2 1.6741933435e-06 1.2 1.67422510163e-06 1.2 1.67425685976e-06 1.2 1.67428861789e-06 1.2 1.67432037602e-06 1.2 1.67435213415e-06 1.2 1.67438389228e-06 1.2 1.67441565041e-06 1.2 1.67444740854e-06 1.2 1.67447916667e-06 1.2 1.6745109248e-06 1.2 1.67454268293e-06 1.2 1.67457444106e-06 1.2 1.67460619919e-06 1.2 1.67463795732e-06 1.2 1.67466971545e-06 1.2 1.67470147358e-06 1.2 1.67473323171e-06 1.2 1.67476498984e-06 1.2 1.67479674797e-06 1.2 1.6748285061e-06 1.2 1.67486026423e-06 1.2 1.67489202236e-06 1.2 1.67492378049e-06 1.2 1.67495553862e-06 1.2 1.67498729675e-06 1.2 1.67501905488e-06 1.2 1.67505081301e-06 1.2 1.67508257114e-06 1.2 1.67511432927e-06 1.2 1.6751460874e-06 1.2 1.67517784553e-06 1.2 1.67520960366e-06 1.2 1.67524136179e-06 1.2 1.67527311992e-06 1.2 1.67530487805e-06 1.2 1.67533663618e-06 1.2 1.67536839431e-06 1.2 1.67540015244e-06 1.2 1.67543191057e-06 1.2 1.6754636687e-06 1.2 1.67549542683e-06 1.2 1.67552718496e-06 1.2 1.67555894309e-06 1.2 1.67559070122e-06 1.2 1.67562245935e-06 1.2 1.67565421748e-06 1.2 1.67568597561e-06 1.2 1.67571773374e-06 1.2 1.67574949187e-06 1.2 1.67578125e-06 1.2 1.67581300813e-06 1.2 1.67584476626e-06 1.2 1.67587652439e-06 1.2 1.67590828252e-06 1.2 1.67594004065e-06 1.2 1.67597179878e-06 1.2 1.67600355691e-06 1.2 1.67603531504e-06 1.2 1.67606707317e-06 1.2 1.6760988313e-06 1.2 1.67613058943e-06 1.2 1.67616234756e-06 1.2 1.67619410569e-06 1.2 1.67622586382e-06 1.2 1.67625762195e-06 1.2 1.67628938008e-06 1.2 1.67632113821e-06 1.2 1.67635289634e-06 1.2 1.67638465447e-06 1.2 1.6764164126e-06 1.2 1.67644817073e-06 1.2 1.67647992886e-06 1.2 1.67651168699e-06 1.2 1.67654344512e-06 1.2 1.67657520325e-06 1.2 1.67660696138e-06 1.2 1.67663871951e-06 1.2 1.67667047764e-06 1.2 1.67670223577e-06 1.2 1.6767339939e-06 1.2 1.67676575203e-06 1.2 1.67679751016e-06 1.2 1.67682926829e-06 1.2 1.67686102642e-06 1.2 1.67689278455e-06 1.2 1.67692454268e-06 1.2 1.67695630081e-06 1.2 1.67698805894e-06 1.2 1.67701981707e-06 1.2 1.6770515752e-06 1.2 1.67708333333e-06 1.2 1.67711509146e-06 1.2 1.67714684959e-06 1.2 1.67717860772e-06 1.2 1.67721036585e-06 1.2 1.67724212398e-06 1.2 1.67727388211e-06 1.2 1.67730564024e-06 1.2 1.67733739837e-06 1.2 1.6773691565e-06 1.2 1.67740091463e-06 1.2 1.67743267276e-06 1.2 1.67746443089e-06 1.2 1.67749618902e-06 1.2 1.67752794715e-06 1.2 1.67755970528e-06 1.2 1.67759146341e-06 1.2 1.67762322154e-06 1.2 1.67765497967e-06 1.2 1.6776867378e-06 1.2 1.67771849593e-06 1.2 1.67775025407e-06 1.2 1.6777820122e-06 1.2 1.67781377033e-06 1.2 1.67784552846e-06 1.2 1.67787728659e-06 1.2 1.67790904472e-06 1.2 1.67794080285e-06 1.2 1.67797256098e-06 1.2 1.67800431911e-06 1.2 1.67803607724e-06 1.2 1.67806783537e-06 1.2 1.6780995935e-06 1.2 1.67813135163e-06 1.2 1.67816310976e-06 1.2 1.67819486789e-06 1.2 1.67822662602e-06 1.2 1.67825838415e-06 1.2 1.67829014228e-06 1.2 1.67832190041e-06 1.2 1.67835365854e-06 1.2 1.67838541667e-06 1.2 1.6784171748e-06 1.2 1.67844893293e-06 1.2 1.67848069106e-06 1.2 1.67851244919e-06 1.2 1.67854420732e-06 1.2 1.67857596545e-06 1.2 1.67860772358e-06 1.2 1.67863948171e-06 1.2 1.67867123984e-06 1.2 1.67870299797e-06 1.2 1.6787347561e-06 1.2 1.67876651423e-06 1.2 1.67879827236e-06 1.2 1.67883003049e-06 1.2 1.67886178862e-06 1.2 1.67889354675e-06 1.2 1.67892530488e-06 1.2 1.67895706301e-06 1.2 1.67898882114e-06 1.2 1.67902057927e-06 1.2 1.6790523374e-06 1.2 1.67908409553e-06 1.2 1.67911585366e-06 1.2 1.67914761179e-06 1.2 1.67917936992e-06 1.2 1.67921112805e-06 1.2 1.67924288618e-06 1.2 1.67927464431e-06 1.2 1.67930640244e-06 1.2 1.67933816057e-06 1.2 1.6793699187e-06 1.2 1.67940167683e-06 1.2 1.67943343496e-06 1.2 1.67946519309e-06 1.2 1.67949695122e-06 1.2 1.67952870935e-06 1.2 1.67956046748e-06 1.2 1.67959222561e-06 1.2 1.67962398374e-06 1.2 1.67965574187e-06 1.2 1.6796875e-06 1.2 1.67971925813e-06 1.2 1.67975101626e-06 1.2 1.67978277439e-06 1.2 1.67981453252e-06 1.2 1.67984629065e-06 1.2 1.67987804878e-06 1.2 1.67990980691e-06 1.2 1.67994156504e-06 1.2 1.67997332317e-06 1.2 1.6800050813e-06 1.2 1.68003683943e-06 1.2 1.68006859756e-06 1.2 1.68010035569e-06 1.2 1.68013211382e-06 1.2 1.68016387195e-06 1.2 1.68019563008e-06 1.2 1.68022738821e-06 1.2 1.68025914634e-06 1.2 1.68029090447e-06 1.2 1.6803226626e-06 1.2 1.68035442073e-06 1.2 1.68038617886e-06 1.2 1.68041793699e-06 1.2 1.68044969512e-06 1.2 1.68048145325e-06 1.2 1.68051321138e-06 1.2 1.68054496951e-06 1.2 1.68057672764e-06 1.2 1.68060848577e-06 1.2 1.6806402439e-06 1.2 1.68067200203e-06 1.2 1.68070376016e-06 1.2 1.68073551829e-06 1.2 1.68076727642e-06 1.2 1.68079903455e-06 1.2 1.68083079268e-06 1.2 1.68086255081e-06 1.2 1.68089430894e-06 1.2 1.68092606707e-06 1.2 1.6809578252e-06 1.2 1.68098958333e-06 1.2 1.68102134146e-06 1.2 1.68105309959e-06 1.2 1.68108485772e-06 1.2 1.68111661585e-06 1.2 1.68114837398e-06 1.2 1.68118013211e-06 1.2 1.68121189024e-06 1.2 1.68124364837e-06 1.2 1.6812754065e-06 1.2 1.68130716463e-06 1.2 1.68133892276e-06 1.2 1.68137068089e-06 1.2 1.68140243902e-06 1.2 1.68143419715e-06 1.2 1.68146595528e-06 1.2 1.68149771341e-06 1.2 1.68152947154e-06 1.2 1.68156122967e-06 1.2 1.6815929878e-06 1.2 1.68162474593e-06 1.2 1.68165650407e-06 1.2 1.6816882622e-06 1.2 1.68172002033e-06 1.2 1.68175177846e-06 1.2 1.68178353659e-06 1.2 1.68181529472e-06 1.2 1.68184705285e-06 1.2 1.68187881098e-06 1.2 1.68191056911e-06 1.2 1.68194232724e-06 1.2 1.68197408537e-06 1.2 1.6820058435e-06 1.2 1.68203760163e-06 1.2 1.68206935976e-06 1.2 1.68210111789e-06 1.2 1.68213287602e-06 1.2 1.68216463415e-06 1.2 1.68219639228e-06 1.2 1.68222815041e-06 1.2 1.68225990854e-06 1.2 1.68229166667e-06 1.2 1.6823234248e-06 1.2 1.68235518293e-06 1.2 1.68238694106e-06 1.2 1.68241869919e-06 1.2 1.68245045732e-06 1.2 1.68248221545e-06 1.2 1.68251397358e-06 1.2 1.68254573171e-06 1.2 1.68257748984e-06 1.2 1.68260924797e-06 1.2 1.6826410061e-06 1.2 1.68267276423e-06 1.2 1.68270452236e-06 1.2 1.68273628049e-06 1.2 1.68276803862e-06 1.2 1.68279979675e-06 1.2 1.68283155488e-06 1.2 1.68286331301e-06 1.2 1.68289507114e-06 1.2 1.68292682927e-06 1.2 1.6829585874e-06 1.2 1.68299034553e-06 1.2 1.68302210366e-06 1.2 1.68305386179e-06 1.2 1.68308561992e-06 1.2 1.68311737805e-06 1.2 1.68314913618e-06 1.2 1.68318089431e-06 1.2 1.68321265244e-06 1.2 1.68324441057e-06 1.2 1.6832761687e-06 1.2 1.68330792683e-06 1.2 1.68333968496e-06 1.2 1.68337144309e-06 1.2 1.68340320122e-06 1.2 1.68343495935e-06 1.2 1.68346671748e-06 1.2 1.68349847561e-06 1.2 1.68353023374e-06 1.2 1.68356199187e-06 1.2 1.68359375e-06 1.2 1.68362550813e-06 1.2 1.68365726626e-06 1.2 1.68368902439e-06 1.2 1.68372078252e-06 1.2 1.68375254065e-06 1.2 1.68378429878e-06 1.2 1.68381605691e-06 1.2 1.68384781504e-06 1.2 1.68387957317e-06 1.2 1.6839113313e-06 1.2 1.68394308943e-06 1.2 1.68397484756e-06 1.2 1.68400660569e-06 1.2 1.68403836382e-06 1.2 1.68407012195e-06 1.2 1.68410188008e-06 1.2 1.68413363821e-06 1.2 1.68416539634e-06 1.2 1.68419715447e-06 1.2 1.6842289126e-06 1.2 1.68426067073e-06 1.2 1.68429242886e-06 1.2 1.68432418699e-06 1.2 1.68435594512e-06 1.2 1.68438770325e-06 1.2 1.68441946138e-06 1.2 1.68445121951e-06 1.2 1.68448297764e-06 1.2 1.68451473577e-06 1.2 1.6845464939e-06 1.2 1.68457825203e-06 1.2 1.68461001016e-06 1.2 1.68464176829e-06 1.2 1.68467352642e-06 1.2 1.68470528455e-06 1.2 1.68473704268e-06 1.2 1.68476880081e-06 1.2 1.68480055894e-06 1.2 1.68483231707e-06 1.2 1.6848640752e-06 1.2 1.68489583333e-06 1.2 1.68492759146e-06 1.2 1.68495934959e-06 1.2 1.68499110772e-06 1.2 1.68502286585e-06 1.2 1.68505462398e-06 1.2 1.68508638211e-06 1.2 1.68511814024e-06 1.2 1.68514989837e-06 1.2 1.6851816565e-06 1.2 1.68521341463e-06 1.2 1.68524517276e-06 1.2 1.68527693089e-06 1.2 1.68530868902e-06 1.2 1.68534044715e-06 1.2 1.68537220528e-06 1.2 1.68540396341e-06 1.2 1.68543572154e-06 1.2 1.68546747967e-06 1.2 1.6854992378e-06 1.2 1.68553099593e-06 1.2 1.68556275407e-06 1.2 1.6855945122e-06 1.2 1.68562627033e-06 1.2 1.68565802846e-06 1.2 1.68568978659e-06 1.2 1.68572154472e-06 1.2 1.68575330285e-06 1.2 1.68578506098e-06 1.2 1.68581681911e-06 1.2 1.68584857724e-06 1.2 1.68588033537e-06 1.2 1.6859120935e-06 1.2 1.68594385163e-06 1.2 1.68597560976e-06 1.2 1.68600736789e-06 1.2 1.68603912602e-06 1.2 1.68607088415e-06 1.2 1.68610264228e-06 1.2 1.68613440041e-06 1.2 1.68616615854e-06 1.2 1.68619791667e-06 1.2 1.6862296748e-06 1.2 1.68626143293e-06 1.2 1.68629319106e-06 1.2 1.68632494919e-06 1.2 1.68635670732e-06 1.2 1.68638846545e-06 1.2 1.68642022358e-06 1.2 1.68645198171e-06 1.2 1.68648373984e-06 1.2 1.68651549797e-06 1.2 1.6865472561e-06 1.2 1.68657901423e-06 1.2 1.68661077236e-06 1.2 1.68664253049e-06 1.2 1.68667428862e-06 1.2 1.68670604675e-06 1.2 1.68673780488e-06 1.2 1.68676956301e-06 1.2 1.68680132114e-06 1.2 1.68683307927e-06 1.2 1.6868648374e-06 1.2 1.68689659553e-06 1.2 1.68692835366e-06 1.2 1.68696011179e-06 1.2 1.68699186992e-06 1.2 1.68702362805e-06 1.2 1.68705538618e-06 1.2 1.68708714431e-06 1.2 1.68711890244e-06 1.2 1.68715066057e-06 1.2 1.6871824187e-06 1.2 1.68721417683e-06 1.2 1.68724593496e-06 1.2 1.68727769309e-06 1.2 1.68730945122e-06 1.2 1.68734120935e-06 1.2 1.68737296748e-06 1.2 1.68740472561e-06 1.2 1.68743648374e-06 1.2 1.68746824187e-06 1.2 1.6875e-06 1.2 1.68753175813e-06 1.2 1.68756351626e-06 1.2 1.68759527439e-06 1.2 1.68762703252e-06 1.2 1.68765879065e-06 1.2 1.68769054878e-06 1.2 1.68772230691e-06 1.2 1.68775406504e-06 1.2 1.68778582317e-06 1.2 1.6878175813e-06 1.2 1.68784933943e-06 1.2 1.68788109756e-06 1.2 1.68791285569e-06 1.2 1.68794461382e-06 1.2 1.68797637195e-06 1.2 1.68800813008e-06 1.2 1.68803988821e-06 1.2 1.68807164634e-06 1.2 1.68810340447e-06 1.2 1.6881351626e-06 1.2 1.68816692073e-06 1.2 1.68819867886e-06 1.2 1.68823043699e-06 1.2 1.68826219512e-06 1.2 1.68829395325e-06 1.2 1.68832571138e-06 1.2 1.68835746951e-06 1.2 1.68838922764e-06 1.2 1.68842098577e-06 1.2 1.6884527439e-06 1.2 1.68848450203e-06 1.2 1.68851626016e-06 1.2 1.68854801829e-06 1.2 1.68857977642e-06 1.2 1.68861153455e-06 1.2 1.68864329268e-06 1.2 1.68867505081e-06 1.2 1.68870680894e-06 1.2 1.68873856707e-06 1.2 1.6887703252e-06 1.2 1.68880208333e-06 1.2 1.68883384146e-06 1.2 1.68886559959e-06 1.2 1.68889735772e-06 1.2 1.68892911585e-06 1.2 1.68896087398e-06 1.2 1.68899263211e-06 1.2 1.68902439024e-06 1.2 1.68905614837e-06 1.2 1.6890879065e-06 1.2 1.68911966463e-06 1.2 1.68915142276e-06 1.2 1.68918318089e-06 1.2 1.68921493902e-06 1.2 1.68924669715e-06 1.2 1.68927845528e-06 1.2 1.68931021341e-06 1.2 1.68934197154e-06 1.2 1.68937372967e-06 1.2 1.6894054878e-06 1.2 1.68943724593e-06 1.2 1.68946900407e-06 1.2 1.6895007622e-06 1.2 1.68953252033e-06 1.2 1.68956427846e-06 1.2 1.68959603659e-06 1.2 1.68962779472e-06 1.2 1.68965955285e-06 1.2 1.68969131098e-06 1.2 1.68972306911e-06 1.2 1.68975482724e-06 1.2 1.68978658537e-06 1.2 1.6898183435e-06 1.2 1.68985010163e-06 1.2 1.68988185976e-06 1.2 1.68991361789e-06 1.2 1.68994537602e-06 1.2 1.68997713415e-06 1.2 1.69000889228e-06 1.2 1.69004065041e-06 1.2 1.69007240854e-06 1.2 1.69010416667e-06 1.2 1.6901359248e-06 1.2 1.69016768293e-06 1.2 1.69019944106e-06 1.2 1.69023119919e-06 1.2 1.69026295732e-06 1.2 1.69029471545e-06 1.2 1.69032647358e-06 1.2 1.69035823171e-06 1.2 1.69038998984e-06 1.2 1.69042174797e-06 1.2 1.6904535061e-06 1.2 1.69048526423e-06 1.2 1.69051702236e-06 1.2 1.69054878049e-06 1.2 1.69058053862e-06 1.2 1.69061229675e-06 1.2 1.69064405488e-06 1.2 1.69067581301e-06 1.2 1.69070757114e-06 1.2 1.69073932927e-06 1.2 1.6907710874e-06 1.2 1.69080284553e-06 1.2 1.69083460366e-06 1.2 1.69086636179e-06 1.2 1.69089811992e-06 1.2 1.69092987805e-06 1.2 1.69096163618e-06 1.2 1.69099339431e-06 1.2 1.69102515244e-06 1.2 1.69105691057e-06 1.2 1.6910886687e-06 1.2 1.69112042683e-06 1.2 1.69115218496e-06 1.2 1.69118394309e-06 1.2 1.69121570122e-06 1.2 1.69124745935e-06 1.2 1.69127921748e-06 1.2 1.69131097561e-06 1.2 1.69134273374e-06 1.2 1.69137449187e-06 1.2 1.69140625e-06 1.2 1.69143800813e-06 1.2 1.69146976626e-06 1.2 1.69150152439e-06 1.2 1.69153328252e-06 1.2 1.69156504065e-06 1.2 1.69159679878e-06 1.2 1.69162855691e-06 1.2 1.69166031504e-06 1.2 1.69169207317e-06 1.2 1.6917238313e-06 1.2 1.69175558943e-06 1.2 1.69178734756e-06 1.2 1.69181910569e-06 1.2 1.69185086382e-06 1.2 1.69188262195e-06 1.2 1.69191438008e-06 1.2 1.69194613821e-06 1.2 1.69197789634e-06 1.2 1.69200965447e-06 1.2 1.6920414126e-06 1.2 1.69207317073e-06 1.2 1.69210492886e-06 1.2 1.69213668699e-06 1.2 1.69216844512e-06 1.2 1.69220020325e-06 1.2 1.69223196138e-06 1.2 1.69226371951e-06 1.2 1.69229547764e-06 1.2 1.69232723577e-06 1.2 1.6923589939e-06 1.2 1.69239075203e-06 1.2 1.69242251016e-06 1.2 1.69245426829e-06 1.2 1.69248602642e-06 1.2 1.69251778455e-06 1.2 1.69254954268e-06 1.2 1.69258130081e-06 1.2 1.69261305894e-06 1.2 1.69264481707e-06 1.2 1.6926765752e-06 1.2 1.69270833333e-06 1.2 1.69274009146e-06 1.2 1.69277184959e-06 1.2 1.69280360772e-06 1.2 1.69283536585e-06 1.2 1.69286712398e-06 1.2 1.69289888211e-06 1.2 1.69293064024e-06 1.2 1.69296239837e-06 1.2 1.6929941565e-06 1.2 1.69302591463e-06 1.2 1.69305767276e-06 1.2 1.69308943089e-06 1.2 1.69312118902e-06 1.2 1.69315294715e-06 1.2 1.69318470528e-06 1.2 1.69321646341e-06 1.2 1.69324822154e-06 1.2 1.69327997967e-06 1.2 1.6933117378e-06 1.2 1.69334349593e-06 1.2 1.69337525407e-06 1.2 1.6934070122e-06 1.2 1.69343877033e-06 1.2 1.69347052846e-06 1.2 1.69350228659e-06 1.2 1.69353404472e-06 1.2 1.69356580285e-06 1.2 1.69359756098e-06 1.2 1.69362931911e-06 1.2 1.69366107724e-06 1.2 1.69369283537e-06 1.2 1.6937245935e-06 1.2 1.69375635163e-06 1.2 1.69378810976e-06 1.2 1.69381986789e-06 1.2 1.69385162602e-06 1.2 1.69388338415e-06 1.2 1.69391514228e-06 1.2 1.69394690041e-06 1.2 1.69397865854e-06 1.2 1.69401041667e-06 1.2 1.6940421748e-06 1.2 1.69407393293e-06 1.2 1.69410569106e-06 1.2 1.69413744919e-06 1.2 1.69416920732e-06 1.2 1.69420096545e-06 1.2 1.69423272358e-06 1.2 1.69426448171e-06 1.2 1.69429623984e-06 1.2 1.69432799797e-06 1.2 1.6943597561e-06 1.2 1.69439151423e-06 1.2 1.69442327236e-06 1.2 1.69445503049e-06 1.2 1.69448678862e-06 1.2 1.69451854675e-06 1.2 1.69455030488e-06 1.2 1.69458206301e-06 1.2 1.69461382114e-06 1.2 1.69464557927e-06 1.2 1.6946773374e-06 1.2 1.69470909553e-06 1.2 1.69474085366e-06 1.2 1.69477261179e-06 1.2 1.69480436992e-06 1.2 1.69483612805e-06 1.2 1.69486788618e-06 1.2 1.69489964431e-06 1.2 1.69493140244e-06 1.2 1.69496316057e-06 1.2 1.6949949187e-06 1.2 1.69502667683e-06 1.2 1.69505843496e-06 1.2 1.69509019309e-06 1.2 1.69512195122e-06 1.2 1.69515370935e-06 1.2 1.69518546748e-06 1.2 1.69521722561e-06 1.2 1.69524898374e-06 1.2 1.69528074187e-06 1.2 1.6953125e-06 1.2 1.69534425813e-06 1.2 1.69537601626e-06 1.2 1.69540777439e-06 1.2 1.69543953252e-06 1.2 1.69547129065e-06 1.2 1.69550304878e-06 1.2 1.69553480691e-06 1.2 1.69556656504e-06 1.2 1.69559832317e-06 1.2 1.6956300813e-06 1.2 1.69566183943e-06 1.2 1.69569359756e-06 1.2 1.69572535569e-06 1.2 1.69575711382e-06 1.2 1.69578887195e-06 1.2 1.69582063008e-06 1.2 1.69585238821e-06 1.2 1.69588414634e-06 1.2 1.69591590447e-06 1.2 1.6959476626e-06 1.2 1.69597942073e-06 1.2 1.69601117886e-06 1.2 1.69604293699e-06 1.2 1.69607469512e-06 1.2 1.69610645325e-06 1.2 1.69613821138e-06 1.2 1.69616996951e-06 1.2 1.69620172764e-06 1.2 1.69623348577e-06 1.2 1.6962652439e-06 1.2 1.69629700203e-06 1.2 1.69632876016e-06 1.2 1.69636051829e-06 1.2 1.69639227642e-06 1.2 1.69642403455e-06 1.2 1.69645579268e-06 1.2 1.69648755081e-06 1.2 1.69651930894e-06 1.2 1.69655106707e-06 1.2 1.6965828252e-06 1.2 1.69661458333e-06 1.2 1.69664634146e-06 1.2 1.69667809959e-06 1.2 1.69670985772e-06 1.2 1.69674161585e-06 1.2 1.69677337398e-06 1.2 1.69680513211e-06 1.2 1.69683689024e-06 1.2 1.69686864837e-06 1.2 1.6969004065e-06 1.2 1.69693216463e-06 1.2 1.69696392276e-06 1.2 1.69699568089e-06 1.2 1.69702743902e-06 1.2 1.69705919715e-06 1.2 1.69709095528e-06 1.2 1.69712271341e-06 1.2 1.69715447154e-06 1.2 1.69718622967e-06 1.2 1.6972179878e-06 1.2 1.69724974593e-06 1.2 1.69728150407e-06 1.2 1.6973132622e-06 1.2 1.69734502033e-06 1.2 1.69737677846e-06 1.2 1.69740853659e-06 1.2 1.69744029472e-06 1.2 1.69747205285e-06 1.2 1.69750381098e-06 1.2 1.69753556911e-06 1.2 1.69756732724e-06 1.2 1.69759908537e-06 1.2 1.6976308435e-06 1.2 1.69766260163e-06 1.2 1.69769435976e-06 1.2 1.69772611789e-06 1.2 1.69775787602e-06 1.2 1.69778963415e-06 1.2 1.69782139228e-06 1.2 1.69785315041e-06 1.2 1.69788490854e-06 1.2 1.69791666667e-06 1.2 1.6979484248e-06 1.2 1.69798018293e-06 1.2 1.69801194106e-06 1.2 1.69804369919e-06 1.2 1.69807545732e-06 1.2 1.69810721545e-06 1.2 1.69813897358e-06 1.2 1.69817073171e-06 1.2 1.69820248984e-06 1.2 1.69823424797e-06 1.2 1.6982660061e-06 1.2 1.69829776423e-06 1.2 1.69832952236e-06 1.2 1.69836128049e-06 1.2 1.69839303862e-06 1.2 1.69842479675e-06 1.2 1.69845655488e-06 1.2 1.69848831301e-06 1.2 1.69852007114e-06 1.2 1.69855182927e-06 1.2 1.6985835874e-06 1.2 1.69861534553e-06 1.2 1.69864710366e-06 1.2 1.69867886179e-06 1.2 1.69871061992e-06 1.2 1.69874237805e-06 1.2 1.69877413618e-06 1.2 1.69880589431e-06 1.2 1.69883765244e-06 1.2 1.69886941057e-06 1.2 1.6989011687e-06 1.2 1.69893292683e-06 1.2 1.69896468496e-06 1.2 1.69899644309e-06 1.2 1.69902820122e-06 1.2 1.69905995935e-06 1.2 1.69909171748e-06 1.2 1.69912347561e-06 1.2 1.69915523374e-06 1.2 1.69918699187e-06 1.2 1.69921875e-06 1.2 1.69925050813e-06 1.2 1.69928226626e-06 1.2 1.69931402439e-06 1.2 1.69934578252e-06 1.2 1.69937754065e-06 1.2 1.69940929878e-06 1.2 1.69944105691e-06 1.2 1.69947281504e-06 1.2 1.69950457317e-06 1.2 1.6995363313e-06 1.2 1.69956808943e-06 1.2 1.69959984756e-06 1.2 1.69963160569e-06 1.2 1.69966336382e-06 1.2 1.69969512195e-06 1.2 1.69972688008e-06 1.2 1.69975863821e-06 1.2 1.69979039634e-06 1.2 1.69982215447e-06 1.2 1.6998539126e-06 1.2 1.69988567073e-06 1.2 1.69991742886e-06 1.2 1.69994918699e-06 1.2 1.69998094512e-06 1.2 1.70001270325e-06 1.2 1.70004446138e-06 1.2 1.70007621951e-06 1.2 1.70010797764e-06 1.2 1.70013973577e-06 1.2 1.7001714939e-06 1.2 1.70020325203e-06 1.2 1.70023501016e-06 1.2 1.70026676829e-06 1.2 1.70029852642e-06 1.2 1.70033028455e-06 1.2 1.70036204268e-06 1.2 1.70039380081e-06 1.2 1.70042555894e-06 1.2 1.70045731707e-06 1.2 1.7004890752e-06 1.2 1.70052083333e-06 1.2 1.70055259146e-06 1.2 1.70058434959e-06 1.2 1.70061610772e-06 1.2 1.70064786585e-06 1.2 1.70067962398e-06 1.2 1.70071138211e-06 1.2 1.70074314024e-06 1.2 1.70077489837e-06 1.2 1.7008066565e-06 1.2 1.70083841463e-06 1.2 1.70087017276e-06 1.2 1.70090193089e-06 1.2 1.70093368902e-06 1.2 1.70096544715e-06 1.2 1.70099720528e-06 1.2 1.70102896341e-06 1.2 1.70106072154e-06 1.2 1.70109247967e-06 1.2 1.7011242378e-06 1.2 1.70115599593e-06 1.2 1.70118775407e-06 1.2 1.7012195122e-06 1.2 1.70125127033e-06 1.2 1.70128302846e-06 1.2 1.70131478659e-06 1.2 1.70134654472e-06 1.2 1.70137830285e-06 1.2 1.70141006098e-06 1.2 1.70144181911e-06 1.2 1.70147357724e-06 1.2 1.70150533537e-06 1.2 1.7015370935e-06 1.2 1.70156885163e-06 1.2 1.70160060976e-06 1.2 1.70163236789e-06 1.2 1.70166412602e-06 1.2 1.70169588415e-06 1.2 1.70172764228e-06 1.2 1.70175940041e-06 1.2 1.70179115854e-06 1.2 1.70182291667e-06 1.2 1.7018546748e-06 1.2 1.70188643293e-06 1.2 1.70191819106e-06 1.2 1.70194994919e-06 1.2 1.70198170732e-06 1.2 1.70201346545e-06 1.2 1.70204522358e-06 1.2 1.70207698171e-06 1.2 1.70210873984e-06 1.2 1.70214049797e-06 1.2 1.7021722561e-06 1.2 1.70220401423e-06 1.2 1.70223577236e-06 1.2 1.70226753049e-06 1.2 1.70229928862e-06 1.2 1.70233104675e-06 1.2 1.70236280488e-06 1.2 1.70239456301e-06 1.2 1.70242632114e-06 1.2 1.70245807927e-06 1.2 1.7024898374e-06 1.2 1.70252159553e-06 1.2 1.70255335366e-06 1.2 1.70258511179e-06 1.2 1.70261686992e-06 1.2 1.70264862805e-06 1.2 1.70268038618e-06 1.2 1.70271214431e-06 1.2 1.70274390244e-06 1.2 1.70277566057e-06 1.2 1.7028074187e-06 1.2 1.70283917683e-06 1.2 1.70287093496e-06 1.2 1.70290269309e-06 1.2 1.70293445122e-06 1.2 1.70296620935e-06 1.2 1.70299796748e-06 1.2 1.70302972561e-06 1.2 1.70306148374e-06 1.2 1.70309324187e-06 1.2 1.703125e-06 1.2 1.70315675813e-06 1.2 1.70318851626e-06 1.2 1.70322027439e-06 1.2 1.70325203252e-06 1.2 1.70328379065e-06 1.2 1.70331554878e-06 1.2 1.70334730691e-06 1.2 1.70337906504e-06 1.2 1.70341082317e-06 1.2 1.7034425813e-06 1.2 1.70347433943e-06 1.2 1.70350609756e-06 1.2 1.70353785569e-06 1.2 1.70356961382e-06 1.2 1.70360137195e-06 1.2 1.70363313008e-06 1.2 1.70366488821e-06 1.2 1.70369664634e-06 1.2 1.70372840447e-06 1.2 1.7037601626e-06 1.2 1.70379192073e-06 1.2 1.70382367886e-06 1.2 1.70385543699e-06 1.2 1.70388719512e-06 1.2 1.70391895325e-06 1.2 1.70395071138e-06 1.2 1.70398246951e-06 1.2 1.70401422764e-06 1.2 1.70404598577e-06 1.2 1.7040777439e-06 1.2 1.70410950203e-06 1.2 1.70414126016e-06 1.2 1.70417301829e-06 1.2 1.70420477642e-06 1.2 1.70423653455e-06 1.2 1.70426829268e-06 1.2 1.70430005081e-06 1.2 1.70433180894e-06 1.2 1.70436356707e-06 1.2 1.7043953252e-06 1.2 1.70442708333e-06 1.2 1.70445884146e-06 1.2 1.70449059959e-06 1.2 1.70452235772e-06 1.2 1.70455411585e-06 1.2 1.70458587398e-06 1.2 1.70461763211e-06 1.2 1.70464939024e-06 1.2 1.70468114837e-06 1.2 1.7047129065e-06 1.2 1.70474466463e-06 1.2 1.70477642276e-06 1.2 1.70480818089e-06 1.2 1.70483993902e-06 1.2 1.70487169715e-06 1.2 1.70490345528e-06 1.2 1.70493521341e-06 1.2 1.70496697154e-06 1.2 1.70499872967e-06 1.2 1.7050304878e-06 1.2 1.70506224593e-06 1.2 1.70509400407e-06 1.2 1.7051257622e-06 1.2 1.70515752033e-06 1.2 1.70518927846e-06 1.2 1.70522103659e-06 1.2 1.70525279472e-06 1.2 1.70528455285e-06 1.2 1.70531631098e-06 1.2 1.70534806911e-06 1.2 1.70537982724e-06 1.2 1.70541158537e-06 1.2 1.7054433435e-06 1.2 1.70547510163e-06 1.2 1.70550685976e-06 1.2 1.70553861789e-06 1.2 1.70557037602e-06 1.2 1.70560213415e-06 1.2 1.70563389228e-06 1.2 1.70566565041e-06 1.2 1.70569740854e-06 1.2 1.70572916667e-06 1.2 1.7057609248e-06 1.2 1.70579268293e-06 1.2 1.70582444106e-06 1.2 1.70585619919e-06 1.2 1.70588795732e-06 1.2 1.70591971545e-06 1.2 1.70595147358e-06 1.2 1.70598323171e-06 1.2 1.70601498984e-06 1.2 1.70604674797e-06 1.2 1.7060785061e-06 1.2 1.70611026423e-06 1.2 1.70614202236e-06 1.2 1.70617378049e-06 1.2 1.70620553862e-06 1.2 1.70623729675e-06 1.2 1.70626905488e-06 1.2 1.70630081301e-06 1.2 1.70633257114e-06 1.2 1.70636432927e-06 1.2 1.7063960874e-06 1.2 1.70642784553e-06 1.2 1.70645960366e-06 1.2 1.70649136179e-06 1.2 1.70652311992e-06 1.2 1.70655487805e-06 1.2 1.70658663618e-06 1.2 1.70661839431e-06 1.2 1.70665015244e-06 1.2 1.70668191057e-06 1.2 1.7067136687e-06 1.2 1.70674542683e-06 1.2 1.70677718496e-06 1.2 1.70680894309e-06 1.2 1.70684070122e-06 1.2 1.70687245935e-06 1.2 1.70690421748e-06 1.2 1.70693597561e-06 1.2 1.70696773374e-06 1.2 1.70699949187e-06 1.2 1.70703125e-06 1.2 1.70706300813e-06 1.2 1.70709476626e-06 1.2 1.70712652439e-06 1.2 1.70715828252e-06 1.2 1.70719004065e-06 1.2 1.70722179878e-06 1.2 1.70725355691e-06 1.2 1.70728531504e-06 1.2 1.70731707317e-06 1.2 1.7073488313e-06 1.2 1.70738058943e-06 1.2 1.70741234756e-06 1.2 1.70744410569e-06 1.2 1.70747586382e-06 1.2 1.70750762195e-06 1.2 1.70753938008e-06 1.2 1.70757113821e-06 1.2 1.70760289634e-06 1.2 1.70763465447e-06 1.2 1.7076664126e-06 1.2 1.70769817073e-06 1.2 1.70772992886e-06 1.2 1.70776168699e-06 1.2 1.70779344512e-06 1.2 1.70782520325e-06 1.2 1.70785696138e-06 1.2 1.70788871951e-06 1.2 1.70792047764e-06 1.2 1.70795223577e-06 1.2 1.7079839939e-06 1.2 1.70801575203e-06 1.2 1.70804751016e-06 1.2 1.70807926829e-06 1.2 1.70811102642e-06 1.2 1.70814278455e-06 1.2 1.70817454268e-06 1.2 1.70820630081e-06 1.2 1.70823805894e-06 1.2 1.70826981707e-06 1.2 1.7083015752e-06 1.2 1.70833333333e-06 1.2 1.70836509146e-06 1.2 1.70839684959e-06 1.2 1.70842860772e-06 1.2 1.70846036585e-06 1.2 1.70849212398e-06 1.2 1.70852388211e-06 1.2 1.70855564024e-06 1.2 1.70858739837e-06 1.2 1.7086191565e-06 1.2 1.70865091463e-06 1.2 1.70868267276e-06 1.2 1.70871443089e-06 1.2 1.70874618902e-06 1.2 1.70877794715e-06 1.2 1.70880970528e-06 1.2 1.70884146341e-06 1.2 1.70887322154e-06 1.2 1.70890497967e-06 1.2 1.7089367378e-06 1.2 1.70896849593e-06 1.2 1.70900025407e-06 1.2 1.7090320122e-06 1.2 1.70906377033e-06 1.2 1.70909552846e-06 1.2 1.70912728659e-06 1.2 1.70915904472e-06 1.2 1.70919080285e-06 1.2 1.70922256098e-06 1.2 1.70925431911e-06 1.2 1.70928607724e-06 1.2 1.70931783537e-06 1.2 1.7093495935e-06 1.2 1.70938135163e-06 1.2 1.70941310976e-06 1.2 1.70944486789e-06 1.2 1.70947662602e-06 1.2 1.70950838415e-06 1.2 1.70954014228e-06 1.2 1.70957190041e-06 1.2 1.70960365854e-06 1.2 1.70963541667e-06 1.2 1.7096671748e-06 1.2 1.70969893293e-06 1.2 1.70973069106e-06 1.2 1.70976244919e-06 1.2 1.70979420732e-06 1.2 1.70982596545e-06 1.2 1.70985772358e-06 1.2 1.70988948171e-06 1.2 1.70992123984e-06 1.2 1.70995299797e-06 1.2 1.7099847561e-06 1.2 1.71001651423e-06 1.2 1.71004827236e-06 1.2 1.71008003049e-06 1.2 1.71011178862e-06 1.2 1.71014354675e-06 1.2 1.71017530488e-06 1.2 1.71020706301e-06 1.2 1.71023882114e-06 1.2 1.71027057927e-06 1.2 1.7103023374e-06 1.2 1.71033409553e-06 1.2 1.71036585366e-06 1.2 1.71039761179e-06 1.2 1.71042936992e-06 1.2 1.71046112805e-06 1.2 1.71049288618e-06 1.2 1.71052464431e-06 1.2 1.71055640244e-06 1.2 1.71058816057e-06 1.2 1.7106199187e-06 1.2 1.71065167683e-06 1.2 1.71068343496e-06 1.2 1.71071519309e-06 1.2 1.71074695122e-06 1.2 1.71077870935e-06 1.2 1.71081046748e-06 1.2 1.71084222561e-06 1.2 1.71087398374e-06 1.2 1.71090574187e-06 1.2 1.7109375e-06 1.2 1.71096925813e-06 1.2 1.71100101626e-06 1.2 1.71103277439e-06 1.2 1.71106453252e-06 1.2 1.71109629065e-06 1.2 1.71112804878e-06 1.2 1.71115980691e-06 1.2 1.71119156504e-06 1.2 1.71122332317e-06 1.2 1.7112550813e-06 1.2 1.71128683943e-06 1.2 1.71131859756e-06 1.2 1.71135035569e-06 1.2 1.71138211382e-06 1.2 1.71141387195e-06 1.2 1.71144563008e-06 1.2 1.71147738821e-06 1.2 1.71150914634e-06 1.2 1.71154090447e-06 1.2 1.7115726626e-06 1.2 1.71160442073e-06 1.2 1.71163617886e-06 1.2 1.71166793699e-06 1.2 1.71169969512e-06 1.2 1.71173145325e-06 1.2 1.71176321138e-06 1.2 1.71179496951e-06 1.2 1.71182672764e-06 1.2 1.71185848577e-06 1.2 1.7118902439e-06 1.2 1.71192200203e-06 1.2 1.71195376016e-06 1.2 1.71198551829e-06 1.2 1.71201727642e-06 1.2 1.71204903455e-06 1.2 1.71208079268e-06 1.2 1.71211255081e-06 1.2 1.71214430894e-06 1.2 1.71217606707e-06 1.2 1.7122078252e-06 1.2 1.71223958333e-06 1.2 1.71227134146e-06 1.2 1.71230309959e-06 1.2 1.71233485772e-06 1.2 1.71236661585e-06 1.2 1.71239837398e-06 1.2 1.71243013211e-06 1.2 1.71246189024e-06 1.2 1.71249364837e-06 1.2 1.7125254065e-06 1.2 1.71255716463e-06 1.2 1.71258892276e-06 1.2 1.71262068089e-06 1.2 1.71265243902e-06 1.2 1.71268419715e-06 1.2 1.71271595528e-06 1.2 1.71274771341e-06 1.2 1.71277947154e-06 1.2 1.71281122967e-06 1.2 1.7128429878e-06 1.2 1.71287474593e-06 1.2 1.71290650407e-06 1.2 1.7129382622e-06 1.2 1.71297002033e-06 1.2 1.71300177846e-06 1.2 1.71303353659e-06 1.2 1.71306529472e-06 1.2 1.71309705285e-06 1.2 1.71312881098e-06 1.2 1.71316056911e-06 1.2 1.71319232724e-06 1.2 1.71322408537e-06 1.2 1.7132558435e-06 1.2 1.71328760163e-06 1.2 1.71331935976e-06 1.2 1.71335111789e-06 1.2 1.71338287602e-06 1.2 1.71341463415e-06 1.2 1.71344639228e-06 1.2 1.71347815041e-06 1.2 1.71350990854e-06 1.2 1.71354166667e-06 1.2 1.7135734248e-06 1.2 1.71360518293e-06 1.2 1.71363694106e-06 1.2 1.71366869919e-06 1.2 1.71370045732e-06 1.2 1.71373221545e-06 1.2 1.71376397358e-06 1.2 1.71379573171e-06 1.2 1.71382748984e-06 1.2 1.71385924797e-06 1.2 1.7138910061e-06 1.2 1.71392276423e-06 1.2 1.71395452236e-06 1.2 1.71398628049e-06 1.2 1.71401803862e-06 1.2 1.71404979675e-06 1.2 1.71408155488e-06 1.2 1.71411331301e-06 1.2 1.71414507114e-06 1.2 1.71417682927e-06 1.2 1.7142085874e-06 1.2 1.71424034553e-06 1.2 1.71427210366e-06 1.2 1.71430386179e-06 1.2 1.71433561992e-06 1.2 1.71436737805e-06 1.2 1.71439913618e-06 1.2 1.71443089431e-06 1.2 1.71446265244e-06 1.2 1.71449441057e-06 1.2 1.7145261687e-06 1.2 1.71455792683e-06 1.2 1.71458968496e-06 1.2 1.71462144309e-06 1.2 1.71465320122e-06 1.2 1.71468495935e-06 1.2 1.71471671748e-06 1.2 1.71474847561e-06 1.2 1.71478023374e-06 1.2 1.71481199187e-06 1.2 1.71484375e-06 1.2 1.71487550813e-06 1.2 1.71490726626e-06 1.2 1.71493902439e-06 1.2 1.71497078252e-06 1.2 1.71500254065e-06 1.2 1.71503429878e-06 1.2 1.71506605691e-06 1.2 1.71509781504e-06 1.2 1.71512957317e-06 1.2 1.7151613313e-06 1.2 1.71519308943e-06 1.2 1.71522484756e-06 1.2 1.71525660569e-06 1.2 1.71528836382e-06 1.2 1.71532012195e-06 1.2 1.71535188008e-06 1.2 1.71538363821e-06 1.2 1.71541539634e-06 1.2 1.71544715447e-06 1.2 1.7154789126e-06 1.2 1.71551067073e-06 1.2 1.71554242886e-06 1.2 1.71557418699e-06 1.2 1.71560594512e-06 1.2 1.71563770325e-06 1.2 1.71566946138e-06 1.2 1.71570121951e-06 1.2 1.71573297764e-06 1.2 1.71576473577e-06 1.2 1.7157964939e-06 1.2 1.71582825203e-06 1.2 1.71586001016e-06 1.2 1.71589176829e-06 1.2 1.71592352642e-06 1.2 1.71595528455e-06 1.2 1.71598704268e-06 1.2 1.71601880081e-06 1.2 1.71605055894e-06 1.2 1.71608231707e-06 1.2 1.7161140752e-06 1.2 1.71614583333e-06 1.2 1.71617759146e-06 1.2 1.71620934959e-06 1.2 1.71624110772e-06 1.2 1.71627286585e-06 1.2 1.71630462398e-06 1.2 1.71633638211e-06 1.2 1.71636814024e-06 1.2 1.71639989837e-06 1.2 1.7164316565e-06 1.2 1.71646341463e-06 1.2 1.71649517276e-06 1.2 1.71652693089e-06 1.2 1.71655868902e-06 1.2 1.71659044715e-06 1.2 1.71662220528e-06 1.2 1.71665396341e-06 1.2 1.71668572154e-06 1.2 1.71671747967e-06 1.2 1.7167492378e-06 1.2 1.71678099593e-06 1.2 1.71681275407e-06 1.2 1.7168445122e-06 1.2 1.71687627033e-06 1.2 1.71690802846e-06 1.2 1.71693978659e-06 1.2 1.71697154472e-06 1.2 1.71700330285e-06 1.2 1.71703506098e-06 1.2 1.71706681911e-06 1.2 1.71709857724e-06 1.2 1.71713033537e-06 1.2 1.7171620935e-06 1.2 1.71719385163e-06 1.2 1.71722560976e-06 1.2 1.71725736789e-06 1.2 1.71728912602e-06 1.2 1.71732088415e-06 1.2 1.71735264228e-06 1.2 1.71738440041e-06 1.2 1.71741615854e-06 1.2 1.71744791667e-06 1.2 1.7174796748e-06 1.2 1.71751143293e-06 1.2 1.71754319106e-06 1.2 1.71757494919e-06 1.2 1.71760670732e-06 1.2 1.71763846545e-06 1.2 1.71767022358e-06 1.2 1.71770198171e-06 1.2 1.71773373984e-06 1.2 1.71776549797e-06 1.2 1.7177972561e-06 1.2 1.71782901423e-06 1.2 1.71786077236e-06 1.2 1.71789253049e-06 1.2 1.71792428862e-06 1.2 1.71795604675e-06 1.2 1.71798780488e-06 1.2 1.71801956301e-06 1.2 1.71805132114e-06 1.2 1.71808307927e-06 1.2 1.7181148374e-06 1.2 1.71814659553e-06 1.2 1.71817835366e-06 1.2 1.71821011179e-06 1.2 1.71824186992e-06 1.2 1.71827362805e-06 1.2 1.71830538618e-06 1.2 1.71833714431e-06 1.2 1.71836890244e-06 1.2 1.71840066057e-06 1.2 1.7184324187e-06 1.2 1.71846417683e-06 1.2 1.71849593496e-06 1.2 1.71852769309e-06 1.2 1.71855945122e-06 1.2 1.71859120935e-06 1.2 1.71862296748e-06 1.2 1.71865472561e-06 1.2 1.71868648374e-06 1.2 1.71871824187e-06 1.2 1.71875e-06 1.2 1.71878175813e-06 1.2 1.71881351626e-06 1.2 1.71884527439e-06 1.2 1.71887703252e-06 1.2 1.71890879065e-06 1.2 1.71894054878e-06 1.2 1.71897230691e-06 1.2 1.71900406504e-06 1.2 1.71903582317e-06 1.2 1.7190675813e-06 1.2 1.71909933943e-06 1.2 1.71913109756e-06 1.2 1.71916285569e-06 1.2 1.71919461382e-06 1.2 1.71922637195e-06 1.2 1.71925813008e-06 1.2 1.71928988821e-06 1.2 1.71932164634e-06 1.2 1.71935340447e-06 1.2 1.7193851626e-06 1.2 1.71941692073e-06 1.2 1.71944867886e-06 1.2 1.71948043699e-06 1.2 1.71951219512e-06 1.2 1.71954395325e-06 1.2 1.71957571138e-06 1.2 1.71960746951e-06 1.2 1.71963922764e-06 1.2 1.71967098577e-06 1.2 1.7197027439e-06 1.2 1.71973450203e-06 1.2 1.71976626016e-06 1.2 1.71979801829e-06 1.2 1.71982977642e-06 1.2 1.71986153455e-06 1.2 1.71989329268e-06 1.2 1.71992505081e-06 1.2 1.71995680894e-06 1.2 1.71998856707e-06 1.2 1.7200203252e-06 1.2 1.72005208333e-06 1.2 1.72008384146e-06 1.2 1.72011559959e-06 1.2 1.72014735772e-06 1.2 1.72017911585e-06 1.2 1.72021087398e-06 1.2 1.72024263211e-06 1.2 1.72027439024e-06 1.2 1.72030614837e-06 1.2 1.7203379065e-06 1.2 1.72036966463e-06 1.2 1.72040142276e-06 1.2 1.72043318089e-06 1.2 1.72046493902e-06 1.2 1.72049669715e-06 1.2 1.72052845528e-06 1.2 1.72056021341e-06 1.2 1.72059197154e-06 1.2 1.72062372967e-06 1.2 1.7206554878e-06 1.2 1.72068724593e-06 1.2 1.72071900407e-06 1.2 1.7207507622e-06 1.2 1.72078252033e-06 1.2 1.72081427846e-06 1.2 1.72084603659e-06 1.2 1.72087779472e-06 1.2 1.72090955285e-06 1.2 1.72094131098e-06 1.2 1.72097306911e-06 1.2 1.72100482724e-06 1.2 1.72103658537e-06 1.2 1.7210683435e-06 1.2 1.72110010163e-06 1.2 1.72113185976e-06 1.2 1.72116361789e-06 1.2 1.72119537602e-06 1.2 1.72122713415e-06 1.2 1.72125889228e-06 1.2 1.72129065041e-06 1.2 1.72132240854e-06 1.2 1.72135416667e-06 1.2 1.7213859248e-06 1.2 1.72141768293e-06 1.2 1.72144944106e-06 1.2 1.72148119919e-06 1.2 1.72151295732e-06 1.2 1.72154471545e-06 1.2 1.72157647358e-06 1.2 1.72160823171e-06 1.2 1.72163998984e-06 1.2 1.72167174797e-06 1.2 1.7217035061e-06 1.2 1.72173526423e-06 1.2 1.72176702236e-06 1.2 1.72179878049e-06 1.2 1.72183053862e-06 1.2 1.72186229675e-06 1.2 1.72189405488e-06 1.2 1.72192581301e-06 1.2 1.72195757114e-06 1.2 1.72198932927e-06 1.2 1.7220210874e-06 1.2 1.72205284553e-06 1.2 1.72208460366e-06 1.2 1.72211636179e-06 1.2 1.72214811992e-06 1.2 1.72217987805e-06 1.2 1.72221163618e-06 1.2 1.72224339431e-06 1.2 1.72227515244e-06 1.2 1.72230691057e-06 1.2 1.7223386687e-06 1.2 1.72237042683e-06 1.2 1.72240218496e-06 1.2 1.72243394309e-06 1.2 1.72246570122e-06 1.2 1.72249745935e-06 1.2 1.72252921748e-06 1.2 1.72256097561e-06 1.2 1.72259273374e-06 1.2 1.72262449187e-06 1.2 1.72265625e-06 1.2 1.72268800813e-06 1.2 1.72271976626e-06 1.2 1.72275152439e-06 1.2 1.72278328252e-06 1.2 1.72281504065e-06 1.2 1.72284679878e-06 1.2 1.72287855691e-06 1.2 1.72291031504e-06 1.2 1.72294207317e-06 1.2 1.7229738313e-06 1.2 1.72300558943e-06 1.2 1.72303734756e-06 1.2 1.72306910569e-06 1.2 1.72310086382e-06 1.2 1.72313262195e-06 1.2 1.72316438008e-06 1.2 1.72319613821e-06 1.2 1.72322789634e-06 1.2 1.72325965447e-06 1.2 1.7232914126e-06 1.2 1.72332317073e-06 1.2 1.72335492886e-06 1.2 1.72338668699e-06 1.2 1.72341844512e-06 1.2 1.72345020325e-06 1.2 1.72348196138e-06 1.2 1.72351371951e-06 1.2 1.72354547764e-06 1.2 1.72357723577e-06 1.2 1.7236089939e-06 1.2 1.72364075203e-06 1.2 1.72367251016e-06 1.2 1.72370426829e-06 1.2 1.72373602642e-06 1.2 1.72376778455e-06 1.2 1.72379954268e-06 1.2 1.72383130081e-06 1.2 1.72386305894e-06 1.2 1.72389481707e-06 1.2 1.7239265752e-06 1.2 1.72395833333e-06 1.2 1.72399009146e-06 1.2 1.72402184959e-06 1.2 1.72405360772e-06 1.2 1.72408536585e-06 1.2 1.72411712398e-06 1.2 1.72414888211e-06 1.2 1.72418064024e-06 1.2 1.72421239837e-06 1.2 1.7242441565e-06 1.2 1.72427591463e-06 1.2 1.72430767276e-06 1.2 1.72433943089e-06 1.2 1.72437118902e-06 1.2 1.72440294715e-06 1.2 1.72443470528e-06 1.2 1.72446646341e-06 1.2 1.72449822154e-06 1.2 1.72452997967e-06 1.2 1.7245617378e-06 1.2 1.72459349593e-06 1.2 1.72462525407e-06 1.2 1.7246570122e-06 1.2 1.72468877033e-06 1.2 1.72472052846e-06 1.2 1.72475228659e-06 1.2 1.72478404472e-06 1.2 1.72481580285e-06 1.2 1.72484756098e-06 1.2 1.72487931911e-06 1.2 1.72491107724e-06 1.2 1.72494283537e-06 1.2 1.7249745935e-06 1.2 1.72500635163e-06 1.2 1.72503810976e-06 1.2 1.72506986789e-06 1.2 1.72510162602e-06 1.2 1.72513338415e-06 1.2 1.72516514228e-06 1.2 1.72519690041e-06 1.2 1.72522865854e-06 1.2 1.72526041667e-06 1.2 1.7252921748e-06 1.2 1.72532393293e-06 1.2 1.72535569106e-06 1.2 1.72538744919e-06 1.2 1.72541920732e-06 1.2 1.72545096545e-06 1.2 1.72548272358e-06 1.2 1.72551448171e-06 1.2 1.72554623984e-06 1.2 1.72557799797e-06 1.2 1.7256097561e-06 1.2 1.72564151423e-06 1.2 1.72567327236e-06 1.2 1.72570503049e-06 1.2 1.72573678862e-06 1.2 1.72576854675e-06 1.2 1.72580030488e-06 1.2 1.72583206301e-06 1.2 1.72586382114e-06 1.2 1.72589557927e-06 1.2 1.7259273374e-06 1.2 1.72595909553e-06 1.2 1.72599085366e-06 1.2 1.72602261179e-06 1.2 1.72605436992e-06 1.2 1.72608612805e-06 1.2 1.72611788618e-06 1.2 1.72614964431e-06 1.2 1.72618140244e-06 1.2 1.72621316057e-06 1.2 1.7262449187e-06 1.2 1.72627667683e-06 1.2 1.72630843496e-06 1.2 1.72634019309e-06 1.2 1.72637195122e-06 1.2 1.72640370935e-06 1.2 1.72643546748e-06 1.2 1.72646722561e-06 1.2 1.72649898374e-06 1.2 1.72653074187e-06 1.2 1.7265625e-06 1.2 1.72659425813e-06 1.2 1.72662601626e-06 1.2 1.72665777439e-06 1.2 1.72668953252e-06 1.2 1.72672129065e-06 1.2 1.72675304878e-06 1.2 1.72678480691e-06 1.2 1.72681656504e-06 1.2 1.72684832317e-06 1.2 1.7268800813e-06 1.2 1.72691183943e-06 1.2 1.72694359756e-06 1.2 1.72697535569e-06 1.2 1.72700711382e-06 1.2 1.72703887195e-06 1.2 1.72707063008e-06 1.2 1.72710238821e-06 1.2 1.72713414634e-06 1.2 1.72716590447e-06 1.2 1.7271976626e-06 1.2 1.72722942073e-06 1.2 1.72726117886e-06 1.2 1.72729293699e-06 1.2 1.72732469512e-06 1.2 1.72735645325e-06 1.2 1.72738821138e-06 1.2 1.72741996951e-06 1.2 1.72745172764e-06 1.2 1.72748348577e-06 1.2 1.7275152439e-06 1.2 1.72754700203e-06 1.2 1.72757876016e-06 1.2 1.72761051829e-06 1.2 1.72764227642e-06 1.2 1.72767403455e-06 1.2 1.72770579268e-06 1.2 1.72773755081e-06 1.2 1.72776930894e-06 1.2 1.72780106707e-06 1.2 1.7278328252e-06 1.2 1.72786458333e-06 1.2 1.72789634146e-06 1.2 1.72792809959e-06 1.2 1.72795985772e-06 1.2 1.72799161585e-06 1.2 1.72802337398e-06 1.2 1.72805513211e-06 1.2 1.72808689024e-06 1.2 1.72811864837e-06 1.2 1.7281504065e-06 1.2 1.72818216463e-06 1.2 1.72821392276e-06 1.2 1.72824568089e-06 1.2 1.72827743902e-06 1.2 1.72830919715e-06 1.2 1.72834095528e-06 1.2 1.72837271341e-06 1.2 1.72840447154e-06 1.2 1.72843622967e-06 1.2 1.7284679878e-06 1.2 1.72849974593e-06 1.2 1.72853150407e-06 1.2 1.7285632622e-06 1.2 1.72859502033e-06 1.2 1.72862677846e-06 1.2 1.72865853659e-06 1.2 1.72869029472e-06 1.2 1.72872205285e-06 1.2 1.72875381098e-06 1.2 1.72878556911e-06 1.2 1.72881732724e-06 1.2 1.72884908537e-06 1.2 1.7288808435e-06 1.2 1.72891260163e-06 1.2 1.72894435976e-06 1.2 1.72897611789e-06 1.2 1.72900787602e-06 1.2 1.72903963415e-06 1.2 1.72907139228e-06 1.2 1.72910315041e-06 1.2 1.72913490854e-06 1.2 1.72916666667e-06 1.2 1.7291984248e-06 1.2 1.72923018293e-06 1.2 1.72926194106e-06 1.2 1.72929369919e-06 1.2 1.72932545732e-06 1.2 1.72935721545e-06 1.2 1.72938897358e-06 1.2 1.72942073171e-06 1.2 1.72945248984e-06 1.2 1.72948424797e-06 1.2 1.7295160061e-06 1.2 1.72954776423e-06 1.2 1.72957952236e-06 1.2 1.72961128049e-06 1.2 1.72964303862e-06 1.2 1.72967479675e-06 1.2 1.72970655488e-06 1.2 1.72973831301e-06 1.2 1.72977007114e-06 1.2 1.72980182927e-06 1.2 1.7298335874e-06 1.2 1.72986534553e-06 1.2 1.72989710366e-06 1.2 1.72992886179e-06 1.2 1.72996061992e-06 1.2 1.72999237805e-06 1.2 1.73002413618e-06 1.2 1.73005589431e-06 1.2 1.73008765244e-06 1.2 1.73011941057e-06 1.2 1.7301511687e-06 1.2 1.73018292683e-06 1.2 1.73021468496e-06 1.2 1.73024644309e-06 1.2 1.73027820122e-06 1.2 1.73030995935e-06 1.2 1.73034171748e-06 1.2 1.73037347561e-06 1.2 1.73040523374e-06 1.2 1.73043699187e-06 1.2 1.73046875e-06 1.2 1.73050050813e-06 1.2 1.73053226626e-06 1.2 1.73056402439e-06 1.2 1.73059578252e-06 1.2 1.73062754065e-06 1.2 1.73065929878e-06 1.2 1.73069105691e-06 1.2 1.73072281504e-06 1.2 1.73075457317e-06 1.2 1.7307863313e-06 1.2 1.73081808943e-06 1.2 1.73084984756e-06 1.2 1.73088160569e-06 1.2 1.73091336382e-06 1.2 1.73094512195e-06 1.2 1.73097688008e-06 1.2 1.73100863821e-06 1.2 1.73104039634e-06 1.2 1.73107215447e-06 1.2 1.7311039126e-06 1.2 1.73113567073e-06 1.2 1.73116742886e-06 1.2 1.73119918699e-06 1.2 1.73123094512e-06 1.2 1.73126270325e-06 1.2 1.73129446138e-06 1.2 1.73132621951e-06 1.2 1.73135797764e-06 1.2 1.73138973577e-06 1.2 1.7314214939e-06 1.2 1.73145325203e-06 1.2 1.73148501016e-06 1.2 1.73151676829e-06 1.2 1.73154852642e-06 1.2 1.73158028455e-06 1.2 1.73161204268e-06 1.2 1.73164380081e-06 1.2 1.73167555894e-06 1.2 1.73170731707e-06 1.2 1.7317390752e-06 1.2 1.73177083333e-06 1.2 1.73180259146e-06 1.2 1.73183434959e-06 1.2 1.73186610772e-06 1.2 1.73189786585e-06 1.2 1.73192962398e-06 1.2 1.73196138211e-06 1.2 1.73199314024e-06 1.2 1.73202489837e-06 1.2 1.7320566565e-06 1.2 1.73208841463e-06 1.2 1.73212017276e-06 1.2 1.73215193089e-06 1.2 1.73218368902e-06 1.2 1.73221544715e-06 1.2 1.73224720528e-06 1.2 1.73227896341e-06 1.2 1.73231072154e-06 1.2 1.73234247967e-06 1.2 1.7323742378e-06 1.2 1.73240599593e-06 1.2 1.73243775407e-06 1.2 1.7324695122e-06 1.2 1.73250127033e-06 1.2 1.73253302846e-06 1.2 1.73256478659e-06 1.2 1.73259654472e-06 1.2 1.73262830285e-06 1.2 1.73266006098e-06 1.2 1.73269181911e-06 1.2 1.73272357724e-06 1.2 1.73275533537e-06 1.2 1.7327870935e-06 1.2 1.73281885163e-06 1.2 1.73285060976e-06 1.2 1.73288236789e-06 1.2 1.73291412602e-06 1.2 1.73294588415e-06 1.2 1.73297764228e-06 1.2 1.73300940041e-06 1.2 1.73304115854e-06 1.2 1.73307291667e-06 1.2 1.7331046748e-06 1.2 1.73313643293e-06 1.2 1.73316819106e-06 1.2 1.73319994919e-06 1.2 1.73323170732e-06 1.2 1.73326346545e-06 1.2 1.73329522358e-06 1.2 1.73332698171e-06 1.2 1.73335873984e-06 1.2 1.73339049797e-06 1.2 1.7334222561e-06 1.2 1.73345401423e-06 1.2 1.73348577236e-06 1.2 1.73351753049e-06 1.2 1.73354928862e-06 1.2 1.73358104675e-06 1.2 1.73361280488e-06 1.2 1.73364456301e-06 1.2 1.73367632114e-06 1.2 1.73370807927e-06 1.2 1.7337398374e-06 1.2 1.73377159553e-06 1.2 1.73380335366e-06 1.2 1.73383511179e-06 1.2 1.73386686992e-06 1.2 1.73389862805e-06 1.2 1.73393038618e-06 1.2 1.73396214431e-06 1.2 1.73399390244e-06 1.2 1.73402566057e-06 1.2 1.7340574187e-06 1.2 1.73408917683e-06 1.2 1.73412093496e-06 1.2 1.73415269309e-06 1.2 1.73418445122e-06 1.2 1.73421620935e-06 1.2 1.73424796748e-06 1.2 1.73427972561e-06 1.2 1.73431148374e-06 1.2 1.73434324187e-06 1.2 1.734375e-06 1.2 1.73440675813e-06 1.2 1.73443851626e-06 1.2 1.73447027439e-06 1.2 1.73450203252e-06 1.2 1.73453379065e-06 1.2 1.73456554878e-06 1.2 1.73459730691e-06 1.2 1.73462906504e-06 1.2 1.73466082317e-06 1.2 1.7346925813e-06 1.2 1.73472433943e-06 1.2 1.73475609756e-06 1.2 1.73478785569e-06 1.2 1.73481961382e-06 1.2 1.73485137195e-06 1.2 1.73488313008e-06 1.2 1.73491488821e-06 1.2 1.73494664634e-06 1.2 1.73497840447e-06 1.2 1.7350101626e-06 1.2 1.73504192073e-06 1.2 1.73507367886e-06 1.2 1.73510543699e-06 1.2 1.73513719512e-06 1.2 1.73516895325e-06 1.2 1.73520071138e-06 1.2 1.73523246951e-06 1.2 1.73526422764e-06 1.2 1.73529598577e-06 1.2 1.7353277439e-06 1.2 1.73535950203e-06 1.2 1.73539126016e-06 1.2 1.73542301829e-06 1.2 1.73545477642e-06 1.2 1.73548653455e-06 1.2 1.73551829268e-06 1.2 1.73555005081e-06 1.2 1.73558180894e-06 1.2 1.73561356707e-06 1.2 1.7356453252e-06 1.2 1.73567708333e-06 1.2 1.73570884146e-06 1.2 1.73574059959e-06 1.2 1.73577235772e-06 1.2 1.73580411585e-06 1.2 1.73583587398e-06 1.2 1.73586763211e-06 1.2 1.73589939024e-06 1.2 1.73593114837e-06 1.2 1.7359629065e-06 1.2 1.73599466463e-06 1.2 1.73602642276e-06 1.2 1.73605818089e-06 1.2 1.73608993902e-06 1.2 1.73612169715e-06 1.2 1.73615345528e-06 1.2 1.73618521341e-06 1.2 1.73621697154e-06 1.2 1.73624872967e-06 1.2 1.7362804878e-06 1.2 1.73631224593e-06 1.2 1.73634400407e-06 1.2 1.7363757622e-06 1.2 1.73640752033e-06 1.2 1.73643927846e-06 1.2 1.73647103659e-06 1.2 1.73650279472e-06 1.2 1.73653455285e-06 1.2 1.73656631098e-06 1.2 1.73659806911e-06 1.2 1.73662982724e-06 1.2 1.73666158537e-06 1.2 1.7366933435e-06 1.2 1.73672510163e-06 1.2 1.73675685976e-06 1.2 1.73678861789e-06 1.2 1.73682037602e-06 1.2 1.73685213415e-06 1.2 1.73688389228e-06 1.2 1.73691565041e-06 1.2 1.73694740854e-06 1.2 1.73697916667e-06 1.2 1.7370109248e-06 1.2 1.73704268293e-06 1.2 1.73707444106e-06 1.2 1.73710619919e-06 1.2 1.73713795732e-06 1.2 1.73716971545e-06 1.2 1.73720147358e-06 1.2 1.73723323171e-06 1.2 1.73726498984e-06 1.2 1.73729674797e-06 1.2 1.7373285061e-06 1.2 1.73736026423e-06 1.2 1.73739202236e-06 1.2 1.73742378049e-06 1.2 1.73745553862e-06 1.2 1.73748729675e-06 1.2 1.73751905488e-06 1.2 1.73755081301e-06 1.2 1.73758257114e-06 1.2 1.73761432927e-06 1.2 1.7376460874e-06 1.2 1.73767784553e-06 1.2 1.73770960366e-06 1.2 1.73774136179e-06 1.2 1.73777311992e-06 1.2 1.73780487805e-06 1.2 1.73783663618e-06 1.2 1.73786839431e-06 1.2 1.73790015244e-06 1.2 1.73793191057e-06 1.2 1.7379636687e-06 1.2 1.73799542683e-06 1.2 1.73802718496e-06 1.2 1.73805894309e-06 1.2 1.73809070122e-06 1.2 1.73812245935e-06 1.2 1.73815421748e-06 1.2 1.73818597561e-06 1.2 1.73821773374e-06 1.2 1.73824949187e-06 1.2 1.73828125e-06 1.2 1.73831300813e-06 1.2 1.73834476626e-06 1.2 1.73837652439e-06 1.2 1.73840828252e-06 1.2 1.73844004065e-06 1.2 1.73847179878e-06 1.2 1.73850355691e-06 1.2 1.73853531504e-06 1.2 1.73856707317e-06 1.2 1.7385988313e-06 1.2 1.73863058943e-06 1.2 1.73866234756e-06 1.2 1.73869410569e-06 1.2 1.73872586382e-06 1.2 1.73875762195e-06 1.2 1.73878938008e-06 1.2 1.73882113821e-06 1.2 1.73885289634e-06 1.2 1.73888465447e-06 1.2 1.7389164126e-06 1.2 1.73894817073e-06 1.2 1.73897992886e-06 1.2 1.73901168699e-06 1.2 1.73904344512e-06 1.2 1.73907520325e-06 1.2 1.73910696138e-06 1.2 1.73913871951e-06 1.2 1.73917047764e-06 1.2 1.73920223577e-06 1.2 1.7392339939e-06 1.2 1.73926575203e-06 1.2 1.73929751016e-06 1.2 1.73932926829e-06 1.2 1.73936102642e-06 1.2 1.73939278455e-06 1.2 1.73942454268e-06 1.2 1.73945630081e-06 1.2 1.73948805894e-06 1.2 1.73951981707e-06 1.2 1.7395515752e-06 1.2 1.73958333333e-06 1.2 1.73961509146e-06 1.2 1.73964684959e-06 1.2 1.73967860772e-06 1.2 1.73971036585e-06 1.2 1.73974212398e-06 1.2 1.73977388211e-06 1.2 1.73980564024e-06 1.2 1.73983739837e-06 1.2 1.7398691565e-06 1.2 1.73990091463e-06 1.2 1.73993267276e-06 1.2 1.73996443089e-06 1.2 1.73999618902e-06 1.2 1.74002794715e-06 1.2 1.74005970528e-06 1.2 1.74009146341e-06 1.2 1.74012322154e-06 1.2 1.74015497967e-06 1.2 1.7401867378e-06 1.2 1.74021849593e-06 1.2 1.74025025407e-06 1.2 1.7402820122e-06 1.2 1.74031377033e-06 1.2 1.74034552846e-06 1.2 1.74037728659e-06 1.2 1.74040904472e-06 1.2 1.74044080285e-06 1.2 1.74047256098e-06 1.2 1.74050431911e-06 1.2 1.74053607724e-06 1.2 1.74056783537e-06 1.2 1.7405995935e-06 1.2 1.74063135163e-06 1.2 1.74066310976e-06 1.2 1.74069486789e-06 1.2 1.74072662602e-06 1.2 1.74075838415e-06 1.2 1.74079014228e-06 1.2 1.74082190041e-06 1.2 1.74085365854e-06 1.2 1.74088541667e-06 1.2 1.7409171748e-06 1.2 1.74094893293e-06 1.2 1.74098069106e-06 1.2 1.74101244919e-06 1.2 1.74104420732e-06 1.2 1.74107596545e-06 1.2 1.74110772358e-06 1.2 1.74113948171e-06 1.2 1.74117123984e-06 1.2 1.74120299797e-06 1.2 1.7412347561e-06 1.2 1.74126651423e-06 1.2 1.74129827236e-06 1.2 1.74133003049e-06 1.2 1.74136178862e-06 1.2 1.74139354675e-06 1.2 1.74142530488e-06 1.2 1.74145706301e-06 1.2 1.74148882114e-06 1.2 1.74152057927e-06 1.2 1.7415523374e-06 1.2 1.74158409553e-06 1.2 1.74161585366e-06 1.2 1.74164761179e-06 1.2 1.74167936992e-06 1.2 1.74171112805e-06 1.2 1.74174288618e-06 1.2 1.74177464431e-06 1.2 1.74180640244e-06 1.2 1.74183816057e-06 1.2 1.7418699187e-06 1.2 1.74190167683e-06 1.2 1.74193343496e-06 1.2 1.74196519309e-06 1.2 1.74199695122e-06 1.2 1.74202870935e-06 1.2 1.74206046748e-06 1.2 1.74209222561e-06 1.2 1.74212398374e-06 1.2 1.74215574187e-06 1.2 1.7421875e-06 1.2 1.74221925813e-06 1.2 1.74225101626e-06 1.2 1.74228277439e-06 1.2 1.74231453252e-06 1.2 1.74234629065e-06 1.2 1.74237804878e-06 1.2 1.74240980691e-06 1.2 1.74244156504e-06 1.2 1.74247332317e-06 1.2 1.7425050813e-06 1.2 1.74253683943e-06 1.2 1.74256859756e-06 1.2 1.74260035569e-06 1.2 1.74263211382e-06 1.2 1.74266387195e-06 1.2 1.74269563008e-06 1.2 1.74272738821e-06 1.2 1.74275914634e-06 1.2 1.74279090447e-06 1.2 1.7428226626e-06 1.2 1.74285442073e-06 1.2 1.74288617886e-06 1.2 1.74291793699e-06 1.2 1.74294969512e-06 1.2 1.74298145325e-06 1.2 1.74301321138e-06 1.2 1.74304496951e-06 1.2 1.74307672764e-06 1.2 1.74310848577e-06 1.2 1.7431402439e-06 1.2 1.74317200203e-06 1.2 1.74320376016e-06 1.2 1.74323551829e-06 1.2 1.74326727642e-06 1.2 1.74329903455e-06 1.2 1.74333079268e-06 1.2 1.74336255081e-06 1.2 1.74339430894e-06 1.2 1.74342606707e-06 1.2 1.7434578252e-06 1.2 1.74348958333e-06 1.2 1.74352134146e-06 1.2 1.74355309959e-06 1.2 1.74358485772e-06 1.2 1.74361661585e-06 1.2 1.74364837398e-06 1.2 1.74368013211e-06 1.2 1.74371189024e-06 1.2 1.74374364837e-06 1.2 1.7437754065e-06 1.2 1.74380716463e-06 1.2 1.74383892276e-06 1.2 1.74387068089e-06 1.2 1.74390243902e-06 1.2 1.74393419715e-06 1.2 1.74396595528e-06 1.2 1.74399771341e-06 1.2 1.74402947154e-06 1.2 1.74406122967e-06 1.2 1.7440929878e-06 1.2 1.74412474593e-06 1.2 1.74415650407e-06 1.2 1.7441882622e-06 1.2 1.74422002033e-06 1.2 1.74425177846e-06 1.2 1.74428353659e-06 1.2 1.74431529472e-06 1.2 1.74434705285e-06 1.2 1.74437881098e-06 1.2 1.74441056911e-06 1.2 1.74444232724e-06 1.2 1.74447408537e-06 1.2 1.7445058435e-06 1.2 1.74453760163e-06 1.2 1.74456935976e-06 1.2 1.74460111789e-06 1.2 1.74463287602e-06 1.2 1.74466463415e-06 1.2 1.74469639228e-06 1.2 1.74472815041e-06 1.2 1.74475990854e-06 1.2 1.74479166667e-06 1.2 1.7448234248e-06 1.2 1.74485518293e-06 1.2 1.74488694106e-06 1.2 1.74491869919e-06 1.2 1.74495045732e-06 1.2 1.74498221545e-06 1.2 1.74501397358e-06 1.2 1.74504573171e-06 1.2 1.74507748984e-06 1.2 1.74510924797e-06 1.2 1.7451410061e-06 1.2 1.74517276423e-06 1.2 1.74520452236e-06 1.2 1.74523628049e-06 1.2 1.74526803862e-06 1.2 1.74529979675e-06 1.2 1.74533155488e-06 1.2 1.74536331301e-06 1.2 1.74539507114e-06 1.2 1.74542682927e-06 1.2 1.7454585874e-06 1.2 1.74549034553e-06 1.2 1.74552210366e-06 1.2 1.74555386179e-06 1.2 1.74558561992e-06 1.2 1.74561737805e-06 1.2 1.74564913618e-06 1.2 1.74568089431e-06 1.2 1.74571265244e-06 1.2 1.74574441057e-06 1.2 1.7457761687e-06 1.2 1.74580792683e-06 1.2 1.74583968496e-06 1.2 1.74587144309e-06 1.2 1.74590320122e-06 1.2 1.74593495935e-06 1.2 1.74596671748e-06 1.2 1.74599847561e-06 1.2 1.74603023374e-06 1.2 1.74606199187e-06 1.2 1.74609375e-06 1.2 1.74612550813e-06 1.2 1.74615726626e-06 1.2 1.74618902439e-06 1.2 1.74622078252e-06 1.2 1.74625254065e-06 1.2 1.74628429878e-06 1.2 1.74631605691e-06 1.2 1.74634781504e-06 1.2 1.74637957317e-06 1.2 1.7464113313e-06 1.2 1.74644308943e-06 1.2 1.74647484756e-06 1.2 1.74650660569e-06 1.2 1.74653836382e-06 1.2 1.74657012195e-06 1.2 1.74660188008e-06 1.2 1.74663363821e-06 1.2 1.74666539634e-06 1.2 1.74669715447e-06 1.2 1.7467289126e-06 1.2 1.74676067073e-06 1.2 1.74679242886e-06 1.2 1.74682418699e-06 1.2 1.74685594512e-06 1.2 1.74688770325e-06 1.2 1.74691946138e-06 1.2 1.74695121951e-06 1.2 1.74698297764e-06 1.2 1.74701473577e-06 1.2 1.7470464939e-06 1.2 1.74707825203e-06 1.2 1.74711001016e-06 1.2 1.74714176829e-06 1.2 1.74717352642e-06 1.2 1.74720528455e-06 1.2 1.74723704268e-06 1.2 1.74726880081e-06 1.2 1.74730055894e-06 1.2 1.74733231707e-06 1.2 1.7473640752e-06 1.2 1.74739583333e-06 1.2 1.74742759146e-06 1.2 1.74745934959e-06 1.2 1.74749110772e-06 1.2 1.74752286585e-06 1.2 1.74755462398e-06 1.2 1.74758638211e-06 1.2 1.74761814024e-06 1.2 1.74764989837e-06 1.2 1.7476816565e-06 1.2 1.74771341463e-06 1.2 1.74774517276e-06 1.2 1.74777693089e-06 1.2 1.74780868902e-06 1.2 1.74784044715e-06 1.2 1.74787220528e-06 1.2 1.74790396341e-06 1.2 1.74793572154e-06 1.2 1.74796747967e-06 1.2 1.7479992378e-06 1.2 1.74803099593e-06 1.2 1.74806275407e-06 1.2 1.7480945122e-06 1.2 1.74812627033e-06 1.2 1.74815802846e-06 1.2 1.74818978659e-06 1.2 1.74822154472e-06 1.2 1.74825330285e-06 1.2 1.74828506098e-06 1.2 1.74831681911e-06 1.2 1.74834857724e-06 1.2 1.74838033537e-06 1.2 1.7484120935e-06 1.2 1.74844385163e-06 1.2 1.74847560976e-06 1.2 1.74850736789e-06 1.2 1.74853912602e-06 1.2 1.74857088415e-06 1.2 1.74860264228e-06 1.2 1.74863440041e-06 1.2 1.74866615854e-06 1.2 1.74869791667e-06 1.2 1.7487296748e-06 1.2 1.74876143293e-06 1.2 1.74879319106e-06 1.2 1.74882494919e-06 1.2 1.74885670732e-06 1.2 1.74888846545e-06 1.2 1.74892022358e-06 1.2 1.74895198171e-06 1.2 1.74898373984e-06 1.2 1.74901549797e-06 1.2 1.7490472561e-06 1.2 1.74907901423e-06 1.2 1.74911077236e-06 1.2 1.74914253049e-06 1.2 1.74917428862e-06 1.2 1.74920604675e-06 1.2 1.74923780488e-06 1.2 1.74926956301e-06 1.2 1.74930132114e-06 1.2 1.74933307927e-06 1.2 1.7493648374e-06 1.2 1.74939659553e-06 1.2 1.74942835366e-06 1.2 1.74946011179e-06 1.2 1.74949186992e-06 1.2 1.74952362805e-06 1.2 1.74955538618e-06 1.2 1.74958714431e-06 1.2 1.74961890244e-06 1.2 1.74965066057e-06 1.2 1.7496824187e-06 1.2 1.74971417683e-06 1.2 1.74974593496e-06 1.2 1.74977769309e-06 1.2 1.74980945122e-06 1.2 1.74984120935e-06 1.2 1.74987296748e-06 1.2 1.74990472561e-06 1.2 1.74993648374e-06 1.2 1.74996824187e-06 1.2 1.75e-06 1.2 1.75003175813e-06 1.2 1.75006351626e-06 1.2 1.75009527439e-06 1.2 1.75012703252e-06 1.2 1.75015879065e-06 1.2 1.75019054878e-06 1.2 1.75022230691e-06 1.2 1.75025406504e-06 1.2 1.75028582317e-06 1.2 1.7503175813e-06 1.2 1.75034933943e-06 1.2 1.75038109756e-06 1.2 1.75041285569e-06 1.2 1.75044461382e-06 1.2 1.75047637195e-06 1.2 1.75050813008e-06 1.2 1.75053988821e-06 1.2 1.75057164634e-06 1.2 1.75060340447e-06 1.2 1.7506351626e-06 1.2 1.75066692073e-06 1.2 1.75069867886e-06 1.2 1.75073043699e-06 1.2 1.75076219512e-06 1.2 1.75079395325e-06 1.2 1.75082571138e-06 1.2 1.75085746951e-06 1.2 1.75088922764e-06 1.2 1.75092098577e-06 1.2 1.7509527439e-06 1.2 1.75098450203e-06 1.2 1.75101626016e-06 1.2 1.75104801829e-06 1.2 1.75107977642e-06 1.2 1.75111153455e-06 1.2 1.75114329268e-06 1.2 1.75117505081e-06 1.2 1.75120680894e-06 1.2 1.75123856707e-06 1.2 1.7512703252e-06 1.2 1.75130208333e-06 1.2 1.75133384146e-06 1.2 1.75136559959e-06 1.2 1.75139735772e-06 1.2 1.75142911585e-06 1.2 1.75146087398e-06 1.2 1.75149263211e-06 1.2 1.75152439024e-06 1.2 1.75155614837e-06 1.2 1.7515879065e-06 1.2 1.75161966463e-06 1.2 1.75165142276e-06 1.2 1.75168318089e-06 1.2 1.75171493902e-06 1.2 1.75174669715e-06 1.2 1.75177845528e-06 1.2 1.75181021341e-06 1.2 1.75184197154e-06 1.2 1.75187372967e-06 1.2 1.7519054878e-06 1.2 1.75193724593e-06 1.2 1.75196900407e-06 1.2 1.7520007622e-06 1.2 1.75203252033e-06 1.2 1.75206427846e-06 1.2 1.75209603659e-06 1.2 1.75212779472e-06 1.2 1.75215955285e-06 1.2 1.75219131098e-06 1.2 1.75222306911e-06 1.2 1.75225482724e-06 1.2 1.75228658537e-06 1.2 1.7523183435e-06 1.2 1.75235010163e-06 1.2 1.75238185976e-06 1.2 1.75241361789e-06 1.2 1.75244537602e-06 1.2 1.75247713415e-06 1.2 1.75250889228e-06 1.2 1.75254065041e-06 1.2 1.75257240854e-06 1.2 1.75260416667e-06 1.2 1.7526359248e-06 1.2 1.75266768293e-06 1.2 1.75269944106e-06 1.2 1.75273119919e-06 1.2 1.75276295732e-06 1.2 1.75279471545e-06 1.2 1.75282647358e-06 1.2 1.75285823171e-06 1.2 1.75288998984e-06 1.2 1.75292174797e-06 1.2 1.7529535061e-06 1.2 1.75298526423e-06 1.2 1.75301702236e-06 1.2 1.75304878049e-06 1.2 1.75308053862e-06 1.2 1.75311229675e-06 1.2 1.75314405488e-06 1.2 1.75317581301e-06 1.2 1.75320757114e-06 1.2 1.75323932927e-06 1.2 1.7532710874e-06 1.2 1.75330284553e-06 1.2 1.75333460366e-06 1.2 1.75336636179e-06 1.2 1.75339811992e-06 1.2 1.75342987805e-06 1.2 1.75346163618e-06 1.2 1.75349339431e-06 1.2 1.75352515244e-06 1.2 1.75355691057e-06 1.2 1.7535886687e-06 1.2 1.75362042683e-06 1.2 1.75365218496e-06 1.2 1.75368394309e-06 1.2 1.75371570122e-06 1.2 1.75374745935e-06 1.2 1.75377921748e-06 1.2 1.75381097561e-06 1.2 1.75384273374e-06 1.2 1.75387449187e-06 1.2 1.75390625e-06 1.2 1.75393800813e-06 1.2 1.75396976626e-06 1.2 1.75400152439e-06 1.2 1.75403328252e-06 1.2 1.75406504065e-06 1.2 1.75409679878e-06 1.2 1.75412855691e-06 1.2 1.75416031504e-06 1.2 1.75419207317e-06 1.2 1.7542238313e-06 1.2 1.75425558943e-06 1.2 1.75428734756e-06 1.2 1.75431910569e-06 1.2 1.75435086382e-06 1.2 1.75438262195e-06 1.2 1.75441438008e-06 1.2 1.75444613821e-06 1.2 1.75447789634e-06 1.2 1.75450965447e-06 1.2 1.7545414126e-06 1.2 1.75457317073e-06 1.2 1.75460492886e-06 1.2 1.75463668699e-06 1.2 1.75466844512e-06 1.2 1.75470020325e-06 1.2 1.75473196138e-06 1.2 1.75476371951e-06 1.2 1.75479547764e-06 1.2 1.75482723577e-06 1.2 1.7548589939e-06 1.2 1.75489075203e-06 1.2 1.75492251016e-06 1.2 1.75495426829e-06 1.2 1.75498602642e-06 1.2 1.75501778455e-06 1.2 1.75504954268e-06 1.2 1.75508130081e-06 1.2 1.75511305894e-06 1.2 1.75514481707e-06 1.2 1.7551765752e-06 1.2 1.75520833333e-06 1.2 1.75524009146e-06 1.2 1.75527184959e-06 1.2 1.75530360772e-06 1.2 1.75533536585e-06 1.2 1.75536712398e-06 1.2 1.75539888211e-06 1.2 1.75543064024e-06 1.2 1.75546239837e-06 1.2 1.7554941565e-06 1.2 1.75552591463e-06 1.2 1.75555767276e-06 1.2 1.75558943089e-06 1.2 1.75562118902e-06 1.2 1.75565294715e-06 1.2 1.75568470528e-06 1.2 1.75571646341e-06 1.2 1.75574822154e-06 1.2 1.75577997967e-06 1.2 1.7558117378e-06 1.2 1.75584349593e-06 1.2 1.75587525407e-06 1.2 1.7559070122e-06 1.2 1.75593877033e-06 1.2 1.75597052846e-06 1.2 1.75600228659e-06 1.2 1.75603404472e-06 1.2 1.75606580285e-06 1.2 1.75609756098e-06 1.2 1.75612931911e-06 1.2 1.75616107724e-06 1.2 1.75619283537e-06 1.2 1.7562245935e-06 1.2 1.75625635163e-06 1.2 1.75628810976e-06 1.2 1.75631986789e-06 1.2 1.75635162602e-06 1.2 1.75638338415e-06 1.2 1.75641514228e-06 1.2 1.75644690041e-06 1.2 1.75647865854e-06 1.2 1.75651041667e-06 1.2 1.7565421748e-06 1.2 1.75657393293e-06 1.2 1.75660569106e-06 1.2 1.75663744919e-06 1.2 1.75666920732e-06 1.2 1.75670096545e-06 1.2 1.75673272358e-06 1.2 1.75676448171e-06 1.2 1.75679623984e-06 1.2 1.75682799797e-06 1.2 1.7568597561e-06 1.2 1.75689151423e-06 1.2 1.75692327236e-06 1.2 1.75695503049e-06 1.2 1.75698678862e-06 1.2 1.75701854675e-06 1.2 1.75705030488e-06 1.2 1.75708206301e-06 1.2 1.75711382114e-06 1.2 1.75714557927e-06 1.2 1.7571773374e-06 1.2 1.75720909553e-06 1.2 1.75724085366e-06 1.2 1.75727261179e-06 1.2 1.75730436992e-06 1.2 1.75733612805e-06 1.2 1.75736788618e-06 1.2 1.75739964431e-06 1.2 1.75743140244e-06 1.2 1.75746316057e-06 1.2 1.7574949187e-06 1.2 1.75752667683e-06 1.2 1.75755843496e-06 1.2 1.75759019309e-06 1.2 1.75762195122e-06 1.2 1.75765370935e-06 1.2 1.75768546748e-06 1.2 1.75771722561e-06 1.2 1.75774898374e-06 1.2 1.75778074187e-06 1.2 1.7578125e-06 1.2 1.75784425813e-06 1.2 1.75787601626e-06 1.2 1.75790777439e-06 1.2 1.75793953252e-06 1.2 1.75797129065e-06 1.2 1.75800304878e-06 1.2 1.75803480691e-06 1.2 1.75806656504e-06 1.2 1.75809832317e-06 1.2 1.7581300813e-06 1.2 1.75816183943e-06 1.2 1.75819359756e-06 1.2 1.75822535569e-06 1.2 1.75825711382e-06 1.2 1.75828887195e-06 1.2 1.75832063008e-06 1.2 1.75835238821e-06 1.2 1.75838414634e-06 1.2 1.75841590447e-06 1.2 1.7584476626e-06 1.2 1.75847942073e-06 1.2 1.75851117886e-06 1.2 1.75854293699e-06 1.2 1.75857469512e-06 1.2 1.75860645325e-06 1.2 1.75863821138e-06 1.2 1.75866996951e-06 1.2 1.75870172764e-06 1.2 1.75873348577e-06 1.2 1.7587652439e-06 1.2 1.75879700203e-06 1.2 1.75882876016e-06 1.2 1.75886051829e-06 1.2 1.75889227642e-06 1.2 1.75892403455e-06 1.2 1.75895579268e-06 1.2 1.75898755081e-06 1.2 1.75901930894e-06 1.2 1.75905106707e-06 1.2 1.7590828252e-06 1.2 1.75911458333e-06 1.2 1.75914634146e-06 1.2 1.75917809959e-06 1.2 1.75920985772e-06 1.2 1.75924161585e-06 1.2 1.75927337398e-06 1.2 1.75930513211e-06 1.2 1.75933689024e-06 1.2 1.75936864837e-06 1.2 1.7594004065e-06 1.2 1.75943216463e-06 1.2 1.75946392276e-06 1.2 1.75949568089e-06 1.2 1.75952743902e-06 1.2 1.75955919715e-06 1.2 1.75959095528e-06 1.2 1.75962271341e-06 1.2 1.75965447154e-06 1.2 1.75968622967e-06 1.2 1.7597179878e-06 1.2 1.75974974593e-06 1.2 1.75978150407e-06 1.2 1.7598132622e-06 1.2 1.75984502033e-06 1.2 1.75987677846e-06 1.2 1.75990853659e-06 1.2 1.75994029472e-06 1.2 1.75997205285e-06 1.2 1.76000381098e-06 1.2 1.76003556911e-06 1.2 1.76006732724e-06 1.2 1.76009908537e-06 1.2 1.7601308435e-06 1.2 1.76016260163e-06 1.2 1.76019435976e-06 1.2 1.76022611789e-06 1.2 1.76025787602e-06 1.2 1.76028963415e-06 1.2 1.76032139228e-06 1.2 1.76035315041e-06 1.2 1.76038490854e-06 1.2 1.76041666667e-06 1.2 1.7604484248e-06 1.2 1.76048018293e-06 1.2 1.76051194106e-06 1.2 1.76054369919e-06 1.2 1.76057545732e-06 1.2 1.76060721545e-06 1.2 1.76063897358e-06 1.2 1.76067073171e-06 1.2 1.76070248984e-06 1.2 1.76073424797e-06 1.2 1.7607660061e-06 1.2 1.76079776423e-06 1.2 1.76082952236e-06 1.2 1.76086128049e-06 1.2 1.76089303862e-06 1.2 1.76092479675e-06 1.2 1.76095655488e-06 1.2 1.76098831301e-06 1.2 1.76102007114e-06 1.2 1.76105182927e-06 1.2 1.7610835874e-06 1.2 1.76111534553e-06 1.2 1.76114710366e-06 1.2 1.76117886179e-06 1.2 1.76121061992e-06 1.2 1.76124237805e-06 1.2 1.76127413618e-06 1.2 1.76130589431e-06 1.2 1.76133765244e-06 1.2 1.76136941057e-06 1.2 1.7614011687e-06 1.2 1.76143292683e-06 1.2 1.76146468496e-06 1.2 1.76149644309e-06 1.2 1.76152820122e-06 1.2 1.76155995935e-06 1.2 1.76159171748e-06 1.2 1.76162347561e-06 1.2 1.76165523374e-06 1.2 1.76168699187e-06 1.2 1.76171875e-06 1.2 1.76175050813e-06 1.2 1.76178226626e-06 1.2 1.76181402439e-06 1.2 1.76184578252e-06 1.2 1.76187754065e-06 1.2 1.76190929878e-06 1.2 1.76194105691e-06 1.2 1.76197281504e-06 1.2 1.76200457317e-06 1.2 1.7620363313e-06 1.2 1.76206808943e-06 1.2 1.76209984756e-06 1.2 1.76213160569e-06 1.2 1.76216336382e-06 1.2 1.76219512195e-06 1.2 1.76222688008e-06 1.2 1.76225863821e-06 1.2 1.76229039634e-06 1.2 1.76232215447e-06 1.2 1.7623539126e-06 1.2 1.76238567073e-06 1.2 1.76241742886e-06 1.2 1.76244918699e-06 1.2 1.76248094512e-06 1.2 1.76251270325e-06 1.2 1.76254446138e-06 1.2 1.76257621951e-06 1.2 1.76260797764e-06 1.2 1.76263973577e-06 1.2 1.7626714939e-06 1.2 1.76270325203e-06 1.2 1.76273501016e-06 1.2 1.76276676829e-06 1.2 1.76279852642e-06 1.2 1.76283028455e-06 1.2 1.76286204268e-06 1.2 1.76289380081e-06 1.2 1.76292555894e-06 1.2 1.76295731707e-06 1.2 1.7629890752e-06 1.2 1.76302083333e-06 1.2 1.76305259146e-06 1.2 1.76308434959e-06 1.2 1.76311610772e-06 1.2 1.76314786585e-06 1.2 1.76317962398e-06 1.2 1.76321138211e-06 1.2 1.76324314024e-06 1.2 1.76327489837e-06 1.2 1.7633066565e-06 1.2 1.76333841463e-06 1.2 1.76337017276e-06 1.2 1.76340193089e-06 1.2 1.76343368902e-06 1.2 1.76346544715e-06 1.2 1.76349720528e-06 1.2 1.76352896341e-06 1.2 1.76356072154e-06 1.2 1.76359247967e-06 1.2 1.7636242378e-06 1.2 1.76365599593e-06 1.2 1.76368775407e-06 1.2 1.7637195122e-06 1.2 1.76375127033e-06 1.2 1.76378302846e-06 1.2 1.76381478659e-06 1.2 1.76384654472e-06 1.2 1.76387830285e-06 1.2 1.76391006098e-06 1.2 1.76394181911e-06 1.2 1.76397357724e-06 1.2 1.76400533537e-06 1.2 1.7640370935e-06 1.2 1.76406885163e-06 1.2 1.76410060976e-06 1.2 1.76413236789e-06 1.2 1.76416412602e-06 1.2 1.76419588415e-06 1.2 1.76422764228e-06 1.2 1.76425940041e-06 1.2 1.76429115854e-06 1.2 1.76432291667e-06 1.2 1.7643546748e-06 1.2 1.76438643293e-06 1.2 1.76441819106e-06 1.2 1.76444994919e-06 1.2 1.76448170732e-06 1.2 1.76451346545e-06 1.2 1.76454522358e-06 1.2 1.76457698171e-06 1.2 1.76460873984e-06 1.2 1.76464049797e-06 1.2 1.7646722561e-06 1.2 1.76470401423e-06 1.2 1.76473577236e-06 1.2 1.76476753049e-06 1.2 1.76479928862e-06 1.2 1.76483104675e-06 1.2 1.76486280488e-06 1.2 1.76489456301e-06 1.2 1.76492632114e-06 1.2 1.76495807927e-06 1.2 1.7649898374e-06 1.2 1.76502159553e-06 1.2 1.76505335366e-06 1.2 1.76508511179e-06 1.2 1.76511686992e-06 1.2 1.76514862805e-06 1.2 1.76518038618e-06 1.2 1.76521214431e-06 1.2 1.76524390244e-06 1.2 1.76527566057e-06 1.2 1.7653074187e-06 1.2 1.76533917683e-06 1.2 1.76537093496e-06 1.2 1.76540269309e-06 1.2 1.76543445122e-06 1.2 1.76546620935e-06 1.2 1.76549796748e-06 1.2 1.76552972561e-06 1.2 1.76556148374e-06 1.2 1.76559324187e-06 1.2 1.765625e-06 1.2 1.76565675813e-06 1.2 1.76568851626e-06 1.2 1.76572027439e-06 1.2 1.76575203252e-06 1.2 1.76578379065e-06 1.2 1.76581554878e-06 1.2 1.76584730691e-06 1.2 1.76587906504e-06 1.2 1.76591082317e-06 1.2 1.7659425813e-06 1.2 1.76597433943e-06 1.2 1.76600609756e-06 1.2 1.76603785569e-06 1.2 1.76606961382e-06 1.2 1.76610137195e-06 1.2 1.76613313008e-06 1.2 1.76616488821e-06 1.2 1.76619664634e-06 1.2 1.76622840447e-06 1.2 1.7662601626e-06 1.2 1.76629192073e-06 1.2 1.76632367886e-06 1.2 1.76635543699e-06 1.2 1.76638719512e-06 1.2 1.76641895325e-06 1.2 1.76645071138e-06 1.2 1.76648246951e-06 1.2 1.76651422764e-06 1.2 1.76654598577e-06 1.2 1.7665777439e-06 1.2 1.76660950203e-06 1.2 1.76664126016e-06 1.2 1.76667301829e-06 1.2 1.76670477642e-06 1.2 1.76673653455e-06 1.2 1.76676829268e-06 1.2 1.76680005081e-06 1.2 1.76683180894e-06 1.2 1.76686356707e-06 1.2 1.7668953252e-06 1.2 1.76692708333e-06 1.2 1.76695884146e-06 1.2 1.76699059959e-06 1.2 1.76702235772e-06 1.2 1.76705411585e-06 1.2 1.76708587398e-06 1.2 1.76711763211e-06 1.2 1.76714939024e-06 1.2 1.76718114837e-06 1.2 1.7672129065e-06 1.2 1.76724466463e-06 1.2 1.76727642276e-06 1.2 1.76730818089e-06 1.2 1.76733993902e-06 1.2 1.76737169715e-06 1.2 1.76740345528e-06 1.2 1.76743521341e-06 1.2 1.76746697154e-06 1.2 1.76749872967e-06 1.2 1.7675304878e-06 1.2 1.76756224593e-06 1.2 1.76759400407e-06 1.2 1.7676257622e-06 1.2 1.76765752033e-06 1.2 1.76768927846e-06 1.2 1.76772103659e-06 1.2 1.76775279472e-06 1.2 1.76778455285e-06 1.2 1.76781631098e-06 1.2 1.76784806911e-06 1.2 1.76787982724e-06 1.2 1.76791158537e-06 1.2 1.7679433435e-06 1.2 1.76797510163e-06 1.2 1.76800685976e-06 1.2 1.76803861789e-06 1.2 1.76807037602e-06 1.2 1.76810213415e-06 1.2 1.76813389228e-06 1.2 1.76816565041e-06 1.2 1.76819740854e-06 1.2 1.76822916667e-06 1.2 1.7682609248e-06 1.2 1.76829268293e-06 1.2 1.76832444106e-06 1.2 1.76835619919e-06 1.2 1.76838795732e-06 1.2 1.76841971545e-06 1.2 1.76845147358e-06 1.2 1.76848323171e-06 1.2 1.76851498984e-06 1.2 1.76854674797e-06 1.2 1.7685785061e-06 1.2 1.76861026423e-06 1.2 1.76864202236e-06 1.2 1.76867378049e-06 1.2 1.76870553862e-06 1.2 1.76873729675e-06 1.2 1.76876905488e-06 1.2 1.76880081301e-06 1.2 1.76883257114e-06 1.2 1.76886432927e-06 1.2 1.7688960874e-06 1.2 1.76892784553e-06 1.2 1.76895960366e-06 1.2 1.76899136179e-06 1.2 1.76902311992e-06 1.2 1.76905487805e-06 1.2 1.76908663618e-06 1.2 1.76911839431e-06 1.2 1.76915015244e-06 1.2 1.76918191057e-06 1.2 1.7692136687e-06 1.2 1.76924542683e-06 1.2 1.76927718496e-06 1.2 1.76930894309e-06 1.2 1.76934070122e-06 1.2 1.76937245935e-06 1.2 1.76940421748e-06 1.2 1.76943597561e-06 1.2 1.76946773374e-06 1.2 1.76949949187e-06 1.2 1.76953125e-06 1.2 1.76956300813e-06 1.2 1.76959476626e-06 1.2 1.76962652439e-06 1.2 1.76965828252e-06 1.2 1.76969004065e-06 1.2 1.76972179878e-06 1.2 1.76975355691e-06 1.2 1.76978531504e-06 1.2 1.76981707317e-06 1.2 1.7698488313e-06 1.2 1.76988058943e-06 1.2 1.76991234756e-06 1.2 1.76994410569e-06 1.2 1.76997586382e-06 1.2 1.77000762195e-06 1.2 1.77003938008e-06 1.2 1.77007113821e-06 1.2 1.77010289634e-06 1.2 1.77013465447e-06 1.2 1.7701664126e-06 1.2 1.77019817073e-06 1.2 1.77022992886e-06 1.2 1.77026168699e-06 1.2 1.77029344512e-06 1.2 1.77032520325e-06 1.2 1.77035696138e-06 1.2 1.77038871951e-06 1.2 1.77042047764e-06 1.2 1.77045223577e-06 1.2 1.7704839939e-06 1.2 1.77051575203e-06 1.2 1.77054751016e-06 1.2 1.77057926829e-06 1.2 1.77061102642e-06 1.2 1.77064278455e-06 1.2 1.77067454268e-06 1.2 1.77070630081e-06 1.2 1.77073805894e-06 1.2 1.77076981707e-06 1.2 1.7708015752e-06 1.2 1.77083333333e-06 1.2 1.77086509146e-06 1.2 1.77089684959e-06 1.2 1.77092860772e-06 1.2 1.77096036585e-06 1.2 1.77099212398e-06 1.2 1.77102388211e-06 1.2 1.77105564024e-06 1.2 1.77108739837e-06 1.2 1.7711191565e-06 1.2 1.77115091463e-06 1.2 1.77118267276e-06 1.2 1.77121443089e-06 1.2 1.77124618902e-06 1.2 1.77127794715e-06 1.2 1.77130970528e-06 1.2 1.77134146341e-06 1.2 1.77137322154e-06 1.2 1.77140497967e-06 1.2 1.7714367378e-06 1.2 1.77146849593e-06 1.2 1.77150025407e-06 1.2 1.7715320122e-06 1.2 1.77156377033e-06 1.2 1.77159552846e-06 1.2 1.77162728659e-06 1.2 1.77165904472e-06 1.2 1.77169080285e-06 1.2 1.77172256098e-06 1.2 1.77175431911e-06 1.2 1.77178607724e-06 1.2 1.77181783537e-06 1.2 1.7718495935e-06 1.2 1.77188135163e-06 1.2 1.77191310976e-06 1.2 1.77194486789e-06 1.2 1.77197662602e-06 1.2 1.77200838415e-06 1.2 1.77204014228e-06 1.2 1.77207190041e-06 1.2 1.77210365854e-06 1.2 1.77213541667e-06 1.2 1.7721671748e-06 1.2 1.77219893293e-06 1.2 1.77223069106e-06 1.2 1.77226244919e-06 1.2 1.77229420732e-06 1.2 1.77232596545e-06 1.2 1.77235772358e-06 1.2 1.77238948171e-06 1.2 1.77242123984e-06 1.2 1.77245299797e-06 1.2 1.7724847561e-06 1.2 1.77251651423e-06 1.2 1.77254827236e-06 1.2 1.77258003049e-06 1.2 1.77261178862e-06 1.2 1.77264354675e-06 1.2 1.77267530488e-06 1.2 1.77270706301e-06 1.2 1.77273882114e-06 1.2 1.77277057927e-06 1.2 1.7728023374e-06 1.2 1.77283409553e-06 1.2 1.77286585366e-06 1.2 1.77289761179e-06 1.2 1.77292936992e-06 1.2 1.77296112805e-06 1.2 1.77299288618e-06 1.2 1.77302464431e-06 1.2 1.77305640244e-06 1.2 1.77308816057e-06 1.2 1.7731199187e-06 1.2 1.77315167683e-06 1.2 1.77318343496e-06 1.2 1.77321519309e-06 1.2 1.77324695122e-06 1.2 1.77327870935e-06 1.2 1.77331046748e-06 1.2 1.77334222561e-06 1.2 1.77337398374e-06 1.2 1.77340574187e-06 1.2 1.7734375e-06 1.2 1.77346925813e-06 1.2 1.77350101626e-06 1.2 1.77353277439e-06 1.2 1.77356453252e-06 1.2 1.77359629065e-06 1.2 1.77362804878e-06 1.2 1.77365980691e-06 1.2 1.77369156504e-06 1.2 1.77372332317e-06 1.2 1.7737550813e-06 1.2 1.77378683943e-06 1.2 1.77381859756e-06 1.2 1.77385035569e-06 1.2 1.77388211382e-06 1.2 1.77391387195e-06 1.2 1.77394563008e-06 1.2 1.77397738821e-06 1.2 1.77400914634e-06 1.2 1.77404090447e-06 1.2 1.7740726626e-06 1.2 1.77410442073e-06 1.2 1.77413617886e-06 1.2 1.77416793699e-06 1.2 1.77419969512e-06 1.2 1.77423145325e-06 1.2 1.77426321138e-06 1.2 1.77429496951e-06 1.2 1.77432672764e-06 1.2 1.77435848577e-06 1.2 1.7743902439e-06 1.2 1.77442200203e-06 1.2 1.77445376016e-06 1.2 1.77448551829e-06 1.2 1.77451727642e-06 1.2 1.77454903455e-06 1.2 1.77458079268e-06 1.2 1.77461255081e-06 1.2 1.77464430894e-06 1.2 1.77467606707e-06 1.2 1.7747078252e-06 1.2 1.77473958333e-06 1.2 1.77477134146e-06 1.2 1.77480309959e-06 1.2 1.77483485772e-06 1.2 1.77486661585e-06 1.2 1.77489837398e-06 1.2 1.77493013211e-06 1.2 1.77496189024e-06 1.2 1.77499364837e-06 1.2 1.7750254065e-06 1.2 1.77505716463e-06 1.2 1.77508892276e-06 1.2 1.77512068089e-06 1.2 1.77515243902e-06 1.2 1.77518419715e-06 1.2 1.77521595528e-06 1.2 1.77524771341e-06 1.2 1.77527947154e-06 1.2 1.77531122967e-06 1.2 1.7753429878e-06 1.2 1.77537474593e-06 1.2 1.77540650407e-06 1.2 1.7754382622e-06 1.2 1.77547002033e-06 1.2 1.77550177846e-06 1.2 1.77553353659e-06 1.2 1.77556529472e-06 1.2 1.77559705285e-06 1.2 1.77562881098e-06 1.2 1.77566056911e-06 1.2 1.77569232724e-06 1.2 1.77572408537e-06 1.2 1.7757558435e-06 1.2 1.77578760163e-06 1.2 1.77581935976e-06 1.2 1.77585111789e-06 1.2 1.77588287602e-06 1.2 1.77591463415e-06 1.2 1.77594639228e-06 1.2 1.77597815041e-06 1.2 1.77600990854e-06 1.2 1.77604166667e-06 1.2 1.7760734248e-06 1.2 1.77610518293e-06 1.2 1.77613694106e-06 1.2 1.77616869919e-06 1.2 1.77620045732e-06 1.2 1.77623221545e-06 1.2 1.77626397358e-06 1.2 1.77629573171e-06 1.2 1.77632748984e-06 1.2 1.77635924797e-06 1.2 1.7763910061e-06 1.2 1.77642276423e-06 1.2 1.77645452236e-06 1.2 1.77648628049e-06 1.2 1.77651803862e-06 1.2 1.77654979675e-06 1.2 1.77658155488e-06 1.2 1.77661331301e-06 1.2 1.77664507114e-06 1.2 1.77667682927e-06 1.2 1.7767085874e-06 1.2 1.77674034553e-06 1.2 1.77677210366e-06 1.2 1.77680386179e-06 1.2 1.77683561992e-06 1.2 1.77686737805e-06 1.2 1.77689913618e-06 1.2 1.77693089431e-06 1.2 1.77696265244e-06 1.2 1.77699441057e-06 1.2 1.7770261687e-06 1.2 1.77705792683e-06 1.2 1.77708968496e-06 1.2 1.77712144309e-06 1.2 1.77715320122e-06 1.2 1.77718495935e-06 1.2 1.77721671748e-06 1.2 1.77724847561e-06 1.2 1.77728023374e-06 1.2 1.77731199187e-06 1.2 1.77734375e-06 1.2 1.77737550813e-06 1.2 1.77740726626e-06 1.2 1.77743902439e-06 1.2 1.77747078252e-06 1.2 1.77750254065e-06 1.2 1.77753429878e-06 1.2 1.77756605691e-06 1.2 1.77759781504e-06 1.2 1.77762957317e-06 1.2 1.7776613313e-06 1.2 1.77769308943e-06 1.2 1.77772484756e-06 1.2 1.77775660569e-06 1.2 1.77778836382e-06 1.2 1.77782012195e-06 1.2 1.77785188008e-06 1.2 1.77788363821e-06 1.2 1.77791539634e-06 1.2 1.77794715447e-06 1.2 1.7779789126e-06 1.2 1.77801067073e-06 1.2 1.77804242886e-06 1.2 1.77807418699e-06 1.2 1.77810594512e-06 1.2 1.77813770325e-06 1.2 1.77816946138e-06 1.2 1.77820121951e-06 1.2 1.77823297764e-06 1.2 1.77826473577e-06 1.2 1.7782964939e-06 1.2 1.77832825203e-06 1.2 1.77836001016e-06 1.2 1.77839176829e-06 1.2 1.77842352642e-06 1.2 1.77845528455e-06 1.2 1.77848704268e-06 1.2 1.77851880081e-06 1.2 1.77855055894e-06 1.2 1.77858231707e-06 1.2 1.7786140752e-06 1.2 1.77864583333e-06 1.2 1.77867759146e-06 1.2 1.77870934959e-06 1.2 1.77874110772e-06 1.2 1.77877286585e-06 1.2 1.77880462398e-06 1.2 1.77883638211e-06 1.2 1.77886814024e-06 1.2 1.77889989837e-06 1.2 1.7789316565e-06 1.2 1.77896341463e-06 1.2 1.77899517276e-06 1.2 1.77902693089e-06 1.2 1.77905868902e-06 1.2 1.77909044715e-06 1.2 1.77912220528e-06 1.2 1.77915396341e-06 1.2 1.77918572154e-06 1.2 1.77921747967e-06 1.2 1.7792492378e-06 1.2 1.77928099593e-06 1.2 1.77931275407e-06 1.2 1.7793445122e-06 1.2 1.77937627033e-06 1.2 1.77940802846e-06 1.2 1.77943978659e-06 1.2 1.77947154472e-06 1.2 1.77950330285e-06 1.2 1.77953506098e-06 1.2 1.77956681911e-06 1.2 1.77959857724e-06 1.2 1.77963033537e-06 1.2 1.7796620935e-06 1.2 1.77969385163e-06 1.2 1.77972560976e-06 1.2 1.77975736789e-06 1.2 1.77978912602e-06 1.2 1.77982088415e-06 1.2 1.77985264228e-06 1.2 1.77988440041e-06 1.2 1.77991615854e-06 1.2 1.77994791667e-06 1.2 1.7799796748e-06 1.2 1.78001143293e-06 1.2 1.78004319106e-06 1.2 1.78007494919e-06 1.2 1.78010670732e-06 1.2 1.78013846545e-06 1.2 1.78017022358e-06 1.2 1.78020198171e-06 1.2 1.78023373984e-06 1.2 1.78026549797e-06 1.2 1.7802972561e-06 1.2 1.78032901423e-06 1.2 1.78036077236e-06 1.2 1.78039253049e-06 1.2 1.78042428862e-06 1.2 1.78045604675e-06 1.2 1.78048780488e-06 1.2 1.78051956301e-06 1.2 1.78055132114e-06 1.2 1.78058307927e-06 1.2 1.7806148374e-06 1.2 1.78064659553e-06 1.2 1.78067835366e-06 1.2 1.78071011179e-06 1.2 1.78074186992e-06 1.2 1.78077362805e-06 1.2 1.78080538618e-06 1.2 1.78083714431e-06 1.2 1.78086890244e-06 1.2 1.78090066057e-06 1.2 1.7809324187e-06 1.2 1.78096417683e-06 1.2 1.78099593496e-06 1.2 1.78102769309e-06 1.2 1.78105945122e-06 1.2 1.78109120935e-06 1.2 1.78112296748e-06 1.2 1.78115472561e-06 1.2 1.78118648374e-06 1.2 1.78121824187e-06 1.2 1.78125e-06 1.2 1.78128175813e-06 1.2 1.78131351626e-06 1.2 1.78134527439e-06 1.2 1.78137703252e-06 1.2 1.78140879065e-06 1.2 1.78144054878e-06 1.2 1.78147230691e-06 1.2 1.78150406504e-06 1.2 1.78153582317e-06 1.2 1.7815675813e-06 1.2 1.78159933943e-06 1.2 1.78163109756e-06 1.2 1.78166285569e-06 1.2 1.78169461382e-06 1.2 1.78172637195e-06 1.2 1.78175813008e-06 1.2 1.78178988821e-06 1.2 1.78182164634e-06 1.2 1.78185340447e-06 1.2 1.7818851626e-06 1.2 1.78191692073e-06 1.2 1.78194867886e-06 1.2 1.78198043699e-06 1.2 1.78201219512e-06 1.2 1.78204395325e-06 1.2 1.78207571138e-06 1.2 1.78210746951e-06 1.2 1.78213922764e-06 1.2 1.78217098577e-06 1.2 1.7822027439e-06 1.2 1.78223450203e-06 1.2 1.78226626016e-06 1.2 1.78229801829e-06 1.2 1.78232977642e-06 1.2 1.78236153455e-06 1.2 1.78239329268e-06 1.2 1.78242505081e-06 1.2 1.78245680894e-06 1.2 1.78248856707e-06 1.2 1.7825203252e-06 1.2 1.78255208333e-06 1.2 1.78258384146e-06 1.2 1.78261559959e-06 1.2 1.78264735772e-06 1.2 1.78267911585e-06 1.2 1.78271087398e-06 1.2 1.78274263211e-06 1.2 1.78277439024e-06 1.2 1.78280614837e-06 1.2 1.7828379065e-06 1.2 1.78286966463e-06 1.2 1.78290142276e-06 1.2 1.78293318089e-06 1.2 1.78296493902e-06 1.2 1.78299669715e-06 1.2 1.78302845528e-06 1.2 1.78306021341e-06 1.2 1.78309197154e-06 1.2 1.78312372967e-06 1.2 1.7831554878e-06 1.2 1.78318724593e-06 1.2 1.78321900407e-06 1.2 1.7832507622e-06 1.2 1.78328252033e-06 1.2 1.78331427846e-06 1.2 1.78334603659e-06 1.2 1.78337779472e-06 1.2 1.78340955285e-06 1.2 1.78344131098e-06 1.2 1.78347306911e-06 1.2 1.78350482724e-06 1.2 1.78353658537e-06 1.2 1.7835683435e-06 1.2 1.78360010163e-06 1.2 1.78363185976e-06 1.2 1.78366361789e-06 1.2 1.78369537602e-06 1.2 1.78372713415e-06 1.2 1.78375889228e-06 1.2 1.78379065041e-06 1.2 1.78382240854e-06 1.2 1.78385416667e-06 1.2 1.7838859248e-06 1.2 1.78391768293e-06 1.2 1.78394944106e-06 1.2 1.78398119919e-06 1.2 1.78401295732e-06 1.2 1.78404471545e-06 1.2 1.78407647358e-06 1.2 1.78410823171e-06 1.2 1.78413998984e-06 1.2 1.78417174797e-06 1.2 1.7842035061e-06 1.2 1.78423526423e-06 1.2 1.78426702236e-06 1.2 1.78429878049e-06 1.2 1.78433053862e-06 1.2 1.78436229675e-06 1.2 1.78439405488e-06 1.2 1.78442581301e-06 1.2 1.78445757114e-06 1.2 1.78448932927e-06 1.2 1.7845210874e-06 1.2 1.78455284553e-06 1.2 1.78458460366e-06 1.2 1.78461636179e-06 1.2 1.78464811992e-06 1.2 1.78467987805e-06 1.2 1.78471163618e-06 1.2 1.78474339431e-06 1.2 1.78477515244e-06 1.2 1.78480691057e-06 1.2 1.7848386687e-06 1.2 1.78487042683e-06 1.2 1.78490218496e-06 1.2 1.78493394309e-06 1.2 1.78496570122e-06 1.2 1.78499745935e-06 1.2 1.78502921748e-06 1.2 1.78506097561e-06 1.2 1.78509273374e-06 1.2 1.78512449187e-06 1.2 1.78515625e-06 1.2 1.78518800813e-06 1.2 1.78521976626e-06 1.2 1.78525152439e-06 1.2 1.78528328252e-06 1.2 1.78531504065e-06 1.2 1.78534679878e-06 1.2 1.78537855691e-06 1.2 1.78541031504e-06 1.2 1.78544207317e-06 1.2 1.7854738313e-06 1.2 1.78550558943e-06 1.2 1.78553734756e-06 1.2 1.78556910569e-06 1.2 1.78560086382e-06 1.2 1.78563262195e-06 1.2 1.78566438008e-06 1.2 1.78569613821e-06 1.2 1.78572789634e-06 1.2 1.78575965447e-06 1.2 1.7857914126e-06 1.2 1.78582317073e-06 1.2 1.78585492886e-06 1.2 1.78588668699e-06 1.2 1.78591844512e-06 1.2 1.78595020325e-06 1.2 1.78598196138e-06 1.2 1.78601371951e-06 1.2 1.78604547764e-06 1.2 1.78607723577e-06 1.2 1.7861089939e-06 1.2 1.78614075203e-06 1.2 1.78617251016e-06 1.2 1.78620426829e-06 1.2 1.78623602642e-06 1.2 1.78626778455e-06 1.2 1.78629954268e-06 1.2 1.78633130081e-06 1.2 1.78636305894e-06 1.2 1.78639481707e-06 1.2 1.7864265752e-06 1.2 1.78645833333e-06 1.2 1.78649009146e-06 1.2 1.78652184959e-06 1.2 1.78655360772e-06 1.2 1.78658536585e-06 1.2 1.78661712398e-06 1.2 1.78664888211e-06 1.2 1.78668064024e-06 1.2 1.78671239837e-06 1.2 1.7867441565e-06 1.2 1.78677591463e-06 1.2 1.78680767276e-06 1.2 1.78683943089e-06 1.2 1.78687118902e-06 1.2 1.78690294715e-06 1.2 1.78693470528e-06 1.2 1.78696646341e-06 1.2 1.78699822154e-06 1.2 1.78702997967e-06 1.2 1.7870617378e-06 1.2 1.78709349593e-06 1.2 1.78712525407e-06 1.2 1.7871570122e-06 1.2 1.78718877033e-06 1.2 1.78722052846e-06 1.2 1.78725228659e-06 1.2 1.78728404472e-06 1.2 1.78731580285e-06 1.2 1.78734756098e-06 1.2 1.78737931911e-06 1.2 1.78741107724e-06 1.2 1.78744283537e-06 1.2 1.7874745935e-06 1.2 1.78750635163e-06 1.2 1.78753810976e-06 1.2 1.78756986789e-06 1.2 1.78760162602e-06 1.2 1.78763338415e-06 1.2 1.78766514228e-06 1.2 1.78769690041e-06 1.2 1.78772865854e-06 1.2 1.78776041667e-06 1.2 1.7877921748e-06 1.2 1.78782393293e-06 1.2 1.78785569106e-06 1.2 1.78788744919e-06 1.2 1.78791920732e-06 1.2 1.78795096545e-06 1.2 1.78798272358e-06 1.2 1.78801448171e-06 1.2 1.78804623984e-06 1.2 1.78807799797e-06 1.2 1.7881097561e-06 1.2 1.78814151423e-06 1.2 1.78817327236e-06 1.2 1.78820503049e-06 1.2 1.78823678862e-06 1.2 1.78826854675e-06 1.2 1.78830030488e-06 1.2 1.78833206301e-06 1.2 1.78836382114e-06 1.2 1.78839557927e-06 1.2 1.7884273374e-06 1.2 1.78845909553e-06 1.2 1.78849085366e-06 1.2 1.78852261179e-06 1.2 1.78855436992e-06 1.2 1.78858612805e-06 1.2 1.78861788618e-06 1.2 1.78864964431e-06 1.2 1.78868140244e-06 1.2 1.78871316057e-06 1.2 1.7887449187e-06 1.2 1.78877667683e-06 1.2 1.78880843496e-06 1.2 1.78884019309e-06 1.2 1.78887195122e-06 1.2 1.78890370935e-06 1.2 1.78893546748e-06 1.2 1.78896722561e-06 1.2 1.78899898374e-06 1.2 1.78903074187e-06 1.2 1.7890625e-06 1.2 1.78909425813e-06 1.2 1.78912601626e-06 1.2 1.78915777439e-06 1.2 1.78918953252e-06 1.2 1.78922129065e-06 1.2 1.78925304878e-06 1.2 1.78928480691e-06 1.2 1.78931656504e-06 1.2 1.78934832317e-06 1.2 1.7893800813e-06 1.2 1.78941183943e-06 1.2 1.78944359756e-06 1.2 1.78947535569e-06 1.2 1.78950711382e-06 1.2 1.78953887195e-06 1.2 1.78957063008e-06 1.2 1.78960238821e-06 1.2 1.78963414634e-06 1.2 1.78966590447e-06 1.2 1.7896976626e-06 1.2 1.78972942073e-06 1.2 1.78976117886e-06 1.2 1.78979293699e-06 1.2 1.78982469512e-06 1.2 1.78985645325e-06 1.2 1.78988821138e-06 1.2 1.78991996951e-06 1.2 1.78995172764e-06 1.2 1.78998348577e-06 1.2 1.7900152439e-06 1.2 1.79004700203e-06 1.2 1.79007876016e-06 1.2 1.79011051829e-06 1.2 1.79014227642e-06 1.2 1.79017403455e-06 1.2 1.79020579268e-06 1.2 1.79023755081e-06 1.2 1.79026930894e-06 1.2 1.79030106707e-06 1.2 1.7903328252e-06 1.2 1.79036458333e-06 1.2 1.79039634146e-06 1.2 1.79042809959e-06 1.2 1.79045985772e-06 1.2 1.79049161585e-06 1.2 1.79052337398e-06 1.2 1.79055513211e-06 1.2 1.79058689024e-06 1.2 1.79061864837e-06 1.2 1.7906504065e-06 1.2 1.79068216463e-06 1.2 1.79071392276e-06 1.2 1.79074568089e-06 1.2 1.79077743902e-06 1.2 1.79080919715e-06 1.2 1.79084095528e-06 1.2 1.79087271341e-06 1.2 1.79090447154e-06 1.2 1.79093622967e-06 1.2 1.7909679878e-06 1.2 1.79099974593e-06 1.2 1.79103150407e-06 1.2 1.7910632622e-06 1.2 1.79109502033e-06 1.2 1.79112677846e-06 1.2 1.79115853659e-06 1.2 1.79119029472e-06 1.2 1.79122205285e-06 1.2 1.79125381098e-06 1.2 1.79128556911e-06 1.2 1.79131732724e-06 1.2 1.79134908537e-06 1.2 1.7913808435e-06 1.2 1.79141260163e-06 1.2 1.79144435976e-06 1.2 1.79147611789e-06 1.2 1.79150787602e-06 1.2 1.79153963415e-06 1.2 1.79157139228e-06 1.2 1.79160315041e-06 1.2 1.79163490854e-06 1.2 1.79166666667e-06 1.2 1.7916984248e-06 1.2 1.79173018293e-06 1.2 1.79176194106e-06 1.2 1.79179369919e-06 1.2 1.79182545732e-06 1.2 1.79185721545e-06 1.2 1.79188897358e-06 1.2 1.79192073171e-06 1.2 1.79195248984e-06 1.2 1.79198424797e-06 1.2 1.7920160061e-06 1.2 1.79204776423e-06 1.2 1.79207952236e-06 1.2 1.79211128049e-06 1.2 1.79214303862e-06 1.2 1.79217479675e-06 1.2 1.79220655488e-06 1.2 1.79223831301e-06 1.2 1.79227007114e-06 1.2 1.79230182927e-06 1.2 1.7923335874e-06 1.2 1.79236534553e-06 1.2 1.79239710366e-06 1.2 1.79242886179e-06 1.2 1.79246061992e-06 1.2 1.79249237805e-06 1.2 1.79252413618e-06 1.2 1.79255589431e-06 1.2 1.79258765244e-06 1.2 1.79261941057e-06 1.2 1.7926511687e-06 1.2 1.79268292683e-06 1.2 1.79271468496e-06 1.2 1.79274644309e-06 1.2 1.79277820122e-06 1.2 1.79280995935e-06 1.2 1.79284171748e-06 1.2 1.79287347561e-06 1.2 1.79290523374e-06 1.2 1.79293699187e-06 1.2 1.79296875e-06 1.2 1.79300050813e-06 1.2 1.79303226626e-06 1.2 1.79306402439e-06 1.2 1.79309578252e-06 1.2 1.79312754065e-06 1.2 1.79315929878e-06 1.2 1.79319105691e-06 1.2 1.79322281504e-06 1.2 1.79325457317e-06 1.2 1.7932863313e-06 1.2 1.79331808943e-06 1.2 1.79334984756e-06 1.2 1.79338160569e-06 1.2 1.79341336382e-06 1.2 1.79344512195e-06 1.2 1.79347688008e-06 1.2 1.79350863821e-06 1.2 1.79354039634e-06 1.2 1.79357215447e-06 1.2 1.7936039126e-06 1.2 1.79363567073e-06 1.2 1.79366742886e-06 1.2 1.79369918699e-06 1.2 1.79373094512e-06 1.2 1.79376270325e-06 1.2 1.79379446138e-06 1.2 1.79382621951e-06 1.2 1.79385797764e-06 1.2 1.79388973577e-06 1.2 1.7939214939e-06 1.2 1.79395325203e-06 1.2 1.79398501016e-06 1.2 1.79401676829e-06 1.2 1.79404852642e-06 1.2 1.79408028455e-06 1.2 1.79411204268e-06 1.2 1.79414380081e-06 1.2 1.79417555894e-06 1.2 1.79420731707e-06 1.2 1.7942390752e-06 1.2 1.79427083333e-06 1.2 1.79430259146e-06 1.2 1.79433434959e-06 1.2 1.79436610772e-06 1.2 1.79439786585e-06 1.2 1.79442962398e-06 1.2 1.79446138211e-06 1.2 1.79449314024e-06 1.2 1.79452489837e-06 1.2 1.7945566565e-06 1.2 1.79458841463e-06 1.2 1.79462017276e-06 1.2 1.79465193089e-06 1.2 1.79468368902e-06 1.2 1.79471544715e-06 1.2 1.79474720528e-06 1.2 1.79477896341e-06 1.2 1.79481072154e-06 1.2 1.79484247967e-06 1.2 1.7948742378e-06 1.2 1.79490599593e-06 1.2 1.79493775407e-06 1.2 1.7949695122e-06 1.2 1.79500127033e-06 1.2 1.79503302846e-06 1.2 1.79506478659e-06 1.2 1.79509654472e-06 1.2 1.79512830285e-06 1.2 1.79516006098e-06 1.2 1.79519181911e-06 1.2 1.79522357724e-06 1.2 1.79525533537e-06 1.2 1.7952870935e-06 1.2 1.79531885163e-06 1.2 1.79535060976e-06 1.2 1.79538236789e-06 1.2 1.79541412602e-06 1.2 1.79544588415e-06 1.2 1.79547764228e-06 1.2 1.79550940041e-06 1.2 1.79554115854e-06 1.2 1.79557291667e-06 1.2 1.7956046748e-06 1.2 1.79563643293e-06 1.2 1.79566819106e-06 1.2 1.79569994919e-06 1.2 1.79573170732e-06 1.2 1.79576346545e-06 1.2 1.79579522358e-06 1.2 1.79582698171e-06 1.2 1.79585873984e-06 1.2 1.79589049797e-06 1.2 1.7959222561e-06 1.2 1.79595401423e-06 1.2 1.79598577236e-06 1.2 1.79601753049e-06 1.2 1.79604928862e-06 1.2 1.79608104675e-06 1.2 1.79611280488e-06 1.2 1.79614456301e-06 1.2 1.79617632114e-06 1.2 1.79620807927e-06 1.2 1.7962398374e-06 1.2 1.79627159553e-06 1.2 1.79630335366e-06 1.2 1.79633511179e-06 1.2 1.79636686992e-06 1.2 1.79639862805e-06 1.2 1.79643038618e-06 1.2 1.79646214431e-06 1.2 1.79649390244e-06 1.2 1.79652566057e-06 1.2 1.7965574187e-06 1.2 1.79658917683e-06 1.2 1.79662093496e-06 1.2 1.79665269309e-06 1.2 1.79668445122e-06 1.2 1.79671620935e-06 1.2 1.79674796748e-06 1.2 1.79677972561e-06 1.2 1.79681148374e-06 1.2 1.79684324187e-06 1.2 1.796875e-06 1.2 1.79690675813e-06 1.2 1.79693851626e-06 1.2 1.79697027439e-06 1.2 1.79700203252e-06 1.2 1.79703379065e-06 1.2 1.79706554878e-06 1.2 1.79709730691e-06 1.2 1.79712906504e-06 1.2 1.79716082317e-06 1.2 1.7971925813e-06 1.2 1.79722433943e-06 1.2 1.79725609756e-06 1.2 1.79728785569e-06 1.2 1.79731961382e-06 1.2 1.79735137195e-06 1.2 1.79738313008e-06 1.2 1.79741488821e-06 1.2 1.79744664634e-06 1.2 1.79747840447e-06 1.2 1.7975101626e-06 1.2 1.79754192073e-06 1.2 1.79757367886e-06 1.2 1.79760543699e-06 1.2 1.79763719512e-06 1.2 1.79766895325e-06 1.2 1.79770071138e-06 1.2 1.79773246951e-06 1.2 1.79776422764e-06 1.2 1.79779598577e-06 1.2 1.7978277439e-06 1.2 1.79785950203e-06 1.2 1.79789126016e-06 1.2 1.79792301829e-06 1.2 1.79795477642e-06 1.2 1.79798653455e-06 1.2 1.79801829268e-06 1.2 1.79805005081e-06 1.2 1.79808180894e-06 1.2 1.79811356707e-06 1.2 1.7981453252e-06 1.2 1.79817708333e-06 1.2 1.79820884146e-06 1.2 1.79824059959e-06 1.2 1.79827235772e-06 1.2 1.79830411585e-06 1.2 1.79833587398e-06 1.2 1.79836763211e-06 1.2 1.79839939024e-06 1.2 1.79843114837e-06 1.2 1.7984629065e-06 1.2 1.79849466463e-06 1.2 1.79852642276e-06 1.2 1.79855818089e-06 1.2 1.79858993902e-06 1.2 1.79862169715e-06 1.2 1.79865345528e-06 1.2 1.79868521341e-06 1.2 1.79871697154e-06 1.2 1.79874872967e-06 1.2 1.7987804878e-06 1.2 1.79881224593e-06 1.2 1.79884400407e-06 1.2 1.7988757622e-06 1.2 1.79890752033e-06 1.2 1.79893927846e-06 1.2 1.79897103659e-06 1.2 1.79900279472e-06 1.2 1.79903455285e-06 1.2 1.79906631098e-06 1.2 1.79909806911e-06 1.2 1.79912982724e-06 1.2 1.79916158537e-06 1.2 1.7991933435e-06 1.2 1.79922510163e-06 1.2 1.79925685976e-06 1.2 1.79928861789e-06 1.2 1.79932037602e-06 1.2 1.79935213415e-06 1.2 1.79938389228e-06 1.2 1.79941565041e-06 1.2 1.79944740854e-06 1.2 1.79947916667e-06 1.2 1.7995109248e-06 1.2 1.79954268293e-06 1.2 1.79957444106e-06 1.2 1.79960619919e-06 1.2 1.79963795732e-06 1.2 1.79966971545e-06 1.2 1.79970147358e-06 1.2 1.79973323171e-06 1.2 1.79976498984e-06 1.2 1.79979674797e-06 1.2 1.7998285061e-06 1.2 1.79986026423e-06 1.2 1.79989202236e-06 1.2 1.79992378049e-06 1.2 1.79995553862e-06 1.2 1.79998729675e-06 1.2 1.80001905488e-06 1.2 1.80005081301e-06 1.2 1.80008257114e-06 1.2]
VP (hp 0) vsource type=pwl wave=[0 .6 600n .6 600.1n .8 800n .8 800.1n .4 1u .4 1.0001u .6]
VN (hn 0) vsource dc=.6
XDET (rf hp hn amp_good phase_good vdd 0) validity_physical_v14
tran tran stop=1.8u maxstep=5p strobeperiod=1n strobeoutput=strobeonly method=traponly errpreset=conservative
save hp hn amp_good phase_good XDET.env XDET.threshold XDET.envref XDET.upper_ok XDET.lower_ok VDD:p
saveOptions options save=selected
