simulator lang=spectre
global 0
include "/home/process/tsmc180bcd_gen2_2022/PDK/TSMC180BCD/models/spectre/c018bcd_gen2_v1d6.scs" section=tt
include "/home/process/tsmc180bcd_gen2_2022/PDK/TSMC180BCD/models/spectre/c018bcd_gen2_v1d6.scs" section=stat_noise
simulator lang=spectre insensitive=no
include "/home/process/tsmc180bcd_gen2_2022/PDK/TSMC180BCD/models/spectre/c018bcd_gen2_v1d6.scs" section=tt_bbmvar
simulator lang=spectre insensitive=no
include "pll_capture_v14.scs"
simulatorOptions options temp=27 reltol=1e-6 vabstol=1e-9 iabstol=1e-13
VDD (vdd_source 0) vsource dc=1.2
VMEAS (vdd_source vdd) vsource dc=0
VR (ref 0) vsource type=pulse val0=0 val1=1.2 period=41.6666666666667n width=20.8233333333333n rise=10p fall=10p delay=9.3333333333351E-9
VRST (reset 0) vsource dc=0
VAP (apply 0) vsource dc=0
VK0 (k0 0) vsource dc=1.2
VK1 (k1 0) vsource dc=0
VK2 (k2 0) vsource dc=0
VK3 (k3 0) vsource dc=1.2
VK4 (k4 0) vsource dc=0
VK5 (k5 0) vsource dc=1.2
XP (ref reset apply k0 k1 k2 k3 k4 k5 out qualified range_error cfg_ready frequency_good phase_good amp_good vdd 0) pll_capture_v14
CL (out 0) capacitor c=10f
tran tran stop=2.2u maxstep=.25p strobeperiod=2n strobeoutput=strobeonly skipstop=1u method=gear2only errpreset=moderate readic="main_fine2200_phase_continuous.ic" skipdc=yes noisefmax=320G noisefmin=1M noiseseed=11 param=isnoisy param_vec=[0 0 1u 0] writefinal="__FINAL_STATE__"
saveOptions options save=selected
save XP.restart XP.hp XP.hn XP.vc1 out ref qualified range_error cfg_ready frequency_good phase_good amp_good XP.ctrl XP.vp XP.vn XP.refb XP.XC.phase_held XP.XC.acquired XP.en VDD:p XP.VVCO:p XP.VRX:p XP.VRT:p XP.XC.XF.X57.XS.XN.x XP.XC.XF.X57.XS.x XP.XC.XF.X57.XS.qb XP.XC.XF.X57.qm XP.XC.XF.X57.clkb XP.XC.XF.X57.resetb XP.XC.XF.n139 XP.XC.XF.n140
