simulator lang=spectre
global 0
include "/home/process/tsmc180bcd_gen2_2022/PDK/TSMC180BCD/models/spectre/c018bcd_gen2_v1d6.scs" section=tt
include "/home/process/tsmc180bcd_gen2_2022/PDK/TSMC180BCD/models/spectre/c018bcd_gen2_v1d6.scs" section=stat_noise
simulator lang=spectre insensitive=no
include "/home/process/tsmc180bcd_gen2_2022/PDK/TSMC180BCD/models/spectre/c018bcd_gen2_v1d6.scs" section=tt_bbmvar
simulator lang=spectre insensitive=no
include "cells.scs"
simulatorOptions options reltol=1e-5 vabstol=1e-7 iabstol=1e-13 temp=27
include "lc_vco_v4r.scs"
VDD (vdd 0) vsource dc=1.2
include "divider_v2.scs"
include "limiter_chain.scs"
include "divider_bank_v5.scs"
include "cp_experiment.scs"
include "digital_cells_v2.scs"
include "cp_timing.scs"
include "sampler_bias_v5.scs"
XBM (vdd 0 vmid) tx_bias_mid_v5
CCP (vp sp) capacitor c=120f
CCN (vn sn) capacitor c=120f
RBP (sp vmid) resistor r=1Meg
RBN (sn vmid) resistor r=1Meg
VR (ref 0) vsource type=pulse val0=0 val1=1.2 period=41.6666666666667n width=20.8233333333333n rise=10p fall=10p delay=1n
XR (ref refb vdd 0) tx_reference_buffer
CR (refb 0) capacitor c=60f
XS (refb sp sn hp hn vdd 0) tx_sampler
XA (refb en rst pulse vdd 0) tx_cp_timing
VE (en 0) vsource dc=1.2
XCP (hp hn pulse en cpout vdd 0) tx_cp_experiment
VO (cpout 0) vsource dc=0.84
VRST (rst 0) vsource dc=0
ahdl_include "tank_waveform_v5.va"
XRF (vp vn 0) tank_waveform_v5 phase_deg=320.25
pss pss fund=24M harms=4 tstab=350n maxstep=2p method=traponly errpreset=conservative saveinit=no
save vp vn hp hn sp sn refb pulse VO:p VDD:p
saveOptions options save=selected
