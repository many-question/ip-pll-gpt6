simulator lang=spectre
global 0
include "/home/process/tsmc180bcd_gen2_2022/PDK/TSMC180BCD/models/spectre/c018bcd_gen2_v1d6.scs" section=tt
include "/home/process/tsmc180bcd_gen2_2022/PDK/TSMC180BCD/models/spectre/c018bcd_gen2_v1d6.scs" section=stat_noise
simulator lang=spectre insensitive=no
include "/home/process/tsmc180bcd_gen2_2022/PDK/TSMC180BCD/models/spectre/c018bcd_gen2_v1d6.scs" section=tt_bbmvar
simulator lang=spectre insensitive=no
include "cells.scs"
include "loop_filter_v5.scs"
simulatorOptions options reltol=1e-5 vabstol=1e-7 iabstol=1e-13 temp=27
include "lc_vco_v4r.scs"
VDD (vdd 0) vsource dc=1.2
VVCO (vco_vdd vdd) vsource dc=0
VPRE (preset 0) vsource dc=0.89
XLF (ctrl vc1 en preset vdd 0) tx_loop_filter_v5 rlf=100k
VB0 (b0 0) vsource dc=0
VB1 (b1 0) vsource dc=1.2
VB2 (b2 0) vsource dc=1.2
VB3 (b3 0) vsource dc=0
VB4 (b4 0) vsource dc=0
VB5 (b5 0) vsource dc=0
VB6 (b6 0) vsource dc=0
VB7 (b7 0) vsource dc=0
XV (vp vn ctrl b0 b1 b2 b3 b4 b5 b6 b7 vco_vdd 0) tx_lc_vco_v4r fixed_c=1e-14 tank_l=2e-09 series_r=6.822430344006 cscale=1 core_w=0.00012 pcore_w=8e-05 ibias=8e-05 unit_c=4.4e-15 unit_w=1.2e-06 fine_w=4.5e-06
include "divider_v2.scs"
include "limiter_chain.scs"
include "divider_bank_v6_clamp.scs"
include "cp_experiment.scs"
include "digital_cells_v2.scs"
include "cp_timing.scs"
include "sampler_bias_v5.scs"
XBM (vdd 0 vmid) tx_bias_mid_v5
CCP (vp sp) capacitor c=120f
CCN (vn sn) capacitor c=120f
RBP (sp vmid) resistor r=10k
RBN (sn vmid) resistor r=10k
VR (ref 0) vsource type=pulse val0=0 val1=1.2 period=41.6666666666667n width=20.8233333333333n rise=10p fall=10p delay=1n
XR (ref refb vdd 0) tx_reference_buffer
CR (refb 0) capacitor c=60f
XS (refb sp sn hp hn vdd 0) tx_sampler
XA (refb en rst pulse vdd 0) tx_cp_timing
VE (en 0) vsource type=pwl wave=[0 0 400n 0 400.05n 1.2]
XCP (hp hn pulse en cpout vdd 0) tx_cp_experiment
VO (cpout ctrl) vsource dc=0
VRST (rst 0) vsource type=pwl wave=[0 1.2 20n 1.2 20.02n 0]
XD (vp vn rst vdd 0 0 0 0 0 out vdd 0) tx_divider_bank_v6_clamp rb_input=50k rb_clock=50k cdec=10p
CL (out 0) capacitor c=10f
ic vp=1.20001 vn=1.2 ctrl=0.89 vc1=0.89
ahdl_include "lc_loop_observer.va"
XOBS (vp vn refb ctrl out 0 obsphase obscycles obsctrl obsdivcycles) lc_loop_observer
tran tran stop=4u maxstep=1p method=traponly errpreset=conservative writefinal="__FINAL_STATE__" strobeperiod=1n strobeoutput=strobeonly
save vp vn XD.acp3 XD.acn3 XD.acp7 XD.acn7 XD.ckp7 XD.nb7 XD.cim XD.cm XV.XL.nb XV.XL.nfilt XV.XL.tail vmid
save obsphase obscycles obsctrl obsdivcycles ctrl vc1 hp hn pulse refb en VDD:p VVCO:p VO:p
saveOptions options save=selected
