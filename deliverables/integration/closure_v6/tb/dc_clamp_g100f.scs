simulator lang=spectre
global 0
include "/home/process/tsmc180bcd_gen2_2022/PDK/TSMC180BCD/models/spectre/c018bcd_gen2_v1d6.scs" section=tt
include "/home/process/tsmc180bcd_gen2_2022/PDK/TSMC180BCD/models/spectre/c018bcd_gen2_v1d6.scs" section=stat_noise
simulator lang=spectre insensitive=no
include "/home/process/tsmc180bcd_gen2_2022/PDK/TSMC180BCD/models/spectre/c018bcd_gen2_v1d6.scs" section=tt_bbmvar
simulator lang=spectre insensitive=no
include "cells.scs"
include "divider_v2.scs"
include "limiter_chain.scs"
include "divider_bank_v6_clamp.scs"
simulatorOptions options reltol=1e-5 vabstol=1e-7 iabstol=1e-13 temp=27 gmin=100f
VDD (vdd 0) vsource dc=1.2
VP (vp 0) vsource dc=1.2
VN (vn 0) vsource dc=1.2
VRST (rst 0) vsource dc=0
XD (vp vn rst vdd 0 0 0 0 0 out vdd 0) tx_divider_bank_v6_clamp rb_input=50k rb_clock=50k cdec=10p
CL (out 0) capacitor c=10f
dcOp dc
save vp vn out XD.acp3 XD.acn3 XD.acp7 XD.acn7 XD.cim XD.cm XD.nb7 VDD:p
saveOptions options save=selected
