simulator lang=spectre
global 0
include "/home/process/tsmc180bcd_gen2_2022/PDK/TSMC180BCD/models/spectre/c018bcd_gen2_v1d6.scs" section=tt
include "/home/process/tsmc180bcd_gen2_2022/PDK/TSMC180BCD/models/spectre/c018bcd_gen2_v1d6.scs" section=stat_noise
simulator lang=spectre insensitive=no
include "cells.scs"
include "receiver.scs"
simulatorOptions options reltol=1e-5 vabstol=1e-7 iabstol=1e-13 temp=27

include "digital_cells_v2.scs"
include "cml_prescaler_experiment.scs"
include "limiter_chain.scs"
include "cmos_divider_v2.scs"
VC (clk 0) vsource type=pulse val0=0 val1=1.2 delay=1n rise=20p fall=20p width=230p period=500p
VR (rst 0) vsource type=pulse val0=1.2 val1=0 delay=10n rise=20p fall=20p width=1u period=2u
VD2 (vdd2 0) vsource dc=1.2
X2 (clk rst vdd2 0 0 0 0 0 o2 vdd2 0) tx_cmos_modn
CL2 (o2 0) capacitor c=10f
VD3 (vdd3 0) vsource dc=1.2
X3 (clk rst 0 vdd3 0 0 0 0 o3 vdd3 0) tx_cmos_modn
CL3 (o3 0) capacitor c=10f
VD4 (vdd4 0) vsource dc=1.2
X4 (clk rst 0 0 vdd4 0 0 0 o4 vdd4 0) tx_cmos_modn
CL4 (o4 0) capacitor c=10f
VD5 (vdd5 0) vsource dc=1.2
X5 (clk rst 0 0 0 vdd5 0 0 o5 vdd5 0) tx_cmos_modn
CL5 (o5 0) capacitor c=10f
VD6 (vdd6 0) vsource dc=1.2
X6 (clk rst 0 0 0 0 vdd6 0 o6 vdd6 0) tx_cmos_modn
CL6 (o6 0) capacitor c=10f
VD7 (vdd7 0) vsource dc=1.2
X7 (clk rst 0 0 0 0 0 vdd7 o7 vdd7 0) tx_cmos_modn
CL7 (o7 0) capacitor c=10f
tran tran stop=100n maxstep=5p errpreset=moderate
save clk rst o2 X2.q0 X2.q1 VD2:p o3 X3.q0 X3.q1 VD3:p o4 X4.q0 X4.q1 VD4:p o5 X5.q0 X5.q1 VD5:p o6 X6.q0 X6.q1 VD6:p o7 X7.q0 X7.q1 VD7:p
saveOptions options save=selected
