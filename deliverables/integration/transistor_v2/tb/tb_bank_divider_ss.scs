simulator lang=spectre
global 0
include "/home/process/tsmc180bcd_gen2_2022/PDK/TSMC180BCD/models/spectre/c018bcd_gen2_v1d6.scs" section=ss
include "/home/process/tsmc180bcd_gen2_2022/PDK/TSMC180BCD/models/spectre/c018bcd_gen2_v1d6.scs" section=stat_noise
simulator lang=spectre insensitive=no
include "cells.scs"
include "receiver.scs"
simulatorOptions options reltol=1e-5 vabstol=1e-7 iabstol=1e-13 temp=60

include "divider_v2.scs"
include "limiter_chain.scs"
include "bank_divider_v2.scs"
VP (cp 0) vsource type=sine dc=1.2 ampl=.2 freq=4G
VN (cn 0) vsource type=sine dc=1.2 ampl=.2 freq=4G sinephase=180
VR (rst 0) vsource type=pulse val0=1.2 val1=0 delay=10n rise=20p fall=20p width=1u period=2u
VD2 (vdd2 0) vsource dc=1.2
X2 (cp cn rst vdd2 0 0 0 0 0 out2 vdd2 0) tx_divider_bank
CL2 (out2 0) capacitor c=10f
VD7 (vdd7 0) vsource dc=1.2
X7 (cp cn rst 0 0 0 0 0 vdd7 out7 vdd7 0) tx_divider_bank
CL7 (out7 0) capacitor c=10f
tran tran stop=100n maxstep=5p errpreset=moderate
save cp cn rst out2 X2.selected X2.q2_1p X2.q2_1n VD2:p out7 X7.selected X7.q7_6p X7.q7_6n VD7:p
saveOptions options save=selected
