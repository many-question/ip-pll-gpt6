simulator lang=spectre
global 0
include "/home/process/tsmc180bcd_gen2_2022/PDK/TSMC180BCD/models/spectre/c018bcd_gen2_v1d6.scs" section=tt
include "/home/process/tsmc180bcd_gen2_2022/PDK/TSMC180BCD/models/spectre/c018bcd_gen2_v1d6.scs" section=stat_noise
simulator lang=spectre insensitive=no
include "cells.scs"
include "receiver.scs"
simulatorOptions options reltol=1e-5 vabstol=1e-7 iabstol=1e-13 temp=27

include "/home/process/tsmc180bcd_gen2_2022/PDK/TSMC180BCD/models/spectre/c018bcd_gen2_v1d6.scs" section=tt_bbmvar
simulator lang=spectre insensitive=no
include "lc_vco_off_biased.scs"
VDD (vdd 0) vsource dc=1.2
VC (ctrl 0) vsource dc=.6
VB0 (b0 0) vsource dc=0
VB1 (b1 0) vsource dc=0
VB2 (b2 0) vsource dc=0
VB3 (b3 0) vsource dc=0
VB4 (b4 0) vsource dc=0
VB5 (b5 0) vsource dc=0
VB6 (b6 0) vsource dc=0
VB7 (b7 0) vsource dc=0
XV (vp vn ctrl b0 b1 b2 b3 b4 b5 b6 b7 vdd 0) tx_lc_vco_off_biased
ic vp=1.20001 vn=1.2
pss (vp vn) pss fund=4000000000.0 harms=31 tstab=300n maxstep=5p errpreset=conservative saveinit=yes
pn (vp vn) pnoise start=10k stop=500M dec=20 maxsideband=31 noiseout=[usb am pm] sweeptype=relative relharmnum=1
save XV.bcm XV.XBP.x7 XV.XBN.x7 vp vn XV.XL.tail VDD:p
saveOptions options save=selected
