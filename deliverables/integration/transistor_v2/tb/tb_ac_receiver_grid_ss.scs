simulator lang=spectre
global 0
include "/home/process/tsmc180bcd_gen2_2022/PDK/TSMC180BCD/models/spectre/c018bcd_gen2_v1d6.scs" section=ss
include "/home/process/tsmc180bcd_gen2_2022/PDK/TSMC180BCD/models/spectre/c018bcd_gen2_v1d6.scs" section=stat_noise
simulator lang=spectre insensitive=no
include "cells.scs"
include "receiver.scs"
simulatorOptions options reltol=1e-5 vabstol=1e-7 iabstol=1e-13 temp=60

include "divider_v2.scs"
VP (ip 0) vsource type=sine dc=1.05 ampl=.08 freq=2G
VD0 (vdd0 0) vsource dc=1.2
X0 (ip o0 vdd0 0) tx_ac_receiver_v2 wn=0.3u ratio=1.5
CL0 (o0 0) capacitor c=10f
VD1 (vdd1 0) vsource dc=1.2
X1 (ip o1 vdd1 0) tx_ac_receiver_v2 wn=0.3u ratio=2.5
CL1 (o1 0) capacitor c=10f
VD2 (vdd2 0) vsource dc=1.2
X2 (ip o2 vdd2 0) tx_ac_receiver_v2 wn=0.3u ratio=4.0
CL2 (o2 0) capacitor c=10f
VD3 (vdd3 0) vsource dc=1.2
X3 (ip o3 vdd3 0) tx_ac_receiver_v2 wn=0.6u ratio=1.5
CL3 (o3 0) capacitor c=10f
VD4 (vdd4 0) vsource dc=1.2
X4 (ip o4 vdd4 0) tx_ac_receiver_v2 wn=0.6u ratio=2.5
CL4 (o4 0) capacitor c=10f
VD5 (vdd5 0) vsource dc=1.2
X5 (ip o5 vdd5 0) tx_ac_receiver_v2 wn=0.6u ratio=4.0
CL5 (o5 0) capacitor c=10f
VD6 (vdd6 0) vsource dc=1.2
X6 (ip o6 vdd6 0) tx_ac_receiver_v2 wn=1.2u ratio=1.5
CL6 (o6 0) capacitor c=10f
VD7 (vdd7 0) vsource dc=1.2
X7 (ip o7 vdd7 0) tx_ac_receiver_v2 wn=1.2u ratio=2.5
CL7 (o7 0) capacitor c=10f
VD8 (vdd8 0) vsource dc=1.2
X8 (ip o8 vdd8 0) tx_ac_receiver_v2 wn=1.2u ratio=4.0
CL8 (o8 0) capacitor c=10f
VD9 (vdd9 0) vsource dc=1.2
X9 (ip o9 vdd9 0) tx_ac_receiver_v2 wn=2.4u ratio=1.5
CL9 (o9 0) capacitor c=10f
VD10 (vdd10 0) vsource dc=1.2
X10 (ip o10 vdd10 0) tx_ac_receiver_v2 wn=2.4u ratio=2.5
CL10 (o10 0) capacitor c=10f
VD11 (vdd11 0) vsource dc=1.2
X11 (ip o11 vdd11 0) tx_ac_receiver_v2 wn=2.4u ratio=4.0
CL11 (o11 0) capacitor c=10f
tran tran stop=100n maxstep=5p errpreset=conservative
save o0 VD0:p o1 VD1:p o2 VD2:p o3 VD3:p o4 VD4:p o5 VD5:p o6 VD6:p o7 VD7:p o8 VD8:p o9 VD9:p o10 VD10:p o11 VD11:p
saveOptions options save=selected
