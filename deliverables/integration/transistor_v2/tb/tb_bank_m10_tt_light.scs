simulator lang=spectre
global 0
include "/home/process/tsmc180bcd_gen2_2022/PDK/TSMC180BCD/models/spectre/c018bcd_gen2_v1d6.scs" section=tt
include "/home/process/tsmc180bcd_gen2_2022/PDK/TSMC180BCD/models/spectre/c018bcd_gen2_v1d6.scs" section=stat_noise
simulator lang=spectre insensitive=no
include "cells.scs"
include "receiver.scs"
simulatorOptions options reltol=1e-5 vabstol=1e-7 iabstol=1e-13 temp=27

include "divider_v2.scs"
include "limiter_chain.scs"
include "bank_divider_light.scs"
VDD (vdd 0) vsource dc=1.2
VP (cp 0) vsource type=sine dc=1.2 ampl=.2 freq=3120000000.0
VN (cn 0) vsource type=sine dc=1.2 ampl=.2 freq=3120000000.0 sinephase=180
VR (rst 0) vsource type=pulse val0=1.2 val1=0 delay=10n rise=20p fall=20p width=1u period=2u
XD (cp cn rst 0 0 0 vdd 0 0 out vdd 0) tx_divider_bank_light
CL (out 0) capacitor c=10f
tran tran stop=120n maxstep=5p errpreset=moderate
save cp cn rst out XD.selected XD.q5_4p XD.q5_4n XD.ckp5 XD.ckn5 VDD:p
saveOptions options save=selected
