simulator lang=spectre
global 0
include "/home/process/tsmc180bcd_gen2_2022/PDK/TSMC180BCD/models/spectre/c018bcd_gen2_v1d6.scs" section=ss
include "/home/process/tsmc180bcd_gen2_2022/PDK/TSMC180BCD/models/spectre/c018bcd_gen2_v1d6.scs" section=stat_noise
simulator lang=spectre insensitive=no
include "cells.scs"
parameters vddval=1.2
VDD (vdd 0) vsource dc=vddval
simulatorOptions options reltol=1e-5 vabstol=1e-7 iabstol=1e-13 temp=60

include "cml_prescaler_experiment.scs"
VP (cp 0) vsource type=sine dc=1.2 ampl=.08 freq=2.688G
VN (cn 0) vsource type=sine dc=1.2 ampl=.08 freq=2.688G sinephase=180
XD (cp cn qp qn vdd 0) tx_cml_div2
CLP (qp 0) capacitor c=5f
CLN (qn 0) capacitor c=5f
include "cml_to_cmos_experiment.scs"
XC (qp qn cout cb vdd 0) tx_cml_to_cmos
COUT (cout 0) capacitor c=20f
COUB (cb 0) capacitor c=20f
ic qp=1.1 qn=1.09
tran tran stop=100n errpreset=conservative maxstep=5p
save cp cn qp qn cout cb VDD:p
saveOptions options save=selected
