simulator lang=spectre
global 0
include "/home/process/tsmc180bcd_gen2_2022/PDK/TSMC180BCD/models/spectre/c018bcd_gen2_v1d6.scs" section=tt
include "/home/process/tsmc180bcd_gen2_2022/PDK/TSMC180BCD/models/spectre/c018bcd_gen2_v1d6.scs" section=stat_noise
simulator lang=spectre insensitive=no
include "cells.scs"
parameters vddval=1.2
VDD (vdd 0) vsource dc=vddval
simulatorOptions options reltol=1e-5 vabstol=1e-7 iabstol=1e-13 temp=27

include "cp_experiment.scs"
ahdl_include "sampler_interface.va"
VP (vp 0) vsource type=sine dc=.6 ampl=.2 freq=3.936G
VN (vn 0) vsource type=sine dc=.6 ampl=.2 freq=3.936G sinephase=180
VE (enable 0) vsource dc=1.2
VR0 (ref0 0) vsource type=pulse val0=0 val1=1.2 period=41.6666666666667n width=20.8233333333333n rise=10p fall=10p delay=1e-09
XR0 (ref0 refb0 vdd 0) tx_reference_buffer
CR0 (refb0 0) capacitor c=60f
XS0 (refb0 vp vn hp0 hn0 vdd 0) tx_sampler
XA0 (refb0 hp0 hn0 sample0 held0 pulse0 vdd 0) sampler_interface
XC0 (hp0 hn0 pulse0 enable out0 vdd 0) tx_cp_experiment
VO0 (out0 0) vsource dc=.6
VR1 (ref1 0) vsource type=pulse val0=0 val1=1.2 period=41.6666666666667n width=20.8233333333333n rise=10p fall=10p delay=1.021172086720867e-09
XR1 (ref1 refb1 vdd 0) tx_reference_buffer
CR1 (refb1 0) capacitor c=60f
XS1 (refb1 vp vn hp1 hn1 vdd 0) tx_sampler
XA1 (refb1 hp1 hn1 sample1 held1 pulse1 vdd 0) sampler_interface
XC1 (hp1 hn1 pulse1 enable out1 vdd 0) tx_cp_experiment
VO1 (out1 0) vsource dc=.6
VR2 (ref2 0) vsource type=pulse val0=0 val1=1.2 period=41.6666666666667n width=20.8233333333333n rise=10p fall=10p delay=1.042344173441734e-09
XR2 (ref2 refb2 vdd 0) tx_reference_buffer
CR2 (refb2 0) capacitor c=60f
XS2 (refb2 vp vn hp2 hn2 vdd 0) tx_sampler
XA2 (refb2 hp2 hn2 sample2 held2 pulse2 vdd 0) sampler_interface
XC2 (hp2 hn2 pulse2 enable out2 vdd 0) tx_cp_experiment
VO2 (out2 0) vsource dc=.6
VR3 (ref3 0) vsource type=pulse val0=0 val1=1.2 period=41.6666666666667n width=20.8233333333333n rise=10p fall=10p delay=1.063516260162602e-09
XR3 (ref3 refb3 vdd 0) tx_reference_buffer
CR3 (refb3 0) capacitor c=60f
XS3 (refb3 vp vn hp3 hn3 vdd 0) tx_sampler
XA3 (refb3 hp3 hn3 sample3 held3 pulse3 vdd 0) sampler_interface
XC3 (hp3 hn3 pulse3 enable out3 vdd 0) tx_cp_experiment
VO3 (out3 0) vsource dc=.6
VR4 (ref4 0) vsource type=pulse val0=0 val1=1.2 period=41.6666666666667n width=20.8233333333333n rise=10p fall=10p delay=1.084688346883469e-09
XR4 (ref4 refb4 vdd 0) tx_reference_buffer
CR4 (refb4 0) capacitor c=60f
XS4 (refb4 vp vn hp4 hn4 vdd 0) tx_sampler
XA4 (refb4 hp4 hn4 sample4 held4 pulse4 vdd 0) sampler_interface
XC4 (hp4 hn4 pulse4 enable out4 vdd 0) tx_cp_experiment
VO4 (out4 0) vsource dc=.6
VR5 (ref5 0) vsource type=pulse val0=0 val1=1.2 period=41.6666666666667n width=20.8233333333333n rise=10p fall=10p delay=1.105860433604336e-09
XR5 (ref5 refb5 vdd 0) tx_reference_buffer
CR5 (refb5 0) capacitor c=60f
XS5 (refb5 vp vn hp5 hn5 vdd 0) tx_sampler
XA5 (refb5 hp5 hn5 sample5 held5 pulse5 vdd 0) sampler_interface
XC5 (hp5 hn5 pulse5 enable out5 vdd 0) tx_cp_experiment
VO5 (out5 0) vsource dc=.6
VR6 (ref6 0) vsource type=pulse val0=0 val1=1.2 period=41.6666666666667n width=20.8233333333333n rise=10p fall=10p delay=1.127032520325203e-09
XR6 (ref6 refb6 vdd 0) tx_reference_buffer
CR6 (refb6 0) capacitor c=60f
XS6 (refb6 vp vn hp6 hn6 vdd 0) tx_sampler
XA6 (refb6 hp6 hn6 sample6 held6 pulse6 vdd 0) sampler_interface
XC6 (hp6 hn6 pulse6 enable out6 vdd 0) tx_cp_experiment
VO6 (out6 0) vsource dc=.6
VR7 (ref7 0) vsource type=pulse val0=0 val1=1.2 period=41.6666666666667n width=20.8233333333333n rise=10p fall=10p delay=1.148204607046071e-09
XR7 (ref7 refb7 vdd 0) tx_reference_buffer
CR7 (refb7 0) capacitor c=60f
XS7 (refb7 vp vn hp7 hn7 vdd 0) tx_sampler
XA7 (refb7 hp7 hn7 sample7 held7 pulse7 vdd 0) sampler_interface
XC7 (hp7 hn7 pulse7 enable out7 vdd 0) tx_cp_experiment
VO7 (out7 0) vsource dc=.6
VR8 (ref8 0) vsource type=pulse val0=0 val1=1.2 period=41.6666666666667n width=20.8233333333333n rise=10p fall=10p delay=1.169376693766938e-09
XR8 (ref8 refb8 vdd 0) tx_reference_buffer
CR8 (refb8 0) capacitor c=60f
XS8 (refb8 vp vn hp8 hn8 vdd 0) tx_sampler
XA8 (refb8 hp8 hn8 sample8 held8 pulse8 vdd 0) sampler_interface
XC8 (hp8 hn8 pulse8 enable out8 vdd 0) tx_cp_experiment
VO8 (out8 0) vsource dc=.6
VR9 (ref9 0) vsource type=pulse val0=0 val1=1.2 period=41.6666666666667n width=20.8233333333333n rise=10p fall=10p delay=1.190548780487805e-09
XR9 (ref9 refb9 vdd 0) tx_reference_buffer
CR9 (refb9 0) capacitor c=60f
XS9 (refb9 vp vn hp9 hn9 vdd 0) tx_sampler
XA9 (refb9 hp9 hn9 sample9 held9 pulse9 vdd 0) sampler_interface
XC9 (hp9 hn9 pulse9 enable out9 vdd 0) tx_cp_experiment
VO9 (out9 0) vsource dc=.6
VR10 (ref10 0) vsource type=pulse val0=0 val1=1.2 period=41.6666666666667n width=20.8233333333333n rise=10p fall=10p delay=1.211720867208672e-09
XR10 (ref10 refb10 vdd 0) tx_reference_buffer
CR10 (refb10 0) capacitor c=60f
XS10 (refb10 vp vn hp10 hn10 vdd 0) tx_sampler
XA10 (refb10 hp10 hn10 sample10 held10 pulse10 vdd 0) sampler_interface
XC10 (hp10 hn10 pulse10 enable out10 vdd 0) tx_cp_experiment
VO10 (out10 0) vsource dc=.6
VR11 (ref11 0) vsource type=pulse val0=0 val1=1.2 period=41.6666666666667n width=20.8233333333333n rise=10p fall=10p delay=1.232892953929539e-09
XR11 (ref11 refb11 vdd 0) tx_reference_buffer
CR11 (refb11 0) capacitor c=60f
XS11 (refb11 vp vn hp11 hn11 vdd 0) tx_sampler
XA11 (refb11 hp11 hn11 sample11 held11 pulse11 vdd 0) sampler_interface
XC11 (hp11 hn11 pulse11 enable out11 vdd 0) tx_cp_experiment
VO11 (out11 0) vsource dc=.6
tran tran stop=145n errpreset=conservative maxstep=5p
save VDD:p hp0 hn0 VO0:p hp1 hn1 VO1:p hp2 hn2 VO2:p hp3 hn3 VO3:p hp4 hn4 VO4:p hp5 hn5 VO5:p hp6 hn6 VO6:p hp7 hn7 VO7:p hp8 hn8 VO8:p hp9 hn9 VO9:p hp10 hn10 VO10:p hp11 hn11 VO11:p
saveOptions options save=selected
