simulator lang=spectre
global 0
include "/home/process/tsmc180bcd_gen2_2022/PDK/TSMC180BCD/models/spectre/c018bcd_gen2_v1d6.scs" section=tt
include "/home/process/tsmc180bcd_gen2_2022/PDK/TSMC180BCD/models/spectre/c018bcd_gen2_v1d6.scs" section=stat_noise
simulator lang=spectre insensitive=no
include "cells.scs"
parameters vddval=1.2
VDD (vdd 0) vsource dc=vddval
simulatorOptions options reltol=1e-5 vabstol=1e-7 iabstol=1e-13 temp=27

VE (en 0) vsource type=pulse val0=0 val1=1.2 delay=1u rise=20p fall=20p width=2u period=4u
VP (pre 0) vsource dc=.6
XF (ctrl vc1 en pre vdd 0) tx_loop_filter
IIN (0 ctrl) isource type=pulse val0=0 val1=1u delay=1.2u rise=10p fall=10p width=100n period=1u
ic ctrl=0 vc1=0
tran tran stop=1.6u errpreset=conservative maxstep=1n
save en ctrl vc1 VDD:p VP:p
saveOptions options save=selected
