simulator lang=spectre
global 0
include "/home/process/tsmc180bcd_gen2_2022/PDK/TSMC180BCD/models/spectre/c018bcd_gen2_v1d6.scs" section=ss
include "/home/process/tsmc180bcd_gen2_2022/PDK/TSMC180BCD/models/spectre/c018bcd_gen2_v1d6.scs" section=stat_noise
simulator lang=spectre insensitive=no
include "cells.scs"
parameters vddval=1.2
VDD (vdd 0) vsource dc=vddval
simulatorOptions options reltol=1e-5 vabstol=1e-7 iabstol=1e-13 temp=60
include "cml_prescaler_experiment.scs"
VP (cp 0) vsource type=sine dc=1.2 ampl=.2 freq=4G
VN (cn 0) vsource type=sine dc=1.2 ampl=.2 freq=4G sinephase=180
VS0 (s0 0) vsource dc=1.2
XD0 (cp cn qp0 qn0 s0 0) tx_cml_div2 rload=1600 ibias=20u
CP0 (qp0 0) capacitor c=5f
CN0 (qn0 0) capacitor c=5f
ic qp0=1.1 qn0=1.09
VS1 (s1 0) vsource dc=1.2
XD1 (cp cn qp1 qn1 s1 0) tx_cml_div2 rload=1600 ibias=30u
CP1 (qp1 0) capacitor c=5f
CN1 (qn1 0) capacitor c=5f
ic qp1=1.1 qn1=1.09
VS2 (s2 0) vsource dc=1.2
XD2 (cp cn qp2 qn2 s2 0) tx_cml_div2 rload=1600 ibias=40u
CP2 (qp2 0) capacitor c=5f
CN2 (qn2 0) capacitor c=5f
ic qp2=1.1 qn2=1.09
VS3 (s3 0) vsource dc=1.2
XD3 (cp cn qp3 qn3 s3 0) tx_cml_div2 rload=2000 ibias=20u
CP3 (qp3 0) capacitor c=5f
CN3 (qn3 0) capacitor c=5f
ic qp3=1.1 qn3=1.09
VS4 (s4 0) vsource dc=1.2
XD4 (cp cn qp4 qn4 s4 0) tx_cml_div2 rload=2000 ibias=30u
CP4 (qp4 0) capacitor c=5f
CN4 (qn4 0) capacitor c=5f
ic qp4=1.1 qn4=1.09
VS5 (s5 0) vsource dc=1.2
XD5 (cp cn qp5 qn5 s5 0) tx_cml_div2 rload=2000 ibias=40u
CP5 (qp5 0) capacitor c=5f
CN5 (qn5 0) capacitor c=5f
ic qp5=1.1 qn5=1.09
VS6 (s6 0) vsource dc=1.2
XD6 (cp cn qp6 qn6 s6 0) tx_cml_div2 rload=2400 ibias=20u
CP6 (qp6 0) capacitor c=5f
CN6 (qn6 0) capacitor c=5f
ic qp6=1.1 qn6=1.09
VS7 (s7 0) vsource dc=1.2
XD7 (cp cn qp7 qn7 s7 0) tx_cml_div2 rload=2400 ibias=30u
CP7 (qp7 0) capacitor c=5f
CN7 (qn7 0) capacitor c=5f
ic qp7=1.1 qn7=1.09
VS8 (s8 0) vsource dc=1.2
XD8 (cp cn qp8 qn8 s8 0) tx_cml_div2 rload=2400 ibias=40u
CP8 (qp8 0) capacitor c=5f
CN8 (qn8 0) capacitor c=5f
ic qp8=1.1 qn8=1.09
tran tran stop=50n errpreset=conservative maxstep=5p
save qp0 qn0 VS0:p qp1 qn1 VS1:p qp2 qn2 VS2:p qp3 qn3 VS3:p qp4 qn4 VS4:p qp5 qn5 VS5:p qp6 qn6 VS6:p qp7 qn7 VS7:p qp8 qn8 VS8:p
saveOptions options save=selected
