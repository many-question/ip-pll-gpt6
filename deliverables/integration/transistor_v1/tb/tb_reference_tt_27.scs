simulator lang=spectre
global 0
include "/home/process/tsmc180bcd_gen2_2022/PDK/TSMC180BCD/models/spectre/c018bcd_gen2_v1d6.scs" section=tt
include "/home/process/tsmc180bcd_gen2_2022/PDK/TSMC180BCD/models/spectre/c018bcd_gen2_v1d6.scs" section=stat_noise
simulator lang=spectre insensitive=no
include "cells.scs"
parameters vddval=1.2
VDD (vdd 0) vsource dc=vddval
simulatorOptions options reltol=1e-5 vabstol=1e-7 iabstol=1e-13 temp=27

VI (inp 0) vsource type=pulse val0=0 val1=1.2 period=41.6666666666667n width=20.73333333333335n rise=100p fall=100p delay=1n
XB (inp out vdd 0) tx_reference_buffer
CL (out 0) capacitor c=60f
tran tran stop=180n errpreset=conservative maxstep=100p
save inp out VDD:p
saveOptions options save=selected
