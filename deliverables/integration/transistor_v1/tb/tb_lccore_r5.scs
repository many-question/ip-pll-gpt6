simulator lang=spectre
global 0
include "/home/process/tsmc180bcd_gen2_2022/PDK/TSMC180BCD/models/spectre/c018bcd_gen2_v1d6.scs" section=tt
include "/home/process/tsmc180bcd_gen2_2022/PDK/TSMC180BCD/models/spectre/c018bcd_gen2_v1d6.scs" section=stat_noise
simulator lang=spectre insensitive=no
include "cells.scs"
parameters vddval=1.2
VDD (vdd 0) vsource dc=vddval
simulatorOptions options reltol=1e-5 vabstol=1e-7 iabstol=1e-13 temp=27

include "lc_core_experiment.scs"
XL (vp vn vdd 0) tx_lc_core_experiment tank_r=5
ic vp=1.20001 vn=1.2
tran tran stop=200n errpreset=conservative maxstep=5p
save vp vn XL.tail XL.nb VDD:p
saveOptions options save=selected
